* OA-SAR8 offset MC: ONE sample per ngspice invocation (parse-time agauss roll).
* SEEDVAL is substituted by the driver script; mm_ok=1 enables IHP mismatch.
.option SEED=SEEDVAL
.lib cornerMOSlv.lib mos_tt_mismatch
.param mm_ok=1
.param vdd=1.5
.param vcm=0.9

* mm_ok is a SUBCKT parameter (default 0): must be enabled per instance
XM1 p   inp tail 0   sg13_lv_nmos w=8u l=0.15u ng=4 mm_ok=1
XM2 q   inn tail 0   sg13_lv_nmos w=8u l=0.15u ng=4 mm_ok=1
XM3 outn outp p 0    sg13_lv_nmos w=4u l=0.13u ng=2 mm_ok=1
XM4 outp outn q 0    sg13_lv_nmos w=4u l=0.13u ng=2 mm_ok=1
XM5 outn outp vdd vdd sg13_lv_pmos w=6u l=0.13u ng=2 mm_ok=1
XM6 outp outn vdd vdd sg13_lv_pmos w=6u l=0.13u ng=2 mm_ok=1
XS1 p    clk vdd vdd sg13_lv_pmos w=2u l=0.13u ng=1 mm_ok=1
XS2 q    clk vdd vdd sg13_lv_pmos w=2u l=0.13u ng=1 mm_ok=1
XS3 outn clk vdd vdd sg13_lv_pmos w=2u l=0.13u ng=1 mm_ok=1
XS4 outp clk vdd vdd sg13_lv_pmos w=2u l=0.13u ng=1 mm_ok=1
XMt tail clk 0 0     sg13_lv_nmos w=3u l=0.3u ng=2 mm_ok=1

VDD  vdd 0 {vdd}
Vclk clk 0 pulse(0 {vdd} 1n 0.05n 0.05n 2n 4n)
* symmetric differential ramp: +/-15mV, constant CM
Vip  inp 0 pwl(0 {vcm-15m} 258n {vcm+15m})
Vin  inn 0 pwl(0 {vcm+15m} 258n {vcm-15m})

.control
set wr_vecnames
set wr_singlescale
tran 100p 259n
wrdata mc_run_SEEDVAL v(outp) v(outn)
quit
.endc
.end
