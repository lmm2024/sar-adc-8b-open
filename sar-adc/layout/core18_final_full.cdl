************************************************************************
*
* Copyright 2023 IHP PDK Authors
*
* Licensed under the Apache License, Version 2.0 (the "License");
* you may not use this file except in compliance with the License.
* You may obtain a copy of the License at
*
*    https://www.apache.org/licenses/LICENSE-2.0
*
* Unless required by applicable law or agreed to in writing, software
* distributed under the License is distributed on an "AS IS" BASIS,
* WITHOUT WARRANTIES OR CONDITIONS OF ANY KIND, either express or implied.
* See the License for the specific language governing permissions and
* limitations under the License.
*
************************************************************************

************************************************************************
* Library Name: sg13g2_stdcell
* Cell Name:    sg13g2_a21o_1
* View Name:    schematic
************************************************************************

.SUBCKT sg13g2_a21o_1 X A1 A2 B1 VDD VSS
*.PININFO A1:I A2:I B1:I X:O VDD:B VSS:B
MN0 net1 A1 net2 VSS sg13_lv_nmos m=1 w=640.00n l=130.00n ng=1
MN1 net2 A2 VSS VSS sg13_lv_nmos m=1 w=640.00n l=130.00n ng=1
MN2 net1 B1 VSS VSS sg13_lv_nmos m=1 w=640.00n l=130.00n ng=1
MN3 X net1 VSS VSS sg13_lv_nmos m=1 w=740.00n l=130.00n ng=1
MP2 net1 B1 net3 VDD sg13_lv_pmos m=1 w=1.000u l=130.00n ng=1
MP0 net3 A1 VDD VDD sg13_lv_pmos m=1 w=1.000u l=130.00n ng=1
MP1 net3 A2 VDD VDD sg13_lv_pmos m=1 w=1.000u l=130.00n ng=1
MP3 X net1 VDD VDD sg13_lv_pmos m=1 w=1.12u l=130.00n ng=1
.ENDS

************************************************************************
* Library Name: sg13g2_stdcell
* Cell Name:    sg13g2_a21o_2
* View Name:    schematic
************************************************************************

.SUBCKT sg13g2_a21o_2 X A1 A2 B1 VDD VSS
*.PININFO A1:I A2:I B1:I X:O VDD:B VSS:B
MN0 net1 A1 net2 VSS sg13_lv_nmos m=1 w=740.00n l=130.00n ng=1
MN1 net2 A2 VSS VSS sg13_lv_nmos m=1 w=740.00n l=130.00n ng=1
MN2 net1 B1 VSS VSS sg13_lv_nmos m=1 w=740.00n l=130.00n ng=1
MN3 X net1 VSS VSS sg13_lv_nmos m=1 w=1.48u l=130.00n ng=2
MP2 net1 B1 net3 VDD sg13_lv_pmos m=1 w=1.000u l=130.00n ng=1
MP0 net3 A1 VDD VDD sg13_lv_pmos m=1 w=1.000u l=130.00n ng=1
MP1 net3 A2 VDD VDD sg13_lv_pmos m=1 w=1.000u l=130.00n ng=1
MP3 X net1 VDD VDD sg13_lv_pmos m=1 w=2.24u l=130.00n ng=2
.ENDS

************************************************************************
* Library Name: sg13g2_stdcell
* Cell Name:    sg13g2_a21oi_1
* View Name:    schematic
************************************************************************

.SUBCKT sg13g2_a21oi_1 Y A1 A2 B1 VDD VSS
*.PININFO A1:I A2:I B1:I Y:O VDD:B VSS:B
MN0 Y B1 VSS VSS sg13_lv_nmos m=1 w=740.00n l=130.00n ng=1
MN2 net1 A2 VSS VSS sg13_lv_nmos m=1 w=740.00n l=130.00n ng=1
MN1 Y A1 net1 VSS sg13_lv_nmos m=1 w=740.00n l=130.00n ng=1
MP2 Y B1 net2 VDD sg13_lv_pmos m=1 w=1.12u l=130.00n ng=1
MP1 net2 A2 VDD VDD sg13_lv_pmos m=1 w=1.12u l=130.00n ng=1
MP0 net2 A1 VDD VDD sg13_lv_pmos m=1 w=1.12u l=130.00n ng=1
.ENDS

************************************************************************
* Library Name: sg13g2_stdcell
* Cell Name:    sg13g2_a21oi_2
* View Name:    schematic
************************************************************************

.SUBCKT sg13g2_a21oi_2 Y A1 A2 B1 VDD VSS
*.PININFO A1:I A2:I B1:I Y:O VDD:B VSS:B
MN0 Y B1 VSS VSS sg13_lv_nmos m=1 w=1.48u l=130.00n ng=2
MN2 net2 A2 VSS VSS sg13_lv_nmos m=1 w=1.48u l=130.00n ng=2
MN1 Y A1 net2 VSS sg13_lv_nmos m=1 w=1.48u l=130.00n ng=2
MP2 Y B1 net1 VDD sg13_lv_pmos m=1 w=2.24u l=130.00n ng=2
MP1 net1 A2 VDD VDD sg13_lv_pmos m=1 w=2.24u l=130.00n ng=2
MP0 net1 A1 VDD VDD sg13_lv_pmos m=1 w=2.24u l=130.00n ng=2
.ENDS

************************************************************************
* Library Name: sg13g2_stdcell
* Cell Name:    sg13g2_a221oi_1
* View Name:    schematic
************************************************************************

.SUBCKT sg13g2_a221oi_1 Y A1 A2 B1 B2 C1 VDD VSS
*.PININFO A1:I A2:I B1:I B2:I C1:I Y:O VDD:B VSS:B
MP2 Y C1 net3 VDD sg13_lv_pmos m=1 w=1.12u l=130.00n ng=1
MP4 net3 B2 net1 VDD sg13_lv_pmos m=1 w=1.12u l=130.00n ng=1
MP1 net3 B1 net1 VDD sg13_lv_pmos m=1 w=1.12u l=130.00n ng=1
MP3 net1 A2 VDD VDD sg13_lv_pmos m=1 w=1.12u l=130.00n ng=1
MP0 net1 A1 VDD VDD sg13_lv_pmos m=1 w=1.12u l=130.00n ng=1
MN4 Y C1 VSS VSS sg13_lv_nmos m=1 w=740.00n l=130.00n ng=1
MN3 net4 B2 VSS VSS sg13_lv_nmos m=1 w=740.00n l=130.00n ng=1
MN2 Y B1 net4 VSS sg13_lv_nmos m=1 w=740.00n l=130.00n ng=1
MN1 net2 A2 VSS VSS sg13_lv_nmos m=1 w=740.00n l=130.00n ng=1
MN0 Y A1 net2 VSS sg13_lv_nmos m=1 w=740.00n l=130.00n ng=1
.ENDS

************************************************************************
* Library Name: sg13g2_stdcell
* Cell Name:    sg13g2_and2_1
* View Name:    schematic
************************************************************************

.SUBCKT sg13g2_and2_1 X A B VDD VSS
*.PININFO A:I B:I X:O VDD:B VSS:B
MN0 net4 A net2 VSS sg13_lv_nmos m=1 w=640.00n l=130.00n ng=1
MN2 X net4 VSS VSS sg13_lv_nmos m=1 w=740.00n l=130.00n ng=1
MN1 net2 B VSS VSS sg13_lv_nmos m=1 w=640.00n l=130.00n ng=1
MP0 net4 B VDD VDD sg13_lv_pmos m=1 w=840.00n l=130.00n ng=1
MP2 X net4 VDD VDD sg13_lv_pmos m=1 w=1.12u l=130.00n ng=1
MP1 net4 A VDD VDD sg13_lv_pmos m=1 w=840.00n l=130.00n ng=1
.ENDS

************************************************************************
* Library Name: sg13g2_stdcell
* Cell Name:    sg13g2_and2_2
* View Name:    schematic
************************************************************************

.SUBCKT sg13g2_and2_2 X A B VDD VSS
*.PININFO A:I B:I X:O VDD:B VSS:B
MN0 net1 A net2 VSS sg13_lv_nmos m=1 w=640.00n l=130.00n ng=1
MN2 X net1 VSS VSS sg13_lv_nmos m=1 w=1.48u l=130.00n ng=2
MN1 net2 B VSS VSS sg13_lv_nmos m=1 w=640.00n l=130.00n ng=1
MP0 net1 B VDD VDD sg13_lv_pmos m=1 w=840.00n l=130.00n ng=1
MP2 X net1 VDD VDD sg13_lv_pmos m=1 w=2.24u l=130.00n ng=2
MP1 net1 A VDD VDD sg13_lv_pmos m=1 w=840.00n l=130.00n ng=1
.ENDS

************************************************************************
* Library Name: sg13g2_stdcell
* Cell Name:    sg13g2_and3_1
* View Name:    schematic
************************************************************************

.SUBCKT sg13g2_and3_1 X A B C VDD VSS
*.PININFO A:I B:I C:I X:O VDD:B VSS:B
MN2 net3 C VSS VSS sg13_lv_nmos m=1 w=640.00n l=130.00n ng=1
MN3 X net2 VSS VSS sg13_lv_nmos m=1 w=740.00n l=130.00n ng=1
MN0 net2 A net1 VSS sg13_lv_nmos m=1 w=640.00n l=130.00n ng=1
MN1 net1 B net3 VSS sg13_lv_nmos m=1 w=640.00n l=130.00n ng=1
MP3 X net2 VDD VDD sg13_lv_pmos m=1 w=1.12u l=130.00n ng=1
MP1 net2 B VDD VDD sg13_lv_pmos m=1 w=840.00n l=130.00n ng=1
MP2 net2 A VDD VDD sg13_lv_pmos m=1 w=840.00n l=130.00n ng=1
MP0 net2 C VDD VDD sg13_lv_pmos m=1 w=840.00n l=130.00n ng=1
.ENDS

************************************************************************
* Library Name: sg13g2_stdcell
* Cell Name:    sg13g2_and3_2
* View Name:    schematic
************************************************************************

.SUBCKT sg13g2_and3_2 X A B C VDD VSS
*.PININFO A:I B:I C:I X:O VDD:B VSS:B
MN2 net3 C VSS VSS sg13_lv_nmos m=1 w=640.00n l=130.00n ng=1
MN3 X net2 VSS VSS sg13_lv_nmos m=1 w=1.48u l=130.00n ng=2
MN0 net2 A net1 VSS sg13_lv_nmos m=1 w=640.00n l=130.00n ng=1
MN1 net1 B net3 VSS sg13_lv_nmos m=1 w=640.00n l=130.00n ng=1
MP3 X net2 VDD VDD sg13_lv_pmos m=1 w=2.24u l=130.00n ng=2
MP1 net2 B VDD VDD sg13_lv_pmos m=1 w=840.00n l=130.00n ng=1
MP2 net2 A VDD VDD sg13_lv_pmos m=1 w=840.00n l=130.00n ng=1
MP0 net2 C VDD VDD sg13_lv_pmos m=1 w=840.00n l=130.00n ng=1
.ENDS

************************************************************************
* Library Name: sg13g2_stdcell
* Cell Name:    sg13g2_and4_1
* View Name:    schematic
************************************************************************

.SUBCKT sg13g2_and4_1 X A B C D VDD VSS
*.PININFO A:I B:I C:I D:I X:O VDD:B VSS:B
MN3 net17 D VSS VSS sg13_lv_nmos m=1 w=640.00n l=130.00n ng=1
MN2 net16 C net17 VSS sg13_lv_nmos m=1 w=640.00n l=130.00n ng=1
MN1 net15 B net16 VSS sg13_lv_nmos m=1 w=640.00n l=130.00n ng=1
MN0 net1 A net15 VSS sg13_lv_nmos m=1 w=640.00n l=130.00n ng=1
MN4 X net1 VSS VSS sg13_lv_nmos m=1 w=740.00n l=130.00n ng=1
MP3 net1 A VDD VDD sg13_lv_pmos m=1 w=840.00n l=130.00n ng=1
MP4 X net1 VDD VDD sg13_lv_pmos m=1 w=1.12u l=130.00n ng=1
MP0 net1 D VDD VDD sg13_lv_pmos m=1 w=840.00n l=130.00n ng=1
MP1 net1 C VDD VDD sg13_lv_pmos m=1 w=840.00n l=130.00n ng=1
MP2 net1 B VDD VDD sg13_lv_pmos m=1 w=840.00n l=130.00n ng=1
.ENDS

************************************************************************
* Library Name: sg13g2_stdcell
* Cell Name:    sg13g2_and4_2
* View Name:    schematic
************************************************************************

.SUBCKT sg13g2_and4_2 X A B C D VDD VSS
*.PININFO A:I B:I C:I D:I X:O VDD:B VSS:B
MN3 net17 D VSS VSS sg13_lv_nmos m=1 w=640.00n l=130.00n ng=1
MN2 net16 C net17 VSS sg13_lv_nmos m=1 w=640.00n l=130.00n ng=1
MN1 net15 B net16 VSS sg13_lv_nmos m=1 w=640.00n l=130.00n ng=1
MN0 net1 A net15 VSS sg13_lv_nmos m=1 w=640.00n l=130.00n ng=1
MN4 X net1 VSS VSS sg13_lv_nmos m=1 w=1.48u l=130.00n ng=2
MP3 net1 A VDD VDD sg13_lv_pmos m=1 w=840.00n l=130.00n ng=1
MP4 X net1 VDD VDD sg13_lv_pmos m=1 w=2.24u l=130.00n ng=2
MP0 net1 D VDD VDD sg13_lv_pmos m=1 w=840.00n l=130.00n ng=1
MP1 net1 C VDD VDD sg13_lv_pmos m=1 w=840.00n l=130.00n ng=1
MP2 net1 B VDD VDD sg13_lv_pmos m=1 w=840.00n l=130.00n ng=1
.ENDS

************************************************************************
* Library Name: sg13g2_stdcell
* Cell Name:    sg13g2_antennanp
* View Name:    schematic
************************************************************************

.SUBCKT sg13g2_antennanp A VDD VSS
*.PININFO A:I VDD:B VSS:B
DD1 VSS A dantenna m=1 w=780n l=780n a=608.4f p=3.12u
DD0 A VDD dpantenna m=1 w=1.05u l=1.34u a=1.407p p=4.78u
.ENDS

************************************************************************
* Library Name: sg13g2_stdcell
* Cell Name:    sg13g2_buf_1
* View Name:    schematic
************************************************************************

.SUBCKT sg13g2_buf_1 X A VDD VSS
*.PININFO A:I X:O VDD:B VSS:B
MN0 net1 A VSS VSS sg13_lv_nmos m=1 w=550.00n l=130.00n ng=1
MN1 X net1 VSS VSS sg13_lv_nmos m=1 w=740.00n l=130.00n ng=1
MP1 X net1 VDD VDD sg13_lv_pmos m=1 w=1.12u l=130.00n ng=1
MP0 net1 A VDD VDD sg13_lv_pmos m=1 w=840.00n l=130.00n ng=1
.ENDS

************************************************************************
* Library Name: sg13g2_stdcell
* Cell Name:    sg13g2_buf_16
* View Name:    schematic
************************************************************************

.SUBCKT sg13g2_buf_16 X A VDD VSS
*.PININFO A:I X:O VDD:B VSS:B
MN0 net1 A VSS VSS sg13_lv_nmos m=1 w=4.44u l=130.00n ng=6
MN1 X net1 VSS VSS sg13_lv_nmos m=1 w=11.84u l=130.00n ng=16
MP1 X net1 VDD VDD sg13_lv_pmos m=1 w=17.92u l=130.00n ng=16
MP0 net1 A VDD VDD sg13_lv_pmos m=1 w=6.72u l=130.00n ng=6
.ENDS

************************************************************************
* Library Name: sg13g2_stdcell
* Cell Name:    sg13g2_buf_2
* View Name:    schematic
************************************************************************

.SUBCKT sg13g2_buf_2 X A VDD VSS
*.PININFO A:I X:O VDD:B VSS:B
MN0 net1 A VSS VSS sg13_lv_nmos m=1 w=640.00n l=130.00n ng=1
MN1 X net1 VSS VSS sg13_lv_nmos m=1 w=1.48u l=130.00n ng=2
MP1 X net1 VDD VDD sg13_lv_pmos m=1 w=2.24u l=130.00n ng=2
MP0 net1 A VDD VDD sg13_lv_pmos m=1 w=1.000u l=130.00n ng=1
.ENDS

************************************************************************
* Library Name: sg13g2_stdcell
* Cell Name:    sg13g2_buf_4
* View Name:    schematic
************************************************************************

.SUBCKT sg13g2_buf_4 X A VDD VSS
*.PININFO A:I X:O VDD:B VSS:B
MN0 net1 A VSS VSS sg13_lv_nmos m=1 w=740.00n l=130.00n ng=1
MN1 X net1 VSS VSS sg13_lv_nmos m=1 w=2.96u l=130.00n ng=4
MP1 X net1 VDD VDD sg13_lv_pmos m=1 w=4.48u l=130.00n ng=4
MP0 net1 A VDD VDD sg13_lv_pmos m=1 w=1.68u l=130.00n ng=2
.ENDS

************************************************************************
* Library Name: sg13g2_stdcell
* Cell Name:    sg13g2_buf_8
* View Name:    schematic
************************************************************************

.SUBCKT sg13g2_buf_8 X A VDD VSS
*.PININFO A:I X:O VDD:B VSS:B
MN0 net1 A VSS VSS sg13_lv_nmos m=1 w=2.22u l=130.00n ng=3
MN1 X net1 VSS VSS sg13_lv_nmos m=1 w=5.92u l=130.00n ng=8
MP1 X net1 VDD VDD sg13_lv_pmos m=1 w=8.96u l=130.00n ng=8
MP0 net1 A VDD VDD sg13_lv_pmos m=1 w=3.36u l=130.00n ng=3
.ENDS

************************************************************************
* Library Name: sg13g2_stdcell
* Cell Name:    sg13g2_decap_4
* View Name:    schematic
************************************************************************

.SUBCKT sg13g2_decap_4 VDD VSS
*.PININFO VDD:B VSS:B
MN0 VSS VDD VSS VSS sg13_lv_nmos m=1 w=420.00n l=1.000u ng=1
MP0 VDD VSS VDD VDD sg13_lv_pmos m=1 w=1.000u l=1.000u ng=1
.ENDS

************************************************************************
* Library Name: sg13g2_stdcell
* Cell Name:    sg13g2_decap_8
* View Name:    schematic
************************************************************************

.SUBCKT sg13g2_decap_8 VDD VSS
*.PININFO VDD:B VSS:B
MN0 VSS VDD VSS VSS sg13_lv_nmos m=1 w=840.00n l=1.000u ng=2
MP0 VDD VSS VDD VDD sg13_lv_pmos m=1 w=2.000u l=1.000u ng=2
.ENDS

************************************************************************
* Library Name: sg13g2_stdcell
* Cell Name:    sg13g2_dfrbp_1
* View Name:    schematic
************************************************************************

.SUBCKT sg13g2_dfrbp_1 Q Q_N CLK D RESET_B VDD VSS
*.PININFO CLK:I D:I RESET_B:I Q:O Q_N:O VDD:B VSS:B
MN11 net12 net2 VSS VSS sg13_lv_nmos m=1 w=420.00n l=130.00n ng=1
MN10 net5 clkneg net12 VSS sg13_lv_nmos m=1 w=420.00n l=130.00n ng=1
MN12 net2 net5 net11 VSS sg13_lv_nmos m=1 w=420.00n l=130.00n ng=1
MN13 net11 RESET_B VSS VSS sg13_lv_nmos m=1 w=420.00n l=130.00n ng=1
MN14 Q_N net5 VSS VSS sg13_lv_nmos m=1 w=740.00n l=130.00n ng=1
MN0 Db D net10 VSS sg13_lv_nmos m=1 w=420.00n l=130.00n ng=1
MN1 net10 RESET_B VSS VSS sg13_lv_nmos m=1 w=420.00n l=130.00n ng=1
MN4 Db clkneg net6 VSS sg13_lv_nmos m=1 w=420.00n l=130.00n ng=1
MN5 net6 clkpos net9 VSS sg13_lv_nmos m=1 w=420.00n l=130.00n ng=1
MN6 net9 net4 net8 VSS sg13_lv_nmos m=1 w=420.00n l=130.00n ng=1
MN7 net8 RESET_B VSS VSS sg13_lv_nmos m=1 w=420.00n l=130.00n ng=1
MN8 net4 net6 VSS VSS sg13_lv_nmos m=1 w=740.00n l=130.00n ng=1
MN2 clkneg CLK VSS VSS sg13_lv_nmos m=1 w=740.00n l=130.00n ng=1
MN9 net4 clkpos net5 VSS sg13_lv_nmos m=1 w=740.00n l=130.00n ng=1
MN3 clkpos clkneg VSS VSS sg13_lv_nmos m=1 w=740.00n l=130.00n ng=1
MN16 Q net1 VSS VSS sg13_lv_nmos m=1 w=740.00n l=130.00n ng=1
MN15 net1 net5 VSS VSS sg13_lv_nmos m=1 w=740.00n l=130.00n ng=1
MP11 net5 clkpos net3 VDD sg13_lv_pmos m=1 w=420.00n l=130.00n ng=1
MP12 net2 net5 VDD VDD sg13_lv_pmos m=1 w=420.00n l=130.00n ng=1
MP13 net2 RESET_B VDD VDD sg13_lv_pmos m=1 w=420.00n l=130.00n ng=1
MP14 Q_N net5 VDD VDD sg13_lv_pmos m=1 w=1.12u l=130.00n ng=1
MP4 Db clkpos net6 VDD sg13_lv_pmos m=1 w=420.00n l=130.00n ng=1
MP0 Db RESET_B VDD VDD sg13_lv_pmos m=1 w=420.00n l=130.00n ng=1
MP1 Db D VDD VDD sg13_lv_pmos m=1 w=420.00n l=130.00n ng=1
MP5 net7 net4 VDD VDD sg13_lv_pmos m=1 w=420.00n l=130.00n ng=1
MP6 net6 clkneg net7 VDD sg13_lv_pmos m=1 w=420.00n l=130.00n ng=1
MP7 net6 RESET_B VDD VDD sg13_lv_pmos m=1 w=420.00n l=130.00n ng=1
MP2 clkneg CLK VDD VDD sg13_lv_pmos m=1 w=1.12u l=130.00n ng=1
MP3 clkpos clkneg VDD VDD sg13_lv_pmos m=1 w=1.12u l=130.00n ng=1
MP8 net4 net6 VDD VDD sg13_lv_pmos m=1 w=1.000u l=130.00n ng=1
MP9 net4 clkneg net5 VDD sg13_lv_pmos m=1 w=1.000u l=130.00n ng=1
MP16 Q net1 VDD VDD sg13_lv_pmos m=1 w=1.12u l=130.00n ng=1
MP10 net3 net2 VDD VDD sg13_lv_pmos m=1 w=420.00n l=130.00n ng=1
MP15 net1 net5 VDD VDD sg13_lv_pmos m=1 w=1.12u l=130.00n ng=1
.ENDS

************************************************************************
* Library Name: sg13g2_stdcell
* Cell Name:    sg13g2_dfrbp_2
* View Name:    schematic
************************************************************************

.SUBCKT sg13g2_dfrbp_2 Q Q_N CLK D RESET_B VDD VSS
*.PININFO CLK:I D:I RESET_B:I Q:O Q_N:O VDD:B VSS:B
MN11 net12 net2 VSS VSS sg13_lv_nmos m=1 w=420.00n l=130.00n ng=1
MN10 net5 clkneg net12 VSS sg13_lv_nmos m=1 w=420.00n l=130.00n ng=1
MN12 net2 net5 net11 VSS sg13_lv_nmos m=1 w=420.00n l=130.00n ng=1
MN13 net11 RESET_B VSS VSS sg13_lv_nmos m=1 w=420.00n l=130.00n ng=1
MN14 Q_N net5 VSS VSS sg13_lv_nmos m=1 w=1.48u l=130.00n ng=2
MN0 Db D net10 VSS sg13_lv_nmos m=1 w=420.00n l=130.00n ng=1
MN1 net10 RESET_B VSS VSS sg13_lv_nmos m=1 w=420.00n l=130.00n ng=1
MN4 Db clkneg net6 VSS sg13_lv_nmos m=1 w=420.00n l=130.00n ng=1
MN5 net6 clkpos net9 VSS sg13_lv_nmos m=1 w=420.00n l=130.00n ng=1
MN6 net9 net4 net8 VSS sg13_lv_nmos m=1 w=420.00n l=130.00n ng=1
MN7 net8 RESET_B VSS VSS sg13_lv_nmos m=1 w=420.00n l=130.00n ng=1
MN8 net4 net6 VSS VSS sg13_lv_nmos m=1 w=740.00n l=130.00n ng=1
MN2 clkneg CLK VSS VSS sg13_lv_nmos m=1 w=740.00n l=130.00n ng=1
MN9 net4 clkpos net5 VSS sg13_lv_nmos m=1 w=740.00n l=130.00n ng=1
MN3 clkpos clkneg VSS VSS sg13_lv_nmos m=1 w=740.00n l=130.00n ng=1
MN16 Q net1 VSS VSS sg13_lv_nmos m=1 w=1.48u l=130.00n ng=2
MN15 net1 net5 VSS VSS sg13_lv_nmos m=1 w=640.00n l=130.00n ng=1
MP11 net5 clkpos net3 VDD sg13_lv_pmos m=1 w=420.00n l=130.00n ng=1
MP12 net2 net5 VDD VDD sg13_lv_pmos m=1 w=420.00n l=130.00n ng=1
MP13 net2 RESET_B VDD VDD sg13_lv_pmos m=1 w=420.00n l=130.00n ng=1
MP14 Q_N net5 VDD VDD sg13_lv_pmos m=1 w=2.24u l=130.00n ng=2
MP4 Db clkpos net6 VDD sg13_lv_pmos m=1 w=420.00n l=130.00n ng=1
MP0 Db RESET_B VDD VDD sg13_lv_pmos m=1 w=420.00n l=130.00n ng=1
MP1 Db D VDD VDD sg13_lv_pmos m=1 w=420.00n l=130.00n ng=1
MP5 net7 net4 VDD VDD sg13_lv_pmos m=1 w=420.00n l=130.00n ng=1
MP6 net6 clkneg net7 VDD sg13_lv_pmos m=1 w=420.00n l=130.00n ng=1
MP7 net6 RESET_B VDD VDD sg13_lv_pmos m=1 w=420.00n l=130.00n ng=1
MP2 clkneg CLK VDD VDD sg13_lv_pmos m=1 w=1.12u l=130.00n ng=1
MP3 clkpos clkneg VDD VDD sg13_lv_pmos m=1 w=1.12u l=130.00n ng=1
MP8 net4 net6 VDD VDD sg13_lv_pmos m=1 w=1.000u l=130.00n ng=1
MP9 net4 clkneg net5 VDD sg13_lv_pmos m=1 w=1.000u l=130.00n ng=1
MP16 Q net1 VDD VDD sg13_lv_pmos m=1 w=2.24u l=130.00n ng=2
MP10 net3 net2 VDD VDD sg13_lv_pmos m=1 w=420.00n l=130.00n ng=1
MP15 net1 net5 VDD VDD sg13_lv_pmos m=1 w=1.000u l=130.00n ng=1
.ENDS

************************************************************************
* Library Name: sg13g2_stdcell
* Cell Name:    sg13g2_dlhq_1
* View Name:    schematic
************************************************************************

.SUBCKT sg13g2_dlhq_1 Q D GATE VDD VSS
*.PININFO D:I GATE:I Q:O VDD:B VSS:B
MP8 Q qint_b VDD VDD sg13_lv_pmos m=1 w=1.12u l=130.00n ng=1
MP6 qint GATE_BB net8 VDD sg13_lv_pmos m=1 w=420.00n l=130.00n ng=1
MP7 qint_b qint VDD VDD sg13_lv_pmos m=1 w=1.12u l=130.00n ng=1
MP2 Db D VDD VDD sg13_lv_pmos m=1 w=840.00n l=130.00n ng=1
MP0 GATE_B GATE VDD VDD sg13_lv_pmos m=1 w=840.00n l=130.00n ng=1
MP1 GATE_BB GATE_B VDD VDD sg13_lv_pmos m=1 w=840.00n l=130.00n ng=1
MP5 net8 qint_b VDD VDD sg13_lv_pmos m=1 w=420.00n l=130.00n ng=1
MP4 net4 GATE_B qint VDD sg13_lv_pmos m=1 w=1.000u l=130.00n ng=1
MP3 net4 Db VDD VDD sg13_lv_pmos m=1 w=1.000u l=130.00n ng=1
MN0 GATE_B GATE VSS VSS sg13_lv_nmos m=1 w=740.00n l=130.00n ng=1
MN1 GATE_BB GATE_B VSS VSS sg13_lv_nmos m=1 w=740.00n l=130.00n ng=1
MN5 qint GATE_B net9 VSS sg13_lv_nmos m=1 w=420.00n l=130.00n ng=1
MN8 Q qint_b VSS VSS sg13_lv_nmos m=1 w=740.00n l=130.00n ng=1
MN4 net7 Db VSS VSS sg13_lv_nmos m=1 w=740.00n l=130.00n ng=1
MN6 net9 qint_b VSS VSS sg13_lv_nmos m=1 w=420.00n l=130.00n ng=1
MN7 qint_b qint VSS VSS sg13_lv_nmos m=1 w=740.00n l=130.00n ng=1
MN3 qint GATE_BB net7 VSS sg13_lv_nmos m=1 w=740.00n l=130.00n ng=1
MN2 Db D VSS VSS sg13_lv_nmos m=1 w=550.00n l=130.00n ng=1
.ENDS

************************************************************************
* Library Name: sg13g2_stdcell
* Cell Name:    sg13g2_dlhr_1
* View Name:    schematic
************************************************************************

.SUBCKT sg13g2_dlhr_1 Q Q_N D GATE RESET_B VDD VSS
*.PININFO D:I GATE:I RESET_B:I Q:O Q_N:O VDD:B VSS:B
MP8 qint_b RESET_B VDD VDD sg13_lv_pmos m=1 w=1.12u l=130.00n ng=1
MP9 Q qint_b VDD VDD sg13_lv_pmos m=1 w=1.12u l=130.00n ng=1
MP6 qint GATE_BB net11 VDD sg13_lv_pmos m=1 w=420.00n l=130.00n ng=1
MP5 net11 qint_b VDD VDD sg13_lv_pmos m=1 w=420.00n l=130.00n ng=1
MP4 qint GATE_B net2 VDD sg13_lv_pmos m=1 w=1.000u l=130.00n ng=1
MP3 net2 Db VDD VDD sg13_lv_pmos m=1 w=1.000u l=130.00n ng=1
MP2 Db D VDD VDD sg13_lv_pmos m=1 w=840.00n l=130.00n ng=1
MP0 GATE_B GATE VDD VDD sg13_lv_pmos m=1 w=840.00n l=130.00n ng=1
MP11 Q_N qintn_b VDD VDD sg13_lv_pmos m=1 w=1.12u l=130.00n ng=1
MP7 qint_b qint VDD VDD sg13_lv_pmos m=1 w=1.12u l=130.00n ng=1
MP1 GATE_BB GATE_B VDD VDD sg13_lv_pmos m=1 w=840.00n l=130.00n ng=1
MP10 qintn_b qint_b VDD VDD sg13_lv_pmos m=1 w=840.00n l=130.00n ng=1
MN7 qint_b qint net9 VSS sg13_lv_nmos m=1 w=740.00n l=130.00n ng=1
MN8 net9 RESET_B VSS VSS sg13_lv_nmos m=1 w=740.00n l=130.00n ng=1
MN5 qint GATE_B net7 VSS sg13_lv_nmos m=1 w=420.00n l=130.00n ng=1
MN6 net7 qint_b VSS VSS sg13_lv_nmos m=1 w=420.00n l=130.00n ng=1
MN9 Q qint_b VSS VSS sg13_lv_nmos m=1 w=740.00n l=130.00n ng=1
MN3 qint GATE_BB net1 VSS sg13_lv_nmos m=1 w=640.00n l=130.00n ng=1
MN4 net1 Db VSS VSS sg13_lv_nmos m=1 w=640.00n l=130.00n ng=1
MN2 Db D VSS VSS sg13_lv_nmos m=1 w=550.00n l=130.00n ng=1
MN0 GATE_B GATE VSS VSS sg13_lv_nmos m=1 w=740.00n l=130.00n ng=1
MN11 Q_N qintn_b VSS VSS sg13_lv_nmos m=1 w=740.00n l=130.00n ng=1
MN1 GATE_BB GATE_B VSS VSS sg13_lv_nmos m=1 w=740.00n l=130.00n ng=1
MN10 qintn_b qint_b VSS VSS sg13_lv_nmos m=1 w=550.00n l=130.00n ng=1
.ENDS

************************************************************************
* Library Name: sg13g2_stdcell
* Cell Name:    sg13g2_dlhrq_1
* View Name:    schematic
************************************************************************

.SUBCKT sg13g2_dlhrq_1 Q D GATE RESET_B VDD VSS
*.PININFO D:I GATE:I RESET_B:I Q:O VDD:B VSS:B
MN8 net116 RESET_B VSS VSS sg13_lv_nmos m=1 w=740.00n l=130.00n ng=1
MN9 Q qint_b VSS VSS sg13_lv_nmos m=1 w=740.00n l=130.00n ng=1
MN1 GATE_BB GATE_B VSS VSS sg13_lv_nmos m=1 w=740.00n l=130.00n ng=1
MN5 qint GATE_B net89 VSS sg13_lv_nmos m=1 w=420.00n l=130.00n ng=1
MN7 qint_b qint net116 VSS sg13_lv_nmos m=1 w=740.00n l=130.00n ng=1
MN2 Db D VSS VSS sg13_lv_nmos m=1 w=550.00n l=130.00n ng=1
MN4 net61 Db VSS VSS sg13_lv_nmos m=1 w=640.00n l=130.00n ng=1
MN3 qint GATE_BB net61 VSS sg13_lv_nmos m=1 w=640.00n l=130.00n ng=1
MN6 net89 qint_b VSS VSS sg13_lv_nmos m=1 w=420.00n l=130.00n ng=1
MN0 GATE_B GATE VSS VSS sg13_lv_nmos m=1 w=740.00n l=130.00n ng=1
MP3 net60 Db VDD VDD sg13_lv_pmos m=1 w=1.000u l=130.00n ng=1
MP8 qint_b RESET_B VDD VDD sg13_lv_pmos m=1 w=1.000u l=130.00n ng=1
MP6 qint GATE_BB net92 VDD sg13_lv_pmos m=1 w=420.00n l=130.00n ng=1
MP9 Q qint_b VDD VDD sg13_lv_pmos m=1 w=1.12u l=130.00n ng=1
MP5 net92 qint_b VDD VDD sg13_lv_pmos m=1 w=420.00n l=130.00n ng=1
MP0 GATE_B GATE VDD VDD sg13_lv_pmos m=1 w=840.00n l=130.00n ng=1
MP2 Db D VDD VDD sg13_lv_pmos m=1 w=840.00n l=130.00n ng=1
MP4 qint GATE_B net60 VDD sg13_lv_pmos m=1 w=1.000u l=130.00n ng=1
MP1 GATE_BB GATE_B VDD VDD sg13_lv_pmos m=1 w=840.00n l=130.00n ng=1
MP7 qint_b qint VDD VDD sg13_lv_pmos m=1 w=1.000u l=130.00n ng=1
.ENDS

************************************************************************
* Library Name: sg13g2_stdcell
* Cell Name:    sg13g2_dllr_1
* View Name:    schematic
************************************************************************

.SUBCKT sg13g2_dllr_1 Q Q_N D GATE_N RESET_B VDD VSS
*.PININFO D:I GATE_N:I RESET_B:I Q:O Q_N:O VDD:B VSS:B
MN2 Db D VSS VSS sg13_lv_nmos m=1 w=550.00n l=130.00n ng=1
MN0 gnb GATE_N VSS VSS sg13_lv_nmos m=1 w=740.00n l=130.00n ng=1
MN1 gnbb gnb VSS VSS sg13_lv_nmos m=1 w=740.00n l=130.00n ng=1
MN6 net89 qint_b VSS VSS sg13_lv_nmos m=1 w=420.00n l=130.00n ng=1
MN7 qint_b qint net116 VSS sg13_lv_nmos m=1 w=740.00n l=130.00n ng=1
MN8 net116 RESET_B VSS VSS sg13_lv_nmos m=1 w=740.00n l=130.00n ng=1
MN5 qint gnbb net89 VSS sg13_lv_nmos m=1 w=420.00n l=130.00n ng=1
MN11 Q_N qintn_b VSS VSS sg13_lv_nmos m=1 w=740.00n l=130.00n ng=1
MN3 qint gnb net61 VSS sg13_lv_nmos m=1 w=640.00n l=130.00n ng=1
MN10 qintn_b qint_b VSS VSS sg13_lv_nmos m=1 w=550.00n l=130.00n ng=1
MN4 net61 Db VSS VSS sg13_lv_nmos m=1 w=640.00n l=130.00n ng=1
MN9 Q qint_b VSS VSS sg13_lv_nmos m=1 w=740.00n l=130.00n ng=1
MP1 gnbb gnb VDD VDD sg13_lv_pmos m=1 w=840.00n l=130.00n ng=1
MP4 qint gnbb net60 VDD sg13_lv_pmos m=1 w=1.000u l=130.00n ng=1
MP10 qintn_b qint_b VDD VDD sg13_lv_pmos m=1 w=840.00n l=130.00n ng=1
MP11 Q_N qintn_b VDD VDD sg13_lv_pmos m=1 w=1.12u l=130.00n ng=1
MP3 net60 Db VDD VDD sg13_lv_pmos m=1 w=1.000u l=130.00n ng=1
MP5 net92 qint_b VDD VDD sg13_lv_pmos m=1 w=420.00n l=130.00n ng=1
MP8 qint_b RESET_B VDD VDD sg13_lv_pmos m=1 w=1.12u l=130.00n ng=1
MP2 Db D VDD VDD sg13_lv_pmos m=1 w=840.00n l=130.00n ng=1
MP0 gnb GATE_N VDD VDD sg13_lv_pmos m=1 w=840.00n l=130.00n ng=1
MP9 Q qint_b VDD VDD sg13_lv_pmos m=1 w=1.12u l=130.00n ng=1
MP6 qint gnb net92 VDD sg13_lv_pmos m=1 w=420.00n l=130.00n ng=1
MP7 qint_b qint VDD VDD sg13_lv_pmos m=1 w=1.12u l=130.00n ng=1
.ENDS

************************************************************************
* Library Name: sg13g2_stdcell
* Cell Name:    sg13g2_dllrq_1
* View Name:    schematic
************************************************************************

.SUBCKT sg13g2_dllrq_1 Q D GATE_N RESET_B VDD VSS
*.PININFO D:I GATE_N:I RESET_B:I Q:O VDD:B VSS:B
MN5 qint gnbb net89 VSS sg13_lv_nmos m=1 w=420.00n l=130.00n ng=1
MN3 qint gnb net61 VSS sg13_lv_nmos m=1 w=640.00n l=130.00n ng=1
MN8 net116 RESET_B VSS VSS sg13_lv_nmos m=1 w=740.00n l=130.00n ng=1
MN9 Q qint_b VSS VSS sg13_lv_nmos m=1 w=740.00n l=130.00n ng=1
MN4 net61 Db VSS VSS sg13_lv_nmos m=1 w=640.00n l=130.00n ng=1
MN6 net89 qint_b VSS VSS sg13_lv_nmos m=1 w=420.00n l=130.00n ng=1
MN7 qint_b qint net116 VSS sg13_lv_nmos m=1 w=740.00n l=130.00n ng=1
MN2 Db D VSS VSS sg13_lv_nmos m=1 w=550.00n l=130.00n ng=1
MN0 gnb GATE_N VSS VSS sg13_lv_nmos m=1 w=740.00n l=130.00n ng=1
MN1 gnbb gnb VSS VSS sg13_lv_nmos m=1 w=740.00n l=130.00n ng=1
MP3 net59 Db VDD VDD sg13_lv_pmos m=1 w=1.000u l=130.00n ng=1
MP8 qint_b RESET_B VDD VDD sg13_lv_pmos m=1 w=1.000u l=130.00n ng=1
MP0 gnb GATE_N VDD VDD sg13_lv_pmos m=1 w=840.00n l=130.00n ng=1
MP5 net92 qint_b VDD VDD sg13_lv_pmos m=1 w=420.00n l=130.00n ng=1
MP7 qint_b qint VDD VDD sg13_lv_pmos m=1 w=1.000u l=130.00n ng=1
MP9 Q qint_b VDD VDD sg13_lv_pmos m=1 w=1.12u l=130.00n ng=1
MP4 qint gnbb net59 VDD sg13_lv_pmos m=1 w=1.000u l=130.00n ng=1
MP2 Db D VDD VDD sg13_lv_pmos m=1 w=840.00n l=130.00n ng=1
MP1 gnbb gnb VDD VDD sg13_lv_pmos m=1 w=840.00n l=130.00n ng=1
MP6 qint gnb net92 VDD sg13_lv_pmos m=1 w=420.00n l=130.00n ng=1
.ENDS

************************************************************************
* Library Name: sg13g2_stdcell
* Cell Name:    sg13g2_dlygate4sd1_1
* View Name:    schematic
************************************************************************

.SUBCKT sg13g2_dlygate4sd1_1 X A VDD VSS
*.PININFO A:I X:O VDD:B VSS:B
MP3 X net3 VDD VDD sg13_lv_pmos m=1 w=1.12u l=130.00n ng=1
MP2 net3 net2 VDD VDD sg13_lv_pmos m=1 w=1.000u l=130.00n ng=1
MP1 net2 net1 VDD VDD sg13_lv_pmos m=1 w=1.000u l=130.00n ng=1
MP0 net1 A VDD VDD sg13_lv_pmos m=1 w=420.00n l=130.00n ng=1
MN3 X net3 VSS VSS sg13_lv_nmos m=1 w=740.00n l=130.00n ng=1
MN2 net3 net2 VSS VSS sg13_lv_nmos m=1 w=420.00n l=130.00n ng=1
MN1 net2 net1 VSS VSS sg13_lv_nmos m=1 w=420.00n l=130.00n ng=1
MN0 net1 A VSS VSS sg13_lv_nmos m=1 w=420.00n l=130.00n ng=1
.ENDS

************************************************************************
* Library Name: sg13g2_stdcell
* Cell Name:    sg13g2_dlygate4sd2_1
* View Name:    schematic
************************************************************************

.SUBCKT sg13g2_dlygate4sd2_1 X A VDD VSS
*.PININFO A:I X:O VDD:B VSS:B
MP3 X net3 VDD VDD sg13_lv_pmos m=1 w=1.12u l=130.00n ng=1
MP2 net3 net2 VDD VDD sg13_lv_pmos m=1 w=1.000u l=250.00n ng=1
MP1 net2 net1 VDD VDD sg13_lv_pmos m=1 w=1.000u l=250.00n ng=1
MP0 net1 A VDD VDD sg13_lv_pmos m=1 w=420.00n l=130.00n ng=1
MN3 X net3 VSS VSS sg13_lv_nmos m=1 w=740.00n l=130.00n ng=1
MN2 net3 net2 VSS VSS sg13_lv_nmos m=1 w=420.00n l=180.00n ng=1
MN1 net2 net1 VSS VSS sg13_lv_nmos m=1 w=420.00n l=180.00n ng=1
MN0 net1 A VSS VSS sg13_lv_nmos m=1 w=420.00n l=130.00n ng=1
.ENDS

************************************************************************
* Library Name: sg13g2_stdcell
* Cell Name:    sg13g2_dlygate4sd3_1
* View Name:    schematic
************************************************************************

.SUBCKT sg13g2_dlygate4sd3_1 X A VDD VSS
*.PININFO A:I X:O VDD:B VSS:B
MP3 X net3 VDD VDD sg13_lv_pmos m=1 w=1.12u l=130.00n ng=1
MP2 net3 net2 VDD VDD sg13_lv_pmos m=1 w=1.000u l=500.0n ng=1
MP1 net2 net1 VDD VDD sg13_lv_pmos m=1 w=1.000u l=500.0n ng=1
MP0 net1 A VDD VDD sg13_lv_pmos m=1 w=420.00n l=130.00n ng=1
MN3 X net3 VSS VSS sg13_lv_nmos m=1 w=740.00n l=130.00n ng=1
MN2 net3 net2 VSS VSS sg13_lv_nmos m=1 w=420.00n l=500.0n ng=1
MN1 net2 net1 VSS VSS sg13_lv_nmos m=1 w=420.00n l=500.0n ng=1
MN0 net1 A VSS VSS sg13_lv_nmos m=1 w=420.00n l=130.00n ng=1
.ENDS

************************************************************************
* Library Name: sg13g2_stdcell
* Cell Name:    sg13g2_ebufn_2
* View Name:    schematic
************************************************************************

.SUBCKT sg13g2_ebufn_2 Z A TE_B VDD VSS
*.PININFO A:I TE_B:I Z:O VDD:B VSS:B
MN3 net4 net3 VSS VSS sg13_lv_nmos m=1 w=1.48u l=130.00n ng=2
MN2 Z net1 net4 VSS sg13_lv_nmos m=1 w=1.48u l=130.00n ng=2
MN1 net3 TE_B VSS VSS sg13_lv_nmos m=1 w=640.00n l=130.00n ng=1
MN0 net1 A VSS VSS sg13_lv_nmos m=1 w=640.00n l=130.00n ng=1
MP2 net2 TE_B VDD VDD sg13_lv_pmos m=1 w=2.24u l=130.00n ng=2
MP3 Z net1 net2 VDD sg13_lv_pmos m=1 w=2.24u l=130.00n ng=2
MP1 net3 TE_B VDD VDD sg13_lv_pmos m=1 w=1.000u l=130.00n ng=1
MP0 net1 A VDD VDD sg13_lv_pmos m=1 w=1.000u l=130.00n ng=1
.ENDS

************************************************************************
* Library Name: sg13g2_stdcell
* Cell Name:    sg13g2_ebufn_4
* View Name:    schematic
************************************************************************

.SUBCKT sg13g2_ebufn_4 Z A TE_B VDD VSS
*.PININFO A:I TE_B:I Z:O VDD:B VSS:B
MN0 net23 A VSS VSS sg13_lv_nmos m=1 w=740.00n l=130.00n ng=1
MN1 net21 TE_B VSS VSS sg13_lv_nmos m=1 w=740.00n l=130.00n ng=1
MN2 Z net23 net22 VSS sg13_lv_nmos m=1 w=2.96u l=130.00n ng=4
MN3 net22 net21 VSS VSS sg13_lv_nmos m=1 w=2.96u l=130.00n ng=4
MP0 net23 A VDD VDD sg13_lv_pmos m=1 w=1.12u l=130.00n ng=1
MP1 net21 TE_B VDD VDD sg13_lv_pmos m=1 w=1.12u l=130.00n ng=1
MP3 Z net23 net24 VDD sg13_lv_pmos m=1 w=4.48u l=130.00n ng=4
MP2 net24 TE_B VDD VDD sg13_lv_pmos m=1 w=4.48u l=130.00n ng=4
.ENDS

************************************************************************
* Library Name: sg13g2_stdcell
* Cell Name:    sg13g2_ebufn_8
* View Name:    schematic
************************************************************************

.SUBCKT sg13g2_ebufn_8 Z A TE_B VDD VSS
*.PININFO A:I TE_B:I Z:O VDD:B VSS:B
MN3 net23 net22 VSS VSS sg13_lv_nmos m=1 w=5.92u l=130.00n ng=8
MN2 Z net21 net23 VSS sg13_lv_nmos m=1 w=5.92u l=130.00n ng=8
MN1 net22 TE_B VSS VSS sg13_lv_nmos m=1 w=740.00n l=130.00n ng=1
MN0 net21 A VSS VSS sg13_lv_nmos m=1 w=1.48u l=130.00n ng=2
MP2 net24 TE_B VDD VDD sg13_lv_pmos m=1 w=8.96u l=130.00n ng=8
MP3 Z net21 net24 VDD sg13_lv_pmos m=1 w=8.96u l=130.00n ng=8
MP1 net22 TE_B VDD VDD sg13_lv_pmos m=1 w=1.12u l=130.00n ng=1
MP0 net21 A VDD VDD sg13_lv_pmos m=1 w=2.24u l=130.00n ng=2
.ENDS

************************************************************************
* Library Name: sg13g2_stdcell
* Cell Name:    sg13g2_einvn_2
* View Name:    schematic
************************************************************************

.SUBCKT sg13g2_einvn_2 Z A TE_B VDD VSS
*.PININFO A:I TE_B:I Z:O VDD:B VSS:B
MN0 TE TE_B VSS VSS sg13_lv_nmos m=1 w=420.00n l=130.00n ng=1
MN2 net1 TE VSS VSS sg13_lv_nmos m=1 w=1.48u l=130.00n ng=2
MN1 Z A net1 VSS sg13_lv_nmos m=1 w=1.48u l=130.00n ng=2
MP0 TE TE_B VDD VDD sg13_lv_pmos m=1 w=640.00n l=130.00n ng=1
MP1 net2 TE_B VDD VDD sg13_lv_pmos m=1 w=2.24u l=130.00n ng=2
MP2 Z A net2 VDD sg13_lv_pmos m=1 w=2.24u l=130.00n ng=2
.ENDS

************************************************************************
* Library Name: sg13g2_stdcell
* Cell Name:    sg13g2_einvn_4
* View Name:    schematic
************************************************************************

.SUBCKT sg13g2_einvn_4 Z A TE_B VDD VSS
*.PININFO A:I TE_B:I Z:O VDD:B VSS:B
MN2 net16 TE VSS VSS sg13_lv_nmos m=1 w=2.96u l=130.00n ng=4
MN0 TE TE_B VSS VSS sg13_lv_nmos m=1 w=740.00n l=130.00n ng=1
MN1 Z A net16 VSS sg13_lv_nmos m=1 w=2.96u l=130.00n ng=4
MP0 TE TE_B VDD VDD sg13_lv_pmos m=1 w=1.12u l=130.00n ng=1
MP1 net17 TE_B VDD VDD sg13_lv_pmos m=1 w=4.48u l=130.00n ng=4
MP2 Z A net17 VDD sg13_lv_pmos m=1 w=4.48u l=130.00n ng=4
.ENDS

************************************************************************
* Library Name: sg13g2_stdcell
* Cell Name:    sg13g2_einvn_8
* View Name:    schematic
************************************************************************

.SUBCKT sg13g2_einvn_8 Z A TE_B VDD VSS
*.PININFO A:I TE_B:I Z:O VDD:B VSS:B
MN1 Z A net29 VSS sg13_lv_nmos m=1 w=5.92u l=130.00n ng=8
MN0 TE TE_B VSS VSS sg13_lv_nmos m=1 w=740.00n l=130.00n ng=1
MN2 net29 TE VSS VSS sg13_lv_nmos m=1 w=5.92u l=130.00n ng=8
MP1 net28 TE_B VDD VDD sg13_lv_pmos m=1 w=8.96u l=130.00n ng=8
MP2 Z A net28 VDD sg13_lv_pmos m=1 w=8.96u l=130.00n ng=8
MP0 TE TE_B VDD VDD sg13_lv_pmos m=1 w=1.12u l=130.00n ng=1
.ENDS

************************************************************************
* Library Name: sg13g2_stdcell
* Cell Name:    sg13g2_inv_1
* View Name:    schematic
************************************************************************

.SUBCKT sg13g2_inv_1 Y A VDD VSS
*.PININFO A:I Y:O VDD:B VSS:B
MN0 Y A VSS VSS sg13_lv_nmos m=1 w=740.00n l=130.00n ng=1
MP0 Y A VDD VDD sg13_lv_pmos m=1 w=1.12u l=130.00n ng=1
.ENDS

************************************************************************
* Library Name: sg13g2_stdcell
* Cell Name:    sg13g2_inv_16
* View Name:    schematic
************************************************************************

.SUBCKT sg13g2_inv_16 Y A VDD VSS
*.PININFO A:I Y:O VDD:B VSS:B
MN0 Y A VSS VSS sg13_lv_nmos m=1 w=11.84u l=130.00n ng=16
MP0 Y A VDD VDD sg13_lv_pmos m=1 w=17.92u l=130.00n ng=16
.ENDS

************************************************************************
* Library Name: sg13g2_stdcell
* Cell Name:    sg13g2_inv_2
* View Name:    schematic
************************************************************************

.SUBCKT sg13g2_inv_2 Y A VDD VSS
*.PININFO A:I Y:O VDD:B VSS:B
MN0 Y A VSS VSS sg13_lv_nmos m=1 w=1.48u l=130.00n ng=2
MP0 Y A VDD VDD sg13_lv_pmos m=1 w=2.24u l=130.00n ng=2
.ENDS

************************************************************************
* Library Name: sg13g2_stdcell
* Cell Name:    sg13g2_inv_4
* View Name:    schematic
************************************************************************

.SUBCKT sg13g2_inv_4 Y A VDD VSS
*.PININFO A:I Y:O VDD:B VSS:B
MP0 Y A VDD VDD sg13_lv_pmos m=1 w=4.48u l=130.00n ng=4
MN0 Y A VSS VSS sg13_lv_nmos m=1 w=2.96u l=130.00n ng=4
.ENDS

************************************************************************
* Library Name: sg13g2_stdcell
* Cell Name:    sg13g2_inv_8
* View Name:    schematic
************************************************************************

.SUBCKT sg13g2_inv_8 Y A VDD VSS
*.PININFO A:I Y:O VDD:B VSS:B
MN0 Y A VSS VSS sg13_lv_nmos m=1 w=5.92u l=130.00n ng=8
MP0 Y A VDD VDD sg13_lv_pmos m=1 w=8.96u l=130.00n ng=8
.ENDS

************************************************************************
* Library Name: sg13g2_stdcell
* Cell Name:    sg13g2_lgcp_1
* View Name:    schematic
************************************************************************

.SUBCKT sg13g2_lgcp_1 GCLK CLK GATE VDD VSS
*.PININFO CLK:I GATE:I GCLK:O VDD:B VSS:B
MP1 CLKBB CLKB VDD VDD sg13_lv_pmos m=1 w=840.00n l=130.00n ng=1
MP3 net1 CLKBB net4 VDD sg13_lv_pmos m=1 w=1.000u l=130.00n ng=1
MP4 int_GATE net1 VDD VDD sg13_lv_pmos m=1 w=1.12u l=130.00n ng=1
MP2 net4 GATE VDD VDD sg13_lv_pmos m=1 w=1.000u l=130.00n ng=1
MP8 net3 int_GATE VDD VDD sg13_lv_pmos m=1 w=840.00n l=130.00n ng=1
MP9 GCLK net3 VDD VDD sg13_lv_pmos m=1 w=1.12u l=130.00n ng=1
MP6 net1 CLKB net6 VDD sg13_lv_pmos m=1 w=420.00n l=130.00n ng=1
MP0 CLKB CLK VDD VDD sg13_lv_pmos m=1 w=840.00n l=130.00n ng=1
MP7 net3 CLK VDD VDD sg13_lv_pmos m=1 w=840.00n l=130.00n ng=1
MP5 net6 int_GATE VDD VDD sg13_lv_pmos m=1 w=420.00n l=130.00n ng=1
MN9 GCLK net3 VSS VSS sg13_lv_nmos m=1 w=740.00n l=130.00n ng=1
MN7 net3 int_GATE net5 VSS sg13_lv_nmos m=1 w=640.00n l=130.00n ng=1
MN4 int_GATE net1 VSS VSS sg13_lv_nmos m=1 w=740.00n l=130.00n ng=1
MN1 CLKBB CLKB VSS VSS sg13_lv_nmos m=1 w=740.00n l=130.00n ng=1
MN6 net7 int_GATE VSS VSS sg13_lv_nmos m=1 w=420.00n l=130.00n ng=1
MN3 net2 GATE VSS VSS sg13_lv_nmos m=1 w=640.00n l=130.00n ng=1
MN5 net1 CLKBB net7 VSS sg13_lv_nmos m=1 w=420.00n l=130.00n ng=1
MN0 CLKB CLK VSS VSS sg13_lv_nmos m=1 w=740.00n l=130.00n ng=1
MN8 net5 CLK VSS VSS sg13_lv_nmos m=1 w=640.00n l=130.00n ng=1
MN2 net1 CLKB net2 VSS sg13_lv_nmos m=1 w=640.00n l=130.00n ng=1
.ENDS

************************************************************************
* Library Name: sg13g2_stdcell
* Cell Name:    sg13g2_mux2_1
* View Name:    schematic
************************************************************************

.SUBCKT sg13g2_mux2_1 X A0 A1 S VDD VSS
*.PININFO A0:I A1:I S:I X:O VDD:B VSS:B
MP1 net4 S VDD VDD sg13_lv_pmos m=1 w=1.000u l=130.00n ng=1
MP5 X net6 VDD VDD sg13_lv_pmos m=1 w=1.12u l=130.00n ng=1
MP4 net6 A1 net5 VDD sg13_lv_pmos m=1 w=1.000u l=130.00n ng=1
MP0 Sb S VDD VDD sg13_lv_pmos m=1 w=840.00n l=130.00n ng=1
MP3 net5 Sb VDD VDD sg13_lv_pmos m=1 w=1.000u l=130.00n ng=1
MP2 net6 A0 net4 VDD sg13_lv_pmos m=1 w=1.000u l=130.00n ng=1
MN4 net3 S VSS VSS sg13_lv_nmos m=1 w=740.00n l=130.00n ng=1
MN2 net1 Sb VSS VSS sg13_lv_nmos m=1 w=740.00n l=130.00n ng=1
MN5 X net6 VSS VSS sg13_lv_nmos m=1 w=740.00n l=130.00n ng=1
MN0 Sb S VSS VSS sg13_lv_nmos m=1 w=550.00n l=130.00n ng=1
MN3 net6 A1 net3 VSS sg13_lv_nmos m=1 w=740.00n l=130.00n ng=1
MN1 net6 A0 net1 VSS sg13_lv_nmos m=1 w=740.00n l=130.00n ng=1
.ENDS

************************************************************************
* Library Name: sg13g2_stdcell
* Cell Name:    sg13g2_mux2_2
* View Name:    schematic
************************************************************************

.SUBCKT sg13g2_mux2_2 X A0 A1 S VDD VSS
*.PININFO A0:I A1:I S:I X:O VDD:B VSS:B
MP1 net4 S VDD VDD sg13_lv_pmos m=1 w=1.000u l=130.00n ng=1
MP5 X net6 VDD VDD sg13_lv_pmos m=1 w=2.24u l=130.00n ng=2
MP4 net6 A1 net5 VDD sg13_lv_pmos m=1 w=1.000u l=130.00n ng=1
MP0 Sb S VDD VDD sg13_lv_pmos m=1 w=840.00n l=130.00n ng=1
MP3 net5 Sb VDD VDD sg13_lv_pmos m=1 w=1.000u l=130.00n ng=1
MP2 net6 A0 net4 VDD sg13_lv_pmos m=1 w=1.000u l=130.00n ng=1
MN4 net3 S VSS VSS sg13_lv_nmos m=1 w=740.00n l=130.00n ng=1
MN2 net1 Sb VSS VSS sg13_lv_nmos m=1 w=740.00n l=130.00n ng=1
MN5 X net6 VSS VSS sg13_lv_nmos m=1 w=1.48u l=130.00n ng=2
MN0 Sb S VSS VSS sg13_lv_nmos m=1 w=550.00n l=130.00n ng=1
MN3 net6 A1 net3 VSS sg13_lv_nmos m=1 w=740.00n l=130.00n ng=1
MN1 net6 A0 net1 VSS sg13_lv_nmos m=1 w=740.00n l=130.00n ng=1
.ENDS

************************************************************************
* Library Name: sg13g2_stdcell
* Cell Name:    sg13g2_mux4_1
* View Name:    schematic
************************************************************************

.SUBCKT sg13g2_mux4_1 X A0 A1 A2 A3 S0 S1 VDD VSS
*.PININFO A0:I A1:I A2:I A3:I S0:I S1:I X:O VDD:B VSS:B
MN12 X Xb VSS VSS sg13_lv_nmos m=1 w=740.00n l=130.00n ng=1
MN2 low S0b net7 VSS sg13_lv_nmos m=1 w=640.00n l=130.00n ng=1
MN3 net7 A0 VSS VSS sg13_lv_nmos m=1 w=640.00n l=130.00n ng=1
MN6 low S1b Xb VSS sg13_lv_nmos m=1 w=640.00n l=130.00n ng=1
MN11 high S1 Xb VSS sg13_lv_nmos m=1 w=640.00n l=130.00n ng=1
MN10 net4 A3 VSS VSS sg13_lv_nmos m=1 w=640.00n l=130.00n ng=1
MN9 high S0 net4 VSS sg13_lv_nmos m=1 w=640.00n l=130.00n ng=1
MN8 net6 A2 VSS VSS sg13_lv_nmos m=1 w=640.00n l=130.00n ng=1
MN7 high S0b net6 VSS sg13_lv_nmos m=1 w=640.00n l=130.00n ng=1
MN5 net2 A1 VSS VSS sg13_lv_nmos m=1 w=640.00n l=130.00n ng=1
MN4 low S0 net2 VSS sg13_lv_nmos m=1 w=640.00n l=130.00n ng=1
MN1 S1b S1 VSS VSS sg13_lv_nmos m=1 w=640.00n l=130.00n ng=1
MN0 S0b S0 VSS VSS sg13_lv_nmos m=1 w=640.00n l=130.00n ng=1
MP6 low S1 Xb VDD sg13_lv_pmos m=1 w=1.000u l=130.00n ng=1
MP11 high S1b Xb VDD sg13_lv_pmos m=1 w=1.000u l=130.00n ng=1
MP12 X Xb VDD VDD sg13_lv_pmos m=1 w=1.12u l=130.00n ng=1
MP10 high S0b net3 VDD sg13_lv_pmos m=1 w=1.000u l=130.00n ng=1
MP9 net3 A3 VDD VDD sg13_lv_pmos m=1 w=1.000u l=130.00n ng=1
MP8 high S0 net5 VDD sg13_lv_pmos m=1 w=1.000u l=130.00n ng=1
MP7 net5 A2 VDD VDD sg13_lv_pmos m=1 w=1.000u l=130.00n ng=1
MP2 net8 A0 VDD VDD sg13_lv_pmos m=1 w=1.000u l=130.00n ng=1
MP3 low S0 net8 VDD sg13_lv_pmos m=1 w=1.000u l=130.00n ng=1
MP1 S1b S1 VDD VDD sg13_lv_pmos m=1 w=1.000u l=130.00n ng=1
MP0 S0b S0 VDD VDD sg13_lv_pmos m=1 w=1.000u l=130.00n ng=1
MP5 low S0b net1 VDD sg13_lv_pmos m=1 w=1.000u l=130.00n ng=1
MP4 net1 A1 VDD VDD sg13_lv_pmos m=1 w=1.000u l=130.00n ng=1
.ENDS

************************************************************************
* Library Name: sg13g2_stdcell
* Cell Name:    sg13g2_nand2_1
* View Name:    schematic
************************************************************************

.SUBCKT sg13g2_nand2_1 Y A B VDD VSS
*.PININFO A:I B:I Y:O VDD:B VSS:B
MP1 Y B VDD VDD sg13_lv_pmos m=1 w=1.12u l=130.00n ng=1
MP0 Y A VDD VDD sg13_lv_pmos m=1 w=1.12u l=130.00n ng=1
MN1 net1 B VSS VSS sg13_lv_nmos m=1 w=740.00n l=130.00n ng=1
MN0 Y A net1 VSS sg13_lv_nmos m=1 w=740.00n l=130.00n ng=1
.ENDS

************************************************************************
* Library Name: sg13g2_stdcell
* Cell Name:    sg13g2_nand2_2
* View Name:    schematic
************************************************************************

.SUBCKT sg13g2_nand2_2 Y A B VDD VSS
*.PININFO A:I B:I Y:O VDD:B VSS:B
MP1 Y B VDD VDD sg13_lv_pmos m=1 w=2.24u l=130.00n ng=2
MP0 Y A VDD VDD sg13_lv_pmos m=1 w=2.24u l=130.00n ng=2
MN1 net1 B VSS VSS sg13_lv_nmos m=1 w=1.44u l=130.00n ng=2
MN0 Y A net1 VSS sg13_lv_nmos m=1 w=1.44u l=130.00n ng=2
.ENDS

************************************************************************
* Library Name: sg13g2_stdcell
* Cell Name:    sg13g2_nand2b_1
* View Name:    schematic
************************************************************************

.SUBCKT sg13g2_nand2b_1 Y A_N B VDD VSS
*.PININFO A_N:I B:I Y:O VDD:B VSS:B
MP2 Y net2 VDD VDD sg13_lv_pmos m=1 w=1.12u l=130.00n ng=1
MP1 net2 A_N VDD VDD sg13_lv_pmos m=1 w=840.00n l=130.00n ng=1
MP0 Y B VDD VDD sg13_lv_pmos m=1 w=1.12u l=130.00n ng=1
MN1 Y net2 net1 VSS sg13_lv_nmos m=1 w=740.00n l=130.00n ng=1
MN0 net2 A_N VSS VSS sg13_lv_nmos m=1 w=550.00n l=130.00n ng=1
MN2 net1 B VSS VSS sg13_lv_nmos m=1 w=740.00n l=130.00n ng=1
.ENDS

************************************************************************
* Library Name: sg13g2_stdcell
* Cell Name:    sg13g2_nand2b_2
* View Name:    schematic
************************************************************************

.SUBCKT sg13g2_nand2b_2 Y A_N B VDD VSS
*.PININFO A_N:I B:I Y:O VDD:B VSS:B
MP2 Y A VDD VDD sg13_lv_pmos m=1 w=2.24u l=130.00n ng=2
MP0 A A_N VDD VDD sg13_lv_pmos m=1 w=840.00n l=130.00n ng=1
MP1 Y B VDD VDD sg13_lv_pmos m=1 w=2.24u l=130.00n ng=2
MN1 Y B net1 VSS sg13_lv_nmos m=1 w=1.44u l=130.00n ng=2
MN0 A A_N VSS VSS sg13_lv_nmos m=1 w=550.00n l=130.00n ng=1
MN2 net1 A VSS VSS sg13_lv_nmos m=1 w=1.44u l=130.00n ng=2
.ENDS

************************************************************************
* Library Name: sg13g2_stdcell
* Cell Name:    sg13g2_nand3_1
* View Name:    schematic
************************************************************************

.SUBCKT sg13g2_nand3_1 Y A B C VDD VSS
*.PININFO A:I B:I C:I Y:O VDD:B VSS:B
MP0 Y A VDD VDD sg13_lv_pmos m=1 w=1.12u l=130.00n ng=1
MP1 Y B VDD VDD sg13_lv_pmos m=1 w=1.12u l=130.00n ng=1
MP2 Y C VDD VDD sg13_lv_pmos m=1 w=1.12u l=130.00n ng=1
MN1 net2 B net3 VSS sg13_lv_nmos m=1 w=740.00n l=130.00n ng=1
MN2 net3 C VSS VSS sg13_lv_nmos m=1 w=740.00n l=130.00n ng=1
MN0 Y A net2 VSS sg13_lv_nmos m=1 w=740.00n l=130.00n ng=1
.ENDS

************************************************************************
* Library Name: sg13g2_stdcell
* Cell Name:    sg13g2_nand3b_1
* View Name:    schematic
************************************************************************

.SUBCKT sg13g2_nand3b_1 Y A_N B C VDD VSS
*.PININFO A_N:I B:I C:I Y:O VDD:B VSS:B
MP0 net1 A_N VDD VDD sg13_lv_pmos m=1 w=840.00n l=130.00n ng=1
MP1 Y net1 VDD VDD sg13_lv_pmos m=1 w=1.12u l=130.00n ng=1
MP2 Y B VDD VDD sg13_lv_pmos m=1 w=1.12u l=130.00n ng=1
MP3 Y C VDD VDD sg13_lv_pmos m=1 w=1.12u l=130.00n ng=1
MN2 net2 B net3 VSS sg13_lv_nmos m=1 w=740.00n l=130.00n ng=1
MN3 net3 C VSS VSS sg13_lv_nmos m=1 w=740.00n l=130.00n ng=1
MN0 net1 A_N VSS VSS sg13_lv_nmos m=1 w=550.00n l=130.00n ng=1
MN1 Y net1 net2 VSS sg13_lv_nmos m=1 w=740.00n l=130.00n ng=1
.ENDS

************************************************************************
* Library Name: sg13g2_stdcell
* Cell Name:    sg13g2_nand4_1
* View Name:    schematic
************************************************************************

.SUBCKT sg13g2_nand4_1 Y A B C D VDD VSS
*.PININFO A:I B:I C:I D:I Y:O VDD:B VSS:B
MP3 Y D VDD VDD sg13_lv_pmos m=1 w=1.12u l=130.00n ng=1
MP0 Y A VDD VDD sg13_lv_pmos m=1 w=1.12u l=130.00n ng=1
MP1 Y B VDD VDD sg13_lv_pmos m=1 w=1.12u l=130.00n ng=1
MP2 Y C VDD VDD sg13_lv_pmos m=1 w=1.12u l=130.00n ng=1
MN1 net2 B net3 VSS sg13_lv_nmos m=1 w=740.00n l=130.00n ng=1
MN2 net3 C net5 VSS sg13_lv_nmos m=1 w=740.00n l=130.00n ng=1
MN0 Y A net2 VSS sg13_lv_nmos m=1 w=740.00n l=130.00n ng=1
MN3 net5 D VSS VSS sg13_lv_nmos m=1 w=740.00n l=130.00n ng=1
.ENDS

************************************************************************
* Library Name: sg13g2_stdcell
* Cell Name:    sg13g2_nor2_1
* View Name:    schematic
************************************************************************

.SUBCKT sg13g2_nor2_1 Y A B VDD VSS
*.PININFO A:I B:I Y:O VDD:B VSS:B
MN0 Y A VSS VSS sg13_lv_nmos m=1 w=740.00n l=130.00n ng=1
MN1 Y B VSS VSS sg13_lv_nmos m=1 w=740.00n l=130.00n ng=1
MP0 net1 A VDD VDD sg13_lv_pmos m=1 w=1.12u l=130.00n ng=1
MP1 Y B net1 VDD sg13_lv_pmos m=1 w=1.12u l=130.00n ng=1
.ENDS

************************************************************************
* Library Name: sg13g2_stdcell
* Cell Name:    sg13g2_nor2_2
* View Name:    schematic
************************************************************************

.SUBCKT sg13g2_nor2_2 Y A B VDD VSS
*.PININFO A:I B:I Y:O VDD:B VSS:B
MN0 Y A VSS VSS sg13_lv_nmos m=1 w=1.48u l=130.00n ng=2
MN1 Y B VSS VSS sg13_lv_nmos m=1 w=1.48u l=130.00n ng=2
MP0 net1 A VDD VDD sg13_lv_pmos m=1 w=2.24u l=130.00n ng=2
MP1 Y B net1 VDD sg13_lv_pmos m=1 w=2.24u l=130.00n ng=2
.ENDS

************************************************************************
* Library Name: sg13g2_stdcell
* Cell Name:    sg13g2_nor2b_1
* View Name:    schematic
************************************************************************

.SUBCKT sg13g2_nor2b_1 Y A B_N VDD VSS
*.PININFO A:I B_N:I Y:O VDD:B VSS:B
MN0 B B_N VSS VSS sg13_lv_nmos m=1 w=550.00n l=130.00n ng=1
MN1 Y A VSS VSS sg13_lv_nmos m=1 w=740.00n l=130.00n ng=1
MN2 Y B VSS VSS sg13_lv_nmos m=1 w=740.00n l=130.00n ng=1
MP0 B B_N VDD VDD sg13_lv_pmos m=1 w=840.00n l=130.00n ng=1
MP1 net1 B VDD VDD sg13_lv_pmos m=1 w=1.12u l=130.00n ng=1
MP2 Y A net1 VDD sg13_lv_pmos m=1 w=1.12u l=130.00n ng=1
.ENDS

************************************************************************
* Library Name: sg13g2_stdcell
* Cell Name:    sg13g2_nor2b_2
* View Name:    schematic
************************************************************************

.SUBCKT sg13g2_nor2b_2 Y A B_N VDD VSS
*.PININFO A:I B_N:I Y:O VDD:B VSS:B
MN0 B B_N VSS VSS sg13_lv_nmos m=1 w=640.00n l=130.00n ng=1
MN1 Y A VSS VSS sg13_lv_nmos m=1 w=1.44u l=130.00n ng=2
MN2 Y B VSS VSS sg13_lv_nmos m=1 w=1.44u l=130.00n ng=2
MP0 B B_N VDD VDD sg13_lv_pmos m=1 w=1.000u l=130.00n ng=1
MP1 net1 B VDD VDD sg13_lv_pmos m=1 w=2.24u l=130.00n ng=2
MP2 Y A net1 VDD sg13_lv_pmos m=1 w=2.24u l=130.00n ng=2
.ENDS

************************************************************************
* Library Name: sg13g2_stdcell
* Cell Name:    sg13g2_nor3_1
* View Name:    schematic
************************************************************************

.SUBCKT sg13g2_nor3_1 Y A B C VDD VSS
*.PININFO A:I B:I C:I Y:O VDD:B VSS:B
MP2 Y C net2 VDD sg13_lv_pmos m=1 w=1.12u l=130.00n ng=1
MP1 net2 B net3 VDD sg13_lv_pmos m=1 w=1.12u l=130.00n ng=1
MP0 net3 A VDD VDD sg13_lv_pmos m=1 w=1.12u l=130.00n ng=1
MN0 Y A VSS VSS sg13_lv_nmos m=1 w=770.00n l=130.00n ng=1
MN1 Y B VSS VSS sg13_lv_nmos m=1 w=770.00n l=130.00n ng=1
MN2 Y C VSS VSS sg13_lv_nmos m=1 w=770.00n l=130.00n ng=1
.ENDS

************************************************************************
* Library Name: sg13g2_stdcell
* Cell Name:    sg13g2_nor3_2
* View Name:    schematic
************************************************************************

.SUBCKT sg13g2_nor3_2 Y A B C VDD VSS
*.PININFO A:I B:I C:I Y:O VDD:B VSS:B
MP2 Y C net2 VDD sg13_lv_pmos m=1 w=2.24u l=130.00n ng=2
MP1 net2 B net3 VDD sg13_lv_pmos m=1 w=2.24u l=130.00n ng=2
MP0 net3 A VDD VDD sg13_lv_pmos m=1 w=2.24u l=130.00n ng=2
MN0 Y A VSS VSS sg13_lv_nmos m=1 w=1.48u l=130.00n ng=2
MN1 Y B VSS VSS sg13_lv_nmos m=1 w=1.48u l=130.00n ng=2
MN2 Y C VSS VSS sg13_lv_nmos m=1 w=1.48u l=130.00n ng=2
.ENDS

************************************************************************
* Library Name: sg13g2_stdcell
* Cell Name:    sg13g2_nor4_1
* View Name:    schematic
************************************************************************

.SUBCKT sg13g2_nor4_1 Y A B C D VDD VSS
*.PININFO A:I B:I C:I D:I Y:O VDD:B VSS:B
MP0 net3 A VDD VDD sg13_lv_pmos m=1 w=1.12u l=130.00n ng=1
MP1 net2 B net3 VDD sg13_lv_pmos m=1 w=1.12u l=130.00n ng=1
MP2 net1 C net2 VDD sg13_lv_pmos m=1 w=1.12u l=130.00n ng=1
MP3 Y D net1 VDD sg13_lv_pmos m=1 w=1.12u l=130.00n ng=1
MN0 Y A VSS VSS sg13_lv_nmos m=1 w=740.00n l=130.00n ng=1
MN3 Y D VSS VSS sg13_lv_nmos m=1 w=740.00n l=130.00n ng=1
MN1 Y B VSS VSS sg13_lv_nmos m=1 w=740.00n l=130.00n ng=1
MN2 Y C VSS VSS sg13_lv_nmos m=1 w=740.00n l=130.00n ng=1
.ENDS

************************************************************************
* Library Name: sg13g2_stdcell
* Cell Name:    sg13g2_nor4_2
* View Name:    schematic
************************************************************************

.SUBCKT sg13g2_nor4_2 Y A B C D VDD VSS
*.PININFO A:I B:I C:I D:I Y:O VDD:B VSS:B
MP0 net3 A VDD VDD sg13_lv_pmos m=1 w=2.24u l=130.00n ng=2
MP1 net2 B net3 VDD sg13_lv_pmos m=1 w=2.24u l=130.00n ng=2
MP2 net1 C net2 VDD sg13_lv_pmos m=1 w=2.24u l=130.00n ng=2
MP3 Y D net1 VDD sg13_lv_pmos m=1 w=2.24u l=130.00n ng=2
MN0 Y A VSS VSS sg13_lv_nmos m=1 w=1.48u l=130.00n ng=2
MN3 Y D VSS VSS sg13_lv_nmos m=1 w=1.48u l=130.00n ng=2
MN1 Y B VSS VSS sg13_lv_nmos m=1 w=1.48u l=130.00n ng=2
MN2 Y C VSS VSS sg13_lv_nmos m=1 w=1.48u l=130.00n ng=2
.ENDS

************************************************************************
* Library Name: sg13g2_stdcell
* Cell Name:    sg13g2_o21ai_1
* View Name:    schematic
************************************************************************

.SUBCKT sg13g2_o21ai_1 Y A1 A2 B1 VDD VSS
*.PININFO A1:I A2:I B1:I Y:O VDD:B VSS:B
MP0 net14 A1 VDD VDD sg13_lv_pmos m=1 w=1.12u l=150.00n ng=1
MP1 Y A2 net14 VDD sg13_lv_pmos m=1 w=1.12u l=150.00n ng=1
MP2 Y B1 VDD VDD sg13_lv_pmos m=1 w=1.12u l=150.00n ng=1
MN0 net1 A2 VSS VSS sg13_lv_nmos m=1 w=740.00n l=150.00n ng=1
MN2 net1 A1 VSS VSS sg13_lv_nmos m=1 w=740.00n l=150.00n ng=1
MN1 Y B1 net1 VSS sg13_lv_nmos m=1 w=740.00n l=150.00n ng=1
.ENDS

************************************************************************
* Library Name: sg13g2_stdcell
* Cell Name:    sg13g2_or2_1
* View Name:    schematic
************************************************************************

.SUBCKT sg13g2_or2_1 X A B VDD VSS
*.PININFO A:I B:I X:O VDD:B VSS:B
MP1 net2 B net3 VDD sg13_lv_pmos m=1 w=840.00n l=130.00n ng=1
MP0 net3 A VDD VDD sg13_lv_pmos m=1 w=840.00n l=130.00n ng=1
MP2 X net2 VDD VDD sg13_lv_pmos m=1 w=1.12u l=130.00n ng=1
MN1 net2 A VSS VSS sg13_lv_nmos m=1 w=550.00n l=130.00n ng=1
MN0 net2 B VSS VSS sg13_lv_nmos m=1 w=550.00n l=130.00n ng=1
MN2 X net2 VSS VSS sg13_lv_nmos m=1 w=740.00n l=130.00n ng=1
.ENDS

************************************************************************
* Library Name: sg13g2_stdcell
* Cell Name:    sg13g2_or2_2
* View Name:    schematic
************************************************************************

.SUBCKT sg13g2_or2_2 X A B VDD VSS
*.PININFO A:I B:I X:O VDD:B VSS:B
MP1 net2 B net3 VDD sg13_lv_pmos m=1 w=840.00n l=130.00n ng=1
MP0 net3 A VDD VDD sg13_lv_pmos m=1 w=840.00n l=130.00n ng=1
MP2 X net2 VDD VDD sg13_lv_pmos m=1 w=2.24u l=130.00n ng=2
MN1 net2 A VSS VSS sg13_lv_nmos m=1 w=550.00n l=130.00n ng=1
MN0 net2 B VSS VSS sg13_lv_nmos m=1 w=550.00n l=130.00n ng=1
MN2 X net2 VSS VSS sg13_lv_nmos m=1 w=1.48u l=130.00n ng=2
.ENDS

************************************************************************
* Library Name: sg13g2_stdcell
* Cell Name:    sg13g2_or3_1
* View Name:    schematic
************************************************************************

.SUBCKT sg13g2_or3_1 X A B C VDD VSS
*.PININFO A:I B:I C:I X:O VDD:B VSS:B
MN2 net1 C VSS VSS sg13_lv_nmos m=1 w=550.00n l=130.00n ng=1
MN3 X net1 VSS VSS sg13_lv_nmos m=1 w=740.00n l=130.00n ng=1
MN1 net1 B VSS VSS sg13_lv_nmos m=1 w=550.00n l=130.00n ng=1
MN0 net1 A VSS VSS sg13_lv_nmos m=1 w=550.00n l=130.00n ng=1
MP3 X net1 VDD VDD sg13_lv_pmos m=1 w=1.12u l=130.00n ng=1
MP1 net9 B net12 VDD sg13_lv_pmos m=1 w=1.000u l=130.00n ng=1
MP0 net12 A VDD VDD sg13_lv_pmos m=1 w=1.000u l=130.00n ng=1
MP2 net1 C net9 VDD sg13_lv_pmos m=1 w=1.000u l=130.00n ng=1
.ENDS

************************************************************************
* Library Name: sg13g2_stdcell
* Cell Name:    sg13g2_or3_2
* View Name:    schematic
************************************************************************

.SUBCKT sg13g2_or3_2 X A B C VDD VSS
*.PININFO A:I B:I C:I X:O VDD:B VSS:B
MN2 net1 C VSS VSS sg13_lv_nmos m=1 w=550.00n l=130.00n ng=1
MN3 X net1 VSS VSS sg13_lv_nmos m=1 w=1.48u l=130.00n ng=2
MN1 net1 B VSS VSS sg13_lv_nmos m=1 w=550.00n l=130.00n ng=1
MN0 net1 A VSS VSS sg13_lv_nmos m=1 w=550.00n l=130.00n ng=1
MP3 X net1 VDD VDD sg13_lv_pmos m=1 w=2.24u l=130.00n ng=2
MP1 net9 B net12 VDD sg13_lv_pmos m=1 w=1.000u l=130.00n ng=1
MP0 net12 A VDD VDD sg13_lv_pmos m=1 w=1.000u l=130.00n ng=1
MP2 net1 C net9 VDD sg13_lv_pmos m=1 w=1.000u l=130.00n ng=1
.ENDS

************************************************************************
* Library Name: sg13g2_stdcell
* Cell Name:    sg13g2_or4_1
* View Name:    schematic
************************************************************************

.SUBCKT sg13g2_or4_1 X A B C D VDD VSS
*.PININFO A:I B:I C:I D:I X:O VDD:B VSS:B
MN4 X net1 VSS VSS sg13_lv_nmos m=1 w=740.00n l=130.00n ng=1
MN3 net1 D VSS VSS sg13_lv_nmos m=1 w=550.00n l=130.00n ng=1
MN2 net1 C VSS VSS sg13_lv_nmos m=1 w=550.00n l=130.00n ng=1
MN1 net1 B VSS VSS sg13_lv_nmos m=1 w=550.00n l=130.00n ng=1
MN0 net1 A VSS VSS sg13_lv_nmos m=1 w=550.00n l=130.00n ng=1
MP0 net4 A VDD VDD sg13_lv_pmos m=1 w=1.000u l=130.00n ng=1
MP1 net3 B net4 VDD sg13_lv_pmos m=1 w=1.000u l=130.00n ng=1
MP2 net2 C net3 VDD sg13_lv_pmos m=1 w=1.000u l=130.00n ng=1
MP3 net1 D net2 VDD sg13_lv_pmos m=1 w=1.000u l=130.00n ng=1
MP4 X net1 VDD VDD sg13_lv_pmos m=1 w=1.12u l=130.00n ng=1
.ENDS

************************************************************************
* Library Name: sg13g2_stdcell
* Cell Name:    sg13g2_or4_2
* View Name:    schematic
************************************************************************

.SUBCKT sg13g2_or4_2 X A B C D VDD VSS
*.PININFO A:I B:I C:I D:I X:O VDD:B VSS:B
MN4 X net1 VSS VSS sg13_lv_nmos m=1 w=1.48u l=130.00n ng=2
MN3 net1 D VSS VSS sg13_lv_nmos m=1 w=550.00n l=130.00n ng=1
MN2 net1 C VSS VSS sg13_lv_nmos m=1 w=550.00n l=130.00n ng=1
MN1 net1 B VSS VSS sg13_lv_nmos m=1 w=550.00n l=130.00n ng=1
MN0 net1 A VSS VSS sg13_lv_nmos m=1 w=550.00n l=130.00n ng=1
MP0 net4 A VDD VDD sg13_lv_pmos m=1 w=1.000u l=130.00n ng=1
MP1 net3 B net4 VDD sg13_lv_pmos m=1 w=1.000u l=130.00n ng=1
MP2 net2 C net3 VDD sg13_lv_pmos m=1 w=1.000u l=130.00n ng=1
MP3 net1 D net2 VDD sg13_lv_pmos m=1 w=1.000u l=130.00n ng=1
MP4 X net1 VDD VDD sg13_lv_pmos m=1 w=2.24u l=130.00n ng=2
.ENDS

************************************************************************
* Library Name: sg13g2_stdcell
* Cell Name:    sg13g2_sdfbbp_1
* View Name:    schematic
************************************************************************

.SUBCKT sg13g2_sdfbbp_1 Q Q_N CLK D RESET_B SCD SCE SET_B VDD VSS
*.PININFO CLK:I D:I RESET_B:I SCD:I SCE:I SET_B:I Q:O Q_N:O VDD:B VSS:B
MP1 resetbb RESET_B VDD VDD sg13_lv_pmos m=1 w=640.00n l=130.00n ng=1
MP19 pre_q DbbLatch2 net8 VDD sg13_lv_pmos m=1 w=1.000u l=130.00n ng=1
MP20 pre_q SET_B VDD VDD sg13_lv_pmos m=1 w=1.000u l=130.00n ng=1
MP3 CLKbb CLKb VDD VDD sg13_lv_pmos m=1 w=1.12u l=130.00n ng=1
MP0 SCEb SCE VDD VDD sg13_lv_pmos m=1 w=640.00n l=130.00n ng=1
MP7 Db D net3 VDD sg13_lv_pmos m=1 w=640.00n l=130.00n ng=1
MP13 DbbTG CLKb net10 VDD sg13_lv_pmos m=1 w=420.00n l=130.00n ng=1
MP12 net10 DbLatchM VDD VDD sg13_lv_pmos m=1 w=420.00n l=130.00n ng=1
MP6 net3 SCE VDD VDD sg13_lv_pmos m=1 w=640.00n l=130.00n ng=1
MP21 Q_N pre_q VDD VDD sg13_lv_pmos m=1 w=1.12u l=130.00n ng=1
MP14 net1 DbLatchM VDD VDD sg13_lv_pmos m=1 w=840.00n l=130.00n ng=1
MP18 net8 resetbb VDD VDD sg13_lv_pmos m=1 w=1.000u l=130.00n ng=1
MP11 DbLatchM SET_B VDD VDD sg13_lv_pmos m=1 w=840.00n l=130.00n ng=1
MP4 net2 SCD VDD VDD sg13_lv_pmos m=1 w=640.00n l=130.00n ng=1
MP2 CLKb CLK VDD VDD sg13_lv_pmos m=1 w=1.12u l=130.00n ng=1
MP10 DbLatchM DbbTG net7 VDD sg13_lv_pmos m=1 w=840.00n l=130.00n ng=1
MP8 Db CLKbb DbbTG VDD sg13_lv_pmos m=1 w=640.00n l=130.00n ng=1
MP5 Db SCEb net2 VDD sg13_lv_pmos m=1 w=640.00n l=130.00n ng=1
MP22 pre_qb pre_q VDD VDD sg13_lv_pmos m=1 w=840.00n l=130.00n ng=1
MP9 net7 resetbb VDD VDD sg13_lv_pmos m=1 w=840.00n l=130.00n ng=1
MP16 net6 pre_q VDD VDD sg13_lv_pmos m=1 w=420.00n l=130.00n ng=1
MP17 DbbLatch2 CLKbb net6 VDD sg13_lv_pmos m=1 w=420.00n l=130.00n ng=1
MP15 DbbLatch2 CLKb net1 VDD sg13_lv_pmos m=1 w=840.00n l=130.00n ng=1
MP23 Q pre_qb VDD VDD sg13_lv_pmos m=1 w=1.12u l=130.00n ng=1
MN4 Db SCE net5 VSS sg13_lv_nmos m=1 w=420.00n l=130.00n ng=1
MN5 net5 SCD VSS VSS sg13_lv_nmos m=1 w=420.00n l=130.00n ng=1
MN18 pre_q DbbLatch2 net11 VSS sg13_lv_nmos m=1 w=740.00n l=130.00n ng=1
MN8 Db CLKb DbbTG VSS sg13_lv_nmos m=1 w=420.00n l=130.00n ng=1
MN7 net4 SCEb VSS VSS sg13_lv_nmos m=1 w=420.00n l=130.00n ng=1
MN3 CLKbb CLKb VSS VSS sg13_lv_nmos m=1 w=740.00n l=130.00n ng=1
MN1 resetbb RESET_B VSS VSS sg13_lv_nmos m=1 w=420.00n l=130.00n ng=1
MN17 net14 pre_q VSS VSS sg13_lv_nmos m=1 w=420.00n l=130.00n ng=1
MN9 DbLatchM DbbTG net12 VSS sg13_lv_nmos m=1 w=550.00n l=130.00n ng=1
MN0 SCEb SCE VSS VSS sg13_lv_nmos m=1 w=420.00n l=130.00n ng=1
MN10 net12 SET_B VSS VSS sg13_lv_nmos m=1 w=550.00n l=130.00n ng=1
MN13 net15 DbLatchM VSS VSS sg13_lv_nmos m=1 w=420.00n l=130.00n ng=1
MN19 net11 SET_B VSS VSS sg13_lv_nmos m=1 w=740.00n l=130.00n ng=1
MN12 DbbTG CLKbb net15 VSS sg13_lv_nmos m=1 w=420.00n l=130.00n ng=1
MN6 Db D net4 VSS sg13_lv_nmos m=1 w=420.00n l=130.00n ng=1
MN22 pre_qb pre_q VSS VSS sg13_lv_nmos m=1 w=550.00n l=130.00n ng=1
MN16 DbbLatch2 CLKb net14 VSS sg13_lv_nmos m=1 w=420.00n l=130.00n ng=1
MN23 Q pre_qb VSS VSS sg13_lv_nmos m=1 w=740.00n l=130.00n ng=1
MN15 net13 DbLatchM VSS VSS sg13_lv_nmos m=1 w=550.00n l=130.00n ng=1
MN2 CLKb CLK VSS VSS sg13_lv_nmos m=1 w=740.00n l=130.00n ng=1
MN14 DbbLatch2 CLKbb net13 VSS sg13_lv_nmos m=1 w=550.00n l=130.00n ng=1
MN11 DbLatchM resetbb net12 VSS sg13_lv_nmos m=1 w=550.00n l=130.00n ng=1
MN21 Q_N pre_q VSS VSS sg13_lv_nmos m=1 w=740.00n l=130.00n ng=1
MN20 pre_q resetbb net11 VSS sg13_lv_nmos m=1 w=740.00n l=130.00n ng=1
.ENDS

************************************************************************
* Library Name: sg13g2_stdcell
* Cell Name:    sg13g2_sighold
* View Name:    schematic
************************************************************************

.SUBCKT sg13g2_sighold SH VDD VSS
*.PININFO SH:B VDD:B VSS:B
MN1 net1 SH VSS VSS sg13_lv_nmos m=1 w=300.0n l=130.00n ng=1
MN0 SH net1 VSS VSS sg13_lv_nmos m=1 w=300.0n l=700.0n ng=1
MP1 net1 SH VDD VDD sg13_lv_pmos m=1 w=450.00n l=130.00n ng=1
MP0 SH net1 VDD VDD sg13_lv_pmos m=1 w=300.0n l=700.0n ng=1
.ENDS

************************************************************************
* Library Name: sg13g2_stdcell
* Cell Name:    sg13g2_slgcp_1
* View Name:    schematic
************************************************************************

.SUBCKT sg13g2_slgcp_1 GCLK CLK GATE SCE VDD VSS
*.PININFO CLK:I GATE:I SCE:I GCLK:O VDD:B VSS:B
MP10 GCLK net5 VDD VDD sg13_lv_pmos m=1 w=1.12u l=130.00n ng=1
MP4 net1 CLKbb net6 VDD sg13_lv_pmos m=1 w=840.00n l=130.00n ng=1
MP1 CLKbb CLKb VDD VDD sg13_lv_pmos m=1 w=840.00n l=130.00n ng=1
MP8 net5 int_GATE VDD VDD sg13_lv_pmos m=1 w=840.00n l=130.00n ng=1
MP2 net3 SCE VDD VDD sg13_lv_pmos m=1 w=840.00n l=130.00n ng=1
MP7 net6 CLKb net4 VDD sg13_lv_pmos m=1 w=420.00n l=130.00n ng=1
MP5 int_GATE net6 VDD VDD sg13_lv_pmos m=1 w=1.12u l=130.00n ng=1
MP0 CLKb CLK VDD VDD sg13_lv_pmos m=1 w=840.00n l=130.00n ng=1
MP9 net5 CLK VDD VDD sg13_lv_pmos m=1 w=840.00n l=130.00n ng=1
MP6 net4 int_GATE VDD VDD sg13_lv_pmos m=1 w=420.00n l=130.00n ng=1
MP3 net1 GATE net3 VDD sg13_lv_pmos m=1 w=840.00n l=130.00n ng=1
MN5 int_GATE net6 VSS VSS sg13_lv_nmos m=1 w=740.00n l=130.00n ng=1
MN9 net2 CLK VSS VSS sg13_lv_nmos m=1 w=640.00n l=130.00n ng=1
MN2 net1 SCE VSS VSS sg13_lv_nmos m=1 w=550.00n l=130.00n ng=1
MN4 net6 CLKb net1 VSS sg13_lv_nmos m=1 w=550.00n l=130.00n ng=1
MN7 net7 int_GATE VSS VSS sg13_lv_nmos m=1 w=420.00n l=130.00n ng=1
MN8 net5 int_GATE net2 VSS sg13_lv_nmos m=1 w=640.00n l=130.00n ng=1
MN10 GCLK net5 VSS VSS sg13_lv_nmos m=1 w=740.00n l=130.00n ng=1
MN1 CLKbb CLKb VSS VSS sg13_lv_nmos m=1 w=740.00n l=130.00n ng=1
MN3 net1 GATE VSS VSS sg13_lv_nmos m=1 w=550.00n l=130.00n ng=1
MN0 CLKb CLK VSS VSS sg13_lv_nmos m=1 w=740.00n l=130.00n ng=1
MN6 net6 CLKbb net7 VSS sg13_lv_nmos m=1 w=420.00n l=130.00n ng=1
.ENDS

************************************************************************
* Library Name: sg13g2_stdcell
* Cell Name:    sg13g2_tiehi
* View Name:    schematic
************************************************************************

.SUBCKT sg13g2_tiehi L_HI VDD VSS
*.PININFO L_HI:O VDD:B VSS:B
MN1 net3 net2 VSS VSS sg13_lv_nmos m=1 w=795.00n l=130.00n ng=1
MN0 net1 net1 VSS VSS sg13_lv_nmos m=1 w=300n l=130.00n ng=1
MP1 L_HI net3 VDD VDD sg13_lv_pmos m=1 w=1.155u l=130.00n ng=1
MP0 net2 net1 VDD VDD sg13_lv_pmos m=1 w=660.0n l=130.00n ng=1
.ENDS

************************************************************************
* Library Name: sg13g2_stdcell
* Cell Name:    sg13g2_tielo
* View Name:    schematic
************************************************************************

.SUBCKT sg13g2_tielo L_LO VDD VSS
*.PININFO L_LO:O VDD:B VSS:B
MN0 net3 net2 VSS VSS sg13_lv_nmos m=1 w=385.00n l=130.00n ng=1
MN1 L_LO net1 VSS VSS sg13_lv_nmos m=1 w=880.0n l=130.00n ng=1
MP0 net2 net2 VDD VDD sg13_lv_pmos m=1 w=300n l=130.00n ng=1
MP1 net1 net3 VDD VDD sg13_lv_pmos m=1 w=1.045u l=130.00n ng=1
.ENDS

************************************************************************
* Library Name: sg13g2_stdcell
* Cell Name:    sg13g2_xnor2_1
* View Name:    schematic
************************************************************************

.SUBCKT sg13g2_xnor2_1 Y A B VDD VSS
*.PININFO A:I B:I Y:O VDD:B VSS:B
MP4 Y net1 VDD VDD sg13_lv_pmos m=1 w=1.12u l=130.00n ng=1
MP3 Y B net4 VDD sg13_lv_pmos m=1 w=1.12u l=130.00n ng=1
MP2 net4 A VDD VDD sg13_lv_pmos m=1 w=1.12u l=130.00n ng=1
MP1 net1 B VDD VDD sg13_lv_pmos m=1 w=840.00n l=130.00n ng=1
MP0 net1 A VDD VDD sg13_lv_pmos m=1 w=840.00n l=130.00n ng=1
MN3 Y net1 net3 VSS sg13_lv_nmos m=1 w=740.00n l=130.00n ng=1
MN1 net2 A VSS VSS sg13_lv_nmos m=1 w=640.00n l=130.00n ng=1
MN0 net1 B net2 VSS sg13_lv_nmos m=1 w=640.00n l=130.00n ng=1
MN4 net3 B VSS VSS sg13_lv_nmos m=1 w=740.00n l=130.00n ng=1
MN2 net3 A VSS VSS sg13_lv_nmos m=1 w=740.00n l=130.00n ng=1
.ENDS

************************************************************************
* Library Name: sg13g2_stdcell
* Cell Name:    sg13g2_xor2_1
* View Name:    schematic
************************************************************************

.SUBCKT sg13g2_xor2_1 X A B VDD VSS
*.PININFO A:I B:I X:O VDD:B VSS:B
MN0 net1 A VSS VSS sg13_lv_nmos m=1 w=550.00n l=130.00n ng=1
MN3 X B net3 VSS sg13_lv_nmos m=1 w=740.00n l=130.00n ng=1
MN2 X net1 VSS VSS sg13_lv_nmos m=1 w=740.00n l=130.00n ng=1
MN4 net3 A VSS VSS sg13_lv_nmos m=1 w=740.00n l=130.00n ng=1
MN1 net1 B VSS VSS sg13_lv_nmos m=1 w=550.00n l=130.00n ng=1
MP0 net6 A VDD VDD sg13_lv_pmos m=1 w=1.000u l=130.00n ng=1
MP1 net1 B net6 VDD sg13_lv_pmos m=1 w=1.000u l=130.00n ng=1
MP2 net5 A VDD VDD sg13_lv_pmos m=1 w=1.12u l=130.00n ng=1
MP4 net5 B VDD VDD sg13_lv_pmos m=1 w=1.12u l=130.00n ng=1
MP3 X net1 net5 VDD sg13_lv_pmos m=1 w=1.12u l=130.00n ng=1
.ENDS

************************************************************************
* Library Name: sg13g2_stdcell
* Cell Name:    sg13g2_a22oi_1
* View Name:    schematic
************************************************************************

.SUBCKT sg13g2_a22oi_1 Y A1 A2 B1 B2 VDD VSS
*.PININFO A1:I A2:I B1:I B2:I Y:O VDD:B VSS:B
MN1 net1 B1 VSS VSS sg13_lv_nmos m=1 w=740.00n l=130.00n ng=1
MN0 Y B2 net1 VSS sg13_lv_nmos m=1 w=740.00n l=130.00n ng=1
MN3 net2 A2 VSS VSS sg13_lv_nmos m=1 w=740.00n l=130.00n ng=1
MN2 Y A1 net2 VSS sg13_lv_nmos m=1 w=740.00n l=130.00n ng=1
MP1 Y B1 net3 VDD sg13_lv_pmos m=1 w=1.12u l=130.00n ng=1
MP3 Y B2 net3 VDD sg13_lv_pmos m=1 w=1.12u l=130.00n ng=1
MP2 net3 A2 VDD VDD sg13_lv_pmos m=1 w=1.12u l=130.00n ng=1
MP0 net3 A1 VDD VDD sg13_lv_pmos m=1 w=1.12u l=130.00n ng=1
.ENDS

************************************************************************
* Library Name: sg13g2_stdcell
* Cell Name:    sg13g2_sdfrbpq_1
* View Name:    schematic
************************************************************************

.SUBCKT sg13g2_sdfrbpq_1 Q CLK D RESET_B SCD SCE VDD VSS
*.PININFO CLK:I D:I RESET_B:I SCD:I SCE:I Q:O VDD:B VSS:B
MN3 Db SCD net63 VSS sg13_lv_nmos m=1 w=740.00n l=130.00n ng=1
MN1 Db D net65 VSS sg13_lv_nmos m=1 w=740.00n l=130.00n ng=1
MN0 SCEb SCE VSS VSS sg13_lv_nmos m=1 w=550.00n l=130.00n ng=1
MN4 net63 SCE VSS VSS sg13_lv_nmos m=1 w=740.00n l=130.00n ng=1
MN2 net65 SCEb VSS VSS sg13_lv_nmos m=1 w=740.00n l=130.00n ng=1
MN17 net12 net2 VSS VSS sg13_lv_nmos m=1 w=420.00n l=130.00n ng=1
MN16 net5 clkneg net12 VSS sg13_lv_nmos m=1 w=420.00n l=130.00n ng=1
MN18 net2 net5 net11 VSS sg13_lv_nmos m=1 w=420.00n l=130.00n ng=1
MN19 net11 RESET_B VSS VSS sg13_lv_nmos m=1 w=420.00n l=130.00n ng=1
MN20 Q net2 VSS VSS sg13_lv_nmos m=1 w=740.00n l=130.00n ng=1
MN6 Dbbb Dbb net10 VSS sg13_lv_nmos m=1 w=420.00n l=130.00n ng=1
MN7 net10 RESET_B VSS VSS sg13_lv_nmos m=1 w=420.00n l=130.00n ng=1
MN10 Dbbb clkneg net6 VSS sg13_lv_nmos m=1 w=420.00n l=130.00n ng=1
MN11 net6 clkpos net9 VSS sg13_lv_nmos m=1 w=420.00n l=130.00n ng=1
MN12 net9 net4 net8 VSS sg13_lv_nmos m=1 w=420.00n l=130.00n ng=1
MN13 net8 RESET_B VSS VSS sg13_lv_nmos m=1 w=420.00n l=130.00n ng=1
MN14 net4 net6 VSS VSS sg13_lv_nmos m=1 w=740.00n l=130.00n ng=1
MN8 clkneg CLK VSS VSS sg13_lv_nmos m=1 w=740.00n l=130.00n ng=1
MN15 net4 clkpos net5 VSS sg13_lv_nmos m=1 w=740.00n l=130.00n ng=1
MN9 clkpos clkneg VSS VSS sg13_lv_nmos m=1 w=740.00n l=130.00n ng=1
MN5 Dbb Db VSS VSS sg13_lv_nmos m=1 w=740.00n l=130.00n ng=1
MP1 net64 SCE VDD VDD sg13_lv_pmos m=1 w=1.000u l=130.00n ng=1
MP3 net62 SCEb VDD VDD sg13_lv_pmos m=1 w=1.000u l=130.00n ng=1
MP0 SCEb SCE VDD VDD sg13_lv_pmos m=1 w=840.00n l=130.00n ng=1
MP4 Db SCD net62 VDD sg13_lv_pmos m=1 w=1.000u l=130.00n ng=1
MP2 Db D net64 VDD sg13_lv_pmos m=1 w=1.000u l=130.00n ng=1
MP17 net5 clkpos net3 VDD sg13_lv_pmos m=1 w=420.00n l=130.00n ng=1
MP18 net2 net5 VDD VDD sg13_lv_pmos m=1 w=420.00n l=130.00n ng=1
MP19 net2 RESET_B VDD VDD sg13_lv_pmos m=1 w=420.00n l=130.00n ng=1
MP20 Q net2 VDD VDD sg13_lv_pmos m=1 w=1.12u l=130.00n ng=1
MP10 Dbbb clkpos net6 VDD sg13_lv_pmos m=1 w=420.00n l=130.00n ng=1
MP6 Dbbb RESET_B VDD VDD sg13_lv_pmos m=1 w=420.00n l=130.00n ng=1
MP7 Dbbb Dbb VDD VDD sg13_lv_pmos m=1 w=420.00n l=130.00n ng=1
MP11 net7 net4 VDD VDD sg13_lv_pmos m=1 w=420.00n l=130.00n ng=1
MP12 net6 clkneg net7 VDD sg13_lv_pmos m=1 w=420.00n l=130.00n ng=1
MP13 net6 RESET_B VDD VDD sg13_lv_pmos m=1 w=420.00n l=130.00n ng=1
MP8 clkneg CLK VDD VDD sg13_lv_pmos m=1 w=1.12u l=130.00n ng=1
MP9 clkpos clkneg VDD VDD sg13_lv_pmos m=1 w=1.12u l=130.00n ng=1
MP14 net4 net6 VDD VDD sg13_lv_pmos m=1 w=1.000u l=130.00n ng=1
MP15 net4 clkneg net5 VDD sg13_lv_pmos m=1 w=1.000u l=130.00n ng=1
MP5 Dbb Db VDD VDD sg13_lv_pmos m=1 w=1.12u l=130.00n ng=1
MP16 net3 net2 VDD VDD sg13_lv_pmos m=1 w=420.00n l=130.00n ng=1
.ENDS

************************************************************************
* Library Name: sg13g2_stdcell
* Cell Name:    sg13g2_sdfrbpq_2
* View Name:    schematic
************************************************************************

.SUBCKT sg13g2_sdfrbpq_2 Q CLK D RESET_B SCD SCE VDD VSS
*.PININFO CLK:I D:I RESET_B:I SCD:I SCE:I Q:O VDD:B VSS:B
MN3 Db SCD net63 VSS sg13_lv_nmos m=1 w=740.00n l=130.00n ng=1
MN1 Db D net65 VSS sg13_lv_nmos m=1 w=740.00n l=130.00n ng=1
MN0 SCEb SCE VSS VSS sg13_lv_nmos m=1 w=550.00n l=130.00n ng=1
MN4 net63 SCE VSS VSS sg13_lv_nmos m=1 w=740.00n l=130.00n ng=1
MN2 net65 SCEb VSS VSS sg13_lv_nmos m=1 w=740.00n l=130.00n ng=1
MN5 Dbb Db VSS VSS sg13_lv_nmos m=1 w=740.00n l=130.00n ng=1
MN17 net12 net2 VSS VSS sg13_lv_nmos m=1 w=420.00n l=130.00n ng=1
MN16 net5 clkneg net12 VSS sg13_lv_nmos m=1 w=420.00n l=130.00n ng=1
MN18 net2 net5 net11 VSS sg13_lv_nmos m=1 w=420.00n l=130.00n ng=1
MN19 net11 RESET_B VSS VSS sg13_lv_nmos m=1 w=420.00n l=130.00n ng=1
MN20 Q net2 VSS VSS sg13_lv_nmos m=1 w=1.48u l=130.00n ng=2
MN6 Dbbb Dbb net10 VSS sg13_lv_nmos m=1 w=420.00n l=130.00n ng=1
MN7 net10 RESET_B VSS VSS sg13_lv_nmos m=1 w=420.00n l=130.00n ng=1
MN10 Dbbb clkneg net6 VSS sg13_lv_nmos m=1 w=420.00n l=130.00n ng=1
MN11 net6 clkpos net9 VSS sg13_lv_nmos m=1 w=420.00n l=130.00n ng=1
MN12 net9 net4 net8 VSS sg13_lv_nmos m=1 w=420.00n l=130.00n ng=1
MN13 net8 RESET_B VSS VSS sg13_lv_nmos m=1 w=420.00n l=130.00n ng=1
MN14 net4 net6 VSS VSS sg13_lv_nmos m=1 w=740.00n l=130.00n ng=1
MN8 clkneg CLK VSS VSS sg13_lv_nmos m=1 w=740.00n l=130.00n ng=1
MN15 net4 clkpos net5 VSS sg13_lv_nmos m=1 w=740.00n l=130.00n ng=1
MN9 clkpos clkneg VSS VSS sg13_lv_nmos m=1 w=740.00n l=130.00n ng=1
MP1 net64 SCE VDD VDD sg13_lv_pmos m=1 w=1.000u l=130.00n ng=1
MP3 net62 SCEb VDD VDD sg13_lv_pmos m=1 w=1.000u l=130.00n ng=1
MP0 SCEb SCE VDD VDD sg13_lv_pmos m=1 w=840.00n l=130.00n ng=1
MP4 Db SCD net62 VDD sg13_lv_pmos m=1 w=1.000u l=130.00n ng=1
MP2 Db D net64 VDD sg13_lv_pmos m=1 w=1.000u l=130.00n ng=1
MP5 Dbb Db VDD VDD sg13_lv_pmos m=1 w=1.12u l=130.00n ng=1
MP17 net5 clkpos net3 VDD sg13_lv_pmos m=1 w=420.00n l=130.00n ng=1
MP18 net2 net5 VDD VDD sg13_lv_pmos m=1 w=420.00n l=130.00n ng=1
MP19 net2 RESET_B VDD VDD sg13_lv_pmos m=1 w=420.00n l=130.00n ng=1
MP20 Q net2 VDD VDD sg13_lv_pmos m=1 w=2.24u l=130.00n ng=2
MP10 Dbbb clkpos net6 VDD sg13_lv_pmos m=1 w=420.00n l=130.00n ng=1
MP6 Dbbb RESET_B VDD VDD sg13_lv_pmos m=1 w=420.00n l=130.00n ng=1
MP7 Dbbb Dbb VDD VDD sg13_lv_pmos m=1 w=420.00n l=130.00n ng=1
MP11 net7 net4 VDD VDD sg13_lv_pmos m=1 w=420.00n l=130.00n ng=1
MP12 net6 clkneg net7 VDD sg13_lv_pmos m=1 w=420.00n l=130.00n ng=1
MP13 net6 RESET_B VDD VDD sg13_lv_pmos m=1 w=420.00n l=130.00n ng=1
MP8 clkneg CLK VDD VDD sg13_lv_pmos m=1 w=1.12u l=130.00n ng=1
MP9 clkpos clkneg VDD VDD sg13_lv_pmos m=1 w=1.12u l=130.00n ng=1
MP14 net4 net6 VDD VDD sg13_lv_pmos m=1 w=1.000u l=130.00n ng=1
MP15 net4 clkneg net5 VDD sg13_lv_pmos m=1 w=1.000u l=130.00n ng=1
MP16 net3 net2 VDD VDD sg13_lv_pmos m=1 w=420.00n l=130.00n ng=1
.ENDS

************************************************************************
* Library Name: sg13g2_stdcell
* Cell Name:    sg13g2_sdfrbp_2
* View Name:    schematic
************************************************************************

.SUBCKT sg13g2_sdfrbp_2 Q Q_N CLK D RESET_B SCD SCE VDD VSS
*.PININFO CLK:I D:I RESET_B:I SCD:I SCE:I Q:O Q_N:O VDD:B VSS:B
MN3 Db SCD net63 VSS sg13_lv_nmos m=1 w=740.00n l=130.00n ng=1
MN1 Db D net65 VSS sg13_lv_nmos m=1 w=740.00n l=130.00n ng=1
MN0 SCEb SCE VSS VSS sg13_lv_nmos m=1 w=550.00n l=130.00n ng=1
MN4 net63 SCE VSS VSS sg13_lv_nmos m=1 w=740.00n l=130.00n ng=1
MN2 net65 SCEb VSS VSS sg13_lv_nmos m=1 w=740.00n l=130.00n ng=1
MN5 Dbb Db VSS VSS sg13_lv_nmos m=1 w=740.00n l=130.00n ng=1
MN17 net12 net2 VSS VSS sg13_lv_nmos m=1 w=420.00n l=130.00n ng=1
MN16 net5 clkneg net12 VSS sg13_lv_nmos m=1 w=420.00n l=130.00n ng=1
MN18 net2 net5 net11 VSS sg13_lv_nmos m=1 w=420.00n l=130.00n ng=1
MN19 net11 RESET_B VSS VSS sg13_lv_nmos m=1 w=420.00n l=130.00n ng=1
MN20 Q_N net5 VSS VSS sg13_lv_nmos m=1 w=1.48u l=130.00n ng=2
MN6 Dbbb Dbb net10 VSS sg13_lv_nmos m=1 w=420.00n l=130.00n ng=1
MN7 net10 RESET_B VSS VSS sg13_lv_nmos m=1 w=420.00n l=130.00n ng=1
MN10 Dbbb clkneg net6 VSS sg13_lv_nmos m=1 w=420.00n l=130.00n ng=1
MN11 net6 clkpos net9 VSS sg13_lv_nmos m=1 w=420.00n l=130.00n ng=1
MN12 net9 net4 net8 VSS sg13_lv_nmos m=1 w=420.00n l=130.00n ng=1
MN13 net8 RESET_B VSS VSS sg13_lv_nmos m=1 w=420.00n l=130.00n ng=1
MN14 net4 net6 VSS VSS sg13_lv_nmos m=1 w=740.00n l=130.00n ng=1
MN8 clkneg CLK VSS VSS sg13_lv_nmos m=1 w=740.00n l=130.00n ng=1
MN15 net4 clkpos net5 VSS sg13_lv_nmos m=1 w=740.00n l=130.00n ng=1
MN9 clkpos clkneg VSS VSS sg13_lv_nmos m=1 w=740.00n l=130.00n ng=1
MN22 Q net1 VSS VSS sg13_lv_nmos m=1 w=1.48u l=130.00n ng=2
MN21 net1 net5 VSS VSS sg13_lv_nmos m=1 w=640.00n l=130.00n ng=1
MP1 net64 SCE VDD VDD sg13_lv_pmos m=1 w=1.000u l=130.00n ng=1
MP3 net62 SCEb VDD VDD sg13_lv_pmos m=1 w=1.000u l=130.00n ng=1
MP0 SCEb SCE VDD VDD sg13_lv_pmos m=1 w=840.00n l=130.00n ng=1
MP4 Db SCD net62 VDD sg13_lv_pmos m=1 w=1.000u l=130.00n ng=1
MP2 Db D net64 VDD sg13_lv_pmos m=1 w=1.000u l=130.00n ng=1
MP5 Dbb Db VDD VDD sg13_lv_pmos m=1 w=1.12u l=130.00n ng=1
MP17 net5 clkpos net3 VDD sg13_lv_pmos m=1 w=420.00n l=130.00n ng=1
MP18 net2 net5 VDD VDD sg13_lv_pmos m=1 w=420.00n l=130.00n ng=1
MP19 net2 RESET_B VDD VDD sg13_lv_pmos m=1 w=420.00n l=130.00n ng=1
MP20 Q_N net5 VDD VDD sg13_lv_pmos m=1 w=2.24u l=130.00n ng=2
MP10 Dbbb clkpos net6 VDD sg13_lv_pmos m=1 w=420.00n l=130.00n ng=1
MP6 Dbbb RESET_B VDD VDD sg13_lv_pmos m=1 w=420.00n l=130.00n ng=1
MP7 Dbbb Dbb VDD VDD sg13_lv_pmos m=1 w=420.00n l=130.00n ng=1
MP11 net7 net4 VDD VDD sg13_lv_pmos m=1 w=420.00n l=130.00n ng=1
MP12 net6 clkneg net7 VDD sg13_lv_pmos m=1 w=420.00n l=130.00n ng=1
MP13 net6 RESET_B VDD VDD sg13_lv_pmos m=1 w=420.00n l=130.00n ng=1
MP8 clkneg CLK VDD VDD sg13_lv_pmos m=1 w=1.12u l=130.00n ng=1
MP9 clkpos clkneg VDD VDD sg13_lv_pmos m=1 w=1.12u l=130.00n ng=1
MP14 net4 net6 VDD VDD sg13_lv_pmos m=1 w=1.000u l=130.00n ng=1
MP15 net4 clkneg net5 VDD sg13_lv_pmos m=1 w=1.000u l=130.00n ng=1
MP22 Q net1 VDD VDD sg13_lv_pmos m=1 w=2.24u l=130.00n ng=2
MP16 net3 net2 VDD VDD sg13_lv_pmos m=1 w=420.00n l=130.00n ng=1
MP21 net1 net5 VDD VDD sg13_lv_pmos m=1 w=1.000u l=130.00n ng=1
.ENDS

************************************************************************
* Library Name: sg13g2_stdcell
* Cell Name:    sg13g2_sdfrbp_1
* View Name:    schematic
************************************************************************

.SUBCKT sg13g2_sdfrbp_1 Q Q_N CLK D RESET_B SCD SCE VDD VSS
*.PININFO CLK:I D:I RESET_B:I SCD:I SCE:I Q:O Q_N:O VDD:B VSS:B
MN3 Db SCD net63 VSS sg13_lv_nmos m=1 w=740.00n l=130.00n ng=1
MN1 Db D net65 VSS sg13_lv_nmos m=1 w=740.00n l=130.00n ng=1
MN0 SCEb SCE VSS VSS sg13_lv_nmos m=1 w=550.00n l=130.00n ng=1
MN4 net63 SCE VSS VSS sg13_lv_nmos m=1 w=740.00n l=130.00n ng=1
MN2 net65 SCEb VSS VSS sg13_lv_nmos m=1 w=740.00n l=130.00n ng=1
MN5 net13 Db VSS VSS sg13_lv_nmos m=1 w=740.00n l=130.00n ng=1
MN17 net12 net2 VSS VSS sg13_lv_nmos m=1 w=420.00n l=130.00n ng=1
MN16 net5 clkneg net12 VSS sg13_lv_nmos m=1 w=420.00n l=130.00n ng=1
MN18 net2 net5 net11 VSS sg13_lv_nmos m=1 w=420.00n l=130.00n ng=1
MN19 net11 RESET_B VSS VSS sg13_lv_nmos m=1 w=420.00n l=130.00n ng=1
MN20 Q_N net5 VSS VSS sg13_lv_nmos m=1 w=740.00n l=130.00n ng=1
MN6 Dbb net13 net10 VSS sg13_lv_nmos m=1 w=420.00n l=130.00n ng=1
MN7 net10 RESET_B VSS VSS sg13_lv_nmos m=1 w=420.00n l=130.00n ng=1
MN10 Dbb clkneg net6 VSS sg13_lv_nmos m=1 w=420.00n l=130.00n ng=1
MN11 net6 clkpos net9 VSS sg13_lv_nmos m=1 w=420.00n l=130.00n ng=1
MN12 net9 net4 net8 VSS sg13_lv_nmos m=1 w=420.00n l=130.00n ng=1
MN13 net8 RESET_B VSS VSS sg13_lv_nmos m=1 w=420.00n l=130.00n ng=1
MN14 net4 net6 VSS VSS sg13_lv_nmos m=1 w=740.00n l=130.00n ng=1
MN8 clkneg CLK VSS VSS sg13_lv_nmos m=1 w=740.00n l=130.00n ng=1
MN15 net4 clkpos net5 VSS sg13_lv_nmos m=1 w=740.00n l=130.00n ng=1
MN9 clkpos clkneg VSS VSS sg13_lv_nmos m=1 w=740.00n l=130.00n ng=1
MN22 Q net1 VSS VSS sg13_lv_nmos m=1 w=740.00n l=130.00n ng=1
MN21 net1 net5 VSS VSS sg13_lv_nmos m=1 w=640.00n l=130.00n ng=1
MP1 net64 SCE VDD VDD sg13_lv_pmos m=1 w=1.000u l=130.00n ng=1
MP3 net62 SCEb VDD VDD sg13_lv_pmos m=1 w=1.000u l=130.00n ng=1
MP0 SCEb SCE VDD VDD sg13_lv_pmos m=1 w=840.00n l=130.00n ng=1
MP4 Db SCD net62 VDD sg13_lv_pmos m=1 w=1.000u l=130.00n ng=1
MP2 Db D net64 VDD sg13_lv_pmos m=1 w=1.000u l=130.00n ng=1
MP5 net13 Db VDD VDD sg13_lv_pmos m=1 w=1.12u l=130.00n ng=1
MP17 net5 clkpos net3 VDD sg13_lv_pmos m=1 w=420.00n l=130.00n ng=1
MP18 net2 net5 VDD VDD sg13_lv_pmos m=1 w=420.00n l=130.00n ng=1
MP19 net2 RESET_B VDD VDD sg13_lv_pmos m=1 w=420.00n l=130.00n ng=1
MP20 Q_N net5 VDD VDD sg13_lv_pmos m=1 w=1.12u l=130.00n ng=1
MP10 Dbb clkpos net6 VDD sg13_lv_pmos m=1 w=420.00n l=130.00n ng=1
MP6 Dbb RESET_B VDD VDD sg13_lv_pmos m=1 w=420.00n l=130.00n ng=1
MP7 Dbb net13 VDD VDD sg13_lv_pmos m=1 w=420.00n l=130.00n ng=1
MP11 net7 net4 VDD VDD sg13_lv_pmos m=1 w=420.00n l=130.00n ng=1
MP12 net6 clkneg net7 VDD sg13_lv_pmos m=1 w=420.00n l=130.00n ng=1
MP13 net6 RESET_B VDD VDD sg13_lv_pmos m=1 w=420.00n l=130.00n ng=1
MP8 clkneg CLK VDD VDD sg13_lv_pmos m=1 w=1.12u l=130.00n ng=1
MP9 clkpos clkneg VDD VDD sg13_lv_pmos m=1 w=1.12u l=130.00n ng=1
MP14 net4 net6 VDD VDD sg13_lv_pmos m=1 w=1.000u l=130.00n ng=1
MP15 net4 clkneg net5 VDD sg13_lv_pmos m=1 w=1.000u l=130.00n ng=1
MP22 Q net1 VDD VDD sg13_lv_pmos m=1 w=1.12u l=130.00n ng=1
MP16 net3 net2 VDD VDD sg13_lv_pmos m=1 w=420.00n l=130.00n ng=1
MP21 net1 net5 VDD VDD sg13_lv_pmos m=1 w=1.000u l=130.00n ng=1
.ENDS

************************************************************************
* Library Name: sg13g2_stdcell
* Cell Name:    sg13g2_dfrbpq_2
* View Name:    schematic
************************************************************************

.SUBCKT sg13g2_dfrbpq_2 Q CLK D RESET_B VDD VSS
*.PININFO CLK:I D:I RESET_B:I Q:O VDD:B VSS:B
MN11 net12 net2 VSS VSS sg13_lv_nmos m=1 w=420.00n l=130.00n ng=1
MN10 net5 clkneg net12 VSS sg13_lv_nmos m=1 w=420.00n l=130.00n ng=1
MN12 net2 net5 net11 VSS sg13_lv_nmos m=1 w=420.00n l=130.00n ng=1
MN13 net11 RESET_B VSS VSS sg13_lv_nmos m=1 w=420.00n l=130.00n ng=1
MN0 Db D net10 VSS sg13_lv_nmos m=1 w=420.00n l=130.00n ng=1
MN1 net10 RESET_B VSS VSS sg13_lv_nmos m=1 w=420.00n l=130.00n ng=1
MN4 Db clkneg net6 VSS sg13_lv_nmos m=1 w=420.00n l=130.00n ng=1
MN5 net6 clkpos net9 VSS sg13_lv_nmos m=1 w=420.00n l=130.00n ng=1
MN6 net9 net4 net8 VSS sg13_lv_nmos m=1 w=420.00n l=130.00n ng=1
MN7 net8 RESET_B VSS VSS sg13_lv_nmos m=1 w=420.00n l=130.00n ng=1
MN8 net4 net6 VSS VSS sg13_lv_nmos m=1 w=740.00n l=130.00n ng=1
MN2 clkneg CLK VSS VSS sg13_lv_nmos m=1 w=740.00n l=130.00n ng=1
MN9 net4 clkpos net5 VSS sg13_lv_nmos m=1 w=740.00n l=130.00n ng=1
MN3 clkpos clkneg VSS VSS sg13_lv_nmos m=1 w=740.00n l=130.00n ng=1
MN15 Q net1 VSS VSS sg13_lv_nmos m=1 w=1.48u l=130.00n ng=2
MN14 net1 net5 VSS VSS sg13_lv_nmos m=1 w=640.00n l=130.00n ng=1
MP11 net5 clkpos net3 VDD sg13_lv_pmos m=1 w=420.00n l=130.00n ng=1
MP12 net2 net5 VDD VDD sg13_lv_pmos m=1 w=420.00n l=130.00n ng=1
MP13 net2 RESET_B VDD VDD sg13_lv_pmos m=1 w=420.00n l=130.00n ng=1
MP4 Db clkpos net6 VDD sg13_lv_pmos m=1 w=420.00n l=130.00n ng=1
MP0 Db RESET_B VDD VDD sg13_lv_pmos m=1 w=420.00n l=130.00n ng=1
MP1 Db D VDD VDD sg13_lv_pmos m=1 w=420.00n l=130.00n ng=1
MP5 net7 net4 VDD VDD sg13_lv_pmos m=1 w=420.00n l=130.00n ng=1
MP6 net6 clkneg net7 VDD sg13_lv_pmos m=1 w=420.00n l=130.00n ng=1
MP7 net6 RESET_B VDD VDD sg13_lv_pmos m=1 w=420.00n l=130.00n ng=1
MP2 clkneg CLK VDD VDD sg13_lv_pmos m=1 w=1.12u l=130.00n ng=1
MP3 clkpos clkneg VDD VDD sg13_lv_pmos m=1 w=1.12u l=130.00n ng=1
MP8 net4 net6 VDD VDD sg13_lv_pmos m=1 w=1.000u l=130.00n ng=1
MP9 net4 clkneg net5 VDD sg13_lv_pmos m=1 w=1.000u l=130.00n ng=1
MP15 Q net1 VDD VDD sg13_lv_pmos m=1 w=2.24u l=130.00n ng=2
MP10 net3 net2 VDD VDD sg13_lv_pmos m=1 w=420.00n l=130.00n ng=1
MP14 net1 net5 VDD VDD sg13_lv_pmos m=1 w=1.000u l=130.00n ng=1
.ENDS

************************************************************************
* Library Name: sg13g2_stdcell
* Cell Name:    sg13g2_dfrbpq_1
* View Name:    schematic
************************************************************************

.SUBCKT sg13g2_dfrbpq_1 Q CLK D RESET_B VDD VSS
*.PININFO CLK:I D:I RESET_B:I Q:O VDD:B VSS:B
MN11 net12 net2 VSS VSS sg13_lv_nmos m=1 w=420.00n l=130.00n ng=1
MN10 net5 clkneg net12 VSS sg13_lv_nmos m=1 w=420.00n l=130.00n ng=1
MN12 net2 net5 net11 VSS sg13_lv_nmos m=1 w=420.00n l=130.00n ng=1
MN13 net11 RESET_B VSS VSS sg13_lv_nmos m=1 w=420.00n l=130.00n ng=1
MN0 Db D net10 VSS sg13_lv_nmos m=1 w=420.00n l=130.00n ng=1
MN1 net10 RESET_B VSS VSS sg13_lv_nmos m=1 w=420.00n l=130.00n ng=1
MN4 Db clkneg net6 VSS sg13_lv_nmos m=1 w=420.00n l=130.00n ng=1
MN5 net6 clkpos net9 VSS sg13_lv_nmos m=1 w=420.00n l=130.00n ng=1
MN6 net9 net4 net8 VSS sg13_lv_nmos m=1 w=420.00n l=130.00n ng=1
MN7 net8 RESET_B VSS VSS sg13_lv_nmos m=1 w=420.00n l=130.00n ng=1
MN8 net4 net6 VSS VSS sg13_lv_nmos m=1 w=740.00n l=130.00n ng=1
MN2 clkneg CLK VSS VSS sg13_lv_nmos m=1 w=740.00n l=130.00n ng=1
MN9 net4 clkpos net5 VSS sg13_lv_nmos m=1 w=740.00n l=130.00n ng=1
MN3 clkpos clkneg VSS VSS sg13_lv_nmos m=1 w=740.00n l=130.00n ng=1
MN15 Q net1 VSS VSS sg13_lv_nmos m=1 w=740.00n l=130.00n ng=1
MN14 net1 net5 VSS VSS sg13_lv_nmos m=1 w=740.00n l=130.00n ng=1
MP11 net5 clkpos net3 VDD sg13_lv_pmos m=1 w=420.00n l=130.00n ng=1
MP12 net2 net5 VDD VDD sg13_lv_pmos m=1 w=420.00n l=130.00n ng=1
MP13 net2 RESET_B VDD VDD sg13_lv_pmos m=1 w=420.00n l=130.00n ng=1
MP4 Db clkpos net6 VDD sg13_lv_pmos m=1 w=420.00n l=130.00n ng=1
MP0 Db RESET_B VDD VDD sg13_lv_pmos m=1 w=420.00n l=130.00n ng=1
MP1 Db D VDD VDD sg13_lv_pmos m=1 w=420.00n l=130.00n ng=1
MP5 net7 net4 VDD VDD sg13_lv_pmos m=1 w=420.00n l=130.00n ng=1
MP6 net6 clkneg net7 VDD sg13_lv_pmos m=1 w=420.00n l=130.00n ng=1
MP7 net6 RESET_B VDD VDD sg13_lv_pmos m=1 w=420.00n l=130.00n ng=1
MP2 clkneg CLK VDD VDD sg13_lv_pmos m=1 w=1.12u l=130.00n ng=1
MP3 clkpos clkneg VDD VDD sg13_lv_pmos m=1 w=1.12u l=130.00n ng=1
MP8 net4 net6 VDD VDD sg13_lv_pmos m=1 w=1.000u l=130.00n ng=1
MP9 net4 clkneg net5 VDD sg13_lv_pmos m=1 w=1.000u l=130.00n ng=1
MP15 Q net1 VDD VDD sg13_lv_pmos m=1 w=1.12u l=130.00n ng=1
MP10 net3 net2 VDD VDD sg13_lv_pmos m=1 w=420.00n l=130.00n ng=1
MP14 net1 net5 VDD VDD sg13_lv_pmos m=1 w=1.12u l=130.00n ng=1
.ENDS

************************************************************************
* Library Name: sg13g2_stdcell
* Cell Name:    sg13g2_fill_1
* View Name:    schematic
************************************************************************

.SUBCKT sg13g2_fill_1 VDD VSS
*.PININFO VDD:B VSS:B
.ENDS

************************************************************************
* Library Name: sg13g2_stdcell
* Cell Name:    sg13g2_fill_2
* View Name:    schematic
************************************************************************

.SUBCKT sg13g2_fill_2 VDD VSS
*.PININFO VDD:B VSS:B
.ENDS

************************************************************************
* Library Name: sg13g2_stdcell
* Cell Name:    sg13g2_fill_4
* View Name:    schematic
************************************************************************

.SUBCKT sg13g2_fill_4 VDD VSS
*.PININFO VDD:B VSS:B
.ENDS

************************************************************************
* Library Name: sg13g2_stdcell
* Cell Name:    sg13g2_fill_8
* View Name:    schematic
************************************************************************

.SUBCKT sg13g2_fill_8 VDD VSS
*.PININFO VDD:B VSS:B
.ENDS

* NGSPICE file created from sar_ctrl.ext - technology: ihp-sg13g2

* NGSPICE file created from sar_ctrl.ext - technology: ihp-sg13g2

* NGSPICE file created from sar_ctrl.ext - technology: ihp-sg13g2

* NGSPICE file created from sar_ctrl.ext - technology: ihp-sg13g2

.subckt sar_ctrl_async_phys VDD VSS busy cmp_fire cmp_n cmp_p dac_code[0] dac_code[1] dac_code[2] dac_code[3] dac_code[4] dac_code[5] dac_code[6] dac_code[7] dac_code_n[0] dac_code_n[1] dac_code_n[2] dac_code_n[3] dac_code_n[4] dac_code_n[5] dac_code_n[6] dac_code_n[7] done hold_req result[0] result[1] result[2] result[3] result[4] result[5] result[6] result[7] rst_n sample track
XFILLER_7_7 VDD VSS sg13g2_decap_8
XFILLER_5_4 VDD VSS sg13g2_decap_8
X_131_ _142_/D _131_/A VDD VSS sg13g2_inv_1
X_062_ _062_/X _165_/A _164_/Q VDD VSS sg13g2_and2_1
XFILLER_0_35 VDD VSS sg13g2_decap_8
XFILLER_0_68 VDD VSS sg13g2_decap_8
XFILLER_9_22 VDD VSS sg13g2_decap_8
X_114_ _148_/D _147_/D VDD VSS sg13g2_inv_1
XFILLER_18_53 VDD VSS sg13g2_fill_2
XFILLER_18_42 VDD VSS sg13g2_decap_8
XFILLER_20_54 VDD VSS sg13g2_decap_8
XFILLER_6_89 VDD VSS sg13g2_decap_4
Xoutput20 dac_code[4] _119_/Y VDD VSS sg13g2_buf_1
Xoutput31 dac_code_n[7] _123_/Y VDD VSS sg13g2_buf_1
Xoutput42 sample _110_/Y VDD VSS sg13g2_buf_1
Xoutput7 bit_active[3] _082_/X VDD VSS sg13g2_buf_1
Xu_event_clock_delay.u_d0 u_event_clock_delay.u_d1/A _111_/A_N VDD VSS sg13g2_dlygate4sd3_1
XFILLER_11_0 VDD VSS sg13g2_fill_2
XFILLER_3_35 VDD VSS sg13g2_decap_8
X_130_ _131_/A _083_/A _081_/B _113_/Y _142_/Q VDD VSS sg13g2_a22oi_1
XFILLER_0_14 VDD VSS sg13g2_decap_8
X_061_ _156_/D _164_/D _061_/B VDD VSS sg13g2_nor2_1
X_113_ _113_/Y _165_/A _113_/B VDD VSS sg13g2_nand2_1
XFILLER_18_21 VDD VSS sg13g2_decap_8
XFILLER_20_99 VDD VSS sg13g2_fill_2
XFILLER_20_33 VDD VSS sg13g2_decap_8
XFILLER_6_35 VDD VSS sg13g2_decap_8
XFILLER_15_66 VDD VSS sg13g2_decap_8
Xoutput10 bit_active[6] _067_/X VDD VSS sg13g2_buf_1
Xoutput21 dac_code[5] _120_/Y VDD VSS sg13g2_buf_1
Xoutput32 done _148_/Q VDD VSS sg13g2_buf_1
Xoutput8 bit_active[4] _077_/X VDD VSS sg13g2_buf_1
Xu_event_clock_delay.u_d1 _112_/B u_event_clock_delay.u_d1/A VDD VSS sg13g2_dlygate4sd3_1
XFILLER_13_113 VDD VSS sg13g2_fill_1
XFILLER_3_14 VDD VSS sg13g2_decap_8
XFILLER_12_78 VDD VSS sg13g2_fill_2
XFILLER_12_45 VDD VSS sg13g2_fill_1
Xu_event_pending.u_q _111_/A_N _108_/Y u_event_pending.u_q/B VDD VSS sg13g2_nor2_1
X_060_ _061_/B _056_/Y _164_/Q _156_/Q VDD VSS sg13g2_a21oi_1
XFILLER_9_46 VDD VSS sg13g2_decap_4
X_112_ _112_/Y _164_/D _112_/B _112_/C _112_/D VDD VSS sg13g2_nor4_1
XFILLER_20_12 VDD VSS sg13g2_decap_8
XFILLER_6_14 VDD VSS sg13g2_decap_8
Xoutput11 bit_active[7] _062_/X VDD VSS sg13g2_buf_1
Xoutput22 dac_code[6] _121_/Y VDD VSS sg13g2_buf_1
Xoutput33 hold_req _165_/X VDD VSS sg13g2_buf_1
Xoutput9 bit_active[5] _072_/X VDD VSS sg13g2_buf_1
XFILLER_15_45 VDD VSS sg13g2_decap_8
XFILLER_15_34 VDD VSS sg13g2_fill_2
XFILLER_15_23 VDD VSS sg13g2_decap_8
XFILLER_11_2 VDD VSS sg13g2_fill_1
XFILLER_0_49 VDD VSS sg13g2_decap_8
Xu_settle_latch.u_q _111_/B _109_/Y u_settle_latch.u_q/B VDD VSS sg13g2_nor2_1
X_111_ _112_/D _111_/A_N _111_/B VDD VSS sg13g2_nand2b_1
XFILLER_20_68 VDD VSS sg13g2_decap_4
XFILLER_20_7 VDD VSS sg13g2_fill_1
Xoutput12 busy _122_/A VDD VSS sg13g2_buf_1
Xoutput23 dac_code[7] _122_/Y VDD VSS sg13g2_buf_1
Xoutput34 result[0] _139_/Q VDD VSS sg13g2_buf_1
XFILLER_0_28 VDD VSS sg13g2_decap_8
XFILLER_18_35 VDD VSS sg13g2_decap_8
X_110_ _110_/Y _165_/A _110_/B VDD VSS sg13g2_nor2_1
XFILLER_20_47 VDD VSS sg13g2_decap_8
XFILLER_6_49 VDD VSS sg13g2_fill_2
Xoutput13 cmp_fault _097_/Y VDD VSS sg13g2_buf_1
Xoutput24 dac_code_n[0] _094_/Y VDD VSS sg13g2_buf_1
Xoutput35 result[1] _140_/Q VDD VSS sg13g2_buf_1
XFILLER_3_28 VDD VSS sg13g2_decap_8
XFILLER_18_14 VDD VSS sg13g2_decap_8
XFILLER_20_26 VDD VSS sg13g2_decap_8
Xu_interbit_delay.u_d0 u_interbit_delay.u_d1/A _112_/B VDD VSS sg13g2_dlygate4sd3_1
XFILLER_6_28 VDD VSS sg13g2_decap_8
XFILLER_19_111 VDD VSS sg13g2_fill_2
XFILLER_15_59 VDD VSS sg13g2_decap_8
Xoutput14 cmp_fire _112_/Y VDD VSS sg13g2_buf_1
Xoutput25 dac_code_n[1] _089_/Y VDD VSS sg13g2_buf_1
Xoutput36 result[2] _141_/Q VDD VSS sg13g2_buf_1
XFILLER_12_38 VDD VSS sg13g2_fill_2
XFILLER_9_17 VDD VSS sg13g2_fill_1
XFILLER_3_7 VDD VSS sg13g2_decap_8
XFILLER_1_4 VDD VSS sg13g2_decap_8
X_099_ _112_/C _106_/B VDD VSS sg13g2_inv_1
XFILLER_1_51 VDD VSS sg13g2_fill_1
XFILLER_10_82 VDD VSS sg13g2_decap_4
Xu_interbit_delay.u_d1 u_interbit_delay.u_d2/A u_interbit_delay.u_d1/A VDD VSS sg13g2_dlygate4sd3_1
XFILLER_19_91 VDD VSS sg13g2_fill_1
XFILLER_15_16 VDD VSS sg13g2_decap_8
Xoutput15 cmp_valid _112_/C VDD VSS sg13g2_buf_1
Xoutput26 dac_code_n[2] _084_/Y VDD VSS sg13g2_buf_1
Xoutput37 result[3] _142_/Q VDD VSS sg13g2_buf_1
XFILLER_21_81 VDD VSS sg13g2_decap_8
XFILLER_8_111 VDD VSS sg13g2_fill_2
XFILLER_12_28 VDD VSS sg13g2_fill_1
XFILLER_9_29 VDD VSS sg13g2_fill_1
Xfanout50 _165_/A _147_/Q VDD VSS sg13g2_buf_1
Xu_decision_hold.u_qn u_decision_hold.u_q/B _101_/Y _056_/A VDD VSS sg13g2_nor2_1
XFILLER_18_49 VDD VSS sg13g2_decap_4
X_098_ _106_/B _101_/A _098_/B VDD VSS sg13g2_and2_1
Xu_interbit_delay.u_d2 _103_/A u_interbit_delay.u_d2/A VDD VSS sg13g2_dlygate4sd3_1
XFILLER_19_113 VDD VSS sg13g2_fill_1
XFILLER_18_0 VDD VSS sg13g2_decap_8
Xoutput16 dac_code[0] _115_/Y VDD VSS sg13g2_buf_1
Xoutput27 dac_code_n[3] _079_/Y VDD VSS sg13g2_buf_1
Xoutput38 result[4] _143_/Q VDD VSS sg13g2_buf_1
XFILLER_7_40 VDD VSS sg13g2_decap_8
Xfanout51 fanout51/X _109_/A VDD VSS sg13g2_buf_1
XFILLER_18_28 VDD VSS sg13g2_decap_8
X_097_ _097_/Y _101_/A _098_/B VDD VSS sg13g2_nor2_1
XFILLER_10_40 VDD VSS sg13g2_decap_8
X_149_ _149_/Q _112_/B _149_/D _108_/B1 VDD VSS sg13g2_dfrbpq_1
Xoutput17 dac_code[1] _116_/Y VDD VSS sg13g2_buf_1
Xoutput28 dac_code_n[4] _074_/Y VDD VSS sg13g2_buf_1
Xoutput39 result[5] _144_/Q VDD VSS sg13g2_buf_1
XFILLER_7_85 VDD VSS sg13g2_fill_1
XFILLER_16_50 VDD VSS sg13g2_fill_2
XFILLER_8_113 VDD VSS sg13g2_fill_1
Xfanout52 _109_/A input3/X VDD VSS sg13g2_buf_1
XFILLER_8_0 VDD VSS sg13g2_decap_8
X_165_ _165_/X _165_/A VDD VSS sg13g2_buf_1
X_096_ _149_/D _157_/D _096_/B VDD VSS sg13g2_nor2_1
XFILLER_1_32 VDD VSS sg13g2_decap_8
XFILLER_20_19 VDD VSS sg13g2_decap_8
X_148_ _148_/Q _112_/B _148_/D _109_/A VDD VSS sg13g2_dfrbpq_1
Xoutput18 dac_code[2] _117_/Y VDD VSS sg13g2_buf_1
Xoutput29 dac_code_n[5] _069_/Y VDD VSS sg13g2_buf_1
X_079_ _079_/Y _152_/Q _123_/B VDD VSS sg13g2_nand2b_1
XFILLER_4_76 VDD VSS sg13g2_decap_4
XFILLER_4_21 VDD VSS sg13g2_decap_8
Xfanout53 _108_/B1 input3/X VDD VSS sg13g2_buf_1
X_164_ _164_/Q _112_/B _164_/D _108_/B1 VDD VSS sg13g2_dfrbpq_1
X_095_ _096_/B _056_/Y _157_/Q _094_/Y VDD VSS sg13g2_a21oi_1
XFILLER_1_11 VDD VSS sg13g2_decap_8
XFILLER_10_75 VDD VSS sg13g2_decap_8
X_147_ _147_/Q _112_/B _147_/D _109_/A VDD VSS sg13g2_dfrbpq_1
X_078_ _160_/D _113_/B _077_/X VDD VSS sg13g2_nor2b_1
Xoutput19 dac_code[3] _118_/Y VDD VSS sg13g2_buf_1
XFILLER_7_21 VDD VSS sg13g2_fill_1
XFILLER_16_0 VDD VSS sg13g2_fill_2
XFILLER_16_52 VDD VSS sg13g2_fill_1
Xfanout43 _147_/D _113_/Y VDD VSS sg13g2_buf_1
Xfanout54 fanout54/X input3/X VDD VSS sg13g2_buf_1
X_163_ _163_/Q _112_/B _163_/D _108_/B1 VDD VSS sg13g2_dfrbpq_1
X_094_ _094_/Y _149_/Q _123_/B VDD VSS sg13g2_nand2b_1
XFILLER_10_54 VDD VSS sg13g2_decap_4
XFILLER_10_65 VDD VSS sg13g2_decap_4
X_146_ _146_/Q _112_/B _146_/D fanout51/X VDD VSS sg13g2_dfrbpq_1
X_077_ _077_/X _077_/A _161_/Q VDD VSS sg13g2_and2_1
XFILLER_21_53 VDD VSS sg13g2_fill_1
XFILLER_21_42 VDD VSS sg13g2_decap_8
X_129_ _141_/D _129_/A VDD VSS sg13g2_inv_1
Xfanout44 _083_/A _113_/B VDD VSS sg13g2_buf_1
XFILLER_13_98 VDD VSS sg13g2_fill_1
X_162_ _162_/Q _112_/B _162_/D fanout54/X VDD VSS sg13g2_dfrbpq_1
X_093_ _157_/D _113_/B _092_/X VDD VSS sg13g2_nor2b_1
XFILLER_6_0 VDD VSS sg13g2_decap_8
XFILLER_1_46 VDD VSS sg13g2_fill_2
XFILLER_10_22 VDD VSS sg13g2_decap_8
Xinput1 _101_/A cmp_n VDD VSS sg13g2_buf_1
XFILLER_19_42 VDD VSS sg13g2_decap_8
X_145_ _145_/Q _112_/B _145_/D fanout51/X VDD VSS sg13g2_dfrbpq_1
X_076_ _153_/D _161_/D _076_/B VDD VSS sg13g2_nor2_1
XFILLER_21_21 VDD VSS sg13g2_decap_8
X_128_ _129_/A _083_/A _086_/B _147_/D _141_/Q VDD VSS sg13g2_a22oi_1
X_059_ _110_/B track VDD VSS sg13g2_inv_1
XFILLER_7_78 VDD VSS sg13g2_decap_8
XFILLER_16_43 VDD VSS sg13g2_decap_8
XFILLER_12_113 VDD VSS sg13g2_fill_1
XFILLER_21_0 VDD VSS sg13g2_decap_8
XFILLER_4_35 VDD VSS sg13g2_decap_8
Xfanout45 _113_/B _157_/Q VDD VSS sg13g2_buf_1
X_161_ _161_/Q _112_/B _161_/D fanout54/X VDD VSS sg13g2_dfrbpq_1
X_092_ _092_/X _122_/A _158_/Q VDD VSS sg13g2_and2_1
XFILLER_1_25 VDD VSS sg13g2_decap_8
Xinput2 _098_/B cmp_p VDD VSS sg13g2_buf_1
X_144_ _144_/Q _112_/B _144_/D fanout51/X VDD VSS sg13g2_dfrbpq_1
X_075_ _076_/B _056_/Y _161_/Q _074_/Y VDD VSS sg13g2_a21oi_1
XFILLER_19_21 VDD VSS sg13g2_decap_8
XFILLER_21_88 VDD VSS sg13g2_fill_2
X_127_ _140_/D _127_/A VDD VSS sg13g2_inv_1
X_058_ _058_/Y _112_/B VDD VSS sg13g2_inv_1
XFILLER_16_22 VDD VSS sg13g2_decap_8
XFILLER_4_14 VDD VSS sg13g2_decap_8
XFILLER_4_69 VDD VSS sg13g2_decap_8
Xfanout46 _123_/B _077_/A VDD VSS sg13g2_buf_1
X_160_ _160_/Q _112_/B _160_/D _108_/B1 VDD VSS sg13g2_dfrbpq_1
X_091_ _150_/D _158_/D _091_/B VDD VSS sg13g2_nor2_1
Xinput3 input3/X rst_n VDD VSS sg13g2_buf_1
X_143_ _143_/Q _112_/B _143_/D fanout51/X VDD VSS sg13g2_dfrbpq_1
X_074_ _074_/Y _153_/Q _123_/B VDD VSS sg13g2_nand2b_1
XFILLER_18_7 VDD VSS sg13g2_decap_8
X_126_ _127_/A _083_/A _091_/B _147_/D _140_/Q VDD VSS sg13g2_a22oi_1
X_057_ _164_/D _165_/A VDD VSS sg13g2_inv_1
XFILLER_7_47 VDD VSS sg13g2_decap_4
XFILLER_7_14 VDD VSS sg13g2_decap_8
XFILLER_16_67 VDD VSS sg13g2_decap_8
X_109_ _109_/Y _109_/A _109_/B VDD VSS sg13g2_nand2_1
Xfanout47 _119_/A _077_/A VDD VSS sg13g2_buf_1
XFILLER_5_80 VDD VSS sg13g2_decap_8
X_090_ _091_/B _056_/Y _158_/Q _089_/Y VDD VSS sg13g2_a21oi_1
XFILLER_10_47 VDD VSS sg13g2_decap_8
XFILLER_10_58 VDD VSS sg13g2_fill_2
XFILLER_10_69 VDD VSS sg13g2_fill_2
X_142_ _142_/Q _112_/B _142_/D fanout51/X VDD VSS sg13g2_dfrbpq_1
XFILLER_19_89 VDD VSS sg13g2_fill_2
XFILLER_19_56 VDD VSS sg13g2_fill_2
X_073_ _161_/D _113_/B _072_/X VDD VSS sg13g2_nor2b_1
XFILLER_4_0 VDD VSS sg13g2_decap_8
XFILLER_21_35 VDD VSS sg13g2_decap_8
X_125_ _139_/D _125_/A VDD VSS sg13g2_inv_1
X_056_ _056_/Y _056_/A VDD VSS sg13g2_inv_1
XFILLER_16_79 VDD VSS sg13g2_fill_1
X_108_ _108_/Y _058_/Y _107_/Y _108_/B1 VDD VSS sg13g2_o21ai_1
Xfanout48 _077_/A _147_/Q VDD VSS sg13g2_buf_1
XFILLER_8_7 VDD VSS sg13g2_decap_8
Xu_event_pending.u_qn u_event_pending.u_q/B _107_/Y _111_/A_N VDD VSS sg13g2_nor2_1
XFILLER_1_39 VDD VSS sg13g2_decap_8
XFILLER_10_15 VDD VSS sg13g2_decap_8
XFILLER_19_35 VDD VSS sg13g2_decap_8
X_141_ _141_/Q _112_/B _141_/D fanout51/X VDD VSS sg13g2_dfrbpq_1
X_072_ _072_/X _162_/Q _165_/A VDD VSS sg13g2_and2_1
X_124_ _125_/A _083_/A _096_/B _147_/D _139_/Q VDD VSS sg13g2_a22oi_1
XFILLER_21_14 VDD VSS sg13g2_decap_8
XFILLER_16_36 VDD VSS sg13g2_decap_8
X_107_ _107_/Y _106_/B _101_/B _106_/Y VDD VSS sg13g2_o21ai_1
XFILLER_4_28 VDD VSS sg13g2_decap_8
Xfanout49 _122_/A _147_/Q VDD VSS sg13g2_buf_1
XFILLER_12_0 VDD VSS sg13g2_fill_2
XFILLER_13_37 VDD VSS sg13g2_fill_2
XFILLER_1_18 VDD VSS sg13g2_decap_8
XFILLER_19_14 VDD VSS sg13g2_decap_8
X_140_ _140_/Q _112_/B _140_/D fanout51/X VDD VSS sg13g2_dfrbpq_1
X_071_ _154_/D _162_/D _071_/B VDD VSS sg13g2_nor2_1
XFILLER_18_112 VDD VSS sg13g2_fill_2
X_123_ _123_/Y _156_/Q _123_/B VDD VSS sg13g2_nand2b_1
XFILLER_16_15 VDD VSS sg13g2_decap_8
X_106_ _106_/Y _106_/A _106_/B _106_/C VDD VSS sg13g2_nand3_1
XFILLER_8_71 VDD VSS sg13g2_fill_1
XFILLER_14_4 VDD VSS sg13g2_decap_4
X_070_ _071_/B _056_/Y _162_/Q _069_/Y VDD VSS sg13g2_a21oi_1
XFILLER_21_49 VDD VSS sg13g2_decap_4
X_122_ _122_/Y _122_/A _156_/Q VDD VSS sg13g2_nand2_1
XFILLER_2_0 VDD VSS sg13g2_decap_8
XFILLER_11_93 VDD VSS sg13g2_decap_4
X_105_ _106_/C track _105_/B VDD VSS sg13g2_nor2_1
XFILLER_8_61 VDD VSS sg13g2_fill_2
XFILLER_8_50 VDD VSS sg13g2_decap_8
XFILLER_22_81 VDD VSS sg13g2_decap_8
XFILLER_5_73 VDD VSS sg13g2_decap_8
XFILLER_6_7 VDD VSS sg13g2_decap_8
XFILLER_14_60 VDD VSS sg13g2_decap_4
XFILLER_10_29 VDD VSS sg13g2_decap_8
XFILLER_19_49 VDD VSS sg13g2_decap_8
XFILLER_21_28 VDD VSS sg13g2_decap_8
XFILLER_11_72 VDD VSS sg13g2_decap_8
X_121_ _121_/Y _122_/A _155_/Q VDD VSS sg13g2_nand2_1
X_104_ _104_/Y _103_/X _109_/A _165_/A VDD VSS sg13g2_nand3b_1
XFILLER_7_113 VDD VSS sg13g2_fill_1
XFILLER_22_60 VDD VSS sg13g2_decap_8
XFILLER_21_7 VDD VSS sg13g2_decap_8
XFILLER_10_0 VDD VSS sg13g2_decap_8
XFILLER_19_28 VDD VSS sg13g2_decap_8
X_120_ _120_/Y _123_/B _154_/Q VDD VSS sg13g2_nand2_1
XFILLER_16_29 VDD VSS sg13g2_decap_8
X_103_ _103_/X _103_/A _109_/B VDD VSS sg13g2_and2_1
XFILLER_5_64 VDD VSS sg13g2_fill_2
XFILLER_5_53 VDD VSS sg13g2_decap_8
XFILLER_2_21 VDD VSS sg13g2_decap_8
XFILLER_11_30 VDD VSS sg13g2_fill_2
XFILLER_0_0 VDD VSS sg13g2_decap_8
X_102_ _109_/B _164_/D _112_/B VDD VSS sg13g2_nor2_1
XFILLER_5_32 VDD VSS sg13g2_decap_8
XFILLER_4_7 VDD VSS sg13g2_decap_8
XFILLER_11_97 VDD VSS sg13g2_fill_1
XFILLER_11_86 VDD VSS sg13g2_decap_8
X_101_ _101_/Y _101_/A _101_/B VDD VSS sg13g2_nor2_1
XFILLER_22_74 VDD VSS sg13g2_decap_8
XFILLER_8_21 VDD VSS sg13g2_decap_4
Xu_decision_hold.u_q _056_/A _104_/Y u_decision_hold.u_q/B VDD VSS sg13g2_nor2_1
XFILLER_5_11 VDD VSS sg13g2_decap_8
XFILLER_14_64 VDD VSS sg13g2_fill_2
XFILLER_14_53 VDD VSS sg13g2_decap_8
XFILLER_11_32 VDD VSS sg13g2_fill_1
X_100_ _101_/B _101_/A _098_/B _165_/A VDD VSS sg13g2_o21ai_1
XFILLER_22_53 VDD VSS sg13g2_decap_8
XFILLER_8_77 VDD VSS sg13g2_fill_2
XFILLER_19_0 VDD VSS sg13g2_decap_8
XFILLER_14_76 VDD VSS sg13g2_fill_2
XFILLER_2_35 VDD VSS sg13g2_fill_2
XFILLER_8_67 VDD VSS sg13g2_decap_4
XFILLER_22_32 VDD VSS sg13g2_decap_8
X_159_ _159_/Q _112_/B _159_/D _109_/A VDD VSS sg13g2_dfrbpq_1
XFILLER_17_32 VDD VSS sg13g2_decap_8
XFILLER_5_46 VDD VSS sg13g2_decap_8
XFILLER_9_0 VDD VSS sg13g2_decap_8
XFILLER_2_14 VDD VSS sg13g2_decap_8
XFILLER_11_23 VDD VSS sg13g2_decap_8
XFILLER_2_7 VDD VSS sg13g2_decap_8
XFILLER_22_88 VDD VSS sg13g2_fill_2
XFILLER_22_11 VDD VSS sg13g2_decap_8
X_158_ _158_/Q _112_/B _158_/D _109_/A VDD VSS sg13g2_dfrbpq_1
X_089_ _089_/Y _150_/Q _123_/B VDD VSS sg13g2_nand2b_1
XFILLER_8_57 VDD VSS sg13g2_decap_4
XFILLER_17_77 VDD VSS sg13g2_fill_2
XFILLER_17_11 VDD VSS sg13g2_decap_8
Xu_launch_width.u_d0 u_launch_width.u_d1/A _106_/A VDD VSS sg13g2_dlygate4sd3_1
XFILLER_5_25 VDD VSS sg13g2_decap_8
XFILLER_14_113 VDD VSS sg13g2_fill_1
XFILLER_11_79 VDD VSS sg13g2_decap_8
XFILLER_3_80 VDD VSS sg13g2_fill_1
XFILLER_22_67 VDD VSS sg13g2_decap_8
X_157_ _157_/Q _112_/B _157_/D _109_/A VDD VSS sg13g2_dfrbpq_1
X_088_ _158_/D _113_/B _087_/X VDD VSS sg13g2_nor2b_1
XFILLER_8_14 VDD VSS sg13g2_decap_8
Xu_launch_width.u_d1 u_launch_width.u_d2/A u_launch_width.u_d1/A VDD VSS sg13g2_dlygate4sd3_1
XFILLER_10_7 VDD VSS sg13g2_fill_2
XFILLER_14_46 VDD VSS sg13g2_decap_8
XFILLER_14_24 VDD VSS sg13g2_fill_2
XFILLER_17_111 VDD VSS sg13g2_fill_2
XFILLER_22_46 VDD VSS sg13g2_decap_8
X_156_ _156_/Q _112_/B _156_/D _108_/B1 VDD VSS sg13g2_dfrbpq_1
X_087_ _087_/X _122_/A _159_/Q VDD VSS sg13g2_and2_1
X_139_ _139_/Q _112_/B _139_/D fanout51/X VDD VSS sg13g2_dfrbpq_1
Xu_launch_width.u_d2 u_launch_width.u_d3/A u_launch_width.u_d2/A VDD VSS sg13g2_dlygate4sd3_1
XFILLER_2_28 VDD VSS sg13g2_decap_8
Xu_hold_delay.u_d0 u_hold_delay.u_d1/A _110_/B VDD VSS sg13g2_dlygate4sd3_1
XFILLER_7_0 VDD VSS sg13g2_decap_8
XFILLER_22_25 VDD VSS sg13g2_decap_8
XFILLER_0_7 VDD VSS sg13g2_decap_8
X_155_ _155_/Q _112_/B _155_/D _108_/B1 VDD VSS sg13g2_dfrbpq_1
X_086_ _151_/D _159_/D _086_/B VDD VSS sg13g2_nor2_1
XFILLER_12_80 VDD VSS sg13g2_fill_1
XFILLER_17_25 VDD VSS sg13g2_decap_8
X_138_ _146_/D _146_/Q _061_/B _148_/D VDD VSS sg13g2_mux2_1
X_069_ _069_/Y _154_/Q _077_/A VDD VSS sg13g2_nand2b_1
XFILLER_0_61 VDD VSS sg13g2_decap_8
Xu_launch_width.u_d3 _105_/B u_launch_width.u_d3/A VDD VSS sg13g2_dlygate4sd3_1
XFILLER_10_9 VDD VSS sg13g2_fill_1
XFILLER_5_39 VDD VSS sg13g2_decap_8
XFILLER_14_26 VDD VSS sg13g2_fill_1
Xu_settle_latch.u_qn u_settle_latch.u_q/B _103_/X _111_/B VDD VSS sg13g2_nor2_1
Xu_hold_delay.u_d1 u_hold_delay.u_d2/A u_hold_delay.u_d1/A VDD VSS sg13g2_dlygate4sd3_1
XFILLER_17_113 VDD VSS sg13g2_fill_1
XFILLER_15_91 VDD VSS sg13g2_fill_1
XFILLER_15_80 VDD VSS sg13g2_decap_8
XFILLER_11_16 VDD VSS sg13g2_fill_2
X_154_ _154_/Q _112_/B _154_/D fanout54/X VDD VSS sg13g2_dfrbpq_1
X_085_ _086_/B _056_/Y _159_/Q _084_/Y VDD VSS sg13g2_a21oi_1
X_137_ _145_/D _137_/A VDD VSS sg13g2_inv_1
X_068_ _162_/D _113_/B _067_/X VDD VSS sg13g2_nor2b_1
XFILLER_9_60 VDD VSS sg13g2_fill_2
XFILLER_5_18 VDD VSS sg13g2_decap_8
XFILLER_15_0 VDD VSS sg13g2_decap_8
Xu_hold_delay.u_d2 u_hold_delay.u_d3/A u_hold_delay.u_d2/A VDD VSS sg13g2_dlygate4sd3_1
X_153_ _153_/Q _112_/B _153_/D fanout54/X VDD VSS sg13g2_dfrbpq_1
X_084_ _084_/Y _151_/Q _123_/B VDD VSS sg13g2_nand2b_1
XFILLER_19_7 VDD VSS sg13g2_decap_8
X_136_ _137_/A _083_/A _066_/B _147_/D _145_/Q VDD VSS sg13g2_a22oi_1
X_067_ _067_/X _163_/Q _122_/A VDD VSS sg13g2_and2_1
XFILLER_17_4 VDD VSS sg13g2_decap_8
X_119_ _119_/Y _119_/A _153_/Q VDD VSS sg13g2_nand2_1
XFILLER_14_39 VDD VSS sg13g2_decap_8
XFILLER_14_17 VDD VSS sg13g2_decap_8
XFILLER_6_51 VDD VSS sg13g2_fill_1
Xu_hold_delay.u_d3 _106_/A u_hold_delay.u_d3/A VDD VSS sg13g2_dlygate4sd3_1
XFILLER_3_52 VDD VSS sg13g2_fill_1
XFILLER_22_39 VDD VSS sg13g2_decap_8
X_152_ _152_/Q _112_/B _152_/D _108_/B1 VDD VSS sg13g2_dfrbpq_1
X_083_ _159_/D _083_/A _082_/X VDD VSS sg13g2_nor2b_1
XFILLER_17_39 VDD VSS sg13g2_fill_1
XFILLER_0_42 VDD VSS sg13g2_decap_8
X_135_ _144_/D _135_/A VDD VSS sg13g2_inv_1
X_066_ _155_/D _163_/D _066_/B VDD VSS sg13g2_nor2_1
XFILLER_9_62 VDD VSS sg13g2_fill_1
X_118_ _118_/Y _123_/B _152_/Q VDD VSS sg13g2_nand2_1
XFILLER_18_82 VDD VSS sg13g2_fill_2
XFILLER_20_61 VDD VSS sg13g2_decap_8
XFILLER_20_0 VDD VSS sg13g2_decap_8
XFILLER_9_7 VDD VSS sg13g2_fill_1
XFILLER_3_42 VDD VSS sg13g2_decap_8
XFILLER_22_18 VDD VSS sg13g2_decap_8
X_151_ _151_/Q _112_/B _151_/D fanout54/X VDD VSS sg13g2_dfrbpq_1
X_082_ _082_/X _122_/A _160_/Q VDD VSS sg13g2_and2_1
XFILLER_12_40 VDD VSS sg13g2_fill_1
XFILLER_17_18 VDD VSS sg13g2_decap_8
XFILLER_0_21 VDD VSS sg13g2_decap_8
X_134_ _135_/A _083_/A _071_/B _147_/D _144_/Q VDD VSS sg13g2_a22oi_1
X_065_ _066_/B _056_/Y _163_/Q _064_/Y VDD VSS sg13g2_a21oi_1
X_117_ _117_/Y _119_/A _151_/Q VDD VSS sg13g2_nand2_1
XFILLER_22_4 VDD VSS sg13g2_decap_8
XFILLER_20_40 VDD VSS sg13g2_decap_8
XFILLER_6_42 VDD VSS sg13g2_decap_8
XFILLER_13_0 VDD VSS sg13g2_fill_1
Xoutput4 bit_active[0] _148_/D VDD VSS sg13g2_buf_1
XFILLER_15_73 VDD VSS sg13g2_decap_8
XFILLER_3_21 VDD VSS sg13g2_decap_8
X_150_ _150_/Q _112_/B _150_/D fanout54/X VDD VSS sg13g2_dfrbpq_1
X_081_ _152_/D _160_/D _081_/B VDD VSS sg13g2_nor2_1
X_133_ _143_/D _133_/A VDD VSS sg13g2_inv_1
X_064_ _064_/Y _155_/Q _122_/A VDD VSS sg13g2_nand2b_1
XFILLER_9_53 VDD VSS sg13g2_decap_8
XFILLER_18_84 VDD VSS sg13g2_fill_1
X_116_ _116_/Y _119_/A _150_/Q VDD VSS sg13g2_nand2_1
XFILLER_6_21 VDD VSS sg13g2_decap_8
Xoutput40 result[6] _145_/Q VDD VSS sg13g2_buf_1
Xoutput5 bit_active[1] _092_/X VDD VSS sg13g2_buf_1
XFILLER_15_52 VDD VSS sg13g2_decap_8
XFILLER_15_30 VDD VSS sg13g2_decap_4
X_080_ _081_/B _056_/Y _160_/Q _079_/Y VDD VSS sg13g2_a21oi_1
X_132_ _133_/A _083_/A _076_/B _147_/D _143_/Q VDD VSS sg13g2_a22oi_1
X_063_ _163_/D _113_/B _062_/X VDD VSS sg13g2_nor2b_1
XFILLER_3_0 VDD VSS sg13g2_decap_8
XFILLER_0_56 VDD VSS sg13g2_fill_2
X_115_ _115_/Y _119_/A _149_/Q VDD VSS sg13g2_nand2_1
Xoutput30 dac_code_n[6] _064_/Y VDD VSS sg13g2_buf_1
Xoutput41 result[7] _146_/Q VDD VSS sg13g2_buf_1
Xoutput6 bit_active[2] _087_/X VDD VSS sg13g2_buf_1
.ends
* OA-SAR8 analog core reference netlist
.subckt cdac_array b7 b6 b5 b4 b3 b2 b1 b0 term topp
Cb7 topp b7 cap_cmim w=2.14u l=2.14u m=128
Cb6 topp b6 cap_cmim w=2.14u l=2.14u m=64
Cb5 topp b5 cap_cmim w=2.14u l=2.14u m=32
Cb4 topp b4 cap_cmim w=2.14u l=2.14u m=16
Cb3 topp b3 cap_cmim w=2.14u l=2.14u m=8
Cb2 topp b2 cap_cmim w=2.14u l=2.14u m=4
Cb1 topp b1 cap_cmim w=2.14u l=2.14u m=2
Cb0 topp b0 cap_cmim w=2.14u l=2.14u m=1
Cterm topp term cap_cmim w=2.14u l=2.14u m=1
.ends
.subckt sa_comp inp inn clk outp outn VDD VSS
M1 p inp tail VSS sg13_lv_nmos w=2.0u l=0.15u rfmode=1
M2 q inn tail VSS sg13_lv_nmos w=2.0u l=0.15u rfmode=1
M3 outn outp p VSS sg13_lv_nmos w=4.0u l=0.13u rfmode=1
M4 outp outn q VSS sg13_lv_nmos w=4.0u l=0.13u rfmode=1
MT tail clk VSS VSS sg13_lv_nmos w=3.0u l=0.3u rfmode=1
M5 outn outp VDD VDD sg13_lv_pmos w=6.0u l=0.13u rfmode=1
M6 outp outn VDD VDD sg13_lv_pmos w=6.0u l=0.13u rfmode=1
MS1 p clk VDD VDD sg13_lv_pmos w=2.0u l=0.13u rfmode=1
MS2 q clk VDD VDD sg13_lv_pmos w=2.0u l=0.13u rfmode=1
MS3 outn clk VDD VDD sg13_lv_pmos w=2.0u l=0.13u rfmode=1
MS4 outp clk VDD VDD sg13_lv_pmos w=2.0u l=0.13u rfmode=1
.ends
.subckt sw_bitcell bot vin ctl trk trkb VDD VSS
MND bot ctl VSS VSS sg13_lv_nmos w=2.0u l=0.13u rfmode=1
MPD bot ctl VDD VDD sg13_lv_pmos w=4.0u l=0.13u rfmode=1
MNT bot trk vin VSS sg13_lv_nmos w=2.0u l=0.13u rfmode=1
MPT bot trkb vin VDD sg13_lv_pmos w=4.0u l=0.13u rfmode=1
.ends
.subckt sw_bitcell11 bot vin ctl trkb gb VDD VSS VSSB
MND bot ctl VSS VSSB sg13_lv_nmos w=2.0u l=0.13u rfmode=1
MPD bot ctl VDD VDD sg13_lv_pmos w=4.0u l=0.13u rfmode=1
MNT bot gb vin VSSB sg13_lv_nmos w=2.0u l=0.13u rfmode=1
MPT bot trkb vin VDD sg13_lv_pmos w=4.0u l=0.13u rfmode=1
.ends
.subckt sw_bitcell10 bot vin ctl trkb gb VDD VSS
MND bot ctl VSS VSS sg13_lv_nmos w=2.0u l=0.13u rfmode=1
MPD bot ctl VDD VDD sg13_lv_pmos w=4.0u l=0.13u rfmode=1
MNT bot gb vin VSS sg13_lv_nmos w=2.0u l=0.13u rfmode=1
MPT bot trkb vin VDD sg13_lv_pmos w=4.0u l=0.13u rfmode=1
.ends
.subckt bstrap40 vin out ckb gb VDD VSS
Msw  out gb  vin VSS sg13_lv_nmos w=4.0u l=0.13u rfmode=1
MN_c gb  VDD x   VSS sg13_lv_nmos w=2.0u l=0.15u rfmode=1
MN_g x   ckb VSS VSS sg13_lv_nmos w=2.0u l=0.15u rfmode=1
MN_cb cb ckb VSS VSS sg13_lv_nmos w=2.0u l=0.15u rfmode=1
MP_ct ct gb  VDD ct  sg13_lv_pmos w=2.0u l=0.13u rfmode=1
MN_bt cb gb  vin VSS sg13_lv_nmos w=2.0u l=0.15u rfmode=1
MP_gt gb ckb ct  ct  sg13_lv_pmos w=2.0u l=0.13u rfmode=1
Cb   ct  cb  cap_cmim w=39.8u l=9.94u
.ends
.subckt sw_tg bot vin trk trkb VDD VSS
MNT bot trk vin VSS sg13_lv_nmos w=2.0u l=0.13u rfmode=1
MPT bot trkb vin VDD sg13_lv_pmos w=4.0u l=0.13u rfmode=1
.ends
.subckt oa_sar8_acore18_opt vinp vinn vcm clk_cmp trk hold ctl7 ctl6 ctl5 ctl4 ctl3 ctl2 ctl1 ctl0 outp outn VDD VSS ctl0n ctl1n ctl2n ctl3n ctl4n ctl5n ctl6n ctl7n
Xmain b7 b6 b5 b4 b3 b2 b1 b0 term topm cdac_array
Xrep b7r b6r b5r b4r b3r b2r b1r b0r termr topr cdac_array
Xcmp topr topm clk_cmp outp outn VDD VSS sa_comp
Xsw0 b7 vinr ctl7 trkb gb VDD vssgp VSS sw_bitcell_opt_b7
Xsw1 b6 vinr ctl6 trkb gb VDD vssgp VSS sw_bitcell_opt_b6
Xsw2 b5 vinr ctl5 trkb gb VDD vssgp VSS sw_bitcell_opt_b5
Xsw3 b4 vinr ctl4 trkb gb VDD vssgp VSS sw_bitcell_opt_b4
Xsw4 b3 vinr ctl3 trkb gb VDD vssgp VSS sw_bitcell_opt_b3
Xsw5 b2 vinr ctl2 trkb gb VDD vssgp VSS sw_bitcell_opt_b2
Xsw6 b1 vinr ctl1 trkb gb VDD vssgp VSS sw_bitcell_opt_b1
Xsw7 b0 vinr ctl0 trkb gb VDD vssgp VSS sw_bitcell_opt_b0
Xsw8 term vinr VDD trkb gb VDD vssgp VSS sw_bitcell_opt_term
Xsw9 trkb VSS trk trk trkb VDD VSS sw_bitcell
Xsw10 topm vcm trk trkb VDD VSS sw_tg_opt
MFP1 vssgp hold VSS VSS sg13_lv_nmos w=4.0u l=0.13u rfmode=1
MFP2 vssgp hold VSS VSS sg13_lv_nmos w=4.0u l=0.13u rfmode=1
MFN1 vssgn hold VSS VSS sg13_lv_nmos w=4.0u l=0.13u rfmode=1
MFN2 vssgn hold VSS VSS sg13_lv_nmos w=4.0u l=0.13u rfmode=1
Xboot vinp vinr trkb gb VDD VSS bstrap_opt_w2_c1200
Xbootn vinn vinnr trkb gbn VDD VSS bstrap_opt_w2_c1200
Xswr0 b7r vinnr ctl7n trkb gbn VDD vssgn VSS sw_bitcell_opt_b7
Xswr1 b6r vinnr ctl6n trkb gbn VDD vssgn VSS sw_bitcell_opt_b6
Xswr2 b5r vinnr ctl5n trkb gbn VDD vssgn VSS sw_bitcell_opt_b5
Xswr3 b4r vinnr ctl4n trkb gbn VDD vssgn VSS sw_bitcell_opt_b4
Xswr4 b3r vinnr ctl3n trkb gbn VDD vssgn VSS sw_bitcell_opt_b3
Xswr5 b2r vinnr ctl2n trkb gbn VDD vssgn VSS sw_bitcell_opt_b2
Xswr6 b1r vinnr ctl1n trkb gbn VDD vssgn VSS sw_bitcell_opt_b1
Xswr7 b0r vinnr ctl0n trkb gbn VDD vssgn VSS sw_bitcell_opt_b0
Xswr8 termr vinnr VDD trkb gbn VDD vssgn VSS sw_bitcell_opt_term
Xtgr topr vcm trk trkb VDD VSS sw_tg_opt
.ends

* bootstrapped sampling switch reference
.subckt bstrap_opt_w2_c1200 vin out ckb gb VDD VSS
Msw  out gb  vin VSS sg13_lv_nmos w=2.0u l=0.13u rfmode=1
MN_c gb  VDD x   VSS sg13_lv_nmos w=2.0u l=0.15u rfmode=1
MN_g x   ckb VSS VSS sg13_lv_nmos w=2.0u l=0.15u rfmode=1
MN_cb cb ckb VSS VSS sg13_lv_nmos w=2.0u l=0.15u rfmode=1
MP_ct ct gb  VDD ct  sg13_lv_pmos w=2.0u l=0.13u rfmode=1
MN_bt cb gb  vin VSS sg13_lv_nmos w=2.0u l=0.15u rfmode=1
MP_gt gb ckb ct  ct  sg13_lv_pmos w=2.0u l=0.13u rfmode=1
Cb0 ct cb cap_cmim w=39.8u l=9.94u
Cb1 ct cb cap_cmim w=39.8u l=9.94u
.ends

* parameterized plain transmission gate
.subckt sw_tg_opt bot vin trk trkb VDD VSS
MNT bot trk vin VSS sg13_lv_nmos w=2.0u l=0.13u rfmode=1
MPT bot trkb vin VDD sg13_lv_pmos w=4.0u l=0.13u rfmode=1
.ends

* parameterized bottom-plate driver + boosted-gate sampling switch
.subckt sw_bitcell_opt_term bot vin ctl trkb gb VDD VSS VSSB
MND bot ctl VSS VSSB sg13_lv_nmos w=3.0u l=0.13u rfmode=1
MPD bot ctl VDD VDD sg13_lv_pmos w=6.0u l=0.13u rfmode=1
MNT bot gb vin VSSB sg13_lv_nmos w=2.0u l=0.13u rfmode=1
MPT bot trkb vin VDD sg13_lv_pmos w=4.0u l=0.13u rfmode=1
.ends

* parameterized bottom-plate driver + boosted-gate sampling switch
.subckt sw_bitcell_opt_b0 bot vin ctl trkb gb VDD VSS VSSB
MND bot ctl VSS VSSB sg13_lv_nmos w=3.0u l=0.13u rfmode=1
MPD bot ctl VDD VDD sg13_lv_pmos w=6.0u l=0.13u rfmode=1
MNT bot gb vin VSSB sg13_lv_nmos w=2.0u l=0.13u rfmode=1
MPT bot trkb vin VDD sg13_lv_pmos w=4.0u l=0.13u rfmode=1
.ends

* parameterized bottom-plate driver + boosted-gate sampling switch
.subckt sw_bitcell_opt_b1 bot vin ctl trkb gb VDD VSS VSSB
MND bot ctl VSS VSSB sg13_lv_nmos w=3.4u l=0.13u rfmode=1
MPD bot ctl VDD VDD sg13_lv_pmos w=6.8u l=0.13u rfmode=1
MNT bot gb vin VSSB sg13_lv_nmos w=2.0u l=0.13u rfmode=1
MPT bot trkb vin VDD sg13_lv_pmos w=4.0u l=0.13u rfmode=1
.ends

* parameterized bottom-plate driver + boosted-gate sampling switch
.subckt sw_bitcell_opt_b2 bot vin ctl trkb gb VDD VSS VSSB
MND bot ctl VSS VSSB sg13_lv_nmos w=3.8u l=0.13u rfmode=1
MPD bot ctl VDD VDD sg13_lv_pmos w=7.6u l=0.13u rfmode=1
MNT bot gb vin VSSB sg13_lv_nmos w=2.0u l=0.13u rfmode=1
MPT bot trkb vin VDD sg13_lv_pmos w=4.0u l=0.13u rfmode=1
.ends

* parameterized bottom-plate driver + boosted-gate sampling switch
.subckt sw_bitcell_opt_b3 bot vin ctl trkb gb VDD VSS VSSB
MND bot ctl VSS VSSB sg13_lv_nmos w=4.2u l=0.13u rfmode=1
MPD bot ctl VDD VDD sg13_lv_pmos w=8.4u l=0.13u rfmode=1
MNT bot gb vin VSSB sg13_lv_nmos w=2.0u l=0.13u rfmode=1
MPT bot trkb vin VDD sg13_lv_pmos w=4.0u l=0.13u rfmode=1
.ends

* parameterized bottom-plate driver + boosted-gate sampling switch
.subckt sw_bitcell_opt_b4 bot vin ctl trkb gb VDD VSS VSSB
MND bot ctl VSS VSSB sg13_lv_nmos w=4.8u l=0.13u rfmode=1
MPD bot ctl VDD VDD sg13_lv_pmos w=9.6u l=0.13u rfmode=1
MNT bot gb vin VSSB sg13_lv_nmos w=2.0u l=0.13u rfmode=1
MPT bot trkb vin VDD sg13_lv_pmos w=4.0u l=0.13u rfmode=1
.ends

* parameterized bottom-plate driver + boosted-gate sampling switch
.subckt sw_bitcell_opt_b5 bot vin ctl trkb gb VDD VSS VSSB
MND bot ctl VSS VSSB sg13_lv_nmos w=5.4u l=0.13u rfmode=1
MPD bot ctl VDD VDD sg13_lv_pmos w=10.8u l=0.13u rfmode=1
MNT bot gb vin VSSB sg13_lv_nmos w=2.0u l=0.13u rfmode=1
MPT bot trkb vin VDD sg13_lv_pmos w=4.0u l=0.13u rfmode=1
.ends

* parameterized bottom-plate driver + boosted-gate sampling switch
.subckt sw_bitcell_opt_b6 bot vin ctl trkb gb VDD VSS VSSB
MND bot ctl VSS VSSB sg13_lv_nmos w=6.0u l=0.13u rfmode=1
MPD bot ctl VDD VDD sg13_lv_pmos w=12.0u l=0.13u rfmode=1
MNT bot gb vin VSSB sg13_lv_nmos w=2.0u l=0.13u rfmode=1
MPT bot trkb vin VDD sg13_lv_pmos w=4.0u l=0.13u rfmode=1
.ends

* parameterized bottom-plate driver + boosted-gate sampling switch
.subckt sw_bitcell_opt_b7 bot vin ctl trkb gb VDD VSS VSSB
MND bot ctl VSS VSSB sg13_lv_nmos w=6.8u l=0.13u rfmode=1
MPD bot ctl VDD VDD sg13_lv_pmos w=13.6u l=0.13u rfmode=1
MNT bot gb vin VSSB sg13_lv_nmos w=2.0u l=0.13u rfmode=1
MPT bot trkb vin VDD sg13_lv_pmos w=4.0u l=0.13u rfmode=1
.ends
.subckt oa_sar8_core18_final vinp vinn vcm VDD VSS track busy done rst_n result[0] result[1] result[2] result[3] result[4] result[5] result[6] result[7]
Xacore vinp vinn vcm clk_cmp trk hold ctl7 ctl6 ctl5 ctl4 ctl3 ctl2 ctl1 ctl0 outp outn VDD VSS ctl0n ctl1n ctl2n ctl3n ctl4n ctl5n ctl6n ctl7n oa_sar8_acore18_opt
Xlogic VDD VSS busy clk_cmp outn outp ctl0n ctl1n ctl2n ctl3n ctl4n ctl5n ctl6n ctl7n ctl0 ctl1 ctl2 ctl3 ctl4 ctl5 ctl6 ctl7 done hold result[0] result[1] result[2] result[3] result[4] result[5] result[6] result[7] rst_n trk track sar_ctrl_async_phys
.ends
