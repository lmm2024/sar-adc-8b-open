.include /foss/pdks/ihp-sg13g2/libs.ref/sg13g2_stdcell/cdl/sg13g2_stdcell.cdl
* NGSPICE file created from sar_ctrl.ext - technology: ihp-sg13g2

.subckt sar_ctrl VDD VSS busy clk cmp dac_code[0] dac_code[1] dac_code[2] dac_code[3] dac_code[4] dac_code[5] dac_code[6] dac_code[7] done result[0] result[1] result[2] result[3] result[4] result[5] result[6] result[7] rst_n sample start
XFILLER_7_7 VDD VSS sg13g2_decap_8
XFILLER_0_68 VDD VSS sg13g2_decap_4
XFILLER_23_31 VDD VSS sg13g2_decap_4
XFILLER_9_22 VDD VSS sg13g2_fill_2
X_131_ _131_/Y _183_/Q _184_/Q VDD VSS sg13g2_nor2b_1
XFILLER_22_7 VDD VSS sg13g2_decap_4
X_114_ _184_/D _187_/Q _149_/B _112_/Y VDD VSS sg13g2_a21oi_1
XFILLER_15_32 VDD VSS sg13g2_decap_8
XFILLER_3_46 VDD VSS sg13g2_fill_1
Xoutput7 dac_code[2] _167_/Q VDD VSS sg13g2_buf_1
Xoutput20 result[6] _181_/Q VDD VSS sg13g2_buf_1
XFILLER_12_66 VDD VSS sg13g2_decap_8
XFILLER_12_77 VDD VSS sg13g2_fill_1
X_130_ _166_/D _085_/Y _127_/Y _129_/Y VDD VSS sg13g2_o21ai_1
XFILLER_0_58 VDD VSS sg13g2_decap_4
X_113_ _149_/B _154_/B _154_/C VDD VSS sg13g2_xor2_1
XFILLER_15_11 VDD VSS sg13g2_decap_8
XFILLER_15_77 VDD VSS sg13g2_fill_1
XFILLER_20_11 VDD VSS sg13g2_decap_4
XFILLER_29_53 VDD VSS sg13g2_decap_8
Xoutput8 dac_code[3] _168_/Q VDD VSS sg13g2_buf_1
Xoutput21 result[7] _182_/Q VDD VSS sg13g2_buf_1
Xoutput10 dac_code[5] _170_/Q VDD VSS sg13g2_buf_1
XFILLER_0_37 VDD VSS sg13g2_decap_8
XFILLER_23_11 VDD VSS sg13g2_fill_1
X_189_ _190_/D _189_/CLK _189_/D fanout29/X VDD VSS sg13g2_dfrbpq_1
XFILLER_1_0 VDD VSS sg13g2_decap_8
XFILLER_20_34 VDD VSS sg13g2_decap_8
XFILLER_29_32 VDD VSS sg13g2_decap_8
XFILLER_6_25 VDD VSS sg13g2_fill_1
XFILLER_6_58 VDD VSS sg13g2_decap_8
X_112_ _112_/Y _154_/C _112_/B VDD VSS sg13g2_nor2_1
Xoutput9 dac_code[4] _169_/Q VDD VSS sg13g2_buf_1
Xoutput22 sample _173_/Q VDD VSS sg13g2_buf_1
Xoutput11 dac_code[6] _171_/Q VDD VSS sg13g2_buf_1
XFILLER_12_46 VDD VSS sg13g2_fill_2
XFILLER_0_16 VDD VSS sg13g2_decap_8
X_111_ _183_/D _187_/Q _154_/B _110_/Y VDD VSS sg13g2_a21oi_1
X_188_ _188_/Q _189_/CLK _188_/D fanout29/X VDD VSS sg13g2_dfrbpq_1
XFILLER_27_0 VDD VSS sg13g2_fill_1
XFILLER_29_11 VDD VSS sg13g2_decap_8
Xoutput12 dac_code[7] _172_/Q VDD VSS sg13g2_buf_1
XFILLER_29_4 VDD VSS sg13g2_decap_8
XFILLER_9_15 VDD VSS sg13g2_decap_8
X_187_ _187_/Q _189_/CLK _187_/D fanout29/X VDD VSS sg13g2_dfrbpq_1
XFILLER_29_67 VDD VSS sg13g2_decap_8
X_110_ _110_/Y _154_/B _112_/B VDD VSS sg13g2_nor2_1
Xclkload0 clkload0/Y _186_/CLK VDD VSS sg13g2_inv_1
XFILLER_13_7 VDD VSS sg13g2_decap_4
XFILLER_15_25 VDD VSS sg13g2_decap_8
Xoutput13 done _190_/Q VDD VSS sg13g2_buf_1
XFILLER_12_48 VDD VSS sg13g2_fill_1
XFILLER_23_69 VDD VSS sg13g2_decap_4
Xclkload1 clkload1/Y _190_/CLK VDD VSS sg13g2_inv_1
X_186_ _186_/Q _186_/CLK _186_/D fanout30/X VDD VSS sg13g2_dfrbpq_1
XFILLER_20_15 VDD VSS sg13g2_fill_2
XFILLER_29_46 VDD VSS sg13g2_decap_8
X_169_ _169_/Q _190_/CLK _169_/D fanout31/X VDD VSS sg13g2_dfrbpq_1
Xoutput14 result[0] _175_/Q VDD VSS sg13g2_buf_1
X_185_ _185_/Q _189_/CLK _185_/D fanout29/X VDD VSS sg13g2_dfrbpq_1
XFILLER_1_62 VDD VSS sg13g2_decap_8
XFILLER_20_27 VDD VSS sg13g2_decap_8
XFILLER_29_25 VDD VSS sg13g2_decap_8
X_099_ _189_/D _154_/A _116_/A VDD VSS sg13g2_nor2_1
X_168_ _168_/Q _181_/CLK _168_/D fanout31/X VDD VSS sg13g2_dfrbpq_1
Xoutput15 result[1] _176_/Q VDD VSS sg13g2_buf_1
XFILLER_12_39 VDD VSS sg13g2_decap_8
XFILLER_13_60 VDD VSS sg13g2_decap_8
X_184_ _184_/Q _189_/CLK _184_/D fanout30/X VDD VSS sg13g2_dfrbpq_1
XFILLER_10_72 VDD VSS sg13g2_fill_2
XFILLER_18_0 VDD VSS sg13g2_fill_1
XFILLER_19_70 VDD VSS sg13g2_fill_1
XFILLER_1_41 VDD VSS sg13g2_decap_8
X_098_ _116_/A _187_/Q _098_/B VDD VSS sg13g2_nand2_1
X_167_ _167_/Q _181_/CLK _167_/D fanout31/X VDD VSS sg13g2_dfrbpq_1
XFILLER_15_39 VDD VSS sg13g2_fill_1
Xoutput16 result[2] _177_/Q VDD VSS sg13g2_buf_1
Xclkbuf_0_clk clkbuf_0_clk/X clk VDD VSS sg13g2_buf_16
XFILLER_27_70 VDD VSS sg13g2_decap_4
X_097_ _115_/B _154_/A _187_/Q VDD VSS sg13g2_nor2b_1
X_183_ _183_/Q _189_/CLK _183_/D fanout30/X VDD VSS sg13g2_dfrbpq_1
X_166_ _166_/Q _181_/CLK _166_/D fanout31/X VDD VSS sg13g2_dfrbpq_1
XFILLER_10_40 VDD VSS sg13g2_fill_1
XFILLER_15_18 VDD VSS sg13g2_decap_8
Xoutput17 result[3] _178_/Q VDD VSS sg13g2_buf_1
X_149_ _150_/B _149_/A _149_/B _149_/C _149_/D VDD VSS sg13g2_nand4_1
XFILLER_16_50 VDD VSS sg13g2_fill_1
XFILLER_7_41 VDD VSS sg13g2_fill_1
XFILLER_7_52 VDD VSS sg13g2_fill_1
XFILLER_8_0 VDD VSS sg13g2_decap_8
Xfanout30 fanout30/X fanout33/X VDD VSS sg13g2_buf_1
Xclkbuf_2_0__f_clk _189_/CLK clkbuf_0_clk/X VDD VSS sg13g2_buf_16
X_182_ _182_/Q _190_/CLK _182_/D fanout32/X VDD VSS sg13g2_dfrbpq_1
XFILLER_1_76 VDD VSS sg13g2_fill_2
XFILLER_29_39 VDD VSS sg13g2_decap_8
X_096_ _187_/D _098_/B _115_/A _093_/Y VDD VSS sg13g2_a21oi_1
X_165_ _165_/Q _181_/CLK _165_/D fanout31/X VDD VSS sg13g2_dfrbpq_1
X_148_ _150_/A _127_/A _147_/Y _170_/Q VDD VSS sg13g2_o21ai_1
XFILLER_23_0 VDD VSS sg13g2_decap_8
Xoutput18 result[4] _179_/Q VDD VSS sg13g2_buf_1
XFILLER_1_55 VDD VSS sg13g2_decap_8
X_095_ _115_/A _188_/Q _154_/A VDD VSS sg13g2_nor2_1
Xfanout31 fanout31/X fanout33/X VDD VSS sg13g2_buf_1
X_181_ _181_/Q _181_/CLK _181_/D fanout32/X VDD VSS sg13g2_dfrbpq_1
X_164_ _177_/D _177_/Q _167_/Q _164_/S VDD VSS sg13g2_mux2_1
XFILLER_21_30 VDD VSS sg13g2_decap_8
XFILLER_25_4 VDD VSS sg13g2_decap_8
XFILLER_29_18 VDD VSS sg13g2_decap_8
Xoutput19 result[5] _180_/Q VDD VSS sg13g2_buf_1
X_147_ _147_/Y _183_/Q _138_/Y _126_/C VDD VSS sg13g2_a21oi_1
XFILLER_16_0 VDD VSS sg13g2_decap_8
XFILLER_16_41 VDD VSS sg13g2_decap_8
XFILLER_7_32 VDD VSS sg13g2_decap_8
XFILLER_13_53 VDD VSS sg13g2_decap_8
XFILLER_4_77 VDD VSS sg13g2_fill_1
Xfanout32 fanout32/X fanout33/X VDD VSS sg13g2_buf_1
X_180_ _180_/Q _190_/CLK _180_/D fanout31/X VDD VSS sg13g2_dfrbpq_1
XFILLER_10_32 VDD VSS sg13g2_fill_1
XFILLER_1_34 VDD VSS sg13g2_decap_8
X_094_ _098_/B _154_/B _154_/C VDD VSS sg13g2_nor2_1
X_163_ _176_/D _164_/S _085_/Y _162_/Y VDD VSS sg13g2_a21oi_1
X_129_ _129_/Y _129_/A _149_/B _149_/C _149_/D VDD VSS sg13g2_nand4_1
X_146_ _169_/D _124_/Y _140_/B _145_/Y VDD VSS sg13g2_o21ai_1
XFILLER_27_63 VDD VSS sg13g2_decap_8
XFILLER_13_32 VDD VSS sg13g2_decap_8
XFILLER_6_0 VDD VSS sg13g2_decap_4
X_093_ _093_/Y _188_/Q _187_/Q VDD VSS sg13g2_nor2_1
Xfanout33 fanout33/X input2/X VDD VSS sg13g2_buf_1
X_162_ _162_/Y _164_/S _176_/Q VDD VSS sg13g2_nor2_1
Xinput1 _128_/B cmp VDD VSS sg13g2_buf_1
X_145_ _145_/Y _127_/A _144_/Y _169_/Q VDD VSS sg13g2_o21ai_1
X_128_ _149_/D _154_/C _128_/B VDD VSS sg13g2_or2_1
XFILLER_13_11 VDD VSS sg13g2_fill_2
XFILLER_13_22 VDD VSS sg13g2_decap_4
XFILLER_27_42 VDD VSS sg13g2_decap_8
Xfanout23 _126_/A _164_/S VDD VSS sg13g2_buf_1
XFILLER_1_69 VDD VSS sg13g2_decap_8
X_092_ _186_/D _127_/A VDD VSS sg13g2_inv_1
Xinput2 input2/X rst_n VDD VSS sg13g2_buf_1
X_161_ _175_/D _175_/Q _165_/Q _164_/S VDD VSS sg13g2_mux2_1
XFILLER_21_44 VDD VSS sg13g2_decap_8
X_127_ _127_/Y _127_/A _127_/B _127_/C VDD VSS sg13g2_nor3_1
X_144_ _144_/Y _154_/A _098_/B _126_/C VDD VSS sg13g2_a21oi_1
XFILLER_14_0 VDD VSS sg13g2_decap_8
XFILLER_13_67 VDD VSS sg13g2_decap_8
Xfanout24 _164_/S _190_/D VDD VSS sg13g2_buf_1
XFILLER_10_68 VDD VSS sg13g2_decap_4
XFILLER_19_66 VDD VSS sg13g2_decap_4
XFILLER_1_48 VDD VSS sg13g2_decap_8
X_091_ _127_/A _164_/S _091_/B VDD VSS sg13g2_nand2b_1
Xinput3 _100_/B start VDD VSS sg13g2_buf_1
X_160_ _174_/D _164_/S _091_/B _157_/B _089_/Y VDD VSS sg13g2_a22oi_1
X_143_ _168_/D _086_/Y _137_/Y _142_/Y VDD VSS sg13g2_o21ai_1
XFILLER_16_34 VDD VSS sg13g2_decap_8
XFILLER_21_23 VDD VSS sg13g2_decap_8
XFILLER_7_25 VDD VSS sg13g2_decap_8
X_126_ _127_/C _126_/A _154_/B _126_/C VDD VSS sg13g2_nor3_1
XFILLER_13_46 VDD VSS sg13g2_decap_8
X_109_ _112_/B _098_/B _115_/B _093_/Y VDD VSS sg13g2_a21oi_1
Xfanout25 _154_/A _185_/Q VDD VSS sg13g2_buf_1
XFILLER_24_45 VDD VSS sg13g2_decap_4
X_090_ _091_/B _100_/B _186_/Q VDD VSS sg13g2_or2_1
Xclkbuf_2_1__f_clk _186_/CLK clkbuf_0_clk/X VDD VSS sg13g2_buf_16
XFILLER_4_0 VDD VSS sg13g2_fill_2
X_125_ _165_/D _117_/X _124_/Y _121_/Y VDD VSS sg13g2_o21ai_1
X_142_ _142_/Y _140_/Y _141_/Y _149_/C VDD VSS sg13g2_o21ai_1
XFILLER_27_56 VDD VSS sg13g2_decap_8
X_108_ _182_/D _126_/A _087_/Y _158_/A VDD VSS sg13g2_o21ai_1
XFILLER_5_70 VDD VSS sg13g2_decap_8
XFILLER_8_7 VDD VSS sg13g2_decap_8
Xfanout26 _149_/A _185_/Q VDD VSS sg13g2_buf_1
X_141_ _141_/Y _155_/A _141_/B VDD VSS sg13g2_nor2_1
XFILLER_16_14 VDD VSS sg13g2_fill_1
XFILLER_23_7 VDD VSS sg13g2_decap_4
X_124_ _124_/Y _149_/C _134_/C VDD VSS sg13g2_nand2_1
XFILLER_21_4 VDD VSS sg13g2_decap_8
XFILLER_27_35 VDD VSS sg13g2_decap_8
X_107_ _158_/A _164_/S _172_/Q VDD VSS sg13g2_nand2_1
Xfanout27 _154_/C _184_/Q VDD VSS sg13g2_buf_1
XFILLER_13_26 VDD VSS sg13g2_fill_1
XFILLER_10_38 VDD VSS sg13g2_fill_2
XFILLER_21_37 VDD VSS sg13g2_decap_8
XFILLER_2_72 VDD VSS sg13g2_fill_2
XFILLER_4_2 VDD VSS sg13g2_fill_1
X_140_ _140_/Y _183_/Q _140_/B VDD VSS sg13g2_nor2_1
XFILLER_16_48 VDD VSS sg13g2_fill_2
XFILLER_16_7 VDD VSS sg13g2_decap_8
XFILLER_7_39 VDD VSS sg13g2_fill_2
X_106_ _181_/D _181_/Q _171_/Q _126_/A VDD VSS sg13g2_mux2_1
X_123_ _134_/C _154_/B _128_/B VDD VSS sg13g2_or2_1
Xfanout28 _154_/B _183_/Q VDD VSS sg13g2_buf_1
XFILLER_19_59 VDD VSS sg13g2_decap_8
XFILLER_16_27 VDD VSS sg13g2_decap_8
XFILLER_21_16 VDD VSS sg13g2_decap_8
XFILLER_2_51 VDD VSS sg13g2_decap_8
XFILLER_7_18 VDD VSS sg13g2_decap_8
X_122_ _149_/C _126_/A _126_/C VDD VSS sg13g2_nor2_1
XFILLER_22_70 VDD VSS sg13g2_decap_8
X_105_ _180_/D _180_/Q _170_/Q _126_/A VDD VSS sg13g2_mux2_1
XFILLER_13_39 VDD VSS sg13g2_decap_8
XFILLER_24_38 VDD VSS sg13g2_decap_8
XFILLER_24_49 VDD VSS sg13g2_fill_2
XFILLER_5_40 VDD VSS sg13g2_decap_4
Xfanout29 fanout29/X fanout33/X VDD VSS sg13g2_buf_1
XFILLER_25_70 VDD VSS sg13g2_decap_8
X_104_ _179_/D _179_/Q _169_/Q _126_/A VDD VSS sg13g2_mux2_1
X_121_ _121_/Y _127_/A _127_/B _165_/Q VDD VSS sg13g2_o21ai_1
XFILLER_27_49 VDD VSS sg13g2_decap_8
XFILLER_10_0 VDD VSS sg13g2_fill_1
XFILLER_5_63 VDD VSS sg13g2_decap_8
X_120_ _127_/B _126_/C _117_/X VDD VSS sg13g2_nor2b_1
XFILLER_14_7 VDD VSS sg13g2_decap_4
XFILLER_27_28 VDD VSS sg13g2_decap_8
X_103_ _178_/D _126_/A _086_/Y _102_/Y VDD VSS sg13g2_a21oi_1
XFILLER_28_60 VDD VSS sg13g2_decap_8
XFILLER_2_65 VDD VSS sg13g2_decap_8
X_102_ _102_/Y _126_/A _178_/Q VDD VSS sg13g2_nor2_1
Xclkbuf_2_2__f_clk _181_/CLK clkbuf_0_clk/X VDD VSS sg13g2_buf_16
X_179_ _179_/Q _190_/CLK _179_/D fanout30/X VDD VSS sg13g2_dfrbpq_1
XFILLER_8_42 VDD VSS sg13g2_decap_8
XFILLER_14_30 VDD VSS sg13g2_decap_8
XFILLER_2_4 VDD VSS sg13g2_decap_4
XFILLER_2_44 VDD VSS sg13g2_decap_8
XFILLER_26_0 VDD VSS sg13g2_decap_8
XFILLER_8_21 VDD VSS sg13g2_decap_8
X_101_ _188_/D _157_/B VDD VSS sg13g2_inv_1
X_178_ _178_/Q _190_/CLK _178_/D fanout31/X VDD VSS sg13g2_dfrbpq_1
XFILLER_5_33 VDD VSS sg13g2_decap_8
XFILLER_5_77 VDD VSS sg13g2_fill_1
XFILLER_25_63 VDD VSS sg13g2_decap_8
XFILLER_11_43 VDD VSS sg13g2_fill_2
XFILLER_22_31 VDD VSS sg13g2_decap_8
XFILLER_28_4 VDD VSS sg13g2_decap_8
X_100_ _157_/B _186_/Q _100_/B VDD VSS sg13g2_nand2b_1
X_177_ _177_/Q _186_/CLK _177_/D fanout29/X VDD VSS sg13g2_dfrbpq_1
XFILLER_19_0 VDD VSS sg13g2_fill_2
XFILLER_28_74 VDD VSS sg13g2_decap_4
X_176_ _176_/Q _186_/CLK _176_/D fanout29/X VDD VSS sg13g2_dfrbpq_1
X_159_ _173_/D _188_/Q _091_/B _157_/B _088_/Y VDD VSS sg13g2_a22oi_1
XFILLER_17_32 VDD VSS sg13g2_decap_8
XFILLER_28_53 VDD VSS sg13g2_decap_8
XFILLER_14_11 VDD VSS sg13g2_fill_2
XFILLER_14_44 VDD VSS sg13g2_fill_2
XFILLER_2_58 VDD VSS sg13g2_decap_8
X_175_ _175_/Q _186_/CLK _175_/D fanout29/X VDD VSS sg13g2_dfrbpq_1
XFILLER_0_4 VDD VSS sg13g2_decap_8
XFILLER_22_77 VDD VSS sg13g2_fill_1
XFILLER_8_35 VDD VSS sg13g2_decap_8
X_089_ _089_/Y _174_/Q VDD VSS sg13g2_inv_1
X_158_ _172_/D _158_/A _158_/B _158_/C VDD VSS sg13g2_nand3_1
XFILLER_14_23 VDD VSS sg13g2_decap_8
XFILLER_24_0 VDD VSS sg13g2_decap_4
XFILLER_28_32 VDD VSS sg13g2_decap_8
XFILLER_25_77 VDD VSS sg13g2_fill_1
XFILLER_2_37 VDD VSS sg13g2_decap_8
XFILLER_2_8 VDD VSS sg13g2_fill_2
XFILLER_8_14 VDD VSS sg13g2_decap_8
X_088_ _088_/Y _173_/Q VDD VSS sg13g2_inv_1
X_174_ _174_/Q _186_/CLK _174_/D fanout30/X VDD VSS sg13g2_dfrbpq_1
X_157_ _158_/C _172_/Q _157_/B _157_/C VDD VSS sg13g2_nand3_1
XFILLER_28_11 VDD VSS sg13g2_decap_8
XFILLER_14_46 VDD VSS sg13g2_fill_1
X_190_ _190_/Q _190_/CLK _190_/D fanout32/X VDD VSS sg13g2_dfrbpq_1
X_173_ _173_/Q _189_/CLK _173_/D fanout29/X VDD VSS sg13g2_dfrbpq_1
XFILLER_22_24 VDD VSS sg13g2_decap_8
X_087_ _087_/Y _182_/Q VDD VSS sg13g2_inv_1
X_156_ _158_/B _188_/Q _155_/Y _186_/D VDD VSS sg13g2_o21ai_1
XFILLER_28_67 VDD VSS sg13g2_decap_8
Xclkbuf_2_3__f_clk _190_/CLK clkbuf_0_clk/X VDD VSS sg13g2_buf_16
X_139_ _140_/B _184_/Q _149_/A VDD VSS sg13g2_nand2b_1
XFILLER_7_0 VDD VSS sg13g2_decap_8
XFILLER_8_49 VDD VSS sg13g2_fill_2
X_086_ _086_/Y _168_/Q VDD VSS sg13g2_inv_1
X_172_ _172_/Q _186_/CLK _172_/D fanout30/X VDD VSS sg13g2_dfrbpq_1
X_155_ _155_/Y _155_/A _157_/C VDD VSS sg13g2_nor2_1
XFILLER_0_72 VDD VSS sg13g2_fill_2
XFILLER_28_46 VDD VSS sg13g2_decap_8
X_138_ _138_/Y _154_/C _149_/A VDD VSS sg13g2_nor2b_1
XFILLER_14_37 VDD VSS sg13g2_decap_8
XFILLER_22_0 VDD VSS sg13g2_decap_8
XFILLER_9_4 VDD VSS sg13g2_decap_8
X_171_ _171_/Q _181_/CLK _171_/D fanout32/X VDD VSS sg13g2_dfrbpq_1
XFILLER_26_7 VDD VSS sg13g2_decap_4
XFILLER_8_28 VDD VSS sg13g2_decap_8
X_085_ _085_/Y _166_/Q VDD VSS sg13g2_inv_1
X_154_ _157_/C _154_/A _154_/B _154_/C _186_/Q VDD VSS sg13g2_nand4_1
XFILLER_0_51 VDD VSS sg13g2_decap_8
XFILLER_0_62 VDD VSS sg13g2_fill_2
XFILLER_24_4 VDD VSS sg13g2_fill_1
XFILLER_28_25 VDD VSS sg13g2_decap_8
XFILLER_9_71 VDD VSS sg13g2_decap_8
X_137_ _137_/Y _119_/Y _141_/B _127_/A VDD VSS sg13g2_a21oi_1
XFILLER_14_16 VDD VSS sg13g2_decap_8
XFILLER_6_72 VDD VSS sg13g2_fill_2
XFILLER_22_16 VDD VSS sg13g2_fill_2
XFILLER_22_38 VDD VSS sg13g2_fill_2
X_170_ _170_/Q _181_/CLK _170_/D fanout31/X VDD VSS sg13g2_dfrbpq_1
XFILLER_0_30 VDD VSS sg13g2_decap_8
XFILLER_12_60 VDD VSS sg13g2_fill_2
XFILLER_17_4 VDD VSS sg13g2_fill_2
X_084_ _155_/A _128_/B VDD VSS sg13g2_inv_1
X_153_ _171_/D _129_/A _134_/Y _152_/Y VDD VSS sg13g2_o21ai_1
X_136_ _141_/B _149_/A _154_/B _154_/C VDD VSS sg13g2_nand3b_1
X_119_ _119_/Y _126_/C VDD VSS sg13g2_inv_1
XFILLER_6_51 VDD VSS sg13g2_decap_8
XFILLER_17_39 VDD VSS sg13g2_decap_8
XFILLER_5_0 VDD VSS sg13g2_fill_2
X_083_ _129_/A _154_/A VDD VSS sg13g2_inv_1
X_152_ _152_/Y _127_/A _151_/Y _171_/Q VDD VSS sg13g2_o21ai_1
XFILLER_18_71 VDD VSS sg13g2_fill_2
X_118_ _126_/C _188_/Q _186_/Q VDD VSS sg13g2_nand2b_1
X_135_ _167_/D _154_/A _134_/Y _133_/Y VDD VSS sg13g2_o21ai_1
XFILLER_20_0 VDD VSS sg13g2_decap_8
XFILLER_22_18 VDD VSS sg13g2_fill_1
XFILLER_3_42 VDD VSS sg13g2_decap_4
XFILLER_12_62 VDD VSS sg13g2_fill_1
XFILLER_12_73 VDD VSS sg13g2_decap_4
X_134_ _134_/Y _184_/Q _149_/C _134_/C VDD VSS sg13g2_nand3_1
X_151_ _151_/Y _149_/A _131_/Y _126_/C VDD VSS sg13g2_a21oi_1
XFILLER_28_39 VDD VSS sg13g2_decap_8
X_117_ _117_/X _154_/A _154_/C VDD VSS sg13g2_or2_1
XFILLER_13_0 VDD VSS sg13g2_decap_8
XFILLER_29_60 VDD VSS sg13g2_decap_8
Xoutput4 busy _174_/Q VDD VSS sg13g2_buf_1
X_150_ _170_/D _150_/A _150_/B VDD VSS sg13g2_nand2_1
XFILLER_0_11 VDD VSS sg13g2_fill_1
XFILLER_0_44 VDD VSS sg13g2_decap_8
XFILLER_18_73 VDD VSS sg13g2_fill_1
XFILLER_23_73 VDD VSS sg13g2_fill_1
XFILLER_28_18 VDD VSS sg13g2_decap_8
X_133_ _133_/Y _127_/A _132_/Y _167_/Q VDD VSS sg13g2_o21ai_1
XFILLER_15_4 VDD VSS sg13g2_decap_8
XFILLER_20_41 VDD VSS sg13g2_fill_2
XFILLER_6_65 VDD VSS sg13g2_decap_8
X_116_ _185_/D _116_/A _116_/B VDD VSS sg13g2_and2_1
Xoutput5 dac_code[0] _165_/Q VDD VSS sg13g2_buf_1
XFILLER_12_53 VDD VSS sg13g2_decap_8
X_132_ _132_/Y _129_/A _131_/Y _126_/C VDD VSS sg13g2_a21oi_1
XFILLER_0_23 VDD VSS sg13g2_decap_8
X_115_ _116_/B _115_/A _115_/B VDD VSS sg13g2_nor2_1
XFILLER_15_75 VDD VSS sg13g2_fill_2
Xoutput6 dac_code[1] _166_/Q VDD VSS sg13g2_buf_1
.ends

* OA-SAR8 analog core reference netlist
.subckt cdac_array b7 b6 b5 b4 b3 b2 b1 b0 term topp
Cb7 topp b7 cap_cmim w=2.14u l=2.14u m=128
Cb6 topp b6 cap_cmim w=2.14u l=2.14u m=64
Cb5 topp b5 cap_cmim w=2.14u l=2.14u m=32
Cb4 topp b4 cap_cmim w=2.14u l=2.14u m=16
Cb3 topp b3 cap_cmim w=2.14u l=2.14u m=8
Cb2 topp b2 cap_cmim w=2.14u l=2.14u m=4
Cb1 topp b1 cap_cmim w=2.14u l=2.14u m=2
Cb0 topp b0 cap_cmim w=2.14u l=2.14u m=1
Cterm topp term cap_cmim w=2.14u l=2.14u m=1
.ends
.subckt sa_comp inp inn clk outp outn VDD VSS
M1 p inp tail VSS sg13_lv_nmos w=2.0u l=0.15u rfmode=1
M2 q inn tail VSS sg13_lv_nmos w=2.0u l=0.15u rfmode=1
M3 outn outp p VSS sg13_lv_nmos w=4.0u l=0.13u rfmode=1
M4 outp outn q VSS sg13_lv_nmos w=4.0u l=0.13u rfmode=1
MT tail clk VSS VSS sg13_lv_nmos w=3.0u l=0.3u rfmode=1
M5 outn outp VDD VDD sg13_lv_pmos w=6.0u l=0.13u rfmode=1
M6 outp outn VDD VDD sg13_lv_pmos w=6.0u l=0.13u rfmode=1
MS1 p clk VDD VDD sg13_lv_pmos w=2.0u l=0.13u rfmode=1
MS2 q clk VDD VDD sg13_lv_pmos w=2.0u l=0.13u rfmode=1
MS3 outn clk VDD VDD sg13_lv_pmos w=2.0u l=0.13u rfmode=1
MS4 outp clk VDD VDD sg13_lv_pmos w=2.0u l=0.13u rfmode=1
.ends
.subckt sw_bitcell bot vin ctl trk trkb VDD VSS
MND bot ctl VSS VSS sg13_lv_nmos w=2.0u l=0.13u rfmode=1
MPD bot ctl VDD VDD sg13_lv_pmos w=4.0u l=0.13u rfmode=1
MNT bot trk vin VSS sg13_lv_nmos w=2.0u l=0.13u rfmode=1
MPT bot trkb vin VDD sg13_lv_pmos w=4.0u l=0.13u rfmode=1
.ends
.subckt sw_bitcell10 bot vin ctl trkb gb VDD VSS
MND bot ctl VSS VSS sg13_lv_nmos w=2.0u l=0.13u rfmode=1
MPD bot ctl VDD VDD sg13_lv_pmos w=4.0u l=0.13u rfmode=1
MNT bot gb vin VSS sg13_lv_nmos w=2.0u l=0.13u rfmode=1
MPT bot trkb vin VDD sg13_lv_pmos w=4.0u l=0.13u rfmode=1
.ends
.subckt bstrap vin out ckb gb VDD VSS
Msw  out gb  vin VSS sg13_lv_nmos w=4.0u l=0.13u rfmode=1
MN_c gb  VDD x   VSS sg13_lv_nmos w=2.0u l=0.15u rfmode=1
MN_g x   ckb VSS VSS sg13_lv_nmos w=2.0u l=0.15u rfmode=1
MN_cb cb ckb VSS VSS sg13_lv_nmos w=2.0u l=0.15u rfmode=1
MP_ct ct gb  VDD ct  sg13_lv_pmos w=2.0u l=0.13u rfmode=1
MN_bt cb gb  vin VSS sg13_lv_nmos w=2.0u l=0.15u rfmode=1
MP_gt gb ckb ct  ct  sg13_lv_pmos w=2.0u l=0.13u rfmode=1
Cb   ct  cb  cap_cmim w=9.94u l=9.94u
.ends
.subckt sw_tg bot vin trk trkb VDD VSS
MNT bot trk vin VSS sg13_lv_nmos w=2.0u l=0.13u rfmode=1
MPT bot trkb vin VDD sg13_lv_pmos w=4.0u l=0.13u rfmode=1
.ends
.subckt oa_sar8_acore7 vin vcm clk_cmp trk ctl7 ctl6 ctl5 ctl4 ctl3 ctl2 ctl1 ctl0 outp outn VDD VSS
Xmain b7 b6 b5 b4 b3 b2 b1 b0 term topm cdac_array
Xrep b7r b6r b5r b4r b3r b2r b1r b0r termr topr cdac_array
Xcmp topr topm clk_cmp outp outn VDD VSS sa_comp
Xsw0 b7 vinr ctl7 trkb gb VDD VSS sw_bitcell10
Xsw1 b6 vinr ctl6 trkb gb VDD VSS sw_bitcell10
Xsw2 b5 vinr ctl5 trkb gb VDD VSS sw_bitcell10
Xsw3 b4 vinr ctl4 trkb gb VDD VSS sw_bitcell10
Xsw4 b3 vinr ctl3 trkb gb VDD VSS sw_bitcell10
Xsw5 b2 vinr ctl2 trkb gb VDD VSS sw_bitcell10
Xsw6 b1 vinr ctl1 trkb gb VDD VSS sw_bitcell10
Xsw7 b0 vinr ctl0 trkb gb VDD VSS sw_bitcell10
Xsw8 term vinr VDD trkb gb VDD VSS sw_bitcell10
Xsw9 trkb VSS trk trk trkb VDD VSS sw_bitcell
Xsw10 topm vcm trk trkb VDD VSS sw_tg
Xboot vin vinr trkb gb VDD VSS bstrap
Xswr0 b7r vcm VSS VDD VSS VDD VSS sw_bitcell10
Xswr1 b6r vcm VDD VDD VSS VDD VSS sw_bitcell10
Xswr2 b5r vcm VDD VDD VSS VDD VSS sw_bitcell10
Xswr3 b4r vcm VDD VDD VSS VDD VSS sw_bitcell10
Xswr4 b3r vcm VDD VDD VSS VDD VSS sw_bitcell10
Xswr5 b2r vcm VDD VDD VSS VDD VSS sw_bitcell10
Xswr6 b1r vcm VDD VDD VSS VDD VSS sw_bitcell10
Xswr7 b0r vcm VDD VDD VSS VDD VSS sw_bitcell10
Xswr8 termr vcm VDD VDD VSS VDD VSS sw_bitcell10
Xtgr topr vcm trk trkb VDD VSS sw_tg
.ends

.subckt oa_sar8_core8 vin vcm outn VDD VSS busy done result[0] result[1] result[2] result[3] result[4] result[5] result[6] result[7] rst_n start
Xacore vin vcm clk_cmp trk ctl7 ctl6 ctl5 ctl4 ctl3 ctl2 ctl1 ctl0 outp outn VDD VSS oa_sar8_acore7
Xlogic VDD VSS busy clk_cmp outp ctl0 ctl1 ctl2 ctl3 ctl4 ctl5 ctl6 ctl7 done result[0] result[1] result[2] result[3] result[4] result[5] result[6] result[7] rst_n trk start sar_ctrl
.ends
