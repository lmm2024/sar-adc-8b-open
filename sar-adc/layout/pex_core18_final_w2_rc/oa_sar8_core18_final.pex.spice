* PEX produced on Sun Aug 30 07:07:01 AM CEST 2026 using /foss/tools/sak/sak-pex.sh with m=3 and s=1 (extresist threshold=10000 mOhm, minres=1000 mOhm, mindelay=1 ps)
* NGSPICE file created from oa_sar8_core18_final.ext - technology: ihp-sg13g2

.subckt oa_sar8_core18_final track rst_n result[0] result[1] result[2] result[3] result[4]
+ result[5] result[6] result[7] done busy vinp vinn vcm VDD VSS
X0 a_26364_45710# sar_ctrl_async_phys_0.sg13g2_and2_1$1_0.A VSS.t333 VSS.t332 sg13_lv_nmos ad=0.187p pd=1.78u as=0.14875p ps=1.16u w=0.55u l=0.13u
X1 oa_sar8_acore18_opt_0.sw_bitcell_opt_b3_1.bot.t0 sar_ctrl_async_phys_0.dac_code_n[3] oa_sar8_acore18_opt_0.sw_bitcell_opt_b7_1.VSS VSS.t1218 sg13_lv_nmos ad=0.4095p pd=2.49u as=0.735p ps=4.9u w=2.1u l=0.13u
X2 result[3] a_33464_31388# VDD.t4 VDD.t3 sg13_lv_pmos ad=0.42p pd=2.99u as=0.2114p ps=1.54u w=1.12u l=0.13u
X3 VSS.t135 sar_ctrl_async_phys_0.sg13g2_buf_1$1_41.X a_31540_45434# VSS.t134 sg13_lv_nmos ad=0.1626p pd=1.415u as=60.89999f ps=0.71u w=0.42u l=0.13u
X4 VSS.t29 sar_ctrl_async_phys_0.sg13g2_nor2_1$1_14.A a_28130_40838# VSS.t647 sg13_lv_nmos ad=0.1406p pd=1.12u as=0.1406p ps=1.12u w=0.74u l=0.15u
X5 VSS.t17 a_30848_32358# a_30497_32215# VSS.t16 sg13_lv_nmos ad=79.8f pd=0.8u as=0.1428p ps=1.52u w=0.42u l=0.13u
X6 a_31716_38912# sar_ctrl_async_phys_0.sg13g2_and2_1$1_0.X VDD.t86 VDD.t29 sg13_lv_pmos ad=0.2856p pd=2.36u as=0.2618p ps=1.63u w=0.84u l=0.13u
X7 a_26270_39215# a_26385_39214# VDD.t120 VDD.t29 sg13_lv_pmos ad=0.34p pd=2.68u as=0.2254p ps=1.53u w=1u l=0.5u
X8 oa_sar8_acore18_opt_0.sw_tg_opt_0.bot.t3 oa_sar8_acore18_opt_0.sw_bitcell_opt_b7_0.bot.t94 cap_cmim l=2.14u w=2.14u
X9 VSS.t208 a_26270_39215# sar_ctrl_async_phys_0.sg13g2_dlygate4sd3_1$1_7.A VSS.t103 sg13_lv_nmos ad=0.1426p pd=1.16u as=0.2516p ps=2.16u w=0.74u l=0.13u
X10 oa_sar8_acore18_opt_0.sw_tg_opt_1.bot.t3 oa_sar8_acore18_opt_0.sw_bitcell_opt_b3_1.bot.t5 cap_cmim l=2.14u w=2.14u
X11 a_31033_35971# a_30676_35928# VDD.t20 VDD.t19 sg13_lv_pmos ad=63f pd=0.72u as=0.1563p ps=1.22u w=0.42u l=0.13u
X12 VSS.t35 VDD.t156 VSS.t240 VSS.t881 sg13_lv_nmos ad=0.1428p pd=1.52u as=0 ps=0 w=0.42u l=1u
X13 a_27354_37436# sar_ctrl_async_phys_0.sg13g2_and2_1$1_3.A VDD.t145 VDD.t16 sg13_lv_pmos ad=0.1176p pd=1.33u as=0.4032p ps=2.96u w=1.12u l=0.13u
X14 a_35391_30703# a_34549_30605# a_34132_30944# VDD.t3 sg13_lv_pmos ad=0.2048p pd=1.63u as=0.34p ps=2.68u w=1u l=0.13u
X15 a_31093_39677# sar_ctrl_async_phys_0.sg13g2_dfrbpq_1$1_0.CLK.t18 VSS.t322 VSS.t528 sg13_lv_nmos ad=0.2516p pd=2.16u as=4.48835p ps=28.62u w=0.74u l=0.13u
X16 sar_ctrl_async_phys_0.cmp_p sar_ctrl_async_phys_0.cmp_n a_26184_21025# VSS.t96 sg13_lv_nmos ad=0.39p pd=2.39u as=0.7p ps=4.7u w=2u l=0.13u
X17 a_28950_39386# a_29755_38959# a_29210_38916# VDD.t29 sg13_lv_pmos ad=0.1428p pd=1.52u as=79.8f ps=0.8u w=0.42u l=0.13u
X18 a_25820_43020# sar_ctrl_async_phys_0.sg13g2_dlygate4sd3_1$1_5.A sar_ctrl_async_phys_0.sg13g2_nor2_1$1_12.Y VDD.t22 sg13_lv_pmos ad=0.1176p pd=1.33u as=0.3808p ps=2.92u w=1.12u l=0.13u
X19 oa_sar8_acore18_opt_0.sw_tg_opt_1.bot.t3 oa_sar8_acore18_opt_0.sw_bitcell_opt_b7_1.bot.t44 cap_cmim l=2.14u w=2.14u
X20 a_29306_32361# a_29749_32117# a_29689_32529# VDD.t76 sg13_lv_pmos ad=79.8f pd=0.8u as=63f ps=0.72u w=0.42u l=0.13u
X21 oa_sar8_acore18_opt_0.sw_tg_opt_0.bot.t3 oa_sar8_acore18_opt_0.sw_bitcell_opt_b4_0.bot.t14 cap_cmim l=2.14u w=2.14u
X22 a_33652_41528# a_33626_41433# VSS.t307 VSS.t1135 sg13_lv_nmos ad=0.2516p pd=2.16u as=0.1626p ps=1.415u w=0.74u l=0.13u
X23 VDD.t64 sar_ctrl_async_phys_0.sg13g2_buf_1$1_41.X a_30678_46946# VDD.t10 sg13_lv_pmos ad=0.36237p pd=2.605u as=79.8f ps=0.8u w=0.42u l=0.13u
X24 VSS.t15 sar_ctrl_async_phys_0.sg13g2_a22oi_1$1_0.A2 sar_ctrl_async_phys_0.sg13g2_nor2_1$1_2.Y VSS.t177 sg13_lv_nmos ad=0.2516p pd=2.16u as=0.1406p ps=1.12u w=0.74u l=0.13u
X25 oa_sar8_acore18_opt_0.sw_tg_opt_1.bot.t3 oa_sar8_acore18_opt_0.sw_bitcell_opt_b6_1.bot.t10 cap_cmim l=2.14u w=2.14u
X26 a_29594_43452# a_30037_43495# a_29977_43531# VDD.t22 sg13_lv_pmos ad=79.8f pd=0.8u as=63f ps=0.72u w=0.42u l=0.13u
X27 a_33289_37559# a_32347_37447# a_33087_37797# VDD.t16 sg13_lv_pmos ad=93.45f pd=0.865u as=0.2048p ps=1.63u w=0.42u l=0.13u
X28 VSS.t309 sar_ctrl_async_phys_0.sg13g2_buf_1$1_6.X a_35814_31813# VSS.t1307 sg13_lv_nmos ad=0.1701p pd=1.65u as=37.8f ps=0.6u w=0.42u l=0.13u
X29 a_33248_35382# a_32991_35239# a_33410_35162# VSS.t1233 sg13_lv_nmos ad=0.1428p pd=1.52u as=37.8f ps=0.6u w=0.42u l=0.13u
X30 oa_sar8_acore18_opt_0.bstrap_opt_w2_c1200_1.out oa_sar8_acore18_opt_0.bstrap_opt_w2_c1200_1.gb oa_sar8_acore18_opt_0.sw_bitcell_opt_b2_1.bot.t0 VSS.t158 sg13_lv_nmos ad=0.35p pd=2.7u as=0.195p ps=1.39u w=1u l=0.13u
X31 VSS.t126 VDD.t132 VSS.t126 VSS.t41 sg13_lv_nmos ad=0.1428p pd=1.52u as=0 ps=0 w=0.42u l=1u
X32 oa_sar8_acore18_opt_0.sw_tg_opt_0.bot.t3 oa_sar8_acore18_opt_0.sw_bitcell_opt_b6_0.bot.t14 cap_cmim l=2.14u w=2.14u
X33 oa_sar8_acore18_opt_0.sw_bitcell_opt_b7_0.bot.t1 sar_ctrl_async_phys_0.dac_code[7] oa_sar8_acore18_opt_0.sw_bitcell_opt_term_0.VSS VSS.t49 sg13_lv_nmos ad=0.663p pd=3.79u as=1.19p ps=7.5u w=3.4u l=0.13u
X34 oa_sar8_acore18_opt_0.sw_tg_opt_1.bot.t3 oa_sar8_acore18_opt_0.sw_bitcell_opt_b6_1.bot.t42 cap_cmim l=2.14u w=2.14u
X35 VDD.t328 sar_ctrl_async_phys_0.sg13g2_and2_1$1_3.X sar_ctrl_async_phys_0.sg13g2_nand3_1$1_0.Y VDD.t317 sg13_lv_pmos ad=0.2128p pd=1.5u as=0.2128p ps=1.5u w=1.12u l=0.13u
X36 sar_ctrl_async_phys_0.sg13g2_nor2_1$1_18.A sar_ctrl_async_phys_0.sg13g2_nor2b_1$1_0.A VSS.t107 VSS.t233 sg13_lv_nmos ad=0.1406p pd=1.12u as=0.2516p ps=2.16u w=0.74u l=0.13u
X37 a_34358_34837# sar_ctrl_async_phys_0.sg13g2_dfrbpq_1$1_0.RESET_B VSS.t270 VSS.t1209 sg13_lv_nmos ad=37.8f pd=0.6u as=0.1701p ps=1.65u w=0.42u l=0.13u
X38 oa_sar8_acore18_opt_0.sw_tg_opt_1.bot.t3 oa_sar8_acore18_opt_0.sw_bitcell_opt_b7_1.bot.t121 cap_cmim l=2.14u w=2.14u
X39 oa_sar8_acore18_opt_0.sw_bitcell_opt_term_0.gb.t0 VDD.t1081 a_35028_n9612# VSS.t1130 sg13_lv_nmos ad=0.19p pd=1.38u as=0.345p ps=2.69u w=1u l=0.15u
X40 a_35648_33142# a_35391_33261# a_35810_33338# VSS.t607 sg13_lv_nmos ad=0.1428p pd=1.52u as=37.8f ps=0.6u w=0.42u l=0.13u
X41 VSS.t48 a_31328_33870# a_30977_33727# VSS.t176 sg13_lv_nmos ad=79.8f pd=0.8u as=0.1428p ps=1.52u w=0.42u l=0.13u
X42 VDD.t11 VSS.t40 VDD.t11 VDD.t10 sg13_lv_pmos ad=0.19p pd=1.38u as=0 ps=0 w=1u l=1u
X43 a_31348_44247# a_31579_44356# a_31034_44457# VSS.t4 sg13_lv_nmos ad=0.2373p pd=1.97u as=79.8f ps=0.8u w=0.42u l=0.13u
X44 a_30676_40016# a_30650_39921# VSS.t243 VSS.t724 sg13_lv_nmos ad=0.2516p pd=2.16u as=0.1626p ps=1.415u w=0.74u l=0.13u
X45 oa_sar8_acore18_opt_0.sw_tg_opt_1.bot.t3 oa_sar8_acore18_opt_0.sw_bitcell_opt_b4_1.bot.t18 cap_cmim l=2.14u w=2.14u
X46 a_30650_35892# a_31093_35935# a_31033_35971# VDD.t19 sg13_lv_pmos ad=79.8f pd=0.8u as=63f ps=0.72u w=0.42u l=0.13u
X47 oa_sar8_acore18_opt_0.sw_tg_opt_0.bot.t3 oa_sar8_acore18_opt_0.sw_bitcell_opt_b7_0.bot.t57 cap_cmim l=2.14u w=2.14u
X48 sar_ctrl_async_phys_0.sg13g2_a22oi_1$1_4.A2 sar_ctrl_async_phys_0.sg13g2_buf_1$1_42.A VSS.t99 VSS.t1185 sg13_lv_nmos ad=0.1406p pd=1.12u as=0.2516p ps=2.16u w=0.74u l=0.13u
X49 oa_sar8_acore18_opt_0.sw_tg_opt_1.bot.t3 oa_sar8_acore18_opt_0.sw_bitcell_opt_b5_1.bot.t15 cap_cmim l=2.14u w=2.14u
X50 VDD.t969 sar_ctrl_async_phys_0.dac_code[0] oa_sar8_acore18_opt_0.sw_bitcell_opt_b0_0.bot.t3 VDD.t968 sg13_lv_pmos ad=1.05p pd=6.7u as=0.585p ps=3.39u w=3u l=0.13u
X51 a_31060_44552# a_31579_44356# a_32319_44311# VSS.t5 sg13_lv_nmos ad=0.3473p pd=2.71u as=0.12665p ps=1.145u w=0.74u l=0.13u
X52 VDD.t457 sar_ctrl_async_phys_0.dac_code[2] oa_sar8_acore18_opt_0.sw_bitcell_opt_b2_0.bot.t0 VDD.t456 sg13_lv_pmos ad=1.33p pd=8.3u as=0.741p ps=4.19u w=3.8u l=0.13u
X53 VDD.t77 VSS.t1029 VDD.t77 VDD.t76 sg13_lv_pmos ad=0.19p pd=1.38u as=0 ps=0 w=1u l=1u
X54 VDD.t159 VSS.t970 VDD.t159 VDD.t19 sg13_lv_pmos ad=0.34p pd=2.68u as=0 ps=0 w=1u l=1u
X55 a_34069_41189# sar_ctrl_async_phys_0.sg13g2_dfrbpq_1$1_0.CLK.t22 VDD.t0 VDD.t0 sg13_lv_pmos ad=0.4088p pd=2.97u as=3.62845p ps=23.965u w=1.12u l=0.13u
X56 VSS.t46 VDD.t219 VSS.t46 VSS.t861 sg13_lv_nmos ad=79.8f pd=0.8u as=0 ps=0 w=0.42u l=1u
X57 a_36089_39744# sar_ctrl_async_phys_0.sg13g2_a21oi_1$1_3.A2 VSS.t79 VSS.t1271 sg13_lv_nmos ad=0.1216p pd=1.02u as=0.1331p ps=1.12u w=0.64u l=0.13u
X58 a_29701_36874# sar_ctrl_async_phys_0.sg13g2_nor2_1$1_7.A VSS.t340 VSS.t544 sg13_lv_nmos ad=0.187p pd=1.78u as=0.18575p ps=1.26u w=0.55u l=0.13u
X59 a_32233_31511# a_31291_31399# a_32031_31749# VDD.t3 sg13_lv_pmos ad=93.45f pd=0.865u as=0.2048p ps=1.63u w=0.42u l=0.13u
X60 VSS.t48 sar_ctrl_async_phys_0.sg13g2_inv_1$1_6.A sar_ctrl_async_phys_0.sg13g2_inv_1$1_6.Y VSS.t47 sg13_lv_nmos ad=0.2516p pd=2.16u as=0.2516p ps=2.16u w=0.74u l=0.13u
X61 a_35245_45266# sar_ctrl_async_phys_0.sg13g2_nand2_1$1_3.B VSS.t109 VSS.t217 sg13_lv_nmos ad=0.187p pd=1.78u as=0.14505p ps=1.15u w=0.55u l=0.13u
X62 a_32319_44311# a_31477_44213# a_31060_44552# VDD.t5 sg13_lv_pmos ad=0.2048p pd=1.63u as=0.34p ps=2.68u w=1u l=0.13u
X63 a_35313_37784# sar_ctrl_async_phys_0.sg13g2_a21oi_1$1_0.A1 sar_ctrl_async_phys_0.sg13g2_a22oi_1$1_0.A2 VSS.t14 sg13_lv_nmos ad=0.1406p pd=1.12u as=0.1406p ps=1.12u w=0.74u l=0.13u
X64 VDD.t3 a_35648_30846# a_35593_30941# VDD.t3 sg13_lv_pmos ad=1.96315p pd=12.675u as=93.45f ps=0.865u w=0.42u l=0.13u
X65 VDD.t326 sar_ctrl_async_phys_0.sg13g2_o21ai_1$1_1.B1.t8 a_31830_40898# VDD.t317 sg13_lv_pmos ad=0.36237p pd=2.605u as=79.8f ps=0.8u w=0.42u l=0.13u
X66 a_31098_43020# sar_ctrl_async_phys_0.sg13g2_nor2b_1$1_0.A sar_ctrl_async_phys_0.sg13g2_nor2_1$1_10.A VDD.t22 sg13_lv_pmos ad=0.1176p pd=1.33u as=0.3808p ps=2.92u w=1.12u l=0.13u
X67 VDD.t30 VSS.t899 VDD.t120 VDD.t29 sg13_lv_pmos ad=0.34p pd=2.68u as=0 ps=0 w=1u l=1u
X68 oa_sar8_acore18_opt_0.sw_bitcell_opt_term_0.vin oa_sar8_acore18_opt_0.sw_bitcell_opt_term_0.gb.t7 oa_sar8_acore18_opt_0.sw_bitcell_opt_b2_0.bot.t1 VSS.t560 sg13_lv_nmos ad=0.35p pd=2.7u as=0.195p ps=1.39u w=1u l=0.13u
X69 VDD.t43 a_25596_47222# sar_ctrl_async_phys_0.hold_req VDD.t42 sg13_lv_pmos ad=0.2114p pd=1.54u as=0.42p ps=2.99u w=1.12u l=0.13u
X70 sar_ctrl_async_phys_0.bit_active[6] a_34904_38948# VSS.t169 VSS.t1190 sg13_lv_nmos ad=0.2886p pd=2.26u as=0.14875p ps=1.16u w=0.74u l=0.13u
X71 oa_sar8_acore18_opt_0.sw_tg_opt_1.bot.t3 oa_sar8_acore18_opt_0.sw_bitcell_opt_b3_1.bot.t15 cap_cmim l=2.14u w=2.14u
X72 oa_sar8_acore18_opt_0.sw_tg_opt_0.bot.t3 oa_sar8_acore18_opt_0.sw_bitcell_opt_b6_0.bot.t61 cap_cmim l=2.14u w=2.14u
X73 a_35103_43845# a_34261_43495# a_35009_43845# VSS.t228 sg13_lv_nmos ad=0.12665p pd=1.145u as=0.1428p ps=1.52u w=0.42u l=0.13u
X74 oa_sar8_acore18_opt_0.sw_tg_opt_1.bot.t3 oa_sar8_acore18_opt_0.sw_bitcell_opt_b6_1.bot.t75 cap_cmim l=2.14u w=2.14u
X75 VSS.t1101 VDD.t59 VSS.t1100 VSS.t1099 sg13_lv_nmos ad=0.1428p pd=1.52u as=0 ps=0 w=0.42u l=1u
X76 a_35360_43726# sar_ctrl_async_phys_0.sg13g2_buf_1$1_41.X VDD.t22 VDD.t22 sg13_lv_pmos ad=79.8f pd=0.8u as=2.2076p ps=14.4u w=0.42u l=0.13u
X77 oa_sar8_acore18_opt_0.sw_tg_opt_1.bot.t4 oa_sar8_acore18_opt_0.sw_bitcell_opt_b7_1.bot.t10 cap_cmim l=2.14u w=2.14u
X78 VSS.t1007 VDD.t309 VSS.t1009 VSS.t1008 sg13_lv_nmos ad=79.8f pd=0.8u as=0 ps=0 w=0.42u l=1u
X79 a_35280_35365# sar_ctrl_async_phys_0.sg13g2_a21oi_1$1_0.A2 VDD.t319 VDD.t19 sg13_lv_pmos ad=0.1596p pd=1.22u as=0.1918p ps=1.5u w=0.84u l=0.13u
X80 VSS.t40 VDD.t11 VSS.t40 VSS.t754 sg13_lv_nmos ad=0.1428p pd=1.52u as=0 ps=0 w=0.42u l=1u
X81 a_34266_38484# sar_ctrl_async_phys_0.sg13g2_nor2b_1$1_2.Y VDD.t858 VDD.t29 sg13_lv_pmos ad=0.1176p pd=1.33u as=0.4032p ps=2.96u w=1.12u l=0.13u
X82 oa_sar8_acore18_opt_0.sw_tg_opt_0.bot.t3 oa_sar8_acore18_opt_0.sw_bitcell_opt_b6_0.bot.t24 cap_cmim l=2.14u w=2.14u
X83 a_32533_40471# sar_ctrl_async_phys_0.sg13g2_dfrbpq_1$1_0.CLK.t19 VSS.t279 VSS.t278 sg13_lv_nmos ad=0.2516p pd=2.16u as=4.20675p ps=26.86u w=0.74u l=0.13u
X84 a_31935_39775# a_31093_39677# a_30676_40016# VDD.t317 sg13_lv_pmos ad=0.2048p pd=1.63u as=0.34p ps=2.68u w=1u l=0.13u
X85 oa_sar8_acore18_opt_0.sw_tg_opt_0.bot.t4 oa_sar8_acore18_opt_0.sw_bitcell_opt_b7_0.bot.t15 cap_cmim l=2.14u w=2.14u
X86 sar_ctrl_async_phys_0.dac_code[7] a_36056_38224# VDD.t435 VDD.t29 sg13_lv_pmos ad=0.42p pd=2.99u as=0.2114p ps=1.54u w=1.12u l=0.13u
X87 a_29238_40898# a_30043_40471# a_29498_40428# VDD.t317 sg13_lv_pmos ad=0.1428p pd=1.52u as=79.8f ps=0.8u w=0.42u l=0.13u
X88 VDD.t64 VSS.t118 VDD.t64 VDD.t10 sg13_lv_pmos ad=0.34p pd=2.68u as=0 ps=0 w=1u l=1u
X89 a_35295_36285# a_34453_35935# a_34036_35928# VDD.t19 sg13_lv_pmos ad=0.2048p pd=1.63u as=0.34p ps=2.68u w=1u l=0.13u
X90 VDD.t317 sar_ctrl_async_phys_0.sg13g2_buf_1$1_3.A a_35952_39901# VDD.t317 sg13_lv_pmos ad=0.2856p pd=2.36u as=0.1596p ps=1.22u w=0.84u l=0.13u
X91 a_29812_40885# a_29524_40464# a_29750_40885# VSS.t1136 sg13_lv_nmos ad=0.1428p pd=1.52u as=37.8f ps=0.6u w=0.42u l=0.13u
X92 oa_sar8_acore18_opt_0.sw_tg_opt_0.bot.t3 oa_sar8_acore18_opt_0.sw_bitcell_opt_b7_0.bot.t65 cap_cmim l=2.14u w=2.14u
X93 sar_ctrl_async_phys_0.sg13g2_nor2_1$1_15.Y sar_ctrl_async_phys_0.sg13g2_nor2b_1$1_3.Y VSS.t428 VSS.t547 sg13_lv_nmos ad=0.1406p pd=1.12u as=0.2516p ps=2.16u w=0.74u l=0.13u
X94 VSS.t46 VDD.t2 VSS.t46 VSS.t870 sg13_lv_nmos ad=79.8f pd=0.8u as=0 ps=0 w=0.42u l=1u
X95 oa_sar8_acore18_opt_0.sw_tg_opt_1.bot.t3 oa_sar8_acore18_opt_0.sw_bitcell_opt_b7_1.bot.t79 cap_cmim l=2.14u w=2.14u
X96 result[6] a_36056_32176# VSS.t116 VSS.t36 sg13_lv_nmos ad=0.2886p pd=2.26u as=0.14875p ps=1.16u w=0.74u l=0.13u
X97 a_34549_32911# sar_ctrl_async_phys_0.sg13g2_dfrbpq_1$1_0.CLK.t6 VSS.t54 VSS.t53 sg13_lv_nmos ad=0.2516p pd=2.16u as=4.49817p ps=29.795u w=0.74u l=0.13u
X98 a_36156_45710# sar_ctrl_async_phys_0.sg13g2_buf_1$1_37.A VSS.t433 VSS.t503 sg13_lv_nmos ad=0.187p pd=1.78u as=0.14875p ps=1.16u w=0.55u l=0.13u
X99 oa_sar8_acore18_opt_0.sw_tg_opt_0.bot.t3 oa_sar8_acore18_opt_0.sw_bitcell_opt_b7_0.bot.t107 cap_cmim l=2.14u w=2.14u
X100 VDD.t636 sar_ctrl_async_phys_0.dac_code_n[2] oa_sar8_acore18_opt_0.sw_bitcell_opt_b2_1.bot.t1 VDD.t635 sg13_lv_pmos ad=1.33p pd=8.3u as=0.741p ps=4.19u w=3.8u l=0.13u
X101 oa_sar8_acore18_opt_0.sw_tg_opt_0.bot.t3 oa_sar8_acore18_opt_0.sw_bitcell_opt_b4_0.bot.t2 cap_cmim l=2.14u w=2.14u
X102 VSS.t146 a_28368_36877# sar_ctrl_async_phys_0.sg13g2_nor2_1$1_7.A VSS.t440 sg13_lv_nmos ad=0.1331p pd=1.12u as=0.2516p ps=2.16u w=0.74u l=0.13u
X103 oa_sar8_acore18_opt_0.sw_tg_opt_1.bot.t3 oa_sar8_acore18_opt_0.sw_bitcell_opt_b5_1.bot.t2 cap_cmim l=2.14u w=2.14u
X104 VDD.t150 sar_ctrl_async_phys_0.sg13g2_nor2_1$1_10.B a_30671_32876# VDD.t76 sg13_lv_pmos ad=0.3808p pd=2.92u as=0.2744p ps=1.61u w=1.12u l=0.13u
X105 sar_ctrl_async_phys_0.sg13g2_nor2_1$1_15.Y sar_ctrl_async_phys_0.sg13g2_a22oi_1$1_3.A2 a_33114_41508# VDD.t0 sg13_lv_pmos ad=0.3808p pd=2.92u as=0.1176p ps=1.33u w=1.12u l=0.13u
X106 a_30676_40016# a_30650_39921# VDD.t361 VDD.t317 sg13_lv_pmos ad=0.34p pd=2.68u as=0.36237p ps=2.605u w=1u l=0.13u
X107 a_32149_45007# sar_ctrl_async_phys_0.sg13g2_dfrbpq_1$1_0.CLK.t28 VDD.t5 VDD.t5 sg13_lv_pmos ad=0.4088p pd=2.97u as=1.79957p ps=11.62u w=1.12u l=0.13u
X108 a_26454_39702# a_26184_39702# VSS.t208 VSS.t103 sg13_lv_nmos ad=0.1428p pd=1.52u as=79.8f ps=0.8u w=0.42u l=0.5u
X109 VDD.t191 VSS.t65 VDD.t191 VDD.t29 sg13_lv_pmos ad=0.34p pd=2.68u as=0 ps=0 w=1u l=1u
X110 oa_sar8_acore18_opt_0.sw_tg_opt_1.bot.t2 oa_sar8_acore18_opt_0.sw_bitcell_opt_b7_1.bot.t168 cap_cmim l=2.14u w=2.14u
X111 oa_sar8_acore18_opt_0.sw_tg_opt_1.bot.t3 oa_sar8_acore18_opt_0.sw_bitcell_opt_b7_1.bot.t36 cap_cmim l=2.14u w=2.14u
X112 oa_sar8_acore18_opt_0.sw_bitcell_opt_term_1.bot.t0 oa_sar8_acore18_opt_0.sw_bitcell_opt_term_0.trkb.t29 oa_sar8_acore18_opt_0.bstrap_opt_w2_c1200_1.out VDD.t671 sg13_lv_pmos ad=0.39p pd=2.39u as=0.7p ps=4.7u w=2u l=0.13u
X113 sar_ctrl_async_phys_0.sg13g2_dfrbpq_1$1_5.D a_30830_35166# VSS.t1 VSS.t0 sg13_lv_nmos ad=0.4033p pd=2.57u as=0.148p ps=1.14u w=0.74u l=0.13u
X114 VDD.t25 VSS.t313 VDD.t25 VDD.t22 sg13_lv_pmos ad=0.34p pd=2.68u as=0 ps=0 w=1u l=1u
X115 a_33846_33338# a_34651_32911# a_34106_32868# VDD.t76 sg13_lv_pmos ad=0.1428p pd=1.52u as=79.8f ps=0.8u w=0.42u l=0.13u
X116 VDD.t561 sar_ctrl_async_phys_0.sg13g2_buf_1$1_6.X a_33846_33338# VDD.t76 sg13_lv_pmos ad=0.36237p pd=2.605u as=79.8f ps=0.8u w=0.42u l=0.13u
X117 VDD.t231 VSS.t906 VDD.t230 VDD.t29 sg13_lv_pmos ad=0.34p pd=2.68u as=0 ps=0 w=1u l=1u
X118 a_30671_33292# sar_ctrl_async_phys_0.sg13g2_a22oi_1$1_0.B1 VSS.t48 VSS.t486 sg13_lv_nmos ad=0.13875p pd=1.115u as=0.2553p ps=2.17u w=0.74u l=0.13u
X119 a_35360_36894# sar_ctrl_async_phys_0.sg13g2_dfrbpq_1$1_8.RESET_B VDD.t16 VDD.t16 sg13_lv_pmos ad=79.8f pd=0.8u as=2.2076p ps=14.4u w=0.42u l=0.13u
X120 a_29620_32151# a_29332_32456# a_29558_32151# VSS.t1258 sg13_lv_nmos ad=0.1428p pd=1.52u as=37.8f ps=0.6u w=0.42u l=0.13u
X121 oa_sar8_acore18_opt_0.sw_tg_opt_0.bot.t2 oa_sar8_acore18_opt_0.sw_bitcell_opt_b7_0.bot.t152 cap_cmim l=2.14u w=2.14u
X122 VDD.t229 sar_ctrl_async_phys_0.sg13g2_a22oi_1$1_3.B1 a_31832_34412# VDD.t147 sg13_lv_pmos ad=0.2114p pd=1.54u as=0.2856p ps=2.36u w=0.84u l=0.13u
X123 VSS.t534 oa_sar8_acore18_opt_0.sw_bitcell_opt_term_0.trkb.t7 a_21332_n9711# VSS.t533 sg13_lv_nmos ad=0.345p pd=2.69u as=0.19p ps=1.38u w=1u l=0.15u
X124 oa_sar8_acore18_opt_0.sw_tg_opt_0.bot.t3 oa_sar8_acore18_opt_0.sw_bitcell_opt_b7_0.bot.t47 cap_cmim l=2.14u w=2.14u
X125 a_35402_46878# sar_ctrl_async_phys_0.sg13g2_nand2b_1$1_5.A_N VSS.t42 VSS.t125 sg13_lv_nmos ad=0.1406p pd=1.12u as=0.2516p ps=2.16u w=0.74u l=0.13u
X126 VSS.t979 VDD.t20 VSS.t979 VSS.t0 sg13_lv_nmos ad=0.1428p pd=1.52u as=0 ps=0 w=0.42u l=1u
X127 a_35360_43726# a_35103_43845# a_35522_43922# VSS.t121 sg13_lv_nmos ad=0.1428p pd=1.52u as=37.8f ps=0.6u w=0.42u l=0.13u
X128 VDD.t340 a_27134_39887# sar_ctrl_async_phys_0.sg13g2_dlygate4sd3_1$1_6.X VDD.t317 sg13_lv_pmos ad=0.2254p pd=1.53u as=0.4256p ps=3u w=1.12u l=0.13u
X129 a_31563_43020# sar_ctrl_async_phys_0.sg13g2_a21oi_1$1_4.B1 sar_ctrl_async_phys_0.sg13g2_nor2_1$1_10.B VDD.t22 sg13_lv_pmos ad=0.2128p pd=1.5u as=0.3808p ps=2.92u w=1.12u l=0.13u
X130 sar_ctrl_async_phys_0.sg13g2_nand2_1$1_1.Y sar_ctrl_async_phys_0.sg13g2_nand2_1$1_1.B VDD.t146 VDD.t16 sg13_lv_pmos ad=0.2128p pd=1.5u as=0.3808p ps=2.92u w=1.12u l=0.13u
X131 a_35391_34773# a_34549_34423# a_34132_34416# VDD.t147 sg13_lv_pmos ad=0.2048p pd=1.63u as=0.34p ps=2.68u w=1u l=0.13u
X132 a_28026_36972# sar_ctrl_async_phys_0.sg13g2_nor2_1$1_3.Y VDD.t145 VDD.t16 sg13_lv_pmos ad=0.1176p pd=1.33u as=0.4032p ps=2.96u w=1.12u l=0.13u
X133 sar_ctrl_async_phys_0.sg13g2_dlygate4sd3_1$1_0.A a_28870_35948# VSS.t62 VSS.t1228 sg13_lv_nmos ad=0.2516p pd=2.16u as=0.1426p ps=1.16u w=0.74u l=0.13u
X134 oa_sar8_acore18_opt_0.sw_tg_opt_1.bot.t3 oa_sar8_acore18_opt_0.sw_bitcell_opt_b5_1.bot.t2 cap_cmim l=2.14u w=2.14u
X135 sar_ctrl_async_phys_0.sg13g2_a22oi_1$1_0.Y sar_ctrl_async_phys_0.sg13g2_a22oi_1$1_0.B1 a_34895_32460# VDD.t76 sg13_lv_pmos ad=0.2128p pd=1.5u as=0.2716p ps=1.605u w=1.12u l=0.13u
X136 sar_ctrl_async_phys_0.dac_code_n[2] a_35288_47296# VDD.t175 VDD.t42 sg13_lv_pmos ad=0.42p pd=2.99u as=0.2114p ps=1.54u w=1.12u l=0.13u
X137 VDD.t407 sar_ctrl_async_phys_0.sg13g2_buf_1$1_41.X a_33654_44234# VDD.t5 sg13_lv_pmos ad=0.36237p pd=2.605u as=79.8f ps=0.8u w=0.42u l=0.13u
X138 VDD.t77 VSS.t1063 VDD.t77 VDD.t76 sg13_lv_pmos ad=0.34p pd=2.68u as=0 ps=0 w=1u l=1u
X139 a_31348_44247# a_31060_44552# a_31286_44247# VSS.t488 sg13_lv_nmos ad=0.1428p pd=1.52u as=37.8f ps=0.6u w=0.42u l=0.13u
X140 a_33440_32358# sar_ctrl_async_phys_0.sg13g2_buf_1$1_6.X VDD.t76 VDD.t76 sg13_lv_pmos ad=79.8f pd=0.8u as=1.79957p ps=11.62u w=0.42u l=0.13u
X141 VDD.t159 VSS.t970 VDD.t159 VDD.t19 sg13_lv_pmos ad=0.19p pd=1.38u as=0 ps=0 w=1u l=1u
X142 VDD.t349 sar_ctrl_async_phys_0.sg13g2_nand2b_1$1_1.B sar_ctrl_async_phys_0.sg13g2_a21oi_1$1_0.B1 VDD.t5 sg13_lv_pmos ad=0.2198p pd=1.53u as=0.2128p ps=1.5u w=1.12u l=0.13u
X143 oa_sar8_acore18_opt_0.sw_tg_opt_0.bot.t3 oa_sar8_acore18_opt_0.sw_bitcell_opt_b6_0.bot.t54 cap_cmim l=2.14u w=2.14u
X144 VDD.t159 VSS.t943 VDD.t159 VDD.t19 sg13_lv_pmos ad=0.19p pd=1.38u as=0 ps=0 w=1u l=1u
X145 oa_sar8_acore18_opt_0.sw_bitcell_opt_b3_0.bot.t0 sar_ctrl_async_phys_0.dac_code[3] VDD.t542 VDD.t540 sg13_lv_pmos ad=0.819p pd=4.59u as=1.47p ps=9.1u w=4.2u l=0.13u
X146 VDD.t329 a_35391_30703# a_36058_30924# VDD.t3 sg13_lv_pmos ad=0.2128p pd=1.5u as=0.3864p ps=2.93u w=1.12u l=0.13u
X147 a_34132_34416# a_34106_34380# VSS.t270 VSS.t566 sg13_lv_nmos ad=0.2516p pd=2.16u as=0.1626p ps=1.415u w=0.74u l=0.13u
X148 VSS.t936 VDD.t159 VSS.t935 VSS.t934 sg13_lv_nmos ad=0.1428p pd=1.52u as=0 ps=0 w=0.42u l=1u
X149 VDD.t9 VSS.t780 VDD.t9 VDD.t5 sg13_lv_pmos ad=0.34p pd=2.68u as=0 ps=0 w=1u l=1u
X150 sar_ctrl_async_phys_0.sg13g2_nand2b_1$1_0.A_N sar_ctrl_async_phys_0.sg13g2_nor2_1$1_13.B a_27738_40460# VDD.t317 sg13_lv_pmos ad=0.3808p pd=2.92u as=0.1176p ps=1.33u w=1.12u l=0.13u
X151 VSS.t583 VDD.t18 VSS.t340 VSS.t950 sg13_lv_nmos ad=0.1428p pd=1.52u as=0 ps=0 w=0.42u l=1u
X152 a_34911_41287# a_34069_41189# a_34817_41287# VSS.t188 sg13_lv_nmos ad=0.12665p pd=1.145u as=0.1428p ps=1.52u w=0.42u l=0.13u
X153 a_33577_40583# a_32635_40471# a_33375_40821# VDD.t317 sg13_lv_pmos ad=93.45f pd=0.865u as=0.2048p ps=1.63u w=0.42u l=0.13u
X154 VSS.t252 a_32192_36166# a_31841_36285# VSS.t74 sg13_lv_nmos ad=79.8f pd=0.8u as=0.1428p ps=1.52u w=0.42u l=0.13u
X155 VDD.t44 VSS.t730 VDD.t44 VDD.t42 sg13_lv_pmos ad=0.34p pd=2.68u as=0 ps=0 w=1u l=1u
X156 a_29332_40898# sar_ctrl_async_phys_0.sg13g2_nor2_1$1_11.Y a_29238_40898# VSS.t94 sg13_lv_nmos ad=60.89999f pd=0.71u as=0.1428p ps=1.52u w=0.42u l=0.13u
X157 a_29760_36682# a_29701_36874# sar_ctrl_async_phys_0.sg13g2_nor2_1$1_8.A VSS.t522 sg13_lv_nmos ad=0.1406p pd=1.12u as=0.3404p ps=2.4u w=0.74u l=0.13u
X158 oa_sar8_acore18_opt_0.sw_tg_opt_1.bot.t3 oa_sar8_acore18_opt_0.sw_bitcell_opt_b7_1.bot.t132 cap_cmim l=2.14u w=2.14u
X159 VSS.t351 a_31935_39775# a_32602_39996# VSS.t202 sg13_lv_nmos ad=0.1406p pd=1.12u as=0.2516p ps=2.16u w=0.74u l=0.13u
X160 oa_sar8_acore18_opt_0.sw_tg_opt_1.bot.t3 oa_sar8_acore18_opt_0.sw_bitcell_opt_b5_1.bot.t22 cap_cmim l=2.14u w=2.14u
X161 VSS.t42 sar_ctrl_async_phys_0.sg13g2_a21oi_1$1_0.B1 a_35288_47296# VSS.t41 sg13_lv_nmos ad=0.14875p pd=1.16u as=0.187p ps=1.78u w=0.55u l=0.13u
X162 VSS.t786 VDD.t6 VSS.t786 VSS.t811 sg13_lv_nmos ad=79.8f pd=0.8u as=0 ps=0 w=0.42u l=1u
X163 oa_sar8_acore18_opt_0.sw_tg_opt_1.bot.t3 oa_sar8_acore18_opt_0.sw_bitcell_opt_b7_1.bot.t95 cap_cmim l=2.14u w=2.14u
X164 VSS.t122 a_35456_44454# a_35105_44311# VSS.t60 sg13_lv_nmos ad=79.8f pd=0.8u as=0.1428p ps=1.52u w=0.42u l=0.13u
X165 oa_sar8_acore18_opt_0.sw_tg_opt_0.bot.t4 oa_sar8_acore18_opt_0.sw_bitcell_opt_b7_0.bot.t10 cap_cmim l=2.14u w=2.14u
X166 VSS.t820 VDD.t13 VSS.t821 VSS.t224 sg13_lv_nmos ad=79.8f pd=0.8u as=0 ps=0 w=0.42u l=1u
X167 a_34093_42912# sar_ctrl_async_phys_0.sg13g2_nand2_1$1_5.B VSS.t99 VSS.t689 sg13_lv_nmos ad=0.187p pd=1.78u as=0.14505p ps=1.15u w=0.55u l=0.13u
X168 oa_sar8_acore18_opt_0.sw_tg_opt_1.bot.t3 oa_sar8_acore18_opt_0.sw_bitcell_opt_b7_1.bot.t26 cap_cmim l=2.14u w=2.14u
X169 a_32192_36166# a_31935_36285# a_32354_36362# VSS.t74 sg13_lv_nmos ad=0.1428p pd=1.52u as=37.8f ps=0.6u w=0.42u l=0.13u
X170 VSS.t895 VDD.t100 VSS.t462 VSS.t893 sg13_lv_nmos ad=79.8f pd=0.8u as=0 ps=0 w=0.42u l=1u
X171 oa_sar8_acore18_opt_0.sw_tg_opt_0.bot.t3 oa_sar8_acore18_opt_0.sw_bitcell_opt_b5_0.bot.t15 cap_cmim l=2.14u w=2.14u
X172 vcm oa_sar8_acore18_opt_0.sw_bitcell_opt_term_0.trkb.t10 oa_sar8_acore18_opt_0.sw_tg_opt_0.bot.t1 VDD.t883 sg13_lv_pmos ad=0.7p pd=4.7u as=0.39p ps=2.39u w=2u l=0.13u
X173 VDD.t148 VSS.t975 VDD.t270 VDD.t147 sg13_lv_pmos ad=0.34p pd=2.68u as=0 ps=0 w=1u l=1u
X174 VSS.t146 sar_ctrl_async_phys_0.sg13g2_dlygate4sd3_1$1_1.A a_28488_35965# VSS.t1198 sg13_lv_nmos ad=79.8f pd=0.8u as=0.1428p ps=1.52u w=0.42u l=0.13u
X175 VSS.t40 VDD.t11 VSS.t40 VSS.t753 sg13_lv_nmos ad=79.8f pd=0.8u as=0 ps=0 w=0.42u l=1u
X176 a_29881_40507# a_29524_40464# VDD.t361 VDD.t317 sg13_lv_pmos ad=63f pd=0.72u as=0.1563p ps=1.22u w=0.42u l=0.13u
X177 sar_ctrl_async_phys_0.sg13g2_nor2b_1$1_0.A a_34520_38224# VDD.t833 VDD.t29 sg13_lv_pmos ad=0.42p pd=2.99u as=0.2114p ps=1.54u w=1.12u l=0.13u
X178 a_31828_37440# a_32347_37447# a_33087_37797# VSS.t14 sg13_lv_nmos ad=0.3473p pd=2.71u as=0.12665p ps=1.145u w=0.74u l=0.13u
X179 a_30964_46512# a_31483_46519# a_32223_46869# VSS.t125 sg13_lv_nmos ad=0.3473p pd=2.71u as=0.12665p ps=1.145u w=0.74u l=0.13u
X180 VDD.t145 VSS.t945 VDD.t169 VDD.t16 sg13_lv_pmos ad=0.34p pd=2.68u as=0 ps=0 w=1u l=1u
X181 VSS.t771 VDD.t11 VSS.t770 VSS.t769 sg13_lv_nmos ad=0.1428p pd=1.52u as=0 ps=0 w=0.42u l=1u
X182 a_26184_21025# sar_ctrl_async_phys_0.cmp_n sar_ctrl_async_phys_0.cmp_p VSS.t96 sg13_lv_nmos ad=0.7p pd=4.7u as=0.39p ps=2.39u w=2u l=0.13u
X183 VSS.t331 sar_ctrl_async_phys_0.sg13g2_buf_1$1_35.A a_36056_42760# VSS.t330 sg13_lv_nmos ad=0.14875p pd=1.16u as=0.187p ps=1.78u w=0.55u l=0.13u
X184 sar_ctrl_async_phys_0.sg13g2_nor2_1$1_0.Y sar_ctrl_async_phys_0.sg13g2_nor2b_1$1_0.Y VSS.t15 VSS.t1175 sg13_lv_nmos ad=0.1406p pd=1.12u as=0.2516p ps=2.16u w=0.74u l=0.13u
X185 VSS.t968 sar_ctrl_async_phys_0.sg13g2_dfrbpq_1$1_8.RESET_B a_33652_36674# VSS.t1227 sg13_lv_nmos ad=0.1626p pd=1.415u as=60.89999f ps=0.71u w=0.42u l=0.13u
X186 a_26394_37436# sar_ctrl_async_phys_0.sg13g2_and2_1$1_3.A VDD.t169 VDD.t16 sg13_lv_pmos ad=0.1176p pd=1.33u as=0.4032p ps=2.96u w=1.12u l=0.13u
X187 VSS.t26 a_31477_44213# a_31579_44356# VSS.t25 sg13_lv_nmos ad=4.3785p pd=27.07u as=0.2516p ps=2.16u w=0.74u l=0.13u
X188 VDD.t120 VSS.t65 VDD.t120 VDD.t29 sg13_lv_pmos ad=0.34p pd=2.68u as=0 ps=0 w=1u l=1u
X189 VDD.t345 sar_ctrl_async_phys_0.sg13g2_a21oi_1$1_5.Y a_31247_32876# VDD.t76 sg13_lv_pmos ad=0.3808p pd=2.92u as=0.2744p ps=1.61u w=1.12u l=0.13u
X190 VSS.t111 VDD.t33 VSS.t111 VSS.t849 sg13_lv_nmos ad=79.8f pd=0.8u as=0 ps=0 w=0.42u l=1u
X191 oa_sar8_acore18_opt_0.sw_tg_opt_1.bot.t3 oa_sar8_acore18_opt_0.sw_bitcell_opt_b7_1.bot.t95 cap_cmim l=2.14u w=2.14u
X192 VDD.t150 VSS.t1034 VDD.t247 VDD.t76 sg13_lv_pmos ad=0.19p pd=1.38u as=0 ps=0 w=1u l=1u
X193 a_32406_45746# sar_ctrl_async_phys_0.sg13g2_nor2_1$1_0.Y VDD.t184 VDD.t10 sg13_lv_pmos ad=79.8f pd=0.8u as=0.1428p ps=1.52u w=0.42u l=0.13u
X194 oa_sar8_acore18_opt_0.sw_tg_opt_1.bot.t3 oa_sar8_acore18_opt_0.sw_bitcell_opt_b6_1.bot.t30 cap_cmim l=2.14u w=2.14u
X195 VDD.t51 VSS.t730 VDD.t51 VDD.t10 sg13_lv_pmos ad=0.19p pd=1.38u as=0 ps=0 w=1u l=1u
X196 a_31247_33292# sar_ctrl_async_phys_0.sg13g2_a22oi_1$1_0.B1 VSS.t48 VSS.t57 sg13_lv_nmos ad=0.13875p pd=1.115u as=0.2553p ps=2.17u w=0.74u l=0.13u
X197 a_26184_21025# oa_sar8_acore18_opt_0.sw_tg_opt_1.bot.t5 a_28008_23477# VSS.t703 sg13_lv_nmos ad=0.19p pd=1.38u as=0.345p ps=2.69u w=1u l=0.15u
X198 VDD.t51 VSS.t783 VDD.t51 VDD.t10 sg13_lv_pmos ad=0.34p pd=2.68u as=0 ps=0 w=1u l=1u
X199 oa_sar8_acore18_opt_0.sw_tg_opt_0.bot.t3 oa_sar8_acore18_opt_0.sw_bitcell_opt_b6_0.bot.t34 cap_cmim l=2.14u w=2.14u
X200 a_35593_33023# a_34651_32911# a_35391_33261# VDD.t76 sg13_lv_pmos ad=93.45f pd=0.865u as=0.2048p ps=1.63u w=0.42u l=0.13u
X201 oa_sar8_acore18_opt_0.sw_tg_opt_0.bot.t3 oa_sar8_acore18_opt_0.sw_bitcell_opt_b5_0.bot.t25 cap_cmim l=2.14u w=2.14u
X202 a_33675_43020# sar_ctrl_async_phys_0.sg13g2_buf_1$1_42.A sar_ctrl_async_phys_0.sg13g2_a22oi_1$1_4.A2 VDD.t22 sg13_lv_pmos ad=0.2128p pd=1.5u as=0.3808p ps=2.92u w=1.12u l=0.13u
X203 VSS.t448 a_32245_37447# a_32347_37447# VSS.t472 sg13_lv_nmos ad=9.86937p pd=64.34499u as=0.2516p ps=2.16u w=0.74u l=0.13u
X204 oa_sar8_acore18_opt_0.bstrap_opt_w2_c1200_1.out oa_sar8_acore18_opt_0.bstrap_opt_w2_c1200_1.gb oa_sar8_acore18_opt_0.sw_bitcell_opt_b4_1.bot.t0 VSS.t160 sg13_lv_nmos ad=0.35p pd=2.7u as=0.195p ps=1.39u w=1u l=0.13u
X205 oa_sar8_acore18_opt_0.sw_bitcell_opt_b0_0.bot.t3 sar_ctrl_async_phys_0.dac_code[0] VDD.t970 VDD.t968 sg13_lv_pmos ad=0.585p pd=3.39u as=1.05p ps=6.7u w=3u l=0.13u
X206 sar_ctrl_async_phys_0.sg13g2_a22oi_1$1_2.A2 sar_ctrl_async_phys_0.sg13g2_a21oi_1$1_6.B1 VSS.t46 VSS.t354 sg13_lv_nmos ad=0.1406p pd=1.12u as=0.2516p ps=2.16u w=0.74u l=0.13u
X207 oa_sar8_acore18_opt_0.sw_tg_opt_0.bot.t3 oa_sar8_acore18_opt_0.sw_bitcell_opt_b1_0.bot.t0 cap_cmim l=2.14u w=2.14u
X208 a_21332_n9711# oa_sar8_acore18_opt_0.sw_bitcell_opt_term_0.trkb.t7 VSS.t534 VSS.t533 sg13_lv_nmos ad=0.19p pd=1.38u as=0.345p ps=2.69u w=1u l=0.15u
X209 a_29046_32138# a_29851_32260# a_29306_32361# VDD.t76 sg13_lv_pmos ad=0.1428p pd=1.52u as=79.8f ps=0.8u w=0.42u l=0.13u
X210 oa_sar8_acore18_opt_0.sw_tg_opt_0.bot.t3 oa_sar8_acore18_opt_0.sw_bitcell_opt_b7_0.bot.t78 cap_cmim l=2.14u w=2.14u
X211 oa_sar8_acore18_opt_0.sw_bitcell_opt_b2_0.bot.t0 sar_ctrl_async_phys_0.dac_code[2] VDD.t458 VDD.t456 sg13_lv_pmos ad=0.741p pd=4.19u as=1.33p ps=8.3u w=3.8u l=0.13u
X212 VSS.t532 a_29749_32117# a_29851_32260# VSS.t531 sg13_lv_nmos ad=4.0265p pd=25.31u as=0.2516p ps=2.16u w=0.74u l=0.13u
X213 oa_sar8_acore18_opt_0.sw_tg_opt_1.bot.t3 oa_sar8_acore18_opt_0.sw_bitcell_opt_b1_1.bot.t2 cap_cmim l=2.14u w=2.14u
X214 VSS.t44 sar_ctrl_async_phys_0.sg13g2_a22oi_1$1_0.B1 sar_ctrl_async_phys_0.sg13g2_buf_1$1_17.A VSS.t484 sg13_lv_nmos ad=0.2516p pd=2.16u as=0.2516p ps=2.16u w=0.74u l=0.13u
X215 VSS.t322 a_31093_39677# a_31195_39820# VSS.t321 sg13_lv_nmos ad=5.61045p pd=35.775u as=0.2516p ps=2.16u w=0.74u l=0.13u
X216 sar_ctrl_async_phys_0.dac_code[5] a_36056_38948# VDD.t611 VDD.t29 sg13_lv_pmos ad=0.42p pd=2.99u as=0.2114p ps=1.54u w=1.12u l=0.13u
X217 a_32049_41236# sar_ctrl_async_phys_0.sg13g2_a21oi_1$1_0.A1 sar_ctrl_async_phys_0.sg13g2_a21oi_1$1_5.Y VSS.t71 sg13_lv_nmos ad=0.1406p pd=1.12u as=0.1406p ps=1.12u w=0.74u l=0.13u
X218 oa_sar8_acore18_opt_0.sw_tg_opt_0.bot.t3 oa_sar8_acore18_opt_0.sw_bitcell_opt_b7_0.bot.t30 cap_cmim l=2.14u w=2.14u
X219 oa_sar8_acore18_opt_0.sw_tg_opt_1.bot.t3 oa_sar8_acore18_opt_0.sw_bitcell_opt_b6_1.bot.t15 cap_cmim l=2.14u w=2.14u
X220 VSS.t219 sar_ctrl_async_phys_0.sg13g2_dfrbpq_1$1_3.RESET_B a_33844_36362# VSS.t1298 sg13_lv_nmos ad=0.1626p pd=1.415u as=60.89999f ps=0.71u w=0.42u l=0.13u
X221 a_34093_42912# sar_ctrl_async_phys_0.sg13g2_nand2_1$1_5.B VDD.t359 VDD.t22 sg13_lv_pmos ad=0.2856p pd=2.36u as=0.2198p ps=1.53u w=0.84u l=0.13u
X222 sar_ctrl_async_phys_0.sg13g2_buf_1$1_6.X.t0 a_35384_32176# VDD.t394 VDD.t76 sg13_lv_pmos ad=0.42p pd=2.99u as=0.2114p ps=1.54u w=1.12u l=0.13u
X223 oa_sar8_acore18_opt_0.sw_tg_opt_1.bot.t3 oa_sar8_acore18_opt_0.sw_bitcell_opt_b6_1.bot.t55 cap_cmim l=2.14u w=2.14u
X224 VDD.t5 a_31477_44213# a_31579_44356# VDD.t5 sg13_lv_pmos ad=1.96315p pd=12.675u as=0.3864p ps=2.93u w=1.12u l=0.13u
X225 VSS.t180 sar_ctrl_async_phys_0.cmp_p a_25496_31388# VSS.t179 sg13_lv_nmos ad=0.14875p pd=1.16u as=0.187p ps=1.78u w=0.55u l=0.13u
X226 VDD.t419 a_35391_34773# a_36058_34412# VDD.t147 sg13_lv_pmos ad=0.2128p pd=1.5u as=0.3864p ps=2.93u w=1.12u l=0.13u
X227 VDD.t361 sar_ctrl_async_phys_0.sg13g2_a21oi_1$1_0.A1 a_30027_39996# VDD.t317 sg13_lv_pmos ad=0.2128p pd=1.5u as=0.2128p ps=1.5u w=1.12u l=0.13u
X228 oa_sar8_acore18_opt_0.sw_tg_opt_1.bot.t3 oa_sar8_acore18_opt_0.sw_bitcell_opt_b7_1.bot.t53 cap_cmim l=2.14u w=2.14u
X229 VSS.t1022 VDD.t97 VSS.t1021 VSS.t1020 sg13_lv_nmos ad=0.1428p pd=1.52u as=0 ps=0 w=0.42u l=1u
X230 a_33777_42748# sar_ctrl_async_phys_0.sg13g2_a21oi_1$1_0.A1 sar_ctrl_async_phys_0.sg13g2_a22oi_1$1_4.A2 VSS.t70 sg13_lv_nmos ad=0.1406p pd=1.12u as=0.1406p ps=1.12u w=0.74u l=0.13u
X231 oa_sar8_acore18_opt_0.sw_tg_opt_0.bot.t3 oa_sar8_acore18_opt_0.sw_bitcell_opt_b5_0.bot.t5 cap_cmim l=2.14u w=2.14u
X232 VSS.t309 sar_ctrl_async_phys_0.sg13g2_buf_1$1_6.A a_35384_32176# VSS.t1206 sg13_lv_nmos ad=0.14875p pd=1.16u as=0.187p ps=1.78u w=0.55u l=0.13u
X233 oa_sar8_acore18_opt_0.sw_tg_opt_0.bot.t3 oa_sar8_acore18_opt_0.sw_bitcell_opt_b7_0.bot.t62 cap_cmim l=2.14u w=2.14u
X234 VDD.t17 sar_ctrl_async_phys_0.sg13g2_and2_1$1_0.A sar_ctrl_async_phys_0.sg13g2_nor2_1$1_8.A VDD.t16 sg13_lv_pmos ad=0.2198p pd=1.53u as=0.2128p ps=1.5u w=1.12u l=0.13u
X235 VDD.t18 sar_ctrl_async_phys_0.sg13g2_buf_1$1_2.X.t6 a_31802_37404# VDD.t16 sg13_lv_pmos ad=0.1563p pd=1.22u as=0.147p ps=1.54u w=0.42u l=0.13u
X236 a_34615_31475# a_34767_31359# VDD.t3 VDD.t3 sg13_lv_pmos ad=0.3864p pd=2.93u as=1.96315p ps=12.675u w=1.12u l=0.13u
X237 VDD.t561 sar_ctrl_async_phys_0.sg13g2_a22oi_1$1_3.A2 a_33359_32876# VDD.t76 sg13_lv_pmos ad=0.3808p pd=2.92u as=0.2744p ps=1.61u w=1.12u l=0.13u
X238 VDD.t85 a_30495_39309# a_31162_38948# VDD.t29 sg13_lv_pmos ad=0.2128p pd=1.5u as=0.3864p ps=2.93u w=1.12u l=0.13u
X239 VDD.t0 a_34069_41189# a_34171_41332# VDD.t0 sg13_lv_pmos ad=3.62845p pd=23.965u as=0.3864p ps=2.93u w=1.12u l=0.13u
X240 VSS.t99 sar_ctrl_async_phys_0.sg13g2_buf_1$1_32.A a_34520_42760# VSS.t98 sg13_lv_nmos ad=0.14875p pd=1.16u as=0.187p ps=1.78u w=0.55u l=0.13u
X241 oa_sar8_acore18_opt_0.sw_bitcell_opt_b2_1.bot.t1 sar_ctrl_async_phys_0.dac_code_n[2] VDD.t637 VDD.t635 sg13_lv_pmos ad=0.741p pd=4.19u as=1.33p ps=8.3u w=3.8u l=0.13u
X242 a_31247_32876# sar_ctrl_async_phys_0.sg13g2_buf_1$1_7.A sar_ctrl_async_phys_0.sg13g2_inv_1$1_6.A VDD.t76 sg13_lv_pmos ad=0.2744p pd=1.61u as=0.2128p ps=1.5u w=1.12u l=0.13u
X243 a_31830_40898# a_32635_40471# a_32090_40428# VDD.t317 sg13_lv_pmos ad=0.1428p pd=1.52u as=79.8f ps=0.8u w=0.42u l=0.13u
X244 VSS.t348 VDD.t82 VSS.t348 VSS.t920 sg13_lv_nmos ad=0.1428p pd=1.52u as=0 ps=0 w=0.42u l=1u
X245 oa_sar8_acore18_opt_0.sw_tg_opt_0.bot.t3 oa_sar8_acore18_opt_0.sw_bitcell_opt_b7_0.bot.t141 cap_cmim l=2.14u w=2.14u
X246 sar_ctrl_async_phys_0.sg13g2_nor2_1$1_10.A sar_ctrl_async_phys_0.sg13g2_nor2b_1$1_0.A VSS.t46 VSS.t232 sg13_lv_nmos ad=0.1406p pd=1.12u as=0.2516p ps=2.16u w=0.74u l=0.13u
X247 a_33948_41936# sar_ctrl_async_phys_0.sg13g2_buf_1$1_2.A VDD.t501 VDD.t0 sg13_lv_pmos ad=0.2856p pd=2.36u as=0.2114p ps=1.54u w=0.84u l=0.13u
X248 a_31947_41508# sar_ctrl_async_phys_0.sg13g2_a21oi_1$1_5.A2 VDD.t114 VDD.t0 sg13_lv_pmos ad=0.3808p pd=2.92u as=0.2128p ps=1.5u w=1.12u l=0.13u
X249 oa_sar8_acore18_opt_0.sw_tg_opt_1.bot.t3 oa_sar8_acore18_opt_0.sw_bitcell_opt_b4_1.bot.t26 cap_cmim l=2.14u w=2.14u
X250 VDD.t258 a_31935_36285# a_32602_35924# VDD.t19 sg13_lv_pmos ad=0.2128p pd=1.5u as=0.3864p ps=2.93u w=1.12u l=0.13u
X251 VDD.t416 sar_ctrl_async_phys_0.sg13g2_nand2_1$1_3.A sar_ctrl_async_phys_0.sg13g2_buf_1$1_46.A VDD.t10 sg13_lv_pmos ad=0.3808p pd=2.92u as=0.2128p ps=1.5u w=1.12u l=0.13u
X252 a_33359_33292# sar_ctrl_async_phys_0.sg13g2_a22oi_1$1_3.B1 VSS.t260 VSS.t57 sg13_lv_nmos ad=0.13875p pd=1.115u as=0.2553p ps=2.17u w=0.74u l=0.13u
X253 VSS.t313 a_29238_41972# a_29350_41996# VSS.t378 sg13_lv_nmos ad=0.1426p pd=1.16u as=0.1428p ps=1.52u w=0.42u l=0.5u
X254 a_32538_36972# sar_ctrl_async_phys_0.sg13g2_nor2b_1$1_0.A sar_ctrl_async_phys_0.sg13g2_nor2b_1$1_0.Y VDD.t16 sg13_lv_pmos ad=0.1176p pd=1.33u as=0.3808p ps=2.92u w=1.12u l=0.13u
X255 VDD.t76 a_29749_32117# a_29851_32260# VDD.t76 sg13_lv_pmos ad=1.96315p pd=12.675u as=0.3864p ps=2.93u w=1.12u l=0.13u
X256 VSS.t822 VDD.t33 VSS.t823 VSS.t224 sg13_lv_nmos ad=79.8f pd=0.8u as=0 ps=0 w=0.42u l=1u
X257 a_29750_40885# sar_ctrl_async_phys_0.sg13g2_o21ai_1$1_1.B1.t10 VSS.t537 VSS.t536 sg13_lv_nmos ad=37.8f pd=0.6u as=0.1701p ps=1.65u w=0.42u l=0.13u
X258 a_29941_40471# sar_ctrl_async_phys_0.sg13g2_dfrbpq_1$1_0.CLK.t20 VSS.t287 VSS.t286 sg13_lv_nmos ad=0.2516p pd=2.16u as=4.20675p ps=26.86u w=0.74u l=0.13u
X259 VSS.t946 VDD.t145 VSS.t945 VSS.t944 sg13_lv_nmos ad=0.1428p pd=1.52u as=0 ps=0 w=0.42u l=1u
X260 a_34268_31826# a_34055_31352# VDD.t3 VDD.t3 sg13_lv_pmos ad=79.8f pd=0.8u as=1.96315p ps=12.675u w=0.42u l=0.13u
X261 oa_sar8_acore18_opt_0.sw_tg_opt_1.bot.t3 oa_sar8_acore18_opt_0.sw_bitcell_opt_b7_1.bot.t107 cap_cmim l=2.14u w=2.14u
X262 oa_sar8_acore18_opt_0.sw_tg_opt_1.bot.t4 oa_sar8_acore18_opt_0.sw_bitcell_opt_b7_1.bot.t15 cap_cmim l=2.14u w=2.14u
X263 a_35391_34773# a_34549_34423# a_35297_34773# VSS.t21 sg13_lv_nmos ad=0.12665p pd=1.145u as=0.1428p ps=1.52u w=0.42u l=0.13u
X264 a_33530_39921# a_33973_39677# a_33270_39698# VSS.t8 sg13_lv_nmos ad=79.8f pd=0.8u as=0.1296p ps=1.52u w=0.42u l=0.13u
X265 oa_sar8_acore18_opt_0.sw_tg_opt_0.bot.t3 oa_sar8_acore18_opt_0.sw_bitcell_opt_b6_0.bot.t74 cap_cmim l=2.14u w=2.14u
X266 vcm oa_sar8_acore18_opt_0.sw_bitcell_opt_term_0.trkb.t11 oa_sar8_acore18_opt_0.sw_tg_opt_1.bot.t1 VDD.t669 sg13_lv_pmos ad=0.7p pd=4.7u as=0.39p ps=2.39u w=2u l=0.13u
X267 a_35648_34654# sar_ctrl_async_phys_0.sg13g2_dfrbpq_1$1_0.RESET_B VDD.t322 VDD.t147 sg13_lv_pmos ad=79.8f pd=0.8u as=2.2076p ps=14.4u w=0.42u l=0.13u
X268 VSS.t777 VDD.t13 VSS.t775 VSS.t804 sg13_lv_nmos ad=0.1428p pd=1.52u as=0 ps=0 w=0.42u l=1u
X269 a_35072_39918# sar_ctrl_async_phys_0.sg13g2_o21ai_1$1_1.B1.t3 VDD.t317 VDD.t317 sg13_lv_pmos ad=79.8f pd=0.8u as=1.55472p ps=9.945u w=0.42u l=0.13u
X270 VDD.t238 VSS.t44 VDD.t229 VDD.t147 sg13_lv_pmos ad=0.34p pd=2.68u as=0 ps=0 w=1u l=1u
X271 oa_sar8_acore18_opt_0.sw_tg_opt_1.bot.t3 oa_sar8_acore18_opt_0.sw_bitcell_opt_b6_1.bot.t2 cap_cmim l=2.14u w=2.14u
X272 oa_sar8_acore18_opt_0.sw_tg_opt_0.bot.t3 oa_sar8_acore18_opt_0.sw_bitcell_opt_b6_0.bot.t29 cap_cmim l=2.14u w=2.14u
X273 VDD.t159 VSS.t948 VDD.t159 VDD.t19 sg13_lv_pmos ad=0.19p pd=1.38u as=0 ps=0 w=1u l=1u
X274 VSS.t428 sar_ctrl_async_phys_0.sg13g2_a22oi_1$1_3.A2 sar_ctrl_async_phys_0.sg13g2_nor2_1$1_15.Y VSS.t427 sg13_lv_nmos ad=0.2516p pd=2.16u as=0.1406p ps=1.12u w=0.74u l=0.13u
X275 a_28008_23477# oa_sar8_acore18_opt_0.sw_tg_opt_1.bot.t5 a_26184_21025# VSS.t703 sg13_lv_nmos ad=0.345p pd=2.69u as=0.19p ps=1.38u w=1u l=0.15u
X276 VSS.t829 VDD.t25 VSS.t831 VSS.t224 sg13_lv_nmos ad=79.8f pd=0.8u as=0 ps=0 w=0.42u l=1u
X277 a_30879_43845# a_30037_43495# a_30785_43845# VSS.t1295 sg13_lv_nmos ad=0.12665p pd=1.145u as=0.1428p ps=1.52u w=0.42u l=0.13u
X278 VSS.t975 VDD.t148 VSS.t975 VSS.t0 sg13_lv_nmos ad=79.8f pd=0.8u as=0 ps=0 w=0.42u l=1u
X279 oa_sar8_acore18_opt_0.sw_tg_opt_0.bot.t3 oa_sar8_acore18_opt_0.sw_bitcell_opt_b7_0.bot.t68 cap_cmim l=2.14u w=2.14u
X280 sar_ctrl_async_phys_0.sg13g2_nand2b_1$1_3.Y a_35053_40730# VDD.t375 VDD.t317 sg13_lv_pmos ad=0.2128p pd=1.5u as=0.3808p ps=2.92u w=1.12u l=0.13u
X281 VSS.t65 VDD.t120 VSS.t65 VSS.t913 sg13_lv_nmos ad=79.8f pd=0.8u as=0 ps=0 w=0.42u l=1u
X282 a_33183_32215# a_32341_32117# a_33089_32215# VSS.t58 sg13_lv_nmos ad=0.12665p pd=1.145u as=0.1428p ps=1.52u w=0.42u l=0.13u
X283 VSS.t786 VDD.t6 VSS.t783 VSS.t810 sg13_lv_nmos ad=0.1428p pd=1.52u as=0 ps=0 w=0.42u l=1u
X284 VDD.t289 VSS.t979 VDD.t289 VDD.t19 sg13_lv_pmos ad=0.19p pd=1.38u as=0 ps=0 w=1u l=1u
X285 VSS.t823 VDD.t13 VSS.t824 VSS.t224 sg13_lv_nmos ad=79.8f pd=0.8u as=0 ps=0 w=0.42u l=1u
X286 VDD.t79 sar_ctrl_async_phys_0.sg13g2_inv_1$1_5.A sar_ctrl_async_phys_0.sg13g2_inv_1$1_5.Y VDD.t3 sg13_lv_pmos ad=0.3808p pd=2.92u as=0.3808p ps=2.92u w=1.12u l=0.13u
X287 a_33652_41528# a_34171_41332# a_34911_41287# VSS.t1232 sg13_lv_nmos ad=0.3473p pd=2.71u as=0.12665p ps=1.145u w=0.74u l=0.13u
X288 a_29977_43531# a_29620_43488# VDD.t25 VDD.t22 sg13_lv_pmos ad=63f pd=0.72u as=0.1563p ps=1.22u w=0.42u l=0.13u
X289 VDD.t496 sar_ctrl_async_phys_0.dac_code[4] oa_sar8_acore18_opt_0.sw_bitcell_opt_b4_0.bot.t0 VDD.t495 sg13_lv_pmos ad=1.68p pd=10.3u as=0.936p ps=5.19u w=4.8u l=0.13u
X290 VDD.t24 VSS.t828 VDD.t23 VDD.t22 sg13_lv_pmos ad=0.19p pd=1.38u as=0 ps=0 w=1u l=1u
X291 VSS.t210 a_35664_37695# sar_ctrl_async_phys_0.sg13g2_buf_1$1_4.A VSS.t14 sg13_lv_nmos ad=0.1331p pd=1.12u as=0.2516p ps=2.16u w=0.74u l=0.13u
X292 VDD.t20 a_28758_35924# a_28870_35948# VDD.t19 sg13_lv_pmos ad=0.2254p pd=1.53u as=0.34p ps=2.68u w=1u l=0.5u
X293 VDD.t289 sar_ctrl_async_phys_0.sg13g2_dfrbpq_1$1_0.CLK.t12 a_27624_35965# VDD.t19 sg13_lv_pmos ad=0.1523p pd=1.38u as=0.1428p ps=1.52u w=0.42u l=0.13u
X294 VDD.t18 sar_ctrl_async_phys_0.sg13g2_buf_1$1_2.X.t6 a_31542_37874# VDD.t16 sg13_lv_pmos ad=0.36237p pd=2.605u as=79.8f ps=0.8u w=0.42u l=0.13u
X295 a_30746_31356# a_31189_31399# a_30486_31826# VSS.t80 sg13_lv_nmos ad=79.8f pd=0.8u as=0.1296p ps=1.52u w=0.42u l=0.13u
X296 a_29558_32151# sar_ctrl_async_phys_0.sg13g2_buf_1$1_6.X VSS.t455 VSS.t454 sg13_lv_nmos ad=37.8f pd=0.6u as=0.1701p ps=1.65u w=0.42u l=0.13u
X297 a_29812_33968# a_29786_33873# VDD.t233 VDD.t147 sg13_lv_pmos ad=0.34p pd=2.68u as=0.36237p ps=2.605u w=1u l=0.13u
X298 a_29334_43922# sar_ctrl_async_phys_0.sg13g2_nor2_1$1_10.A VDD.t25 VDD.t22 sg13_lv_pmos ad=79.8f pd=0.8u as=0.1428p ps=1.52u w=0.42u l=0.13u
X299 a_33844_43488# a_33818_43452# VSS.t128 VSS.t492 sg13_lv_nmos ad=0.2516p pd=2.16u as=0.1626p ps=1.415u w=0.74u l=0.13u
X300 oa_sar8_acore18_opt_0.sw_tg_opt_0.bot.t3 oa_sar8_acore18_opt_0.sw_bitcell_opt_b7_0.bot.t25 cap_cmim l=2.14u w=2.14u
X301 oa_sar8_acore18_opt_0.sw_tg_opt_1.bot.t3 oa_sar8_acore18_opt_0.sw_bitcell_opt_b6_1.bot.t62 cap_cmim l=2.14u w=2.14u
X302 a_32137_40013# a_31195_39820# a_31935_39775# VDD.t317 sg13_lv_pmos ad=93.45f pd=0.865u as=0.2048p ps=1.63u w=0.42u l=0.13u
X303 a_32991_45357# a_32149_45007# a_31732_45000# VDD.t5 sg13_lv_pmos ad=0.2048p pd=1.63u as=0.34p ps=2.68u w=1u l=0.13u
X304 sar_ctrl_async_phys_0.sg13g2_a21oi_1$1_3.B1 a_35245_42242# VDD.t562 VDD.t0 sg13_lv_pmos ad=0.2128p pd=1.5u as=0.3808p ps=2.92u w=1.12u l=0.13u
X305 VSS.t272 sar_ctrl_async_phys_0.sg13g2_o21ai_1$1_1.B1.t2 a_29044_39386# VSS.t458 sg13_lv_nmos ad=0.1626p pd=1.415u as=60.89999f ps=0.71u w=0.42u l=0.13u
X306 VDD.t169 VSS.t65 VDD.t169 VDD.t16 sg13_lv_pmos ad=0.34p pd=2.68u as=0 ps=0 w=1u l=1u
X307 VDD.t10 a_32223_46869# a_32480_46750# VDD.t10 sg13_lv_pmos ad=2.2076p pd=14.4u as=79.8f ps=0.8u w=0.42u l=0.13u
X308 sar_ctrl_async_phys_0.sg13g2_dlygate4sd3_1$1_1.A a_28006_35948# VDD.t289 VDD.t19 sg13_lv_pmos ad=0.4256p pd=3u as=0.2254p ps=1.53u w=1.12u l=0.13u
X309 VDD.t114 a_32400_41413# sar_ctrl_async_phys_0.sg13g2_and2_1$1_6.X VDD.t0 sg13_lv_pmos ad=0.1918p pd=1.5u as=0.3808p ps=2.92u w=1.12u l=0.13u
X310 sar_ctrl_async_phys_0.sg13g2_dfrbpq_1$1_5.D a_30830_35166# VDD.t20 VDD.t19 sg13_lv_pmos ad=0.6048p pd=3.32u as=0.2198p ps=1.52u w=1.12u l=0.13u
X311 sar_ctrl_async_phys_0.dac_code[3] a_36056_42760# VDD.t330 VDD.t22 sg13_lv_pmos ad=0.42p pd=2.99u as=0.2114p ps=1.54u w=1.12u l=0.13u
X312 a_35593_30941# a_34651_30748# a_35391_30703# VDD.t3 sg13_lv_pmos ad=93.45f pd=0.865u as=0.2048p ps=1.63u w=0.42u l=0.13u
X313 VDD.t247 VSS.t1031 VDD.t77 VDD.t76 sg13_lv_pmos ad=0.34p pd=2.68u as=0 ps=0 w=1u l=1u
X314 a_31446_35162# sar_ctrl_async_phys_0.sg13g2_dfrbpq_1$1_5.D VDD.t20 VDD.t19 sg13_lv_pmos ad=79.8f pd=0.8u as=0.1428p ps=1.52u w=0.42u l=0.13u
X315 oa_sar8_acore18_opt_0.sw_tg_opt_0.bot.t3 oa_sar8_acore18_opt_0.sw_bitcell_opt_b7_0.bot.t110 cap_cmim l=2.14u w=2.14u
X316 a_31716_38912# sar_ctrl_async_phys_0.sg13g2_and2_1$1_0.X VSS.t107 VSS.t549 sg13_lv_nmos ad=0.187p pd=1.78u as=0.17255p ps=1.25u w=0.55u l=0.13u
X317 VDD.t146 sar_ctrl_async_phys_0.sg13g2_buf_1$1_2.X.t7 sar_ctrl_async_phys_0.sg13g2_nand2_1$1_1.Y VDD.t16 sg13_lv_pmos ad=0.3808p pd=2.92u as=0.2128p ps=1.5u w=1.12u l=0.13u
X318 oa_sar8_acore18_opt_0.sw_tg_opt_0.bot.t3 oa_sar8_acore18_opt_0.sw_bitcell_opt_b4_0.bot.t20 cap_cmim l=2.14u w=2.14u
X319 oa_sar8_acore18_opt_0.sw_tg_opt_0.bot.t1 oa_sar8_acore18_opt_0.sw_bitcell_opt_term_0.trkb.t10 vcm VDD.t883 sg13_lv_pmos ad=0.39p pd=2.39u as=0.7p ps=4.7u w=2u l=0.13u
X320 VDD.t51 VSS.t737 VDD.t51 VDD.t10 sg13_lv_pmos ad=0.19p pd=1.38u as=0 ps=0 w=1u l=1u
X321 oa_sar8_acore18_opt_0.sw_tg_opt_0.bot.t3 oa_sar8_acore18_opt_0.sw_bitcell_opt_b7_0.bot.t52 cap_cmim l=2.14u w=2.14u
X322 oa_sar8_acore18_opt_0.sw_tg_opt_1.bot.t4 oa_sar8_acore18_opt_0.sw_bitcell_opt_b7_1.bot.t5 cap_cmim l=2.14u w=2.14u
X323 oa_sar8_acore18_opt_0.sw_tg_opt_0.bot.t3 oa_sar8_acore18_opt_0.sw_bitcell_opt_b4_0.bot.t8 cap_cmim l=2.14u w=2.14u
X324 oa_sar8_acore18_opt_0.sw_bitcell_opt_term_0.VSS sar_ctrl_async_phys_0.dac_code[2] oa_sar8_acore18_opt_0.sw_bitcell_opt_b2_0.bot.t1 VSS.t200 sg13_lv_nmos ad=0.665p pd=4.5u as=0.3705p ps=2.29u w=1.9u l=0.13u
X325 a_33940_30626# sar_ctrl_async_phys_0.sg13g2_inv_1$1_2.Y a_33846_30626# VSS.t375 sg13_lv_nmos ad=60.89999f pd=0.71u as=0.1428p ps=1.52u w=0.42u l=0.13u
X326 VDD.t431 sar_ctrl_async_phys_0.sg13g2_and2_1$1_6.X a_34904_38948# VDD.t29 sg13_lv_pmos ad=0.2114p pd=1.54u as=0.2856p ps=2.36u w=0.84u l=0.13u
X327 a_32031_31749# a_31189_31399# a_30772_31392# VDD.t3 sg13_lv_pmos ad=0.2048p pd=1.63u as=0.34p ps=2.68u w=1u l=0.13u
X328 a_33359_32876# sar_ctrl_async_phys_0.sg13g2_buf_1$1_8.A sar_ctrl_async_phys_0.sg13g2_inv_1$1_0.A VDD.t76 sg13_lv_pmos ad=0.2744p pd=1.61u as=0.2128p ps=1.5u w=1.12u l=0.13u
X329 VDD.t721 sar_ctrl_async_phys_0.sg13g2_inv_1$1_10.Y a_28236_40440# VDD.t317 sg13_lv_pmos ad=0.3808p pd=2.92u as=0.2128p ps=1.5u w=1.12u l=0.15u
X330 a_30848_32358# sar_ctrl_async_phys_0.sg13g2_buf_1$1_6.X VDD.t76 VDD.t76 sg13_lv_pmos ad=79.8f pd=0.8u as=1.79957p ps=11.62u w=0.42u l=0.13u
X331 VDD.t51 VSS.t786 VDD.t51 VDD.t10 sg13_lv_pmos ad=0.34p pd=2.68u as=0 ps=0 w=1u l=1u
X332 a_31823_32876# sar_ctrl_async_phys_0.sg13g2_a22oi_1$1_2.B2 sar_ctrl_async_phys_0.sg13g2_a22oi_1$1_2.Y VDD.t76 sg13_lv_pmos ad=0.2744p pd=1.61u as=0.2128p ps=1.5u w=1.12u l=0.13u
X333 a_35648_34654# a_35391_34773# a_35810_34850# VSS.t21 sg13_lv_nmos ad=0.1428p pd=1.52u as=37.8f ps=0.6u w=0.42u l=0.13u
X334 VDD.t361 sar_ctrl_async_phys_0.sg13g2_nand2b_1$1_0.A_N a_28651_39740# VDD.t317 sg13_lv_pmos ad=0.2198p pd=1.53u as=0.2856p ps=2.36u w=0.84u l=0.13u
X335 oa_sar8_acore18_opt_0.sw_tg_opt_0.bot.t3 oa_sar8_acore18_opt_0.sw_bitcell_opt_b6_0.bot.t9 cap_cmim l=2.14u w=2.14u
X336 a_35659_31435# a_34767_31359# a_35557_31435# VDD.t3 sg13_lv_pmos ad=63f pd=0.72u as=79.8f ps=0.8u w=0.42u l=0.13u
X337 VSS.t17 sar_ctrl_async_phys_0.sg13g2_buf_1$1_6.X a_30580_31826# VSS.t450 sg13_lv_nmos ad=0.1626p pd=1.415u as=60.89999f ps=0.71u w=0.42u l=0.13u
X338 a_33652_36674# sar_ctrl_async_phys_0.sg13g2_nor2b_1$1_1.Y a_33558_36674# VSS.t234 sg13_lv_nmos ad=60.89999f pd=0.71u as=0.1428p ps=1.52u w=0.42u l=0.13u
X339 sar_ctrl_async_phys_0.dac_code_n[5] a_36056_47296# VSS.t152 VSS.t41 sg13_lv_nmos ad=0.2886p pd=2.26u as=0.14875p ps=1.16u w=0.74u l=0.13u
X340 VSS.t836 VDD.t8 VSS.t836 VSS.t837 sg13_lv_nmos ad=0.1428p pd=1.52u as=0 ps=0 w=0.42u l=1u
X341 VDD.t558 sar_ctrl_async_phys_0.sg13g2_and2_1$1_0.X a_35672_38224# VDD.t29 sg13_lv_pmos ad=0.2114p pd=1.54u as=0.2856p ps=2.36u w=0.84u l=0.13u
X342 oa_sar8_acore18_opt_0.sw_bitcell_opt_term_0.trkb.t0 sar_ctrl_async_phys_0.sample VSS.t390 VSS.t389 sg13_lv_nmos ad=0.195p pd=1.39u as=0.35p ps=2.7u w=1u l=0.13u
X343 sar_ctrl_async_phys_0.sg13g2_nor2b_1$1_2.Y sar_ctrl_async_phys_0.sg13g2_a22oi_1$1_0.A1 VSS.t15 VSS.t14 sg13_lv_nmos ad=0.1406p pd=1.12u as=0.2516p ps=2.16u w=0.74u l=0.13u
X344 oa_sar8_acore18_opt_0.sw_tg_opt_1.bot.t3 oa_sar8_acore18_opt_0.sw_bitcell_opt_b7_1.bot.t142 cap_cmim l=2.14u w=2.14u
X345 a_34489_31017# a_34132_30944# VDD.t592 VDD.t3 sg13_lv_pmos ad=63f pd=0.72u as=0.1563p ps=1.22u w=0.42u l=0.13u
X346 a_31823_33292# sar_ctrl_async_phys_0.sg13g2_a22oi_1$1_0.B1 VSS.t481 VSS.t57 sg13_lv_nmos ad=0.13875p pd=1.115u as=0.2553p ps=2.17u w=0.74u l=0.13u
X347 VSS.t650 VDD.t30 VSS.t899 VSS.t103 sg13_lv_nmos ad=0.1428p pd=1.52u as=0 ps=0 w=0.42u l=1u
X348 a_32580_43448# sar_ctrl_async_phys_0.sg13g2_buf_1$1_20.A VDD.t219 VDD.t22 sg13_lv_pmos ad=0.2856p pd=2.36u as=0.2618p ps=1.63u w=0.84u l=0.13u
X349 VDD.t603 sar_ctrl_async_phys_0.sg13g2_buf_1$1_6.X a_33846_30626# VDD.t3 sg13_lv_pmos ad=0.36237p pd=2.605u as=79.8f ps=0.8u w=0.42u l=0.13u
X350 oa_sar8_acore18_opt_0.sw_tg_opt_0.bot.t3 oa_sar8_acore18_opt_0.sw_bitcell_opt_b6_0.bot.t69 cap_cmim l=2.14u w=2.14u
X351 a_30944_35166# sar_ctrl_async_phys_0.sg13g2_buf_1$1_1.A a_30830_35166# VSS.t0 sg13_lv_nmos ad=0.3367p pd=1.65u as=0.1628p ps=1.18u w=0.74u l=0.13u
X352 oa_sar8_acore18_opt_0.sw_tg_opt_1.bot.t3 oa_sar8_acore18_opt_0.sw_bitcell_opt_b5_1.bot.t10 cap_cmim l=2.14u w=2.14u
X353 oa_sar8_acore18_opt_0.sw_bitcell_opt_b7_1.VSS sar_ctrl_async_phys_0.hold_req VSS.t511 VSS.t512 sg13_lv_nmos ad=0.39p pd=2.39u as=0.7p ps=4.7u w=2u l=0.13u
X354 sar_ctrl_async_phys_0.sg13g2_dlygate4sd3_1$1_3.A a_28774_41278# VDD.t1 VDD.t0 sg13_lv_pmos ad=0.4256p pd=3u as=0.2254p ps=1.53u w=1.12u l=0.13u
X355 VSS.t1032 VDD.t233 VSS.t1034 VSS.t1033 sg13_lv_nmos ad=79.8f pd=0.8u as=0 ps=0 w=0.42u l=1u
X356 oa_sar8_acore18_opt_0.sw_tg_opt_1.bot.t3 oa_sar8_acore18_opt_0.sw_bitcell_opt_b7_1.bot.t2 cap_cmim l=2.14u w=2.14u
X357 VSS.t46 VDD.t2 VSS.t46 VSS.t871 sg13_lv_nmos ad=0.1428p pd=1.52u as=0 ps=0 w=0.42u l=1u
X358 a_33558_43922# a_34363_43495# a_33818_43452# VDD.t22 sg13_lv_pmos ad=0.1428p pd=1.52u as=79.8f ps=0.8u w=0.42u l=0.13u
X359 a_32116_40464# a_32090_40428# VDD.t326 VDD.t317 sg13_lv_pmos ad=0.34p pd=2.68u as=0.36237p ps=2.605u w=1u l=0.13u
X360 oa_sar8_acore18_opt_0.sw_tg_opt_0.bot.t3 oa_sar8_acore18_opt_0.sw_bitcell_opt_b5_0.bot.t15 cap_cmim l=2.14u w=2.14u
X361 VDD.t416 sar_ctrl_async_phys_0.sg13g2_buf_1$1_46.A a_36056_46508# VDD.t10 sg13_lv_pmos ad=0.2114p pd=1.54u as=0.2856p ps=2.36u w=0.84u l=0.13u
X362 a_32521_44549# a_31579_44356# a_32319_44311# VDD.t5 sg13_lv_pmos ad=93.45f pd=0.865u as=0.2048p ps=1.63u w=0.42u l=0.13u
X363 a_34201_37065# a_33844_36992# VDD.t320 VDD.t16 sg13_lv_pmos ad=63f pd=0.72u as=0.1563p ps=1.22u w=0.42u l=0.13u
X364 a_32715_43020# sar_ctrl_async_phys_0.sg13g2_a21oi_1$1_6.B1 sar_ctrl_async_phys_0.sg13g2_a22oi_1$1_2.A2 VDD.t22 sg13_lv_pmos ad=0.2128p pd=1.5u as=0.3808p ps=2.92u w=1.12u l=0.13u
X365 oa_sar8_acore18_opt_0.sw_tg_opt_0.bot.t3 oa_sar8_acore18_opt_0.sw_bitcell_opt_b6_0.bot.t54 cap_cmim l=2.14u w=2.14u
X366 VSS.t1027 VDD.t77 VSS.t1029 VSS.t1028 sg13_lv_nmos ad=79.8f pd=0.8u as=0 ps=0 w=0.42u l=1u
X367 VSS.t506 sar_ctrl_async_phys_0.sg13g2_nand2b_1$1_1.B a_35327_42342# VSS.t1170 sg13_lv_nmos ad=0.14505p pd=1.15u as=0.1406p ps=1.12u w=0.74u l=0.13u
X368 a_25878_40460# a_25608_40501# VSS.t240 VSS.t567 sg13_lv_nmos ad=0.1428p pd=1.52u as=79.8f ps=0.8u w=0.42u l=0.5u
X369 a_31060_31813# a_30772_31392# a_30998_31813# VSS.t294 sg13_lv_nmos ad=0.1428p pd=1.52u as=37.8f ps=0.6u w=0.42u l=0.13u
X370 sar_ctrl_async_phys_0.sg13g2_buf_1$1_3.A a_35288_38224# VSS.t210 VSS.t177 sg13_lv_nmos ad=0.2886p pd=2.26u as=0.14875p ps=1.16u w=0.74u l=0.13u
X371 sar_ctrl_async_phys_0.sg13g2_a22oi_1$1_1.Y sar_ctrl_async_phys_0.sg13g2_a22oi_1$1_1.B2 a_34319_32120# VSS.t58 sg13_lv_nmos ad=0.2664p pd=1.46u as=0.13875p ps=1.115u w=0.74u l=0.13u
X372 VSS.t29 sar_ctrl_async_phys_0.sg13g2_nor2_1$1_13.B sar_ctrl_async_phys_0.sg13g2_nand2b_1$1_0.A_N VSS.t580 sg13_lv_nmos ad=0.2516p pd=2.16u as=0.1406p ps=1.12u w=0.74u l=0.13u
X373 VDD.t270 VSS.t1024 VDD.t148 VDD.t147 sg13_lv_pmos ad=0.19p pd=1.38u as=0 ps=0 w=1u l=1u
X374 a_26681_38232# sar_ctrl_async_phys_0.sg13g2_buf_1$1_26.X VSS.t65 VSS.t1222 sg13_lv_nmos ad=0.1216p pd=1.02u as=0.1331p ps=1.12u w=0.64u l=0.13u
X375 oa_sar8_acore18_opt_0.sw_tg_opt_1.bot.t3 oa_sar8_acore18_opt_0.sw_bitcell_opt_b5_1.bot.t22 cap_cmim l=2.14u w=2.14u
X376 sar_ctrl_async_phys_0.dac_code_n[0] a_34904_47296# VDD.t175 VDD.t42 sg13_lv_pmos ad=0.42p pd=2.99u as=0.2114p ps=1.54u w=1.12u l=0.13u
X377 VSS.t113 a_34596_40424# sar_ctrl_async_phys_0.sg13g2_nor2b_1$1_3.Y VSS.t153 sg13_lv_nmos ad=0.17255p pd=1.25u as=0.1406p ps=1.12u w=0.74u l=0.13u
X378 oa_sar8_acore18_opt_0.sw_tg_opt_1.bot.t3 oa_sar8_acore18_opt_0.sw_bitcell_opt_b7_1.bot.t100 cap_cmim l=2.14u w=2.14u
X379 VSS.t40 VDD.t43 VSS.t40 VSS.t726 sg13_lv_nmos ad=79.8f pd=0.8u as=0 ps=0 w=0.42u l=1u
X380 VDD.t1 a_29238_41972# a_29350_41996# VDD.t0 sg13_lv_pmos ad=0.2254p pd=1.53u as=0.34p ps=2.68u w=1u l=0.5u
X381 VSS.t82 a_32341_32117# a_32443_32260# VSS.t661 sg13_lv_nmos ad=4.0265p pd=25.31u as=0.2516p ps=2.16u w=0.74u l=0.13u
X382 a_29620_33650# sar_ctrl_async_phys_0.sg13g2_inv_1$1_6.Y a_29526_33650# VSS.t251 sg13_lv_nmos ad=60.89999f pd=0.71u as=0.1428p ps=1.52u w=0.42u l=0.13u
X383 sar_ctrl_async_phys_0.sg13g2_and2_1$1_3.A a_25496_34412# VDD.t309 VDD.t147 sg13_lv_pmos ad=0.42p pd=2.99u as=0.2114p ps=1.54u w=1.12u l=0.13u
X384 VDD.t145 VSS.t65 VDD.t145 VDD.t16 sg13_lv_pmos ad=0.34p pd=2.68u as=0 ps=0 w=1u l=1u
X385 VDD.t252 VSS.t15 VDD.t251 VDD.t29 sg13_lv_pmos ad=0.34p pd=2.68u as=0 ps=0 w=1u l=1u
X386 oa_sar8_acore18_opt_0.sw_tg_opt_0.bot.t4 oa_sar8_acore18_opt_0.sw_bitcell_opt_b7_0.bot.t15 cap_cmim l=2.14u w=2.14u
X387 oa_sar8_acore18_opt_0.sw_tg_opt_1.bot.t3 oa_sar8_acore18_opt_0.sw_bitcell_opt_b6_1.bot.t35 cap_cmim l=2.14u w=2.14u
X388 sar_ctrl_async_phys_0.bit_active[1] a_36056_33688# VSS.t92 VSS.t91 sg13_lv_nmos ad=0.2886p pd=2.26u as=0.14875p ps=1.16u w=0.74u l=0.13u
X389 VSS.t128 sar_ctrl_async_phys_0.sg13g2_buf_1$1_41.X a_33748_44234# VSS.t129 sg13_lv_nmos ad=0.1626p pd=1.415u as=60.89999f ps=0.71u w=0.42u l=0.13u
X390 VDD.t686 sar_ctrl_async_phys_0.dac_code_n[7].t2 oa_sar8_acore18_opt_0.sw_bitcell_opt_b7_1.bot.t1 VDD.t685 sg13_lv_pmos ad=2.38p pd=14.3u as=1.326p ps=7.19u w=6.8u l=0.13u
X391 VSS.t975 VDD.t289 VSS.t975 VSS.t0 sg13_lv_nmos ad=0.1428p pd=1.52u as=0 ps=0 w=0.42u l=1u
X392 a_32020_45421# a_31732_45000# a_31958_45421# VSS.t676 sg13_lv_nmos ad=0.1428p pd=1.52u as=37.8f ps=0.6u w=0.42u l=0.13u
X393 a_25596_41174# sar_ctrl_async_phys_0.sg13g2_nor4_1$1_0.Y VSS.t383 VSS.t1276 sg13_lv_nmos ad=0.187p pd=1.78u as=0.14875p ps=1.16u w=0.55u l=0.13u
X394 a_31898_32361# a_32341_32117# a_32281_32529# VDD.t76 sg13_lv_pmos ad=79.8f pd=0.8u as=63f ps=0.72u w=0.42u l=0.13u
X395 a_33844_36362# sar_ctrl_async_phys_0.sg13g2_nor2b_1$1_2.Y a_33750_36362# VSS.t74 sg13_lv_nmos ad=60.89999f pd=0.71u as=0.1428p ps=1.52u w=0.42u l=0.13u
X396 VDD.t359 sar_ctrl_async_phys_0.sg13g2_a21oi_1$1_0.A1 a_33675_43020# VDD.t22 sg13_lv_pmos ad=0.2128p pd=1.5u as=0.2128p ps=1.5u w=1.12u l=0.13u
X397 VSS.t99 a_33276_42686# sar_ctrl_async_phys_0.sg13g2_buf_1$1_37.A VSS.t250 sg13_lv_nmos ad=0.14875p pd=1.16u as=0.2886p ps=2.26u w=0.74u l=0.13u
X398 VSS.t248 sar_ctrl_async_phys_0.sg13g2_o21ai_1$1_1.B1.t4 a_33364_39698# VSS.t247 sg13_lv_nmos ad=0.1626p pd=1.415u as=60.89999f ps=0.71u w=0.42u l=0.13u
X399 VDD.t330 sar_ctrl_async_phys_0.sg13g2_nand2_1$1_3.Y a_35672_42760# VDD.t22 sg13_lv_pmos ad=0.2114p pd=1.54u as=0.2856p ps=2.36u w=0.84u l=0.13u
X400 a_32817_42748# sar_ctrl_async_phys_0.sg13g2_a21oi_1$1_0.A1 sar_ctrl_async_phys_0.sg13g2_a22oi_1$1_2.A2 VSS.t69 sg13_lv_nmos ad=0.1406p pd=1.12u as=0.1406p ps=1.12u w=0.74u l=0.13u
X401 VSS.t907 VDD.t1088 VSS.t906 VSS.t905 sg13_lv_nmos ad=0.1428p pd=1.52u as=0 ps=0 w=0.42u l=1u
X402 sar_ctrl_async_phys_0.dac_code[1] a_34520_42760# VDD.t330 VDD.t22 sg13_lv_pmos ad=0.42p pd=2.99u as=0.2114p ps=1.54u w=1.12u l=0.13u
X403 a_33210_36972# sar_ctrl_async_phys_0.sg13g2_nor2b_1$1_0.A sar_ctrl_async_phys_0.sg13g2_nor2b_1$1_1.Y VDD.t16 sg13_lv_pmos ad=0.1176p pd=1.33u as=0.3808p ps=2.92u w=1.12u l=0.13u
X404 VDD.t175 sar_ctrl_async_phys_0.sg13g2_buf_1$1_42.A a_34904_47296# VDD.t42 sg13_lv_pmos ad=0.2114p pd=1.54u as=0.2856p ps=2.36u w=0.84u l=0.13u
X405 VDD.t147 a_31071_33727# a_31328_33870# VDD.t147 sg13_lv_pmos ad=2.2076p pd=14.4u as=79.8f ps=0.8u w=0.42u l=0.13u
X406 VDD.t10 a_33951_45823# a_34208_45966# VDD.t10 sg13_lv_pmos ad=2.2076p pd=14.4u as=79.8f ps=0.8u w=0.42u l=0.13u
X407 VDD.t349 sar_ctrl_async_phys_0.sg13g2_nand2b_1$1_1.B sar_ctrl_async_phys_0.sg13g2_a21oi_1$1_6.B1 VDD.t5 sg13_lv_pmos ad=0.2198p pd=1.53u as=0.2128p ps=1.5u w=1.12u l=0.13u
X408 sar_ctrl_async_phys_0.sg13g2_nor2_1$1_13.A sar_ctrl_async_phys_0.sg13g2_o21ai_1$1_1.B1.t11 VDD.t721 VDD.t317 sg13_lv_pmos ad=0.2128p pd=1.5u as=0.3808p ps=2.92u w=1.12u l=0.15u
X409 VSS.t970 VDD.t270 VSS.t970 VSS.t0 sg13_lv_nmos ad=0.1428p pd=1.52u as=0 ps=0 w=0.42u l=1u
X410 VSS.t111 sar_ctrl_async_phys_0.sg13g2_and2_1$1_0.A sar_ctrl_async_phys_0.sg13g2_nor2_1$1_12.Y VSS.t335 sg13_lv_nmos ad=0.2516p pd=2.16u as=0.1406p ps=1.12u w=0.74u l=0.13u
X411 a_30914_39386# sar_ctrl_async_phys_0.sg13g2_o21ai_1$1_1.B1.t1 VSS.t243 VSS.t494 sg13_lv_nmos ad=37.8f pd=0.6u as=79.8f ps=0.8u w=0.42u l=0.13u
X412 oa_sar8_acore18_opt_0.sw_tg_opt_0.bot.t3 oa_sar8_acore18_opt_0.sw_bitcell_opt_b3_0.bot.t4 cap_cmim l=2.14u w=2.14u
X413 sar_ctrl_async_phys_0.sg13g2_a22oi_1$1_1.A2 sar_ctrl_async_phys_0.sg13g2_a21oi_1$1_0.B1 VSS.t401 VSS.t14 sg13_lv_nmos ad=0.1406p pd=1.12u as=0.2516p ps=2.16u w=0.74u l=0.13u
X414 oa_sar8_acore18_opt_0.sw_tg_opt_0.bot.t3 oa_sar8_acore18_opt_0.sw_bitcell_opt_b7_0.bot.t83 cap_cmim l=2.14u w=2.14u
X415 a_34549_32911# sar_ctrl_async_phys_0.sg13g2_dfrbpq_1$1_0.CLK.t6 VDD.t76 VDD.t76 sg13_lv_pmos ad=0.4088p pd=2.97u as=1.79957p ps=11.62u w=1.12u l=0.13u
X416 sar_ctrl_async_phys_0.sg13g2_a21oi_1$1_0.A2 a_35962_35924# VSS.t277 VSS.t369 sg13_lv_nmos ad=0.2516p pd=2.16u as=0.1406p ps=1.12u w=0.74u l=0.13u
X417 a_34324_36349# a_34555_35935# a_34010_35892# VSS.t641 sg13_lv_nmos ad=0.2373p pd=1.97u as=79.8f ps=0.8u w=0.42u l=0.13u
X418 a_28862_36863# a_28977_36864# VDD.t146 VDD.t16 sg13_lv_pmos ad=0.34p pd=2.68u as=0.2254p ps=1.53u w=1u l=0.5u
X419 VDD.t4 sar_ctrl_async_phys_0.sg13g2_buf_1$1_10.A a_33080_30664# VDD.t3 sg13_lv_pmos ad=0.2114p pd=1.54u as=0.2856p ps=2.36u w=0.84u l=0.13u
X420 oa_sar8_acore18_opt_0.sw_bitcell_opt_b6_1.bot.t0 sar_ctrl_async_phys_0.dac_code_n[6] oa_sar8_acore18_opt_0.sw_bitcell_opt_b7_1.VSS VSS.t571 sg13_lv_nmos ad=0.585p pd=3.39u as=1.05p ps=6.7u w=3u l=0.13u
X421 VSS.t118 VDD.t130 VSS.t118 VSS.t741 sg13_lv_nmos ad=79.8f pd=0.8u as=0 ps=0 w=0.42u l=1u
X422 oa_sar8_acore18_opt_0.sw_tg_opt_1.bot.t3 oa_sar8_acore18_opt_0.sw_bitcell_opt_b7_1.bot.t31 cap_cmim l=2.14u w=2.14u
X423 sar_ctrl_async_phys_0.sg13g2_buf_1$1_0.A a_31258_32436# VDD.t345 VDD.t76 sg13_lv_pmos ad=0.3808p pd=2.92u as=0.2128p ps=1.5u w=1.12u l=0.13u
X424 VDD.t43 VSS.t40 VDD.t43 VDD.t42 sg13_lv_pmos ad=0.34p pd=2.68u as=0 ps=0 w=1u l=1u
X425 a_29524_39373# a_29236_38952# a_29462_39373# VSS.t255 sg13_lv_nmos ad=0.1428p pd=1.52u as=37.8f ps=0.6u w=0.42u l=0.13u
X426 VSS.t783 VDD.t51 VSS.t783 VSS.t784 sg13_lv_nmos ad=0.1428p pd=1.52u as=0 ps=0 w=0.42u l=1u
X427 VSS.t554 a_32192_39918# a_31841_39775# VSS.t202 sg13_lv_nmos ad=79.8f pd=0.8u as=0.1428p ps=1.52u w=0.42u l=0.13u
X428 a_29258_36642# sar_ctrl_async_phys_0.sg13g2_dlygate4sd3_1$1_0.A VDD.t146 VDD.t16 sg13_lv_pmos ad=0.1428p pd=1.52u as=0.1523p ps=1.38u w=0.42u l=0.13u
X429 oa_sar8_acore18_opt_0.sw_tg_opt_0.bot.t3 oa_sar8_acore18_opt_0.sw_bitcell_opt_b6_0.bot.t4 cap_cmim l=2.14u w=2.14u
X430 a_30129_39724# sar_ctrl_async_phys_0.sg13g2_a21oi_1$1_0.A1 sar_ctrl_async_phys_0.sg13g2_a21oi_1$1_2.Y VSS.t73 sg13_lv_nmos ad=0.1406p pd=1.12u as=0.1406p ps=1.12u w=0.74u l=0.13u
X431 oa_sar8_acore18_opt_0.sw_tg_opt_0.bot.t3 oa_sar8_acore18_opt_0.sw_bitcell_opt_b7_0.bot.t35 cap_cmim l=2.14u w=2.14u
X432 VDD.t6 VSS.t836 VDD.t6 VDD.t5 sg13_lv_pmos ad=0.19p pd=1.38u as=0 ps=0 w=1u l=1u
X433 VSS.t789 VDD.t6 VSS.t786 VSS.t812 sg13_lv_nmos ad=0.1428p pd=1.52u as=0 ps=0 w=0.42u l=1u
X434 a_32576_44454# a_32319_44311# a_32738_44234# VSS.t478 sg13_lv_nmos ad=0.1428p pd=1.52u as=37.8f ps=0.6u w=0.42u l=0.13u
X435 oa_sar8_acore18_opt_0.sw_bitcell_opt_b7_1.VSS sar_ctrl_async_phys_0.hold_req VSS.t508 VSS.t509 sg13_lv_nmos ad=0.39p pd=2.39u as=0.7p ps=4.7u w=2u l=0.13u
X436 VDD.t20 VSS.t979 VDD.t20 VDD.t19 sg13_lv_pmos ad=0.19p pd=1.38u as=0 ps=0 w=1u l=1u
X437 a_31093_35935# sar_ctrl_async_phys_0.sg13g2_dfrbpq_1$1_0.CLK.t11 VSS.t672 VSS.t708 sg13_lv_nmos ad=0.2516p pd=2.16u as=4.1082p ps=26.51u w=0.74u l=0.13u
X438 sar_ctrl_async_phys_0.cmp_valid a_34520_47296# VSS.t126 VSS.t41 sg13_lv_nmos ad=0.2886p pd=2.26u as=0.14875p ps=1.16u w=0.74u l=0.13u
X439 VDD.t407 a_32991_45357# a_33658_44996# VDD.t5 sg13_lv_pmos ad=0.2128p pd=1.5u as=0.3864p ps=2.93u w=1.12u l=0.13u
X440 a_32192_39918# a_31935_39775# a_32354_39698# VSS.t202 sg13_lv_nmos ad=0.1428p pd=1.52u as=37.8f ps=0.6u w=0.42u l=0.13u
X441 VDD.t270 VSS.t970 VDD.t309 VDD.t147 sg13_lv_pmos ad=0.34p pd=2.68u as=0 ps=0 w=1u l=1u
X442 a_35807_45366# a_35725_45266# sar_ctrl_async_phys_0.sg13g2_a21oi_1$1_1.B1 VSS.t385 sg13_lv_nmos ad=0.1406p pd=1.12u as=0.333p ps=2.38u w=0.74u l=0.13u
X443 oa_sar8_acore18_opt_0.sw_tg_opt_0.bot.t3 oa_sar8_acore18_opt_0.sw_bitcell_opt_b7_0.bot.t44 cap_cmim l=2.14u w=2.14u
X444 oa_sar8_acore18_opt_0.sw_tg_opt_1.bot.t1 oa_sar8_acore18_opt_0.sw_bitcell_opt_term_0.trkb.t11 vcm VDD.t669 sg13_lv_pmos ad=0.39p pd=2.39u as=0.7p ps=4.7u w=2u l=0.13u
X445 oa_sar8_acore18_opt_0.sw_tg_opt_1.bot.t3 oa_sar8_acore18_opt_0.sw_bitcell_opt_b7_1.bot.t58 cap_cmim l=2.14u w=2.14u
X446 a_28758_35924# a_28488_35965# VDD.t289 VDD.t19 sg13_lv_pmos ad=0.34p pd=2.68u as=0.1523p ps=1.38u w=1u l=0.5u
X447 sar_ctrl_async_phys_0.sg13g2_nor4_1$1_0.C sar_ctrl_async_phys_0.sg13g2_and2_1$1_3.X VSS.t650 VSS.t103 sg13_lv_nmos ad=0.2516p pd=2.16u as=0.2516p ps=2.16u w=0.74u l=0.13u
X448 a_29236_38952# a_29210_38916# VDD.t30 VDD.t29 sg13_lv_pmos ad=0.34p pd=2.68u as=0.36237p ps=2.605u w=1u l=0.13u
X449 VSS.t85 sar_ctrl_async_phys_0.sg13g2_o21ai_1$1_1.B1.t8 a_31924_40898# VSS.t541 sg13_lv_nmos ad=0.1626p pd=1.415u as=60.89999f ps=0.71u w=0.42u l=0.13u
X450 oa_sar8_acore18_opt_0.sw_tg_opt_0.bot.t3 oa_sar8_acore18_opt_0.sw_bitcell_opt_b7_0.bot.t86 cap_cmim l=2.14u w=2.14u
X451 VDD.t76 a_32341_32117# a_32443_32260# VDD.t76 sg13_lv_pmos ad=1.96315p pd=12.675u as=0.3864p ps=2.93u w=1.12u l=0.13u
X452 VDD.t289 a_27894_35924# a_28006_35948# VDD.t19 sg13_lv_pmos ad=0.2254p pd=1.53u as=0.34p ps=2.68u w=1u l=0.5u
X453 a_32580_36642# sar_ctrl_async_phys_0.sg13g2_buf_1$1_4.A VSS.t75 VSS.t234 sg13_lv_nmos ad=0.187p pd=1.78u as=0.17255p ps=1.25u w=0.55u l=0.13u
X454 a_35402_39318# sar_ctrl_async_phys_0.sg13g2_a21oi_1$1_2.B1 VSS.t498 VSS.t497 sg13_lv_nmos ad=0.1406p pd=1.12u as=0.2516p ps=2.16u w=0.74u l=0.13u
X455 oa_sar8_acore18_opt_0.sw_tg_opt_0.bot.t3 oa_sar8_acore18_opt_0.sw_bitcell_opt_b5_0.bot.t10 cap_cmim l=2.14u w=2.14u
X456 w_16692_n9960# oa_sar8_acore18_opt_0.sw_bitcell_opt_term_0.trkb.t9 oa_sar8_acore18_opt_0.bstrap_opt_w2_c1200_1.gb w_16692_n9960# sg13_lv_pmos ad=0.7p pd=4.7u as=0.7p ps=4.7u w=2u l=0.13u
X457 oa_sar8_acore18_opt_0.sw_tg_opt_1.bot.t3 oa_sar8_acore18_opt_0.sw_bitcell_opt_b6_1.bot.t22 cap_cmim l=2.14u w=2.14u
X458 VDD.t8 VSS.t789 VDD.t6 VDD.t5 sg13_lv_pmos ad=0.34p pd=2.68u as=0 ps=0 w=1u l=1u
X459 VDD.t13 VSS.t816 VDD.t13 VDD.t5 sg13_lv_pmos ad=0.34p pd=2.68u as=0 ps=0 w=1u l=1u
X460 VDD.t390 sar_ctrl_async_phys_0.sg13g2_a21oi_1$1_1.B1 a_34520_46508# VDD.t10 sg13_lv_pmos ad=0.2114p pd=1.54u as=0.2856p ps=2.36u w=0.84u l=0.13u
X461 a_33252_36642# sar_ctrl_async_phys_0.sg13g2_nor2b_1$1_1.B_N VDD.t649 VDD.t16 sg13_lv_pmos ad=0.2856p pd=2.36u as=0.2618p ps=1.63u w=0.84u l=0.13u
X462 VSS.t851 VDD.t23 VSS.t851 VSS.t850 sg13_lv_nmos ad=0.1428p pd=1.52u as=0 ps=0 w=0.42u l=1u
X463 VDD.t132 VSS.t118 VDD.t132 VDD.t42 sg13_lv_pmos ad=0.34p pd=2.68u as=0 ps=0 w=1u l=1u
X464 VSS.t730 VDD.t51 VSS.t737 VSS.t763 sg13_lv_nmos ad=79.8f pd=0.8u as=0 ps=0 w=0.42u l=1u
X465 sar_ctrl_async_phys_0.sg13g2_buf_1$1_36.A sar_ctrl_async_phys_0.sg13g2_nand2b_1$1_5.A_N VDD.t416 VDD.t10 sg13_lv_pmos ad=0.2128p pd=1.5u as=0.3808p ps=2.92u w=1.12u l=0.13u
X466 VDD.t3 sar_ctrl_async_phys_0.sg13g2_dfrbpq_1$1_0.CLK.t2 a_34767_31359# VDD.t3 sg13_lv_pmos ad=1.79957p pd=11.62u as=0.4088p ps=2.97u w=1.12u l=0.13u
X467 VSS.t46 a_31140_42690# sar_ctrl_async_phys_0.sg13g2_nor2_1$1_10.A VSS.t45 sg13_lv_nmos ad=0.17255p pd=1.25u as=0.1406p ps=1.12u w=0.74u l=0.13u
X468 VDD.t150 VSS.t1050 VDD.t150 VDD.t76 sg13_lv_pmos ad=0.34p pd=2.68u as=0 ps=0 w=1u l=1u
X469 a_32137_36047# a_31195_35935# a_31935_36285# VDD.t19 sg13_lv_pmos ad=93.45f pd=0.865u as=0.2048p ps=1.63u w=0.42u l=0.13u
X470 VDD.t90 VSS.t1059 VDD.t90 VDD.t3 sg13_lv_pmos ad=0.19p pd=1.38u as=0 ps=0 w=1u l=1u
X471 a_31540_45434# sar_ctrl_async_phys_0.sg13g2_dfrbpq_1$1_9.D a_31446_45434# VSS.t414 sg13_lv_nmos ad=60.89999f pd=0.71u as=0.1428p ps=1.52u w=0.42u l=0.13u
X472 sar_ctrl_async_phys_0.sg13g2_nand2b_1$1_6.A_N a_34618_46044# VSS.t109 VSS.t108 sg13_lv_nmos ad=0.2516p pd=2.16u as=0.1406p ps=1.12u w=0.74u l=0.13u
X473 oa_sar8_acore18_opt_0.sw_bitcell_opt_b4_0.bot.t0 sar_ctrl_async_phys_0.dac_code[4] VDD.t497 VDD.t495 sg13_lv_pmos ad=0.936p pd=5.19u as=1.68p ps=10.3u w=4.8u l=0.13u
X474 VDD.t51 VSS.t730 VDD.t51 VDD.t10 sg13_lv_pmos ad=0.34p pd=2.68u as=0 ps=0 w=1u l=1u
X475 a_33375_40821# a_32533_40471# a_32116_40464# VDD.t317 sg13_lv_pmos ad=0.2048p pd=1.63u as=0.34p ps=2.68u w=1u l=0.13u
X476 a_32666_45969# a_33109_45725# a_33049_46137# VDD.t10 sg13_lv_pmos ad=79.8f pd=0.8u as=63f ps=0.72u w=0.42u l=0.13u
X477 a_36074_40830# sar_ctrl_async_phys_0.sg13g2_buf_1$1_3.A sar_ctrl_async_phys_0.sg13g2_nand2_1$1_2.Y VSS.t88 sg13_lv_nmos ad=0.1406p pd=1.12u as=0.2516p ps=2.16u w=0.74u l=0.13u
X478 oa_sar8_acore18_opt_0.sw_tg_opt_1.bot.t3 oa_sar8_acore18_opt_0.sw_bitcell_opt_b6_1.bot.t42 cap_cmim l=2.14u w=2.14u
X479 VSS.t1061 VDD.t97 VSS.t1062 VSS.t179 sg13_lv_nmos ad=79.8f pd=0.8u as=0 ps=0 w=0.42u l=1u
X480 a_29046_32138# sar_ctrl_async_phys_0.sg13g2_inv_1$1_5.Y VDD.t247 VDD.t76 sg13_lv_pmos ad=79.8f pd=0.8u as=0.1428p ps=1.52u w=0.42u l=0.13u
X481 VDD.t317 a_34815_39775# a_35072_39918# VDD.t317 sg13_lv_pmos ad=1.6658p pd=10.66u as=79.8f ps=0.8u w=0.42u l=0.13u
X482 oa_sar8_acore18_opt_0.sw_tg_opt_0.bot.t4 oa_sar8_acore18_opt_0.sw_bitcell_opt_b7_0.bot.t5 cap_cmim l=2.14u w=2.14u
X483 a_31189_31399# sar_ctrl_async_phys_0.sg13g2_dfrbpq_1$1_0.CLK.t3 VDD.t3 VDD.t3 sg13_lv_pmos ad=0.4088p pd=2.97u as=1.79957p ps=11.62u w=1.12u l=0.13u
X484 VSS.t194 sar_ctrl_async_phys_0.sg13g2_a22oi_1$1_2.A2 a_32094_33292# VSS.t57 sg13_lv_nmos ad=0.2516p pd=2.16u as=96.2f ps=1u w=0.74u l=0.13u
X485 VDD.t79 VSS.t1076 VDD.t79 VDD.t3 sg13_lv_pmos ad=0.19p pd=1.38u as=0 ps=0 w=1u l=1u
X486 a_29238_41972# a_28968_42013# VSS.t313 VSS.t312 sg13_lv_nmos ad=0.1428p pd=1.52u as=79.8f ps=0.8u w=0.42u l=0.5u
X487 sar_ctrl_async_phys_0.sg13g2_buf_1$1_2.X.t0 a_34520_33688# VSS.t260 VSS.t1150 sg13_lv_nmos ad=0.2886p pd=2.26u as=0.14875p ps=1.16u w=0.74u l=0.13u
X488 a_27738_40460# sar_ctrl_async_phys_0.sg13g2_nor2_1$1_13.A VDD.t325 VDD.t317 sg13_lv_pmos ad=0.1176p pd=1.33u as=0.4032p ps=2.96u w=1.12u l=0.13u
X489 oa_sar8_acore18_opt_0.bstrap_opt_w2_c1200_1.out oa_sar8_acore18_opt_0.sw_bitcell_opt_term_0.trkb.t28 oa_sar8_acore18_opt_0.sw_bitcell_opt_b0_1.bot.t0 VDD.t951 sg13_lv_pmos ad=0.7p pd=4.7u as=0.39p ps=2.39u w=2u l=0.13u
X490 VSS.t1017 VDD.t270 VSS.t1016 VSS.t1015 sg13_lv_nmos ad=0.1428p pd=1.52u as=0 ps=0 w=0.42u l=1u
X491 a_33948_41936# sar_ctrl_async_phys_0.sg13g2_buf_1$1_2.A VSS.t99 VSS.t258 sg13_lv_nmos ad=0.187p pd=1.78u as=0.14875p ps=1.16u w=0.55u l=0.13u
X492 a_29812_33968# a_30331_33772# a_31071_33727# VSS.t176 sg13_lv_nmos ad=0.3473p pd=2.71u as=0.12665p ps=1.145u w=0.74u l=0.13u
X493 oa_sar8_acore18_opt_0.sw_tg_opt_1.bot.t3 oa_sar8_acore18_opt_0.sw_bitcell_opt_b6_1.bot.t22 cap_cmim l=2.14u w=2.14u
X494 a_32223_46869# a_31381_46519# a_32129_46869# VSS.t125 sg13_lv_nmos ad=0.12665p pd=1.145u as=0.1428p ps=1.52u w=0.42u l=0.13u
X495 a_30591_32215# a_29749_32117# a_30497_32215# VSS.t1255 sg13_lv_nmos ad=0.12665p pd=1.145u as=0.1428p ps=1.52u w=0.42u l=0.13u
X496 VSS.t1 sar_ctrl_async_phys_0.sg13g2_buf_1$1_6.X.t2 a_31540_35162# VSS.t603 sg13_lv_nmos ad=0.1626p pd=1.415u as=60.89999f ps=0.71u w=0.42u l=0.13u
X497 VDD.t375 sar_ctrl_async_phys_0.sg13g2_buf_1$1_3.A sar_ctrl_async_phys_0.sg13g2_nand2b_1$1_3.Y VDD.t317 sg13_lv_pmos ad=0.2198p pd=1.53u as=0.2128p ps=1.5u w=1.12u l=0.13u
X498 a_29044_39386# sar_ctrl_async_phys_0.sg13g2_nor2_1$1_5.A a_28950_39386# VSS.t103 sg13_lv_nmos ad=60.89999f pd=0.71u as=0.1428p ps=1.52u w=0.42u l=0.13u
X499 a_30495_39309# a_29653_38959# a_30401_39309# VSS.t669 sg13_lv_nmos ad=0.12665p pd=1.145u as=0.1428p ps=1.52u w=0.42u l=0.13u
X500 oa_sar8_acore18_opt_0.sw_tg_opt_0.bot.t3 oa_sar8_acore18_opt_0.sw_bitcell_opt_b7_0.bot.t146 cap_cmim l=2.14u w=2.14u
X501 a_31071_33727# a_30229_33629# a_29812_33968# VDD.t147 sg13_lv_pmos ad=0.2048p pd=1.63u as=0.34p ps=2.68u w=1u l=0.13u
X502 a_29498_40428# a_29941_40471# a_29238_40898# VSS.t1250 sg13_lv_nmos ad=79.8f pd=0.8u as=0.1296p ps=1.52u w=0.42u l=0.13u
X503 VSS.t65 VDD.t191 VSS.t65 VSS.t910 sg13_lv_nmos ad=0.1428p pd=1.52u as=0 ps=0 w=0.42u l=1u
X504 oa_sar8_acore18_opt_0.sw_tg_opt_0.bot.t3 oa_sar8_acore18_opt_0.sw_bitcell_opt_b5_0.bot.t35 cap_cmim l=2.14u w=2.14u
X505 VDD.t82 VSS.t102 VDD.t82 VDD.t29 sg13_lv_pmos ad=0.34p pd=2.68u as=0 ps=0 w=1u l=1u
X506 VSS.t111 VDD.t154 VSS.t111 VSS.t862 sg13_lv_nmos ad=0.1428p pd=1.52u as=0 ps=0 w=0.42u l=1u
X507 VSS.t260 sar_ctrl_async_phys_0.sg13g2_buf_1$1_6.X a_33940_33338# VSS.t1308 sg13_lv_nmos ad=0.1626p pd=1.415u as=60.89999f ps=0.71u w=0.42u l=0.13u
X508 VDD.t229 VSS.t260 VDD.t229 VDD.t147 sg13_lv_pmos ad=0.19p pd=1.38u as=0 ps=0 w=1u l=1u
X509 VSS.t13 sar_ctrl_async_phys_0.sg13g2_buf_1$1_15.A a_36056_35200# VSS.t12 sg13_lv_nmos ad=0.14875p pd=1.16u as=0.187p ps=1.78u w=0.55u l=0.13u
X510 sar_ctrl_async_phys_0.bit_active[3] a_35672_35200# VSS.t13 VSS.t12 sg13_lv_nmos ad=0.2886p pd=2.26u as=0.14875p ps=1.16u w=0.74u l=0.13u
X511 a_32400_41413# sar_ctrl_async_phys_0.sg13g2_a21oi_1$1_5.A2 a_32537_41256# VSS.t640 sg13_lv_nmos ad=0.2176p pd=1.96u as=0.1216p ps=1.02u w=0.64u l=0.13u
X512 a_32094_33292# sar_ctrl_async_phys_0.sg13g2_a22oi_1$1_0.A1 sar_ctrl_async_phys_0.sg13g2_a22oi_1$1_2.Y VSS.t57 sg13_lv_nmos ad=96.2f pd=1u as=0.2664p ps=1.46u w=0.74u l=0.13u
X513 VSS.t1032 VDD.t233 VSS.t1031 VSS.t1030 sg13_lv_nmos ad=0.1428p pd=1.52u as=0 ps=0 w=0.42u l=1u
X514 a_31060_31813# a_31291_31399# a_30746_31356# VSS.t467 sg13_lv_nmos ad=0.2373p pd=1.97u as=79.8f ps=0.8u w=0.42u l=0.13u
X515 VSS.t118 VDD.t130 VSS.t118 VSS.t740 sg13_lv_nmos ad=0.1428p pd=1.52u as=0 ps=0 w=0.42u l=1u
X516 VDD.t5 a_32991_45357# a_33248_45238# VDD.t5 sg13_lv_pmos ad=1.96315p pd=12.675u as=79.8f ps=0.8u w=0.42u l=0.13u
X517 VDD.t1 VSS.t851 VDD.t71 VDD.t0 sg13_lv_pmos ad=0.34p pd=2.68u as=0 ps=0 w=1u l=1u
X518 VDD.t114 VSS.t46 VDD.t114 VDD.t0 sg13_lv_pmos ad=0.19p pd=1.38u as=0 ps=0 w=1u l=1u
X519 oa_sar8_acore18_opt_0.sw_tg_opt_1.bot.t3 oa_sar8_acore18_opt_0.sw_bitcell_opt_b7_1.bot.t111 cap_cmim l=2.14u w=2.14u
X520 VSS.t1063 VDD.t59 VSS.t1062 VSS.t179 sg13_lv_nmos ad=0.1428p pd=1.52u as=0 ps=0 w=0.42u l=1u
X521 VDD.t64 VSS.t792 VDD.t64 VDD.t10 sg13_lv_pmos ad=0.34p pd=2.68u as=0 ps=0 w=1u l=1u
X522 a_30486_31826# sar_ctrl_async_phys_0.sg13g2_inv_1$1_11.Y VDD.t79 VDD.t3 sg13_lv_pmos ad=79.8f pd=0.8u as=0.1428p ps=1.52u w=0.42u l=0.13u
X523 a_33844_36992# a_33818_36897# VSS.t968 VSS.t1227 sg13_lv_nmos ad=0.2516p pd=2.16u as=0.1626p ps=1.415u w=0.74u l=0.13u
X524 oa_sar8_acore18_opt_0.sw_tg_opt_1.bot.t3 oa_sar8_acore18_opt_0.sw_bitcell_opt_b2_1.bot.t6 cap_cmim l=2.14u w=2.14u
X525 w_39600_n9960# a_35948_n9612# cap_cmim l=9.94u w=39.8u
X526 oa_sar8_acore18_opt_0.sw_tg_opt_1.bot.t3 oa_sar8_acore18_opt_0.sw_bitcell_opt_b6_1.bot.t70 cap_cmim l=2.14u w=2.14u
X527 oa_sar8_acore18_opt_0.sw_tg_opt_0.bot.t3 oa_sar8_acore18_opt_0.sw_bitcell_opt_b7_0.bot.t30 cap_cmim l=2.14u w=2.14u
X528 oa_sar8_acore18_opt_0.sw_tg_opt_0.bot.t3 oa_sar8_acore18_opt_0.sw_bitcell_opt_b6_0.bot.t34 cap_cmim l=2.14u w=2.14u
X529 a_30752_39190# a_30495_39309# a_30914_39386# VSS.t105 sg13_lv_nmos ad=0.1428p pd=1.52u as=37.8f ps=0.6u w=0.42u l=0.13u
X530 oa_sar8_acore18_opt_0.sw_tg_opt_1.bot.t2 oa_sar8_acore18_opt_0.sw_bitcell_opt_b7_1.bot.t153 cap_cmim l=2.14u w=2.14u
X531 VDD.t25 VSS.t855 VDD.t24 VDD.t22 sg13_lv_pmos ad=0.19p pd=1.38u as=0 ps=0 w=1u l=1u
X532 VSS.t99 VDD.t114 VSS.t99 VSS.t879 sg13_lv_nmos ad=0.1428p pd=1.52u as=0 ps=0 w=0.42u l=1u
X533 oa_sar8_acore18_opt_0.sw_tg_opt_0.bot.t3 oa_sar8_acore18_opt_0.sw_bitcell_opt_b6_0.bot.t44 cap_cmim l=2.14u w=2.14u
X534 oa_sar8_acore18_opt_0.sw_bitcell_opt_b1_1.bot.t0 oa_sar8_acore18_opt_0.bstrap_opt_w2_c1200_1.gb oa_sar8_acore18_opt_0.bstrap_opt_w2_c1200_1.out VSS.t157 sg13_lv_nmos ad=0.195p pd=1.39u as=0.35p ps=2.7u w=1u l=0.13u
X535 a_34420_33325# a_34132_32904# a_34358_33325# VSS.t1191 sg13_lv_nmos ad=0.1428p pd=1.52u as=37.8f ps=0.6u w=0.42u l=0.13u
X536 sar_ctrl_async_phys_0.sg13g2_dfrbpq_1$1_9.D sar_ctrl_async_phys_0.sg13g2_nor2b_1$1_4.Y VSS.t172 VSS.t171 sg13_lv_nmos ad=0.1406p pd=1.12u as=0.2516p ps=2.16u w=0.74u l=0.13u
X537 a_29238_41972# a_28968_42013# VDD.t1 VDD.t0 sg13_lv_pmos ad=0.34p pd=2.68u as=0.1523p ps=1.38u w=1u l=0.5u
X538 sar_ctrl_async_phys_0.sg13g2_nor4_1$1_0.C sar_ctrl_async_phys_0.sg13g2_and2_1$1_3.X VDD.t721 VDD.t317 sg13_lv_pmos ad=0.3808p pd=2.92u as=0.3808p ps=2.92u w=1.12u l=0.13u
X539 VDD.t583 sar_ctrl_async_phys_0.dac_code_n[0] oa_sar8_acore18_opt_0.sw_bitcell_opt_b0_1.bot.t1 VDD.t582 sg13_lv_pmos ad=1.05p pd=6.7u as=0.585p ps=3.39u w=3u l=0.13u
X540 VDD.t362 a_35103_36751# a_35770_36972# VDD.t16 sg13_lv_pmos ad=0.2128p pd=1.5u as=0.3864p ps=2.93u w=1.12u l=0.13u
X541 VDD.t317 a_31040_40702# a_30985_40583# VDD.t317 sg13_lv_pmos ad=1.6658p pd=10.66u as=93.45f ps=0.865u w=0.42u l=0.13u
X542 sar_ctrl_async_phys_0.sg13g2_a21oi_1$1_0.A1 sar_ctrl_async_phys_0.sg13g2_inv_1$1_7.A VSS.t348 VSS.t347 sg13_lv_nmos ad=0.2516p pd=2.16u as=0.2516p ps=2.16u w=0.74u l=0.13u
X543 VDD.t18 VSS.t344 VDD.t18 VDD.t16 sg13_lv_pmos ad=0.34p pd=2.68u as=0 ps=0 w=1u l=1u
X544 VSS.t62 a_29258_36642# a_28977_36864# VSS.t61 sg13_lv_nmos ad=79.8f pd=0.8u as=0.1428p ps=1.52u w=0.42u l=0.5u
X545 VDD.t5 a_35199_44311# a_35456_44454# VDD.t5 sg13_lv_pmos ad=1.96315p pd=12.675u as=79.8f ps=0.8u w=0.42u l=0.13u
X546 sar_ctrl_async_phys_0.sg13g2_and2_1$1_0.X a_31261_38232# VDD.t85 VDD.t29 sg13_lv_pmos ad=0.3808p pd=2.92u as=0.1918p ps=1.5u w=1.12u l=0.13u
X547 oa_sar8_acore18_opt_0.sw_tg_opt_0.bot.t3 oa_sar8_acore18_opt_0.sw_bitcell_opt_b4_0.bot.t16 cap_cmim l=2.14u w=2.14u
X548 VSS.t975 VDD.t289 VSS.t979 VSS.t0 sg13_lv_nmos ad=79.8f pd=0.8u as=0 ps=0 w=0.42u l=1u
X549 oa_sar8_acore18_opt_0.sw_tg_opt_1.bot.t3 oa_sar8_acore18_opt_0.sw_bitcell_opt_b6_1.bot.t70 cap_cmim l=2.14u w=2.14u
X550 a_32212_32151# a_32443_32260# a_31898_32361# VSS.t100 sg13_lv_nmos ad=0.2373p pd=1.97u as=79.8f ps=0.8u w=0.42u l=0.13u
X551 VSS.t963 VDD.t20 VSS.t62 VSS.t962 sg13_lv_nmos ad=0.1428p pd=1.52u as=0 ps=0 w=0.42u l=1u
X552 sar_ctrl_async_phys_0.sg13g2_nand3_1$1_0.C sar_ctrl_async_phys_0.sg13g2_dlygate4sd3_1$1_6.X a_25914_38948# VDD.t29 sg13_lv_pmos ad=0.3808p pd=2.92u as=0.1176p ps=1.33u w=1.12u l=0.13u
X553 oa_sar8_acore18_opt_0.sw_tg_opt_1.bot.t3 oa_sar8_acore18_opt_0.sw_bitcell_opt_b6_1.bot.t10 cap_cmim l=2.14u w=2.14u
X554 a_32480_46750# a_32223_46869# a_32642_46946# VSS.t125 sg13_lv_nmos ad=0.1428p pd=1.52u as=37.8f ps=0.6u w=0.42u l=0.13u
X555 oa_sar8_acore18_opt_0.sw_tg_opt_0.bot.t3 oa_sar8_acore18_opt_0.sw_bitcell_opt_b6_0.bot.t14 cap_cmim l=2.14u w=2.14u
X556 oa_sar8_acore18_opt_0.sw_bitcell_opt_b1_0.bot.t4 oa_sar8_acore18_opt_0.sw_bitcell_opt_term_0.gb.t6 oa_sar8_acore18_opt_0.sw_bitcell_opt_term_0.vin VSS.t1201 sg13_lv_nmos ad=0.195p pd=1.39u as=0.35p ps=2.7u w=1u l=0.13u
X557 oa_sar8_acore18_opt_0.sw_tg_opt_0.bot.t3 oa_sar8_acore18_opt_0.sw_bitcell_opt_b4_0.bot.t28 cap_cmim l=2.14u w=2.14u
X558 oa_sar8_acore18_opt_0.sw_bitcell_opt_term_0.VSS sar_ctrl_async_phys_0.dac_code[3] oa_sar8_acore18_opt_0.sw_bitcell_opt_b3_0.bot.t1 VSS.t303 sg13_lv_nmos ad=0.735p pd=4.9u as=0.4095p ps=2.49u w=2.1u l=0.13u
X559 VSS.t1 a_30507_35204# a_30944_35166# VSS.t0 sg13_lv_nmos ad=0.148p pd=1.14u as=0.3367p ps=1.65u w=0.74u l=0.13u
X560 oa_sar8_acore18_opt_0.sw_tg_opt_0.bot.t3 oa_sar8_acore18_opt_0.sw_bitcell_opt_b5_0.bot.t2 cap_cmim l=2.14u w=2.14u
X561 VDD.t270 VSS.t1011 VDD.t270 VDD.t147 sg13_lv_pmos ad=0.34p pd=2.68u as=0 ps=0 w=1u l=1u
X562 oa_sar8_acore18_opt_0.sw_bitcell_opt_b7_1.bot.t1 sar_ctrl_async_phys_0.dac_code_n[7].t2 VDD.t687 VDD.t685 sg13_lv_pmos ad=1.326p pd=7.19u as=2.38p ps=14.3u w=6.8u l=0.13u
X563 VDD.t319 sar_ctrl_async_phys_0.sg13g2_buf_1$1_14.A a_35672_35200# VDD.t19 sg13_lv_pmos ad=0.2114p pd=1.54u as=0.2856p ps=2.36u w=0.84u l=0.13u
X564 VDD.t43 VSS.t40 VDD.t43 VDD.t42 sg13_lv_pmos ad=0.34p pd=2.68u as=0 ps=0 w=1u l=1u
X565 oa_sar8_acore18_opt_0.sw_tg_opt_1.bot.t3 oa_sar8_acore18_opt_0.sw_bitcell_opt_b5_1.bot.t15 cap_cmim l=2.14u w=2.14u
X566 oa_sar8_acore18_opt_0.sw_tg_opt_0.bot.t3 oa_sar8_acore18_opt_0.sw_bitcell_opt_b7_0.bot.t57 cap_cmim l=2.14u w=2.14u
X567 VSS.t786 VDD.t51 VSS.t786 VSS.t787 sg13_lv_nmos ad=0.1428p pd=1.52u as=0 ps=0 w=0.42u l=1u
X568 VDD.t219 sar_ctrl_async_phys_0.sg13g2_a21oi_1$1_0.A1 a_32715_43020# VDD.t22 sg13_lv_pmos ad=0.2128p pd=1.5u as=0.2128p ps=1.5u w=1.12u l=0.13u
X569 VDD.t120 a_26666_38912# a_26385_39214# VDD.t29 sg13_lv_pmos ad=0.1523p pd=1.38u as=0.34p ps=2.68u w=1u l=0.5u
X570 VSS.t979 VDD.t148 VSS.t979 VSS.t0 sg13_lv_nmos ad=0.1428p pd=1.52u as=0 ps=0 w=0.42u l=1u
X571 VSS.t102 VDD.t120 VSS.t65 VSS.t914 sg13_lv_nmos ad=0.1428p pd=1.52u as=0 ps=0 w=0.42u l=1u
X572 oa_sar8_acore18_opt_0.sw_tg_opt_1.bot.t2 oa_sar8_acore18_opt_0.sw_bitcell_opt_b7_1.bot.t158 cap_cmim l=2.14u w=2.14u
X573 VDD.t289 VSS.t979 VDD.t20 VDD.t19 sg13_lv_pmos ad=0.34p pd=2.68u as=0 ps=0 w=1u l=1u
X574 a_33364_39698# sar_ctrl_async_phys_0.sg13g2_nor2b_1$1_3.Y a_33270_39698# VSS.t202 sg13_lv_nmos ad=60.89999f pd=0.71u as=0.1428p ps=1.52u w=0.42u l=0.13u
X575 oa_sar8_acore18_opt_0.sw_bitcell_opt_term_0.vin oa_sar8_acore18_opt_0.sw_bitcell_opt_term_0.gb.t3 vinn VSS.t561 sg13_lv_nmos ad=0.195p pd=1.39u as=0.35p ps=2.7u w=1u l=0.13u
X576 VDD.t44 VSS.t737 VDD.t44 VDD.t42 sg13_lv_pmos ad=0.34p pd=2.68u as=0 ps=0 w=1u l=1u
X577 VSS.t40 VDD.t11 VSS.t40 VSS.t756 sg13_lv_nmos ad=0.1428p pd=1.52u as=0 ps=0 w=0.42u l=1u
X578 sar_ctrl_async_phys_0.sg13g2_nand2_1$1_3.B a_35866_44532# VDD.t349 VDD.t5 sg13_lv_pmos ad=0.3808p pd=2.92u as=0.2128p ps=1.5u w=1.12u l=0.13u
X579 VDD.t25 VSS.t829 VDD.t24 VDD.t22 sg13_lv_pmos ad=0.34p pd=2.68u as=0 ps=0 w=1u l=1u
X580 a_30100_33663# a_29812_33968# a_30038_33663# VSS.t173 sg13_lv_nmos ad=0.1428p pd=1.52u as=37.8f ps=0.6u w=0.42u l=0.13u
X581 sar_ctrl_async_phys_0.sg13g2_nand2b_1$1_1.Y a_34765_42242# VDD.t562 VDD.t0 sg13_lv_pmos ad=0.2128p pd=1.5u as=0.3808p ps=2.92u w=1.12u l=0.13u
X582 a_33878_41223# sar_ctrl_async_phys_0.sg13g2_o21ai_1$1_1.B1.t13 VSS.t307 VSS.t553 sg13_lv_nmos ad=37.8f pd=0.6u as=0.1701p ps=1.65u w=0.42u l=0.13u
X583 a_33530_39921# a_33973_39677# a_33913_40089# VDD.t317 sg13_lv_pmos ad=79.8f pd=0.8u as=63f ps=0.72u w=0.42u l=0.13u
X584 VDD.t16 a_33344_37678# a_33289_37559# VDD.t16 sg13_lv_pmos ad=2.48357p pd=16.205u as=93.45f ps=0.865u w=0.42u l=0.13u
X585 vcm sar_ctrl_async_phys_0.sample oa_sar8_acore18_opt_0.sw_tg_opt_0.bot.t0 VSS.t396 sg13_lv_nmos ad=0.35p pd=2.7u as=0.195p ps=1.39u w=1u l=0.13u
X586 a_31958_45421# sar_ctrl_async_phys_0.sg13g2_buf_1$1_41.X VSS.t131 VSS.t130 sg13_lv_nmos ad=37.8f pd=0.6u as=0.1701p ps=1.65u w=0.42u l=0.13u
X587 oa_sar8_acore18_opt_0.sw_tg_opt_1.bot.t3 oa_sar8_acore18_opt_0.sw_bitcell_opt_b5_1.bot.t35 cap_cmim l=2.14u w=2.14u
X588 sar_ctrl_async_phys_0.sg13g2_buf_1$1_2.A a_32696_30664# VDD.t4 VDD.t3 sg13_lv_pmos ad=0.42p pd=2.99u as=0.2114p ps=1.54u w=1.12u l=0.13u
X589 VDD.t219 a_32580_43448# a_32538_43484# VDD.t22 sg13_lv_pmos ad=0.2618p pd=1.63u as=0.1176p ps=1.33u w=1.12u l=0.13u
X590 oa_sar8_acore18_opt_0.sw_tg_opt_1.bot.t4 oa_sar8_acore18_opt_0.sw_bitcell_opt_b7_1.bot.t10 cap_cmim l=2.14u w=2.14u
X591 oa_sar8_acore18_opt_0.sw_tg_opt_1.bot.t3 oa_sar8_acore18_opt_0.sw_bitcell_opt_b7_1.bot.t128 cap_cmim l=2.14u w=2.14u
X592 VDD.t59 VSS.t1098 VDD.t59 VDD.t3 sg13_lv_pmos ad=0.19p pd=1.38u as=0 ps=0 w=1u l=1u
X593 VSS.t730 VDD.t51 VSS.t730 VSS.t762 sg13_lv_nmos ad=0.1428p pd=1.52u as=0 ps=0 w=0.42u l=1u
X594 VSS.t87 a_35168_41430# a_34817_41287# VSS.t364 sg13_lv_nmos ad=79.8f pd=0.8u as=0.1428p ps=1.52u w=0.42u l=0.13u
X595 VDD.t342 sar_ctrl_async_phys_0.sg13g2_buf_1$1_6.X a_31898_32361# VDD.t76 sg13_lv_pmos ad=0.1563p pd=1.22u as=0.147p ps=1.54u w=0.42u l=0.13u
X596 VDD.t121 VSS.t1016 VDD.t121 VDD.t76 sg13_lv_pmos ad=0.34p pd=2.68u as=0 ps=0 w=1u l=1u
X597 VDD.t184 VSS.t131 VDD.t184 VDD.t10 sg13_lv_pmos ad=0.34p pd=2.68u as=0 ps=0 w=1u l=1u
X598 oa_sar8_acore18_opt_0.sw_tg_opt_0.bot.t3 oa_sar8_acore18_opt_0.sw_bitcell_opt_b6_0.bot.t24 cap_cmim l=2.14u w=2.14u
X599 oa_sar8_acore18_opt_0.sw_tg_opt_0.bot.t4 oa_sar8_acore18_opt_0.sw_bitcell_opt_b7_0.bot.t20 cap_cmim l=2.14u w=2.14u
X600 VSS.t137 sar_ctrl_async_phys_0.sg13g2_and2_1$1_0.A a_32027_43832# VSS.t336 sg13_lv_nmos ad=0.1331p pd=1.12u as=0.1216p ps=1.02u w=0.64u l=0.13u
X601 a_30902_39711# sar_ctrl_async_phys_0.sg13g2_o21ai_1$1_1.B1.t6 VSS.t243 VSS.t244 sg13_lv_nmos ad=37.8f pd=0.6u as=0.1701p ps=1.65u w=0.42u l=0.13u
X602 VDD.t362 sar_ctrl_async_phys_0.sg13g2_a21oi_1$1_0.A1 a_35211_37436# VDD.t16 sg13_lv_pmos ad=0.2128p pd=1.5u as=0.2128p ps=1.5u w=1.12u l=0.13u
X603 a_30229_33629# sar_ctrl_async_phys_0.sg13g2_dfrbpq_1$1_0.CLK.t7 VDD.t147 VDD.t147 sg13_lv_pmos ad=0.4088p pd=2.97u as=1.98685p ps=12.96u w=1.12u l=0.13u
X604 VDD.t30 VSS.t102 VDD.t30 VDD.t29 sg13_lv_pmos ad=0.34p pd=2.68u as=0 ps=0 w=1u l=1u
X605 a_30676_35928# a_31195_35935# a_31935_36285# VSS.t74 sg13_lv_nmos ad=0.3473p pd=2.71u as=0.12665p ps=1.145u w=0.74u l=0.13u
X606 VDD.t64 VSS.t737 VDD.t51 VDD.t10 sg13_lv_pmos ad=0.34p pd=2.68u as=0 ps=0 w=1u l=1u
X607 VSS.t696 rst_n a_32696_30664# VSS.t1156 sg13_lv_nmos ad=0.14875p pd=1.16u as=0.187p ps=1.78u w=0.55u l=0.13u
X608 VDD.t603 a_33936_31675# sar_ctrl_async_phys_0.sg13g2_buf_1$1_8.A VDD.t3 sg13_lv_pmos ad=0.2128p pd=1.5u as=0.3808p ps=2.92u w=1.12u l=0.13u
X609 a_33940_44552# a_34459_44356# a_35199_44311# VSS.t60 sg13_lv_nmos ad=0.3473p pd=2.71u as=0.12665p ps=1.145u w=0.74u l=0.13u
X610 VDD.t11 VSS.t777 VDD.t11 VDD.t10 sg13_lv_pmos ad=0.34p pd=2.68u as=0 ps=0 w=1u l=1u
X611 VDD.t9 VSS.t827 VDD.t9 VDD.t5 sg13_lv_pmos ad=0.34p pd=2.68u as=0 ps=0 w=1u l=1u
X612 a_29653_38959# sar_ctrl_async_phys_0.sg13g2_dfrbpq_1$1_0.CLK.t16 VSS.t519 VSS.t518 sg13_lv_nmos ad=0.2516p pd=2.16u as=4.48835p ps=28.62u w=0.74u l=0.13u
X613 a_29462_39373# sar_ctrl_async_phys_0.sg13g2_o21ai_1$1_1.B1.t2 VSS.t457 VSS.t456 sg13_lv_nmos ad=37.8f pd=0.6u as=0.1701p ps=1.65u w=0.42u l=0.13u
X614 oa_sar8_acore18_opt_0.sw_tg_opt_1.bot.t3 oa_sar8_acore18_opt_0.sw_bitcell_opt_b7_1.bot.t84 cap_cmim l=2.14u w=2.14u
X615 VSS.t175 a_30229_33629# a_30331_33772# VSS.t174 sg13_lv_nmos ad=5.99755p pd=39.725u as=0.2516p ps=2.16u w=0.74u l=0.13u
X616 VDD.t132 VSS.t126 VDD.t132 VDD.t42 sg13_lv_pmos ad=0.34p pd=2.68u as=0 ps=0 w=1u l=1u
X617 oa_sar8_acore18_opt_0.sw_tg_opt_0.bot.t3 oa_sar8_acore18_opt_0.sw_bitcell_opt_b7_0.bot.t120 cap_cmim l=2.14u w=2.14u
X618 VDD.t79 VSS.t455 VDD.t79 VDD.t3 sg13_lv_pmos ad=0.19p pd=1.38u as=0 ps=0 w=1u l=1u
X619 a_32738_44234# sar_ctrl_async_phys_0.sg13g2_buf_1$1_41.X VSS.t137 VSS.t136 sg13_lv_nmos ad=37.8f pd=0.6u as=79.8f ps=0.8u w=0.42u l=0.13u
X620 VSS.t260 sar_ctrl_async_phys_0.sg13g2_a22oi_1$1_1.Y sar_ctrl_async_phys_0.sg13g2_inv_1$1_1.Y VSS.t176 sg13_lv_nmos ad=0.2516p pd=2.16u as=0.2516p ps=2.16u w=0.74u l=0.13u
X621 a_31924_40898# sar_ctrl_async_phys_0.sg13g2_dfrbpq_1$1_11.D a_31830_40898# VSS.t30 sg13_lv_nmos ad=60.89999f pd=0.71u as=0.1428p ps=1.52u w=0.42u l=0.13u
X622 sar_ctrl_async_phys_0.sg13g2_nor2_1$1_8.B sar_ctrl_async_phys_0.sg13g2_inv_1$1_7.A a_28026_36972# VDD.t16 sg13_lv_pmos ad=0.3808p pd=2.92u as=0.1176p ps=1.33u w=1.12u l=0.13u
X623 sar_ctrl_async_phys_0.sg13g2_a22oi_1$1_0.A1 a_34904_38224# VSS.t210 VSS.t177 sg13_lv_nmos ad=0.2886p pd=2.26u as=0.14875p ps=1.16u w=0.74u l=0.13u
X624 VDD.t419 sar_ctrl_async_phys_0.sg13g2_buf_1$1_4.A a_36056_33688# VDD.t147 sg13_lv_pmos ad=0.2114p pd=1.54u as=0.2856p ps=2.36u w=0.84u l=0.13u
X625 oa_sar8_acore18_opt_0.sw_tg_opt_1.bot.t3 oa_sar8_acore18_opt_0.sw_bitcell_opt_b7_1.bot.t36 cap_cmim l=2.14u w=2.14u
X626 oa_sar8_acore18_opt_0.sw_tg_opt_1.bot.t3 oa_sar8_acore18_opt_0.sw_bitcell_opt_b7_1.bot.t86 cap_cmim l=2.14u w=2.14u
X627 VSS.t104 sar_ctrl_async_phys_0.sg13g2_nand2b_1$1_0.A_N a_28651_39740# VSS.t103 sg13_lv_nmos ad=0.14505p pd=1.15u as=0.187p ps=1.78u w=0.55u l=0.13u
X628 a_30942_33292# sar_ctrl_async_phys_0.sg13g2_a22oi_1$1_0.A1 sar_ctrl_async_phys_0.sg13g2_inv_1$1_5.A VSS.t56 sg13_lv_nmos ad=96.2f pd=1u as=0.2664p ps=1.46u w=0.74u l=0.13u
X629 a_31040_40702# a_30783_40821# a_31202_40898# VSS.t30 sg13_lv_nmos ad=0.1428p pd=1.52u as=37.8f ps=0.6u w=0.42u l=0.13u
X630 oa_sar8_acore18_opt_0.sw_tg_opt_0.bot.t3 oa_sar8_acore18_opt_0.sw_bitcell_opt_b6_0.bot.t9 cap_cmim l=2.14u w=2.14u
X631 VSS.t23 sar_ctrl_async_phys_0.sg13g2_buf_1$1_6.X a_29140_32138# VSS.t452 sg13_lv_nmos ad=0.1626p pd=1.415u as=60.89999f ps=0.71u w=0.42u l=0.13u
X632 VDD.t501 sar_ctrl_async_phys_0.sg13g2_o21ai_1$1_1.B1.t13 a_33626_41433# VDD.t0 sg13_lv_pmos ad=0.1563p pd=1.22u as=0.147p ps=1.54u w=0.42u l=0.13u
X633 a_33940_44552# a_33914_44457# VDD.t407 VDD.t5 sg13_lv_pmos ad=0.34p pd=2.68u as=0.36237p ps=2.605u w=1u l=0.13u
X634 VDD.t317 a_29941_40471# a_30043_40471# VDD.t317 sg13_lv_pmos ad=1.6658p pd=10.66u as=0.3864p ps=2.93u w=1.12u l=0.13u
X635 oa_sar8_acore18_opt_0.sw_tg_opt_0.bot.t2 oa_sar8_acore18_opt_0.sw_bitcell_opt_b7_0.bot.t162 cap_cmim l=2.14u w=2.14u
X636 VSS.t672 a_31093_35935# a_31195_35935# VSS.t671 sg13_lv_nmos ad=5.13525p pd=33.135u as=0.2516p ps=2.16u w=0.74u l=0.13u
X637 a_35199_44311# a_34357_44213# a_35105_44311# VSS.t60 sg13_lv_nmos ad=0.12665p pd=1.145u as=0.1428p ps=1.52u w=0.42u l=0.13u
X638 VSS.t216 sar_ctrl_async_phys_0.sg13g2_nand2b_1$1_1.B a_34847_42342# VSS.t1171 sg13_lv_nmos ad=0.14505p pd=1.15u as=0.1406p ps=1.12u w=0.74u l=0.13u
X639 oa_sar8_acore18_opt_0.sw_tg_opt_0.bot.t3 oa_sar8_acore18_opt_0.sw_bitcell_opt_b7_0.bot.t131 cap_cmim l=2.14u w=2.14u
X640 a_35391_33261# a_34549_32911# a_34132_32904# VDD.t76 sg13_lv_pmos ad=0.2048p pd=1.63u as=0.34p ps=2.68u w=1u l=0.13u
X641 sar_ctrl_async_phys_0.sg13g2_a21oi_1$1_6.A2 a_32890_46508# VDD.t176 VDD.t10 sg13_lv_pmos ad=0.3808p pd=2.92u as=0.2128p ps=1.5u w=1.12u l=0.13u
X642 VSS.t51 a_26558_40727# sar_ctrl_async_phys_0.sg13g2_dlygate4sd3_1$1_9.X VSS.t1229 sg13_lv_nmos ad=0.1426p pd=1.16u as=0.2516p ps=2.16u w=0.74u l=0.13u
X643 a_34308_37400# sar_ctrl_async_phys_0.sg13g2_buf_1$1_14.A VSS.t15 VSS.t14 sg13_lv_nmos ad=0.187p pd=1.78u as=0.17255p ps=1.25u w=0.55u l=0.13u
X644 oa_sar8_acore18_opt_0.sw_tg_opt_0.bot.t3 oa_sar8_acore18_opt_0.sw_bitcell_opt_b7_0.bot.t47 cap_cmim l=2.14u w=2.14u
X645 oa_sar8_acore18_opt_0.sw_bitcell_opt_b0_1.bot.t0 oa_sar8_acore18_opt_0.sw_bitcell_opt_term_0.trkb.t28 oa_sar8_acore18_opt_0.bstrap_opt_w2_c1200_1.out VDD.t951 sg13_lv_pmos ad=0.39p pd=2.39u as=0.7p ps=4.7u w=2u l=0.13u
X646 a_26666_38912# sar_ctrl_async_phys_0.sg13g2_dlygate4sd3_1$1_11.X VSS.t341 VSS.t103 sg13_lv_nmos ad=0.1428p pd=1.52u as=79.8f ps=0.8u w=0.42u l=0.13u
X647 VSS.t1012 VDD.t121 VSS.t1014 VSS.t1013 sg13_lv_nmos ad=79.8f pd=0.8u as=0 ps=0 w=0.42u l=1u
X648 VSS.t1056 VDD.t121 VSS.t1055 VSS.t179 sg13_lv_nmos ad=0.1428p pd=1.52u as=0 ps=0 w=0.42u l=1u
X649 a_32500_45746# sar_ctrl_async_phys_0.sg13g2_nor2_1$1_0.Y a_32406_45746# VSS.t418 sg13_lv_nmos ad=60.89999f pd=0.71u as=0.1428p ps=1.52u w=0.42u l=0.13u
X650 oa_sar8_acore18_opt_0.sw_bitcell_opt_b3_1.bot.t0 oa_sar8_acore18_opt_0.bstrap_opt_w2_c1200_1.gb oa_sar8_acore18_opt_0.bstrap_opt_w2_c1200_1.out VSS.t159 sg13_lv_nmos ad=0.195p pd=1.39u as=0.35p ps=2.7u w=1u l=0.13u
X651 VDD.t309 VSS.t1009 VDD.t270 VDD.t147 sg13_lv_pmos ad=0.19p pd=1.38u as=0 ps=0 w=1u l=1u
X652 VDD.t25 VSS.t313 VDD.t25 VDD.t22 sg13_lv_pmos ad=0.19p pd=1.38u as=0 ps=0 w=1u l=1u
X653 sar_ctrl_async_phys_0.sg13g2_dlygate4sd3_1$1_9.A a_26662_41278# VDD.t157 VDD.t0 sg13_lv_pmos ad=0.4256p pd=3u as=0.2254p ps=1.53u w=1.12u l=0.13u
X654 VDD.t146 sar_ctrl_async_phys_0.sg13g2_nor2_1$1_7.A a_29276_37436# VDD.t16 sg13_lv_pmos ad=0.4032p pd=2.96u as=0.1176p ps=1.33u w=1.12u l=0.13u
X655 VDD.t243 VSS.t246 VDD.t242 VDD.t29 sg13_lv_pmos ad=0.19p pd=1.38u as=0 ps=0 w=1u l=1u
X656 sar_ctrl_async_phys_0.cmp_n sar_ctrl_async_phys_0.cmp_fire VDD.t446 VDD.t445 sg13_lv_pmos ad=0.7p pd=4.7u as=0.7p ps=4.7u w=2u l=0.13u
X657 a_32406_45746# a_33211_45868# a_32666_45969# VDD.t10 sg13_lv_pmos ad=0.1428p pd=1.52u as=79.8f ps=0.8u w=0.42u l=0.13u
X658 VSS.t721 sar_ctrl_async_phys_0.sg13g2_nand2_1$1_2.B a_36074_40830# VSS.t720 sg13_lv_nmos ad=0.2516p pd=2.16u as=0.1406p ps=1.12u w=0.74u l=0.13u
X659 oa_sar8_acore18_opt_0.sw_bitcell_opt_b7_1.VSS sar_ctrl_async_phys_0.dac_code_n[2] oa_sar8_acore18_opt_0.sw_bitcell_opt_b2_1.bot.t0 VSS.t415 sg13_lv_nmos ad=0.665p pd=4.5u as=0.3705p ps=2.29u w=1.9u l=0.13u
X660 a_34393_35971# a_34036_35928# VDD.t19 VDD.t19 sg13_lv_pmos ad=63f pd=0.72u as=0.1563p ps=1.22u w=0.42u l=0.13u
X661 a_27530_39666# sar_ctrl_async_phys_0.sg13g2_dlygate4sd3_1$1_6.A VDD.t325 VDD.t317 sg13_lv_pmos ad=0.1428p pd=1.52u as=0.1523p ps=1.38u w=0.42u l=0.13u
X662 VDD.t394 sar_ctrl_async_phys_0.sg13g2_buf_1$1_6.A a_35384_32176# VDD.t76 sg13_lv_pmos ad=0.2114p pd=1.54u as=0.2856p ps=2.36u w=0.84u l=0.13u
X663 oa_sar8_acore18_opt_0.sw_tg_opt_0.bot.t3 oa_sar8_acore18_opt_0.sw_bitcell_opt_b7_0.bot.t89 cap_cmim l=2.14u w=2.14u
X664 VSS.t146 sar_ctrl_async_phys_0.sg13g2_dfrbpq_1$1_0.CLK.t12 a_27624_35965# VSS.t249 sg13_lv_nmos ad=79.8f pd=0.8u as=0.1428p ps=1.52u w=0.42u l=0.13u
X665 a_32580_43448# sar_ctrl_async_phys_0.sg13g2_buf_1$1_20.A VSS.t137 VSS.t1215 sg13_lv_nmos ad=0.187p pd=1.78u as=0.17255p ps=1.25u w=0.55u l=0.13u
X666 oa_sar8_acore18_opt_0.sw_tg_opt_0.bot.t4 oa_sar8_acore18_opt_0.sw_bitcell_opt_b7_0.bot.t10 cap_cmim l=2.14u w=2.14u
X667 VSS.t44 VDD.t202 VSS.t44 VSS.t1003 sg13_lv_nmos ad=0.1428p pd=1.52u as=0 ps=0 w=0.42u l=1u
X668 VDD.t258 VSS.t968 VDD.t258 VDD.t19 sg13_lv_pmos ad=0.19p pd=1.38u as=0 ps=0 w=1u l=1u
X669 a_30697_39071# a_29755_38959# a_30495_39309# VDD.t29 sg13_lv_pmos ad=93.45f pd=0.865u as=0.2048p ps=1.63u w=0.42u l=0.13u
X670 oa_sar8_acore18_opt_0.sw_tg_opt_1.bot.t3 oa_sar8_acore18_opt_0.sw_bitcell_opt_b7_1.bot.t26 cap_cmim l=2.14u w=2.14u
X671 VDD.t3 a_31189_31399# a_31291_31399# VDD.t3 sg13_lv_pmos ad=1.96315p pd=12.675u as=0.3864p ps=2.93u w=1.12u l=0.13u
X672 oa_sar8_acore18_opt_0.sw_tg_opt_0.bot.t3 oa_sar8_acore18_opt_0.sw_bitcell_opt_b5_0.bot.t15 cap_cmim l=2.14u w=2.14u
X673 VDD.t329 a_35557_31435# a_34636_31749# VDD.t3 sg13_lv_pmos ad=0.36237p pd=2.605u as=0.34p ps=2.68u w=1u l=0.13u
X674 oa_sar8_acore18_opt_0.sw_bitcell_opt_term_0.vin oa_sar8_acore18_opt_0.sw_bitcell_opt_term_0.gb.t11 oa_sar8_acore18_opt_0.sw_bitcell_opt_b6_0.bot.t0 VSS.t407 sg13_lv_nmos ad=0.35p pd=2.7u as=0.195p ps=1.39u w=1u l=0.13u
X675 a_33914_44457# a_34357_44213# a_33654_44234# VSS.t684 sg13_lv_nmos ad=79.8f pd=0.8u as=0.1296p ps=1.52u w=0.42u l=0.13u
X676 VDD.t16 a_32245_37447# a_32347_37447# VDD.t16 sg13_lv_pmos ad=2.48357p pd=16.205u as=0.3864p ps=2.93u w=1.12u l=0.13u
X677 oa_sar8_acore18_opt_0.bstrap_opt_w2_c1200_1.out oa_sar8_acore18_opt_0.sw_bitcell_opt_term_0.trkb.t23 oa_sar8_acore18_opt_0.sw_bitcell_opt_b5_1.bot.t0 VDD.t518 sg13_lv_pmos ad=0.7p pd=4.7u as=0.39p ps=2.39u w=2u l=0.13u
X678 a_33940_44552# a_33914_44457# VSS.t128 VSS.t198 sg13_lv_nmos ad=0.2516p pd=2.16u as=0.1626p ps=1.415u w=0.74u l=0.13u
X679 oa_sar8_acore18_opt_0.sw_bitcell_opt_b0_1.bot.t1 sar_ctrl_async_phys_0.dac_code_n[0] VDD.t584 VDD.t582 sg13_lv_pmos ad=0.585p pd=3.39u as=1.05p ps=6.7u w=3u l=0.13u
X680 VDD.t1009 sar_ctrl_async_phys_0.dac_code[1] oa_sar8_acore18_opt_0.sw_bitcell_opt_b1_0.bot.t5 VDD.t1008 sg13_lv_pmos ad=1.19p pd=7.5u as=0.663p ps=3.79u w=3.4u l=0.13u
X681 sar_ctrl_async_phys_0.bit_active[7] a_35672_38224# VDD.t558 VDD.t29 sg13_lv_pmos ad=0.42p pd=2.99u as=0.2114p ps=1.54u w=1.12u l=0.13u
X682 vcm sar_ctrl_async_phys_0.sample oa_sar8_acore18_opt_0.sw_tg_opt_1.bot.t0 VSS.t395 sg13_lv_nmos ad=0.35p pd=2.7u as=0.195p ps=1.39u w=1u l=0.13u
X683 a_34132_36687# a_34363_36796# a_33818_36897# VSS.t1288 sg13_lv_nmos ad=0.2373p pd=1.97u as=79.8f ps=0.8u w=0.42u l=0.13u
X684 VDD.t20 VSS.t340 VDD.t20 VDD.t19 sg13_lv_pmos ad=0.34p pd=2.68u as=0 ps=0 w=1u l=1u
X685 a_30037_43495# sar_ctrl_async_phys_0.sg13g2_dfrbpq_1$1_0.CLK.t25 VDD.t22 VDD.t22 sg13_lv_pmos ad=0.4088p pd=2.97u as=2.2076p ps=14.4u w=1.12u l=0.13u
X686 VSS.t979 VDD.t233 VSS.t979 VSS.t0 sg13_lv_nmos ad=0.1428p pd=1.52u as=0 ps=0 w=0.42u l=1u
X687 VSS.t780 VDD.t15 VSS.t777 VSS.t806 sg13_lv_nmos ad=0.1428p pd=1.52u as=0 ps=0 w=0.42u l=1u
X688 oa_sar8_acore18_opt_0.sw_tg_opt_1.bot.t3 oa_sar8_acore18_opt_0.sw_bitcell_opt_b7_1.bot.t121 cap_cmim l=2.14u w=2.14u
X689 VDD.t317 a_33632_40702# a_33577_40583# VDD.t317 sg13_lv_pmos ad=1.6658p pd=10.66u as=93.45f ps=0.865u w=0.42u l=0.13u
X690 a_35280_35365# sar_ctrl_async_phys_0.sg13g2_buf_1$1_3.A a_35417_35208# VSS.t12 sg13_lv_nmos ad=0.2176p pd=1.96u as=0.1216p ps=1.02u w=0.64u l=0.13u
X691 VDD.t372 sar_ctrl_async_phys_0.sg13g2_buf_1$1_2.A a_34520_33688# VDD.t147 sg13_lv_pmos ad=0.2114p pd=1.54u as=0.2856p ps=2.36u w=0.84u l=0.13u
X692 oa_sar8_acore18_opt_0.sw_tg_opt_1.bot.t3 oa_sar8_acore18_opt_0.sw_bitcell_opt_b6_1.bot.t30 cap_cmim l=2.14u w=2.14u
X693 a_34358_33325# sar_ctrl_async_phys_0.sg13g2_buf_1$1_6.X VSS.t260 VSS.t1309 sg13_lv_nmos ad=37.8f pd=0.6u as=0.1701p ps=1.65u w=0.42u l=0.13u
X694 VDD.t20 VSS.t979 VDD.t20 VDD.t19 sg13_lv_pmos ad=0.34p pd=2.68u as=0 ps=0 w=1u l=1u
X695 a_32425_46631# a_31483_46519# a_32223_46869# VDD.t10 sg13_lv_pmos ad=93.45f pd=0.865u as=0.2048p ps=1.63u w=0.42u l=0.13u
X696 VDD.t169 VSS.t943 VDD.t169 VDD.t16 sg13_lv_pmos ad=0.19p pd=1.38u as=0 ps=0 w=1u l=1u
X697 oa_sar8_acore18_opt_0.sw_tg_opt_1.bot.t3 oa_sar8_acore18_opt_0.sw_bitcell_opt_b7_1.bot.t22 cap_cmim l=2.14u w=2.14u
X698 a_30671_32876# sar_ctrl_async_phys_0.sg13g2_a22oi_1$1_0.A1 VDD.t150 VDD.t76 sg13_lv_pmos ad=0.2716p pd=1.605u as=0.3808p ps=2.92u w=1.12u l=0.13u
X699 a_34489_34459# a_34132_34416# VDD.t372 VDD.t147 sg13_lv_pmos ad=63f pd=0.72u as=0.1563p ps=1.22u w=0.42u l=0.13u
X700 a_33248_35382# sar_ctrl_async_phys_0.sg13g2_buf_1$1_6.X.t1 VDD.t19 VDD.t19 sg13_lv_pmos ad=79.8f pd=0.8u as=1.79957p ps=11.62u w=0.42u l=0.13u
X701 oa_sar8_acore18_opt_0.sw_tg_opt_0.bot.t3 oa_sar8_acore18_opt_0.sw_bitcell_opt_b6_0.bot.t34 cap_cmim l=2.14u w=2.14u
X702 VSS.t172 sar_ctrl_async_phys_0.sg13g2_a22oi_1$1_2.A2 sar_ctrl_async_phys_0.sg13g2_dfrbpq_1$1_9.D VSS.t1318 sg13_lv_nmos ad=0.2516p pd=2.16u as=0.1406p ps=1.12u w=0.74u l=0.13u
X703 oa_sar8_acore18_opt_0.sw_tg_opt_0.bot.t3 oa_sar8_acore18_opt_0.sw_bitcell_opt_b5_0.bot.t35 cap_cmim l=2.14u w=2.14u
X704 sar_ctrl_async_phys_0.cmp_n sar_ctrl_async_phys_0.cmp_p VDD.t597 VDD.t594 sg13_lv_pmos ad=0.585p pd=3.39u as=1.05p ps=6.7u w=3u l=0.13u
X705 a_30964_46512# a_30938_46476# VSS.t118 VSS.t329 sg13_lv_nmos ad=0.2516p pd=2.16u as=0.1626p ps=1.415u w=0.74u l=0.13u
X706 sar_ctrl_async_phys_0.sg13g2_and2_1$1_0.X a_31261_38232# VSS.t344 VSS.t405 sg13_lv_nmos ad=0.2516p pd=2.16u as=0.1331p ps=1.12u w=0.74u l=0.13u
X707 sar_ctrl_async_phys_0.sg13g2_and2_1$1_1.B a_35770_36972# VDD.t362 VDD.t16 sg13_lv_pmos ad=0.3808p pd=2.92u as=0.2128p ps=1.5u w=1.12u l=0.13u
X708 a_30774_44234# sar_ctrl_async_phys_0.sg13g2_nor2_1$1_10.Y VDD.t8 VDD.t5 sg13_lv_pmos ad=79.8f pd=0.8u as=0.1428p ps=1.52u w=0.42u l=0.13u
X709 VSS.t739 VDD.t64 VSS.t737 VSS.t764 sg13_lv_nmos ad=0.1428p pd=1.52u as=0 ps=0 w=0.42u l=1u
X710 sar_ctrl_async_phys_0.sg13g2_inv_1$1_7.A sar_ctrl_async_phys_0.sg13g2_nor2_1$1_8.B VSS.t102 VSS.t441 sg13_lv_nmos ad=0.1406p pd=1.12u as=0.2516p ps=2.16u w=0.74u l=0.13u
X711 oa_sar8_acore18_opt_0.sw_tg_opt_1.bot.t3 oa_sar8_acore18_opt_0.sw_bitcell_opt_term_1.bot.t1 cap_cmim l=2.14u w=2.14u
X712 VDD.t97 VSS.t1021 VDD.t121 VDD.t76 sg13_lv_pmos ad=0.34p pd=2.68u as=0 ps=0 w=1u l=1u
X713 a_32642_46946# sar_ctrl_async_phys_0.sg13g2_buf_1$1_41.X VSS.t126 VSS.t125 sg13_lv_nmos ad=37.8f pd=0.6u as=79.8f ps=0.8u w=0.42u l=0.13u
X714 oa_sar8_acore18_opt_0.sw_tg_opt_1.bot.t3 oa_sar8_acore18_opt_0.sw_bitcell_opt_b3_1.bot.t13 cap_cmim l=2.14u w=2.14u
X715 VDD.t177 a_34236_46472# sar_ctrl_async_phys_0.sg13g2_buf_1$1_41.X VDD.t10 sg13_lv_pmos ad=0.2114p pd=1.54u as=0.42p ps=2.99u w=1.12u l=0.13u
X716 VSS.t26 a_34357_44213# a_34459_44356# VSS.t685 sg13_lv_nmos ad=4.3785p pd=27.07u as=0.2516p ps=2.16u w=0.74u l=0.13u
X717 VDD.t11 VSS.t40 VDD.t11 VDD.t10 sg13_lv_pmos ad=0.34p pd=2.68u as=0 ps=0 w=1u l=1u
X718 oa_sar8_acore18_opt_0.sw_tg_opt_1.bot.t3 oa_sar8_acore18_opt_0.sw_bitcell_opt_b6_1.bot.t75 cap_cmim l=2.14u w=2.14u
X719 VDD.t649 sar_ctrl_async_phys_0.sg13g2_dfrbpq_1$1_8.RESET_B a_33558_36674# VDD.t16 sg13_lv_pmos ad=0.36237p pd=2.605u as=79.8f ps=0.8u w=0.42u l=0.13u
X720 oa_sar8_acore18_opt_0.sw_tg_opt_0.bot.t2 oa_sar8_acore18_opt_0.sw_bitcell_opt_b7_0.bot.t152 cap_cmim l=2.14u w=2.14u
X721 VSS.t501 a_35648_30846# a_35297_30703# VSS.t500 sg13_lv_nmos ad=79.8f pd=0.8u as=0.1428p ps=1.52u w=0.42u l=0.13u
X722 VSS.t29 sar_ctrl_async_phys_0.sg13g2_nand2b_1$1_0.A_N a_28392_41214# VSS.t361 sg13_lv_nmos ad=79.8f pd=0.8u as=0.1428p ps=1.52u w=0.42u l=0.13u
X723 oa_sar8_acore18_opt_0.sw_tg_opt_0.bot.t3 oa_sar8_acore18_opt_0.sw_bitcell_opt_b7_0.bot.t35 cap_cmim l=2.14u w=2.14u
X724 VSS.t1053 VDD.t121 VSS.t1054 VSS.t179 sg13_lv_nmos ad=79.8f pd=0.8u as=0 ps=0 w=0.42u l=1u
X725 VDD.t51 VSS.t783 VDD.t51 VDD.t10 sg13_lv_pmos ad=0.19p pd=1.38u as=0 ps=0 w=1u l=1u
X726 oa_sar8_acore18_opt_0.sw_tg_opt_1.bot.t3 oa_sar8_acore18_opt_0.sw_bitcell_opt_b6_1.bot.t15 cap_cmim l=2.14u w=2.14u
X727 a_33366_41210# sar_ctrl_async_phys_0.sg13g2_nor2_1$1_15.Y VDD.t114 VDD.t0 sg13_lv_pmos ad=79.8f pd=0.8u as=0.1428p ps=1.52u w=0.42u l=0.13u
X728 VDD.t394 a_35391_33261# a_36058_32900# VDD.t76 sg13_lv_pmos ad=0.2128p pd=1.5u as=0.3864p ps=2.93u w=1.12u l=0.13u
X729 oa_sar8_acore18_opt_0.sw_tg_opt_0.bot.t3 oa_sar8_acore18_opt_0.sw_bitcell_opt_b6_0.bot.t49 cap_cmim l=2.14u w=2.14u
X730 a_34132_43909# a_33844_43488# a_34070_43909# VSS.t342 sg13_lv_nmos ad=0.1428p pd=1.52u as=37.8f ps=0.6u w=0.42u l=0.13u
X731 VSS.t1125 VDD.t4 VSS.t696 VSS.t1126 sg13_lv_nmos ad=79.8f pd=0.8u as=0 ps=0 w=0.42u l=1u
X732 a_34526_31826# a_34268_31826# VSS.t578 VSS.t2 sg13_lv_nmos ad=0.1428p pd=1.52u as=79.8f ps=0.8u w=0.42u l=0.13u
X733 a_31093_35935# sar_ctrl_async_phys_0.sg13g2_dfrbpq_1$1_0.CLK.t11 VDD.t19 VDD.t19 sg13_lv_pmos ad=0.4088p pd=2.97u as=1.66112p ps=10.725u w=1.12u l=0.13u
X734 VSS.t373 a_35360_36894# a_35009_36751# VSS.t275 sg13_lv_nmos ad=79.8f pd=0.8u as=0.1428p ps=1.52u w=0.42u l=0.13u
X735 a_26544_38389# sar_ctrl_async_phys_0.sg13g2_buf_1$1_26.X VDD.t120 VDD.t29 sg13_lv_pmos ad=0.1596p pd=1.22u as=0.1918p ps=1.5u w=0.84u l=0.13u
X736 a_30038_33663# sar_ctrl_async_phys_0.sg13g2_buf_1$1_6.X VSS.t48 VSS.t173 sg13_lv_nmos ad=37.8f pd=0.6u as=0.1701p ps=1.65u w=0.42u l=0.13u
X737 sar_ctrl_async_phys_0.sg13g2_buf_1$1_1.A a_33658_35460# VSS.t270 VSS.t269 sg13_lv_nmos ad=0.2516p pd=2.16u as=0.1406p ps=1.12u w=0.74u l=0.13u
X738 oa_sar8_acore18_opt_0.sw_tg_opt_0.bot.t3 oa_sar8_acore18_opt_0.sw_bitcell_opt_b5_0.bot.t5 cap_cmim l=2.14u w=2.14u
X739 oa_sar8_acore18_opt_0.sw_tg_opt_0.bot.t3 oa_sar8_acore18_opt_0.sw_bitcell_opt_b7_0.bot.t62 cap_cmim l=2.14u w=2.14u
X740 VDD.t20 a_30507_35204# a_31007_35460# VDD.t19 sg13_lv_pmos ad=0.2198p pd=1.52u as=0.2975p ps=1.595u w=1u l=0.13u
X741 VSS.t42 sar_ctrl_async_phys_0.sg13g2_buf_1$1_42.A a_34904_47296# VSS.t41 sg13_lv_nmos ad=0.14875p pd=1.16u as=0.187p ps=1.78u w=0.55u l=0.13u
X742 a_34596_40424# sar_ctrl_async_phys_0.sg13g2_buf_1$1_15.A VSS.t113 VSS.t153 sg13_lv_nmos ad=0.187p pd=1.78u as=0.17255p ps=1.25u w=0.55u l=0.13u
X743 VDD.t90 VSS.t1085 VDD.t80 VDD.t3 sg13_lv_pmos ad=0.34p pd=2.68u as=0 ps=0 w=1u l=1u
X744 VDD.t349 sar_ctrl_async_phys_0.sg13g2_nand2_1$1_3.A sar_ctrl_async_phys_0.sg13g2_buf_1$1_32.A VDD.t5 sg13_lv_pmos ad=0.3808p pd=2.92u as=0.2128p ps=1.5u w=1.12u l=0.13u
X745 VDD.t338 sar_ctrl_async_phys_0.dac_code[7] oa_sar8_acore18_opt_0.sw_bitcell_opt_b7_0.bot.t0 VDD.t337 sg13_lv_pmos ad=2.38p pd=14.3u as=1.326p ps=7.19u w=6.8u l=0.13u
X746 VDD.t2 VSS.t46 VDD.t2 VDD.t0 sg13_lv_pmos ad=0.19p pd=1.38u as=0 ps=0 w=1u l=1u
X747 a_33087_37797# a_32245_37447# a_32993_37797# VSS.t14 sg13_lv_nmos ad=0.12665p pd=1.145u as=0.1428p ps=1.52u w=0.42u l=0.13u
X748 a_33344_37678# sar_ctrl_async_phys_0.sg13g2_buf_1$1_2.X.t5 VDD.t16 VDD.t16 sg13_lv_pmos ad=79.8f pd=0.8u as=2.2076p ps=14.4u w=0.42u l=0.13u
X749 a_31355_38232# sar_ctrl_async_phys_0.sg13g2_and2_1$1_0.A a_31261_38232# VSS.t337 sg13_lv_nmos ad=0.1216p pd=1.02u as=0.2176p ps=1.96u w=0.64u l=0.13u
X750 a_33630_33292# sar_ctrl_async_phys_0.sg13g2_a22oi_1$1_0.A1 sar_ctrl_async_phys_0.sg13g2_inv_1$1_0.A VSS.t57 sg13_lv_nmos ad=96.2f pd=1u as=0.2664p ps=1.46u w=0.74u l=0.13u
X751 VSS.t333 a_26364_45710# sar_ctrl_async_phys_0.sg13g2_buf_1$1_29.X VSS.t352 sg13_lv_nmos ad=0.14875p pd=1.16u as=0.2886p ps=2.26u w=0.74u l=0.13u
X752 a_28236_40440# sar_ctrl_async_phys_0.sg13g2_nor2_1$1_14.A sar_ctrl_async_phys_0.sg13g2_nor2_1$1_13.A VDD.t317 sg13_lv_pmos ad=0.2128p pd=1.5u as=0.2128p ps=1.5u w=1.12u l=0.15u
X753 VSS.t15 VDD.t1086 VSS.t15 VSS.t924 sg13_lv_nmos ad=0.1428p pd=1.52u as=0 ps=0 w=0.42u l=1u
X754 VSS.t1017 VDD.t121 VSS.t1019 VSS.t1018 sg13_lv_nmos ad=79.8f pd=0.8u as=0 ps=0 w=0.42u l=1u
X755 VSS.t506 sar_ctrl_async_phys_0.sg13g2_nand2_1$1_3.Y a_35672_42760# VSS.t652 sg13_lv_nmos ad=0.14875p pd=1.16u as=0.187p ps=1.78u w=0.55u l=0.13u
X756 a_34895_32460# sar_ctrl_async_phys_0.sg13g2_a22oi_1$1_0.B2 sar_ctrl_async_phys_0.sg13g2_a22oi_1$1_0.Y VDD.t76 sg13_lv_pmos ad=0.2744p pd=1.61u as=0.2128p ps=1.5u w=1.12u l=0.13u
X757 a_30678_46946# a_31483_46519# a_30938_46476# VDD.t10 sg13_lv_pmos ad=0.1428p pd=1.52u as=79.8f ps=0.8u w=0.42u l=0.13u
X758 VDD.t22 sar_ctrl_async_phys_0.sg13g2_and2_1$1_0.A a_25820_43020# VDD.t22 sg13_lv_pmos ad=0.4032p pd=2.96u as=0.1176p ps=1.33u w=1.12u l=0.13u
X759 oa_sar8_acore18_opt_0.sw_tg_opt_0.bot.t4 oa_sar8_acore18_opt_0.sw_bitcell_opt_b7_0.bot.t2 cap_cmim l=2.14u w=2.14u
X760 oa_sar8_acore18_opt_0.sw_tg_opt_0.bot.t2 oa_sar8_acore18_opt_0.sw_bitcell_opt_b7_0.bot.t157 cap_cmim l=2.14u w=2.14u
X761 VDD.t5 a_34357_44213# a_34459_44356# VDD.t5 sg13_lv_pmos ad=1.96315p pd=12.675u as=0.3864p ps=2.93u w=1.12u l=0.13u
X762 oa_sar8_acore18_opt_0.sw_tg_opt_1.bot.t4 oa_sar8_acore18_opt_0.sw_bitcell_opt_b7_1.bot.t15 cap_cmim l=2.14u w=2.14u
X763 a_31247_32876# sar_ctrl_async_phys_0.sg13g2_a22oi_1$1_0.A1 VDD.t345 VDD.t76 sg13_lv_pmos ad=0.2716p pd=1.605u as=0.3808p ps=2.92u w=1.12u l=0.13u
X764 oa_sar8_acore18_opt_0.sw_tg_opt_0.bot.t3 oa_sar8_acore18_opt_0.sw_bitcell_opt_b6_0.bot.t61 cap_cmim l=2.14u w=2.14u
X765 result[1] a_33464_30664# VSS.t311 VSS.t397 sg13_lv_nmos ad=0.2886p pd=2.26u as=0.14875p ps=1.16u w=0.74u l=0.13u
X766 VSS.t270 sar_ctrl_async_phys_0.sg13g2_dfrbpq_1$1_0.RESET_B a_33940_34850# VSS.t1207 sg13_lv_nmos ad=0.1626p pd=1.415u as=60.89999f ps=0.71u w=0.42u l=0.13u
X767 sar_ctrl_async_phys_0.sg13g2_nand2_1$1_5.B a_32986_44532# VSS.t128 VSS.t1203 sg13_lv_nmos ad=0.2516p pd=2.16u as=0.1406p ps=1.12u w=0.74u l=0.13u
X768 VDD.t219 VSS.t46 VDD.t219 VDD.t22 sg13_lv_pmos ad=0.19p pd=1.38u as=0 ps=0 w=1u l=1u
X769 VDD.t231 VSS.t169 VDD.t259 VDD.t29 sg13_lv_pmos ad=0.19p pd=1.38u as=0 ps=0 w=1u l=1u
X770 oa_sar8_acore18_opt_0.sw_tg_opt_1.bot.t3 oa_sar8_acore18_opt_0.sw_bitcell_opt_b6_1.bot.t2 cap_cmim l=2.14u w=2.14u
X771 oa_sar8_acore18_opt_0.sw_tg_opt_0.bot.t3 oa_sar8_acore18_opt_0.sw_bitcell_opt_b6_0.bot.t29 cap_cmim l=2.14u w=2.14u
X772 sar_ctrl_async_phys_0.sg13g2_a22oi_1$1_1.Y sar_ctrl_async_phys_0.sg13g2_a22oi_1$1_0.B1 a_34319_32460# VDD.t76 sg13_lv_pmos ad=0.2128p pd=1.5u as=0.2716p ps=1.605u w=1.12u l=0.13u
X773 VSS.t51 a_26550_41214# a_26662_41278# VSS.t617 sg13_lv_nmos ad=0.1426p pd=1.16u as=0.1428p ps=1.52u w=0.42u l=0.5u
X774 a_32288_31630# sar_ctrl_async_phys_0.sg13g2_buf_1$1_6.X VDD.t3 VDD.t3 sg13_lv_pmos ad=79.8f pd=0.8u as=1.79957p ps=11.62u w=0.42u l=0.13u
X775 sar_ctrl_async_phys_0.bit_active[1] a_36056_33688# VDD.t419 VDD.t147 sg13_lv_pmos ad=0.42p pd=2.99u as=0.2114p ps=1.54u w=1.12u l=0.13u
X776 a_32089_35553# a_31732_35480# VDD.t20 VDD.t19 sg13_lv_pmos ad=63f pd=0.72u as=0.1563p ps=1.22u w=0.42u l=0.13u
X777 VDD.t148 VSS.t1029 VDD.t148 VDD.t147 sg13_lv_pmos ad=0.19p pd=1.38u as=0 ps=0 w=1u l=1u
X778 VSS.t970 VDD.t159 VSS.t970 VSS.t0 sg13_lv_nmos ad=79.8f pd=0.8u as=0 ps=0 w=0.42u l=1u
X779 VSS.t373 a_35552_36166# a_35201_36285# VSS.t369 sg13_lv_nmos ad=79.8f pd=0.8u as=0.1428p ps=1.52u w=0.42u l=0.13u
X780 VSS.t65 VDD.t169 VSS.t65 VSS.t911 sg13_lv_nmos ad=79.8f pd=0.8u as=0 ps=0 w=0.42u l=1u
X781 oa_sar8_acore18_opt_0.sw_tg_opt_0.bot.t3 oa_sar8_acore18_opt_0.sw_bitcell_opt_b6_0.bot.t54 cap_cmim l=2.14u w=2.14u
X782 oa_sar8_acore18_opt_0.sw_tg_opt_0.bot.t3 oa_sar8_acore18_opt_0.sw_bitcell_opt_b7_0.bot.t73 cap_cmim l=2.14u w=2.14u
X783 a_35557_31435# a_34615_31475# a_35418_31668# VSS.t3 sg13_lv_nmos ad=79.8f pd=0.8u as=0.2373p ps=1.97u w=0.42u l=0.13u
X784 VDD.t29 a_29653_38959# a_29755_38959# VDD.t29 sg13_lv_pmos ad=3.62845p pd=23.965u as=0.3864p ps=2.93u w=1.12u l=0.13u
X785 VDD.t317 a_32533_40471# a_32635_40471# VDD.t317 sg13_lv_pmos ad=1.6658p pd=10.66u as=0.3864p ps=2.93u w=1.12u l=0.13u
X786 VSS.t968 VDD.t258 VSS.t431 VSS.t74 sg13_lv_nmos ad=79.8f pd=0.8u as=0 ps=0 w=0.42u l=1u
X787 VDD.t176 a_32223_46869# a_32890_46508# VDD.t10 sg13_lv_pmos ad=0.2128p pd=1.5u as=0.3864p ps=2.93u w=1.12u l=0.13u
X788 oa_sar8_acore18_opt_0.bstrap_opt_w2_c1200_1.out oa_sar8_acore18_opt_0.bstrap_opt_w2_c1200_1.gb oa_sar8_acore18_opt_0.sw_bitcell_opt_b6_1.bot.t0 VSS.t162 sg13_lv_nmos ad=0.35p pd=2.7u as=0.195p ps=1.39u w=1u l=0.13u
X789 VSS.t92 sar_ctrl_async_phys_0.sg13g2_buf_1$1_4.A a_36056_33688# VSS.t91 sg13_lv_nmos ad=0.14875p pd=1.16u as=0.187p ps=1.78u w=0.55u l=0.13u
X790 VSS.t834 VDD.t6 VSS.t836 VSS.t835 sg13_lv_nmos ad=79.8f pd=0.8u as=0 ps=0 w=0.42u l=1u
X791 VDD.t328 a_26454_39702# a_26566_39766# VDD.t317 sg13_lv_pmos ad=0.2254p pd=1.53u as=0.34p ps=2.68u w=1u l=0.5u
X792 oa_sar8_acore18_opt_0.sw_tg_opt_1.bot.t3 oa_sar8_acore18_opt_0.sw_bitcell_opt_b5_1.bot.t22 cap_cmim l=2.14u w=2.14u
X793 oa_sar8_acore18_opt_0.sw_tg_opt_1.bot.t3 oa_sar8_acore18_opt_0.sw_bitcell_opt_b7_1.bot.t65 cap_cmim l=2.14u w=2.14u
X794 a_25596_41174# sar_ctrl_async_phys_0.sg13g2_nor4_1$1_0.Y VDD.t154 VDD.t0 sg13_lv_pmos ad=0.2856p pd=2.36u as=0.2114p ps=1.54u w=0.84u l=0.13u
X795 oa_sar8_acore18_opt_0.sw_tg_opt_0.bot.t3 oa_sar8_acore18_opt_0.sw_bitcell_opt_b7_0.bot.t25 cap_cmim l=2.14u w=2.14u
X796 sar_ctrl_async_phys_0.sg13g2_a22oi_1$1_0.Y sar_ctrl_async_phys_0.sg13g2_a22oi_1$1_0.B2 a_34895_32120# VSS.t704 sg13_lv_nmos ad=0.2664p pd=1.46u as=0.13875p ps=1.115u w=0.74u l=0.13u
X797 a_33602_32138# sar_ctrl_async_phys_0.sg13g2_buf_1$1_6.X VSS.t178 VSS.t58 sg13_lv_nmos ad=37.8f pd=0.6u as=79.8f ps=0.8u w=0.42u l=0.13u
X798 VDD.t159 VSS.t935 VDD.t159 VDD.t19 sg13_lv_pmos ad=0.34p pd=2.68u as=0 ps=0 w=1u l=1u
X799 a_29084_38484# sar_ctrl_async_phys_0.sg13g2_dfrbpq_1$1_0.CLK.t15 sar_ctrl_async_phys_0.sg13g2_nand2_1$1_1.B VDD.t29 sg13_lv_pmos ad=0.1176p pd=1.33u as=0.3808p ps=2.92u w=1.12u l=0.13u
X800 oa_sar8_acore18_opt_0.sw_tg_opt_1.bot.t3 oa_sar8_acore18_opt_0.sw_bitcell_opt_b6_1.bot.t60 cap_cmim l=2.14u w=2.14u
X801 a_33818_43452# a_34261_43495# a_33558_43922# VSS.t226 sg13_lv_nmos ad=79.8f pd=0.8u as=0.1296p ps=1.52u w=0.42u l=0.13u
X802 VDD.t218 a_31140_42690# a_31098_43020# VDD.t22 sg13_lv_pmos ad=0.2618p pd=1.63u as=0.1176p ps=1.33u w=1.12u l=0.13u
X803 sar_ctrl_async_phys_0.dac_code[6] a_35672_38948# VDD.t678 VDD.t29 sg13_lv_pmos ad=0.42p pd=2.99u as=0.2114p ps=1.54u w=1.12u l=0.13u
X804 a_33344_37678# a_33087_37797# a_33506_37874# VSS.t14 sg13_lv_nmos ad=0.1428p pd=1.52u as=37.8f ps=0.6u w=0.42u l=0.13u
X805 oa_sar8_acore18_opt_0.sw_tg_opt_1.bot.t3 oa_sar8_acore18_opt_0.sw_bitcell_opt_b6_1.bot.t2 cap_cmim l=2.14u w=2.14u
X806 VDD.t384 sar_ctrl_async_phys_0.dac_code_n[5] oa_sar8_acore18_opt_0.sw_bitcell_opt_b5_1.bot.t1 VDD.t383 sg13_lv_pmos ad=1.89p pd=11.5u as=1.053p ps=5.79u w=5.4u l=0.13u
X807 VSS.t970 VDD.t270 VSS.t970 VSS.t0 sg13_lv_nmos ad=0.1428p pd=1.52u as=0 ps=0 w=0.42u l=1u
X808 VSS.t128 sar_ctrl_async_phys_0.sg13g2_a21oi_1$1_6.A2 a_33179_43832# VSS.t438 sg13_lv_nmos ad=0.1331p pd=1.12u as=0.1216p ps=1.02u w=0.64u l=0.13u
X809 sar_ctrl_async_phys_0.sg13g2_nor2_1$1_1.Y sar_ctrl_async_phys_0.sg13g2_nor2b_1$1_2.Y VSS.t15 VSS.t177 sg13_lv_nmos ad=0.1406p pd=1.12u as=0.2516p ps=2.16u w=0.74u l=0.13u
X810 a_34208_45966# a_33951_45823# a_34370_45746# VSS.t564 sg13_lv_nmos ad=0.1428p pd=1.52u as=37.8f ps=0.6u w=0.42u l=0.13u
X811 VSS.t783 VDD.t9 VSS.t783 VSS.t809 sg13_lv_nmos ad=79.8f pd=0.8u as=0 ps=0 w=0.42u l=1u
X812 sar_ctrl_async_phys_0.sg13g2_nor2_1$1_13.B sar_ctrl_async_phys_0.sg13g2_nor2_1$1_14.A VSS.t648 VSS.t103 sg13_lv_nmos ad=0.1406p pd=1.12u as=0.2516p ps=2.16u w=0.74u l=0.13u
X813 oa_sar8_acore18_opt_0.sw_tg_opt_0.bot.t3 oa_sar8_acore18_opt_0.sw_bitcell_opt_b7_0.bot.t125 cap_cmim l=2.14u w=2.14u
X814 VDD.t159 VSS.t970 VDD.t159 VDD.t19 sg13_lv_pmos ad=0.34p pd=2.68u as=0 ps=0 w=1u l=1u
X815 VSS.t817 VDD.t13 VSS.t816 VSS.t224 sg13_lv_nmos ad=0.1428p pd=1.52u as=0 ps=0 w=0.42u l=1u
X816 oa_sar8_acore18_opt_0.sw_tg_opt_0.bot.t3 oa_sar8_acore18_opt_0.sw_bitcell_opt_b3_0.bot.t16 cap_cmim l=2.14u w=2.14u
X817 VDD.t33 VSS.t821 VDD.t22 VDD.t22 sg13_lv_pmos ad=0.34p pd=2.68u as=0 ps=0 w=1u l=1u
X818 VDD.t362 a_35664_37695# sar_ctrl_async_phys_0.sg13g2_buf_1$1_4.A VDD.t16 sg13_lv_pmos ad=0.1918p pd=1.5u as=0.3808p ps=2.92u w=1.12u l=0.13u
X819 sar_ctrl_async_phys_0.sg13g2_a22oi_1$1_2.B2 a_32698_31388# VDD.t4 VDD.t3 sg13_lv_pmos ad=0.3808p pd=2.92u as=0.2128p ps=1.5u w=1.12u l=0.13u
X820 a_34261_43495# sar_ctrl_async_phys_0.sg13g2_dfrbpq_1$1_0.CLK.t24 VDD.t22 VDD.t22 sg13_lv_pmos ad=0.4088p pd=2.97u as=2.2076p ps=14.4u w=1.12u l=0.13u
X821 VDD.t145 VSS.t948 VDD.t145 VDD.t16 sg13_lv_pmos ad=0.19p pd=1.38u as=0 ps=0 w=1u l=1u
X822 oa_sar8_acore18_opt_0.sw_bitcell_opt_b5_1.bot.t0 oa_sar8_acore18_opt_0.sw_bitcell_opt_term_0.trkb.t23 oa_sar8_acore18_opt_0.bstrap_opt_w2_c1200_1.out VDD.t518 sg13_lv_pmos ad=0.39p pd=2.39u as=0.7p ps=4.7u w=2u l=0.13u
X823 a_34132_30944# a_34106_30849# VDD.t603 VDD.t3 sg13_lv_pmos ad=0.34p pd=2.68u as=0.36237p ps=2.605u w=1u l=0.13u
X824 a_34132_34416# a_34106_34380# VDD.t728 VDD.t147 sg13_lv_pmos ad=0.34p pd=2.68u as=0.36237p ps=2.605u w=1u l=0.13u
X825 a_27530_39666# sar_ctrl_async_phys_0.sg13g2_dlygate4sd3_1$1_6.A VSS.t899 VSS.t103 sg13_lv_nmos ad=0.1428p pd=1.52u as=79.8f ps=0.8u w=0.42u l=0.13u
X826 a_31093_39677# sar_ctrl_async_phys_0.sg13g2_dfrbpq_1$1_0.CLK.t18 VDD.t317 VDD.t317 sg13_lv_pmos ad=0.4088p pd=2.97u as=1.55472p ps=9.945u w=1.12u l=0.13u
X827 oa_sar8_acore18_opt_0.sw_tg_opt_1.bot.t3 oa_sar8_acore18_opt_0.sw_bitcell_opt_b7_1.bot.t90 cap_cmim l=2.14u w=2.14u
X828 oa_sar8_acore18_opt_0.sw_bitcell_opt_b1_0.bot.t5 sar_ctrl_async_phys_0.dac_code[1] VDD.t1010 VDD.t1008 sg13_lv_pmos ad=0.663p pd=3.79u as=1.19p ps=7.5u w=3.4u l=0.13u
X829 a_33951_45823# a_33109_45725# a_32692_46064# VDD.t10 sg13_lv_pmos ad=0.2048p pd=1.63u as=0.34p ps=2.68u w=1u l=0.13u
X830 VDD.t392 a_33375_40821# a_34042_40460# VDD.t317 sg13_lv_pmos ad=0.2128p pd=1.5u as=0.3864p ps=2.93u w=1.12u l=0.13u
X831 a_31140_42690# sar_ctrl_async_phys_0.sg13g2_and2_1$1_6.X VSS.t46 VSS.t167 sg13_lv_nmos ad=0.187p pd=1.78u as=0.17255p ps=1.25u w=0.55u l=0.13u
X832 VSS.t222 a_31644_36638# sar_ctrl_async_phys_0.sg13g2_and2_1$1_0.A VSS.t404 sg13_lv_nmos ad=0.14875p pd=1.16u as=0.2886p ps=2.26u w=0.74u l=0.13u
X833 VSS.t212 a_32031_31749# a_32698_31388# VSS.t625 sg13_lv_nmos ad=0.1406p pd=1.12u as=0.2516p ps=2.16u w=0.74u l=0.13u
X834 oa_sar8_acore18_opt_0.sw_tg_opt_0.bot.t3 oa_sar8_acore18_opt_0.sw_bitcell_opt_b6_0.bot.t14 cap_cmim l=2.14u w=2.14u
X835 VDD.t81 VSS.t1083 VDD.t80 VDD.t3 sg13_lv_pmos ad=0.19p pd=1.38u as=0 ps=0 w=1u l=1u
X836 sar_ctrl_async_phys_0.sg13g2_inv_1$1_0.Y sar_ctrl_async_phys_0.sg13g2_inv_1$1_0.A VDD.t394 VDD.t76 sg13_lv_pmos ad=0.3808p pd=2.92u as=0.3808p ps=2.92u w=1.12u l=0.13u
X837 a_28410_39996# sar_ctrl_async_phys_0.sg13g2_nor2_1$1_14.A VDD.t721 VDD.t317 sg13_lv_pmos ad=0.1176p pd=1.33u as=0.4032p ps=2.96u w=1.12u l=0.13u
X838 sar_ctrl_async_phys_0.sg13g2_buf_1$1_46.A sar_ctrl_async_phys_0.sg13g2_nand2_1$1_3.A a_35786_45750# VSS.t147 sg13_lv_nmos ad=0.2516p pd=2.16u as=0.1406p ps=1.12u w=0.74u l=0.13u
X839 VDD.t317 a_32192_39918# a_32137_40013# VDD.t317 sg13_lv_pmos ad=1.6658p pd=10.66u as=93.45f ps=0.865u w=0.42u l=0.13u
X840 a_33359_32876# sar_ctrl_async_phys_0.sg13g2_a22oi_1$1_0.A1 VDD.t342 VDD.t76 sg13_lv_pmos ad=0.2716p pd=1.605u as=0.3808p ps=2.92u w=1.12u l=0.13u
X841 oa_sar8_acore18_opt_0.sw_tg_opt_0.bot.t3 oa_sar8_acore18_opt_0.sw_bitcell_opt_b7_0.bot.t136 cap_cmim l=2.14u w=2.14u
X842 VDD.t361 sar_ctrl_async_phys_0.sg13g2_nor2_1$1_5.A a_28782_40460# VDD.t317 sg13_lv_pmos ad=0.3808p pd=2.92u as=0.2128p ps=1.5u w=1.12u l=0.13u
X843 oa_sar8_acore18_opt_0.sw_tg_opt_0.bot.t3 oa_sar8_acore18_opt_0.sw_bitcell_opt_b5_0.bot.t25 cap_cmim l=2.14u w=2.14u
X844 VSS.t1 VDD.t233 VSS.t1 VSS.t0 sg13_lv_nmos ad=0.1428p pd=1.52u as=0 ps=0 w=0.42u l=1u
X845 VSS.t7 a_33248_45238# a_32897_45357# VSS.t123 sg13_lv_nmos ad=79.8f pd=0.8u as=0.1428p ps=1.52u w=0.42u l=0.13u
X846 a_29524_39373# a_29755_38959# a_29210_38916# VSS.t1269 sg13_lv_nmos ad=0.2373p pd=1.97u as=79.8f ps=0.8u w=0.42u l=0.13u
X847 VDD.t49 VSS.t730 VDD.t11 VDD.t10 sg13_lv_pmos ad=0.34p pd=2.68u as=0 ps=0 w=1u l=1u
X848 VSS.t128 sar_ctrl_async_phys_0.sg13g2_buf_1$1_41.X a_33652_43922# VSS.t140 sg13_lv_nmos ad=0.1626p pd=1.415u as=60.89999f ps=0.71u w=0.42u l=0.13u
X849 VSS.t575 a_28662_41214# a_28774_41278# VSS.t624 sg13_lv_nmos ad=0.1426p pd=1.16u as=0.1428p ps=1.52u w=0.42u l=0.5u
X850 a_35595_40460# sar_ctrl_async_phys_0.sg13g2_a21oi_1$1_3.B1 sar_ctrl_async_phys_0.sg13g2_a22oi_1$1_3.A2 VDD.t317 sg13_lv_pmos ad=0.2128p pd=1.5u as=0.3808p ps=2.92u w=1.12u l=0.13u
X851 VDD.t114 sar_ctrl_async_phys_0.sg13g2_a21oi_1$1_5.A2 a_32400_41413# VDD.t0 sg13_lv_pmos ad=0.2856p pd=2.36u as=0.1596p ps=1.22u w=0.84u l=0.13u
X852 a_31802_37404# a_32245_37447# a_32185_37483# VDD.t16 sg13_lv_pmos ad=79.8f pd=0.8u as=63f ps=0.72u w=0.42u l=0.13u
X853 a_30676_35928# a_30650_35892# VDD.t20 VDD.t19 sg13_lv_pmos ad=0.34p pd=2.68u as=0.36237p ps=2.605u w=1u l=0.13u
X854 VSS.t433 a_36156_45710# sar_ctrl_async_phys_0.sg13g2_nand2_1$1_3.A VSS.t432 sg13_lv_nmos ad=0.14875p pd=1.16u as=0.2886p ps=2.26u w=0.74u l=0.13u
X855 a_34166_44247# sar_ctrl_async_phys_0.sg13g2_buf_1$1_41.X VSS.t128 VSS.t127 sg13_lv_nmos ad=37.8f pd=0.6u as=0.1701p ps=1.65u w=0.42u l=0.13u
X856 VDD.t595 sar_ctrl_async_phys_0.cmp_p sar_ctrl_async_phys_0.cmp_n VDD.t594 sg13_lv_pmos ad=1.05p pd=6.7u as=0.585p ps=3.39u w=3u l=0.13u
X857 VSS.t102 VDD.t82 VSS.t102 VSS.t918 sg13_lv_nmos ad=0.1428p pd=1.52u as=0 ps=0 w=0.42u l=1u
X858 VSS.t102 VDD.t145 VSS.t102 VSS.t915 sg13_lv_nmos ad=79.8f pd=0.8u as=0 ps=0 w=0.42u l=1u
X859 oa_sar8_acore18_opt_0.sw_tg_opt_0.bot.t3 oa_sar8_acore18_opt_0.sw_bitcell_opt_b5_0.bot.t15 cap_cmim l=2.14u w=2.14u
X860 VDD.t90 VSS.t1061 VDD.t59 VDD.t3 sg13_lv_pmos ad=0.19p pd=1.38u as=0 ps=0 w=1u l=1u
X861 sar_ctrl_async_phys_0.sg13g2_buf_1$1_2.X.t1 a_34520_33688# VDD.t372 VDD.t147 sg13_lv_pmos ad=0.42p pd=2.99u as=0.2114p ps=1.54u w=1.12u l=0.13u
X862 VDD.t202 sar_ctrl_async_phys_0.sg13g2_a22oi_1$1_1.Y sar_ctrl_async_phys_0.sg13g2_inv_1$1_1.Y VDD.t147 sg13_lv_pmos ad=0.3808p pd=2.92u as=0.3808p ps=2.92u w=1.12u l=0.13u
X863 a_34266_37436# sar_ctrl_async_phys_0.sg13g2_a22oi_1$1_0.A1 sar_ctrl_async_phys_0.sg13g2_nor2b_1$1_2.Y VDD.t16 sg13_lv_pmos ad=0.1176p pd=1.33u as=0.3808p ps=2.92u w=1.12u l=0.13u
X864 oa_sar8_acore18_opt_0.sw_tg_opt_0.bot.t3 oa_sar8_acore18_opt_0.sw_bitcell_opt_b7_0.bot.t65 cap_cmim l=2.14u w=2.14u
X865 VSS.t40 VDD.t43 VSS.t40 VSS.t728 sg13_lv_nmos ad=79.8f pd=0.8u as=0 ps=0 w=0.42u l=1u
X866 a_33626_41433# a_34069_41189# a_34009_41601# VDD.t0 sg13_lv_pmos ad=79.8f pd=0.8u as=63f ps=0.72u w=0.42u l=0.13u
X867 a_32089_45043# a_31732_45000# VDD.t8 VDD.t5 sg13_lv_pmos ad=63f pd=0.72u as=0.1563p ps=1.22u w=0.42u l=0.13u
X868 sar_ctrl_async_phys_0.bit_active[5] a_36056_37436# VDD.t362 VDD.t16 sg13_lv_pmos ad=0.42p pd=2.99u as=0.2114p ps=1.54u w=1.12u l=0.13u
X869 oa_sar8_acore18_opt_0.sw_bitcell_opt_term_0.VSS VDD.t1083 oa_sar8_acore18_opt_0.sw_bitcell_opt_term_0.bot.t0 VSS.t1128 sg13_lv_nmos ad=0.525p pd=3.7u as=0.2925p ps=1.89u w=1.5u l=0.13u
X870 oa_sar8_acore18_opt_0.sw_tg_opt_1.bot.t2 oa_sar8_acore18_opt_0.sw_bitcell_opt_b7_1.bot.t163 cap_cmim l=2.14u w=2.14u
X871 oa_sar8_acore18_opt_0.sw_bitcell_opt_b4_0.bot.t1 sar_ctrl_async_phys_0.dac_code[4] oa_sar8_acore18_opt_0.sw_bitcell_opt_term_0.VSS VSS.t254 sg13_lv_nmos ad=0.468p pd=2.79u as=0.84p ps=5.5u w=2.4u l=0.13u
X872 a_30650_35892# a_31093_35935# a_30390_36362# VSS.t670 sg13_lv_nmos ad=79.8f pd=0.8u as=0.1296p ps=1.52u w=0.42u l=0.13u
X873 VSS.t260 sar_ctrl_async_phys_0.sg13g2_buf_1$1_2.A a_34520_33688# VSS.t259 sg13_lv_nmos ad=0.14875p pd=1.16u as=0.187p ps=1.78u w=0.55u l=0.13u
X874 VSS.t1022 VDD.t270 VSS.t1021 VSS.t1020 sg13_lv_nmos ad=0.1428p pd=1.52u as=0 ps=0 w=0.42u l=1u
X875 VSS.t730 VDD.t44 VSS.t730 VSS.t735 sg13_lv_nmos ad=79.8f pd=0.8u as=0 ps=0 w=0.42u l=1u
X876 oa_sar8_acore18_opt_0.sw_tg_opt_0.bot.t3 oa_sar8_acore18_opt_0.sw_bitcell_opt_b6_0.bot.t21 cap_cmim l=2.14u w=2.14u
X877 oa_sar8_acore18_opt_0.sw_tg_opt_0.bot.t4 oa_sar8_acore18_opt_0.sw_bitcell_opt_b7_0.bot.t15 cap_cmim l=2.14u w=2.14u
X878 a_31933_43832# sar_ctrl_async_phys_0.sg13g2_a21oi_1$1_4.A2 VDD.t218 VDD.t22 sg13_lv_pmos ad=0.1596p pd=1.22u as=0.2856p ps=2.36u w=0.84u l=0.13u
X879 oa_sar8_acore18_opt_0.sw_tg_opt_1.bot.t3 oa_sar8_acore18_opt_0.sw_bitcell_opt_b6_1.bot.t35 cap_cmim l=2.14u w=2.14u
X880 VSS.t113 a_33375_40821# a_34042_40460# VSS.t1260 sg13_lv_nmos ad=0.1406p pd=1.12u as=0.2516p ps=2.16u w=0.74u l=0.13u
X881 a_30774_44234# a_31579_44356# a_31034_44457# VDD.t5 sg13_lv_pmos ad=0.1428p pd=1.52u as=79.8f ps=0.8u w=0.42u l=0.13u
X882 VSS.t851 VDD.t69 VSS.t851 VSS.t866 sg13_lv_nmos ad=0.1428p pd=1.52u as=0 ps=0 w=0.42u l=1u
X883 vinp oa_sar8_acore18_opt_0.bstrap_opt_w2_c1200_1.gb oa_sar8_acore18_opt_0.bstrap_opt_w2_c1200_1.out VSS.t165 sg13_lv_nmos ad=0.35p pd=2.7u as=0.195p ps=1.39u w=1u l=0.13u
X884 a_32538_43484# sar_ctrl_async_phys_0.sg13g2_nor2b_1$1_0.A sar_ctrl_async_phys_0.sg13g2_nor2b_1$1_4.Y VDD.t22 sg13_lv_pmos ad=0.1176p pd=1.33u as=0.3808p ps=2.92u w=1.12u l=0.13u
X885 a_33844_39711# a_34075_39820# a_33530_39921# VSS.t299 sg13_lv_nmos ad=0.2373p pd=1.97u as=79.8f ps=0.8u w=0.42u l=0.13u
X886 VDD.t23 VSS.t111 VDD.t33 VDD.t22 sg13_lv_pmos ad=0.19p pd=1.38u as=0 ps=0 w=1u l=1u
X887 a_31140_42690# sar_ctrl_async_phys_0.sg13g2_and2_1$1_6.X VDD.t218 VDD.t22 sg13_lv_pmos ad=0.2856p pd=2.36u as=0.2618p ps=1.63u w=0.84u l=0.13u
X888 oa_sar8_acore18_opt_0.sw_tg_opt_0.bot.t3 oa_sar8_acore18_opt_0.sw_bitcell_opt_b3_0.bot.t6 cap_cmim l=2.14u w=2.14u
X889 oa_sar8_acore18_opt_0.sw_tg_opt_0.bot.t3 oa_sar8_acore18_opt_0.sw_bitcell_opt_b7_0.bot.t141 cap_cmim l=2.14u w=2.14u
X890 a_33375_40821# a_32533_40471# a_33281_40821# VSS.t422 sg13_lv_nmos ad=0.12665p pd=1.145u as=0.1428p ps=1.52u w=0.42u l=0.13u
X891 oa_sar8_acore18_opt_0.sw_tg_opt_1.bot.t3 oa_sar8_acore18_opt_0.sw_bitcell_opt_b4_1.bot.t24 cap_cmim l=2.14u w=2.14u
X892 sar_ctrl_async_phys_0.dac_code[2] a_35672_42760# VDD.t330 VDD.t22 sg13_lv_pmos ad=0.42p pd=2.99u as=0.2114p ps=1.54u w=1.12u l=0.13u
X893 VSS.t146 sar_ctrl_async_phys_0.sg13g2_inv_1$1_7.A sar_ctrl_async_phys_0.sg13g2_nor2_1$1_8.B VSS.t349 sg13_lv_nmos ad=0.2516p pd=2.16u as=0.1406p ps=1.12u w=0.74u l=0.13u
X894 oa_sar8_acore18_opt_0.sw_bitcell_opt_b7_0.bot.t0 sar_ctrl_async_phys_0.dac_code[7] VDD.t339 VDD.t337 sg13_lv_pmos ad=1.326p pd=7.19u as=2.38p ps=14.3u w=6.8u l=0.13u
X895 VDD.t22 a_30879_43845# a_31136_43726# VDD.t22 sg13_lv_pmos ad=2.48357p pd=16.205u as=79.8f ps=0.8u w=0.42u l=0.13u
X896 oa_sar8_acore18_opt_0.sw_tg_opt_1.bot.t3 oa_sar8_acore18_opt_0.sw_bitcell_opt_b7_1.bot.t31 cap_cmim l=2.14u w=2.14u
X897 VDD.t408 sar_ctrl_async_phys_0.sg13g2_buf_1$1_41.X a_33914_44457# VDD.t5 sg13_lv_pmos ad=0.1563p pd=1.22u as=0.147p ps=1.54u w=0.42u l=0.13u
X898 oa_sar8_acore18_opt_0.sw_tg_opt_1.bot.t3 oa_sar8_acore18_opt_0.sw_bitcell_opt_b4_1.bot.t4 cap_cmim l=2.14u w=2.14u
X899 oa_sar8_acore18_opt_0.sw_tg_opt_1.bot.t3 oa_sar8_acore18_opt_0.sw_bitcell_opt_b7_1.bot.t107 cap_cmim l=2.14u w=2.14u
X900 VSS.t970 VDD.t159 VSS.t975 VSS.t0 sg13_lv_nmos ad=79.8f pd=0.8u as=0 ps=0 w=0.42u l=1u
X901 VSS.t126 VDD.t132 VSS.t126 VSS.t41 sg13_lv_nmos ad=79.8f pd=0.8u as=0 ps=0 w=0.42u l=1u
X902 oa_sar8_acore18_opt_0.sw_tg_opt_0.bot.t3 oa_sar8_acore18_opt_0.sw_bitcell_opt_b6_0.bot.t4 cap_cmim l=2.14u w=2.14u
X903 w_39600_n9960# a_35948_n9612# cap_cmim l=9.94u w=39.8u
X904 VDD.t233 VSS.t1034 VDD.t233 VDD.t147 sg13_lv_pmos ad=0.19p pd=1.38u as=0 ps=0 w=1u l=1u
X905 a_31540_35162# sar_ctrl_async_phys_0.sg13g2_dfrbpq_1$1_5.D a_31446_35162# VSS.t0 sg13_lv_nmos ad=60.89999f pd=0.71u as=0.1428p ps=1.52u w=0.42u l=0.13u
X906 sar_ctrl_async_phys_0.sg13g2_nor2_1$1_4.Y sar_ctrl_async_phys_0.sg13g2_buf_1$1_26.X a_26394_37436# VDD.t16 sg13_lv_pmos ad=0.3808p pd=2.92u as=0.1176p ps=1.33u w=1.12u l=0.13u
X907 oa_sar8_acore18_opt_0.sw_tg_opt_0.bot.t3 oa_sar8_acore18_opt_0.sw_bitcell_opt_b7_0.bot.t40 cap_cmim l=2.14u w=2.14u
X908 vinp oa_sar8_acore18_opt_0.bstrap_opt_w2_c1200_1.gb a_20412_n9612# VSS.t166 sg13_lv_nmos ad=0.345p pd=2.69u as=0.19p ps=1.38u w=1u l=0.15u
X909 oa_sar8_acore18_opt_0.bstrap_opt_w2_c1200_1.out oa_sar8_acore18_opt_0.sw_bitcell_opt_term_0.trkb.t21 oa_sar8_acore18_opt_0.sw_bitcell_opt_b7_1.bot.t0 VDD.t779 sg13_lv_pmos ad=0.7p pd=4.7u as=0.39p ps=2.39u w=2u l=0.13u
X910 sar_ctrl_async_phys_0.sg13g2_a21oi_1$1_3.A2 a_35482_39996# VDD.t317 VDD.t317 sg13_lv_pmos ad=0.3808p pd=2.92u as=0.2128p ps=1.5u w=1.12u l=0.13u
X911 oa_sar8_acore18_opt_0.sw_tg_opt_1.bot.t3 oa_sar8_acore18_opt_0.sw_bitcell_opt_b7_1.bot.t147 cap_cmim l=2.14u w=2.14u
X912 a_35391_33261# a_34549_32911# a_35297_33261# VSS.t607 sg13_lv_nmos ad=0.12665p pd=1.145u as=0.1428p ps=1.52u w=0.42u l=0.13u
X913 VSS.t248 VDD.t1089 VSS.t246 VSS.t549 sg13_lv_nmos ad=79.8f pd=0.8u as=0 ps=0 w=0.42u l=1u
X914 a_35648_33142# sar_ctrl_async_phys_0.sg13g2_buf_1$1_6.X VDD.t76 VDD.t76 sg13_lv_pmos ad=79.8f pd=0.8u as=1.79957p ps=11.62u w=0.42u l=0.13u
X915 a_27894_35924# a_27624_35965# VDD.t289 VDD.t19 sg13_lv_pmos ad=0.34p pd=2.68u as=0.1523p ps=1.38u w=1u l=0.5u
X916 a_31823_32876# sar_ctrl_async_phys_0.sg13g2_a22oi_1$1_0.A1 VDD.t345 VDD.t76 sg13_lv_pmos ad=0.2716p pd=1.605u as=0.3808p ps=2.92u w=1.12u l=0.13u
X917 a_33940_33338# sar_ctrl_async_phys_0.sg13g2_inv_1$1_1.Y a_33846_33338# VSS.t57 sg13_lv_nmos ad=60.89999f pd=0.71u as=0.1428p ps=1.52u w=0.42u l=0.13u
X918 a_34731_37436# sar_ctrl_async_phys_0.sg13g2_a21oi_1$1_0.B1 sar_ctrl_async_phys_0.sg13g2_a22oi_1$1_1.A2 VDD.t16 sg13_lv_pmos ad=0.2128p pd=1.5u as=0.3808p ps=2.92u w=1.12u l=0.13u
X919 oa_sar8_acore18_opt_0.sw_tg_opt_1.bot.t3 oa_sar8_acore18_opt_0.sw_bitcell_opt_b7_1.bot.t63 cap_cmim l=2.14u w=2.14u
X920 VDD.t19 a_31093_35935# a_31195_35935# VDD.t19 sg13_lv_pmos ad=1.79957p pd=11.62u as=0.3864p ps=2.93u w=1.12u l=0.13u
X921 sar_ctrl_async_phys_0.dac_code_n[4] a_35672_47296# VSS.t42 VSS.t41 sg13_lv_nmos ad=0.2886p pd=2.26u as=0.14875p ps=1.16u w=0.74u l=0.13u
X922 sar_ctrl_async_phys_0.sg13g2_buf_1$1_42.A a_35245_45936# VDD.t416 VDD.t10 sg13_lv_pmos ad=0.2128p pd=1.5u as=0.3808p ps=2.92u w=1.12u l=0.13u
X923 VSS.t1 sar_ctrl_async_phys_0.sg13g2_a22oi_1$1_3.B1 a_31832_34412# VSS.t1266 sg13_lv_nmos ad=0.14875p pd=1.16u as=0.187p ps=1.78u w=0.55u l=0.13u
X924 a_34069_41189# sar_ctrl_async_phys_0.sg13g2_dfrbpq_1$1_0.CLK.t22 VSS.t187 VSS.t186 sg13_lv_nmos ad=0.2516p pd=2.16u as=4.20675p ps=26.86u w=0.74u l=0.13u
X925 oa_sar8_acore18_opt_0.sw_tg_opt_0.bot.t3 oa_sar8_acore18_opt_0.sw_bitcell_opt_b7_0.bot.t99 cap_cmim l=2.14u w=2.14u
X926 VDD.t0 a_34911_41287# a_35168_41430# VDD.t0 sg13_lv_pmos ad=3.62845p pd=23.965u as=79.8f ps=0.8u w=0.42u l=0.13u
X927 VSS.t344 VDD.t86 VSS.t344 VSS.t923 sg13_lv_nmos ad=0.1428p pd=1.52u as=0 ps=0 w=0.42u l=1u
X928 VSS.t431 a_33252_36642# sar_ctrl_async_phys_0.sg13g2_nor2b_1$1_1.Y VSS.t234 sg13_lv_nmos ad=0.17255p pd=1.25u as=0.1406p ps=1.12u w=0.74u l=0.13u
X929 oa_sar8_acore18_opt_0.sw_bitcell_opt_b7_1.VSS sar_ctrl_async_phys_0.dac_code_n[7].t1 oa_sar8_acore18_opt_0.sw_bitcell_opt_b7_1.bot.t0 VSS.t163 sg13_lv_nmos ad=1.19p pd=7.5u as=0.663p ps=3.79u w=3.4u l=0.13u
X930 VDD.t43 VSS.t40 VDD.t43 VDD.t42 sg13_lv_pmos ad=0.19p pd=1.38u as=0 ps=0 w=1u l=1u
X931 VSS.t827 VDD.t23 VSS.t826 VSS.t224 sg13_lv_nmos ad=0.1428p pd=1.52u as=0 ps=0 w=0.42u l=1u
X932 VSS.t62 a_28758_35924# a_28870_35948# VSS.t526 sg13_lv_nmos ad=0.1426p pd=1.16u as=0.1428p ps=1.52u w=0.42u l=0.5u
X933 VSS.t780 VDD.t51 VSS.t783 VSS.t782 sg13_lv_nmos ad=79.8f pd=0.8u as=0 ps=0 w=0.42u l=1u
X934 VSS.t344 sar_ctrl_async_phys_0.sg13g2_and2_1$1_0.B a_31355_38232# VSS.t713 sg13_lv_nmos ad=0.1331p pd=1.12u as=0.1216p ps=1.02u w=0.64u l=0.13u
X935 a_35557_31435# sar_ctrl_async_phys_0.sg13g2_buf_1$1_6.X VDD.t329 VDD.t3 sg13_lv_pmos ad=0.147p pd=1.54u as=0.1563p ps=1.22u w=0.42u l=0.13u
X936 a_31381_46519# sar_ctrl_async_phys_0.sg13g2_dfrbpq_1$1_0.CLK.t30 VSS.t193 VSS.t527 sg13_lv_nmos ad=0.2516p pd=2.16u as=9.09497p ps=59.065u w=0.74u l=0.13u
X937 VSS.t975 VDD.t270 VSS.t975 VSS.t0 sg13_lv_nmos ad=0.1428p pd=1.52u as=0 ps=0 w=0.42u l=1u
X938 oa_sar8_acore18_opt_0.sw_bitcell_opt_term_0.VSS sar_ctrl_async_phys_0.dac_code[1] oa_sar8_acore18_opt_0.sw_bitcell_opt_b1_0.bot.t4 VSS.t1236 sg13_lv_nmos ad=0.595p pd=4.1u as=0.3315p ps=2.09u w=1.7u l=0.13u
X939 oa_sar8_acore18_opt_0.sw_tg_opt_1.bot.t3 oa_sar8_acore18_opt_0.sw_bitcell_opt_b6_1.bot.t62 cap_cmim l=2.14u w=2.14u
X940 VDD.t289 VSS.t975 VDD.t159 VDD.t19 sg13_lv_pmos ad=0.34p pd=2.68u as=0 ps=0 w=1u l=1u
X941 VDD.t416 sar_ctrl_async_phys_0.sg13g2_nand2b_1$1_3.Y a_35672_46508# VDD.t10 sg13_lv_pmos ad=0.2114p pd=1.54u as=0.2856p ps=2.36u w=0.84u l=0.13u
X942 VDD.t76 a_30591_32215# a_30848_32358# VDD.t76 sg13_lv_pmos ad=1.96315p pd=12.675u as=79.8f ps=0.8u w=0.42u l=0.13u
X943 VSS.t1096 VDD.t59 VSS.t1098 VSS.t1097 sg13_lv_nmos ad=79.8f pd=0.8u as=0 ps=0 w=0.42u l=1u
X944 a_31665_42748# sar_ctrl_async_phys_0.sg13g2_a21oi_1$1_0.A1 sar_ctrl_async_phys_0.sg13g2_nor2_1$1_10.B VSS.t68 sg13_lv_nmos ad=0.1406p pd=1.12u as=0.1406p ps=1.12u w=0.74u l=0.13u
X945 VDD.t23 VSS.t824 VDD.t33 VDD.t22 sg13_lv_pmos ad=0.34p pd=2.68u as=0 ps=0 w=1u l=1u
X946 VSS.t554 sar_ctrl_async_phys_0.sg13g2_nor2_1$1_18.A sar_ctrl_async_phys_0.sg13g2_dfrbpq_1$1_11.D VSS.t549 sg13_lv_nmos ad=0.2516p pd=2.16u as=0.1406p ps=1.12u w=0.74u l=0.13u
X947 VSS.t210 sar_ctrl_async_phys_0.sg13g2_buf_1$1_13.A a_35288_38224# VSS.t177 sg13_lv_nmos ad=0.14875p pd=1.16u as=0.187p ps=1.78u w=0.55u l=0.13u
X948 VSS.t46 VDD.t2 VSS.t313 VSS.t869 sg13_lv_nmos ad=0.1428p pd=1.52u as=0 ps=0 w=0.42u l=1u
X949 oa_sar8_acore18_opt_0.sw_tg_opt_0.bot.t3 oa_sar8_acore18_opt_0.sw_bitcell_opt_b7_0.bot.t110 cap_cmim l=2.14u w=2.14u
X950 VDD.t717 sar_ctrl_async_phys_0.dac_code_n[1].t2 oa_sar8_acore18_opt_0.sw_bitcell_opt_b1_1.bot.t1 VDD.t716 sg13_lv_pmos ad=1.19p pd=7.5u as=0.663p ps=3.79u w=3.4u l=0.13u
X951 a_27134_39887# a_27249_39888# VDD.t340 VDD.t317 sg13_lv_pmos ad=0.34p pd=2.68u as=0.2254p ps=1.53u w=1u l=0.5u
X952 oa_sar8_acore18_opt_0.sw_tg_opt_0.bot.t4 oa_sar8_acore18_opt_0.sw_bitcell_opt_b7_0.bot.t5 cap_cmim l=2.14u w=2.14u
X953 VSS.t29 sar_ctrl_async_phys_0.sg13g2_nor4_1$1_0.C sar_ctrl_async_phys_0.sg13g2_nor4_1$1_0.Y VSS.t425 sg13_lv_nmos ad=0.1406p pd=1.12u as=0.1406p ps=1.12u w=0.74u l=0.13u
X954 VDD.t390 a_33951_45823# a_34618_46044# VDD.t10 sg13_lv_pmos ad=0.2128p pd=1.5u as=0.3864p ps=2.93u w=1.12u l=0.13u
X955 VSS.t828 VDD.t9 VSS.t827 VSS.t224 sg13_lv_nmos ad=0.1428p pd=1.52u as=0 ps=0 w=0.42u l=1u
X956 oa_sar8_acore18_opt_0.sw_bitcell_opt_b5_1.bot.t1 sar_ctrl_async_phys_0.dac_code_n[5] VDD.t385 VDD.t383 sg13_lv_pmos ad=1.053p pd=5.79u as=1.89p ps=11.5u w=5.4u l=0.13u
X957 VDD.t132 VSS.t118 VDD.t130 VDD.t42 sg13_lv_pmos ad=0.19p pd=1.38u as=0 ps=0 w=1u l=1u
X958 VSS.t730 VDD.t49 VSS.t730 VSS.t758 sg13_lv_nmos ad=0.1428p pd=1.52u as=0 ps=0 w=0.42u l=1u
X959 busy a_35672_33688# VSS.t92 VSS.t91 sg13_lv_nmos ad=0.2886p pd=2.26u as=0.14875p ps=1.16u w=0.74u l=0.13u
X960 a_31828_37440# a_31802_37404# VSS.t344 VSS.t343 sg13_lv_nmos ad=0.2516p pd=2.16u as=0.1626p ps=1.415u w=0.74u l=0.13u
X961 oa_sar8_acore18_opt_0.sw_tg_opt_0.bot.t3 oa_sar8_acore18_opt_0.sw_bitcell_opt_term_0.bot.t1 cap_cmim l=2.14u w=2.14u
X962 sar_ctrl_async_phys_0.sg13g2_a22oi_1$1_4.Y sar_ctrl_async_phys_0.sg13g2_buf_1$1_10.A a_32687_33292# VSS.t57 sg13_lv_nmos ad=0.2664p pd=1.46u as=0.13875p ps=1.115u w=0.74u l=0.13u
X963 VDD.t19 a_32192_36166# a_32137_36047# VDD.t19 sg13_lv_pmos ad=1.79957p pd=11.62u as=93.45f ps=0.865u w=0.42u l=0.13u
X964 VDD.t59 VSS.t1103 VDD.t331 VDD.t3 sg13_lv_pmos ad=0.19p pd=1.38u as=0 ps=0 w=1u l=1u
X965 a_31010_32138# sar_ctrl_async_phys_0.sg13g2_buf_1$1_6.X VSS.t17 VSS.t453 sg13_lv_nmos ad=37.8f pd=0.6u as=79.8f ps=0.8u w=0.42u l=0.13u
X966 VDD.t19 a_32149_35141# a_32251_35284# VDD.t19 sg13_lv_pmos ad=1.79957p pd=11.62u as=0.3864p ps=2.93u w=1.12u l=0.13u
X967 sar_ctrl_async_phys_0.sg13g2_nor2_1$1_6.Y sar_ctrl_async_phys_0.sg13g2_nor2_1$1_6.B a_28506_37436# VDD.t16 sg13_lv_pmos ad=0.3808p pd=2.92u as=0.1176p ps=1.33u w=1.12u l=0.13u
X968 a_31370_34782# sar_ctrl_async_phys_0.sg13g2_nor2b_1$1_0.A VSS.t1 VSS.t0 sg13_lv_nmos ad=0.1406p pd=1.12u as=0.2516p ps=2.16u w=0.74u l=0.13u
X969 oa_sar8_acore18_opt_0.sw_tg_opt_0.bot.t3 oa_sar8_acore18_opt_0.sw_bitcell_opt_b6_0.bot.t64 cap_cmim l=2.14u w=2.14u
X970 oa_sar8_acore18_opt_0.sw_bitcell_opt_term_0.VSS sar_ctrl_async_phys_0.dac_code[6] oa_sar8_acore18_opt_0.sw_bitcell_opt_b6_0.bot.t0 VSS.t1179 sg13_lv_nmos ad=1.05p pd=6.7u as=0.585p ps=3.39u w=3u l=0.13u
X971 result[3] a_33464_31388# VSS.t178 VSS.t2 sg13_lv_nmos ad=0.2886p pd=2.26u as=0.14875p ps=1.16u w=0.74u l=0.13u
X972 VSS.t883 VDD.t157 VSS.t51 VSS.t882 sg13_lv_nmos ad=0.1428p pd=1.52u as=0 ps=0 w=0.42u l=1u
X973 VDD.t4 rst_n a_32696_30664# VDD.t3 sg13_lv_pmos ad=0.2114p pd=1.54u as=0.2856p ps=2.36u w=0.84u l=0.13u
X974 oa_sar8_acore18_opt_0.sw_tg_opt_0.bot.t3 oa_sar8_acore18_opt_0.sw_bitcell_opt_b7_0.bot.t30 cap_cmim l=2.14u w=2.14u
X975 oa_sar8_acore18_opt_0.sw_tg_opt_0.bot.t3 oa_sar8_acore18_opt_0.sw_bitcell_opt_b6_0.bot.t34 cap_cmim l=2.14u w=2.14u
X976 VDD.t218 a_30879_43845# a_31546_43484# VDD.t22 sg13_lv_pmos ad=0.2128p pd=1.5u as=0.3864p ps=2.93u w=1.12u l=0.13u
X977 VDD.t30 VSS.t900 VDD.t30 VDD.t29 sg13_lv_pmos ad=0.19p pd=1.38u as=0 ps=0 w=1u l=1u
X978 a_20412_n9612# oa_sar8_acore18_opt_0.bstrap_opt_w2_c1200_1.gb vinp VSS.t166 sg13_lv_nmos ad=0.19p pd=1.38u as=0.345p ps=2.69u w=1u l=0.15u
X979 VSS.t48 sar_ctrl_async_phys_0.sg13g2_buf_1$1_6.X a_29620_33650# VSS.t173 sg13_lv_nmos ad=0.1626p pd=1.415u as=60.89999f ps=0.71u w=0.42u l=0.13u
X980 a_29334_43922# a_30139_43495# a_29594_43452# VDD.t22 sg13_lv_pmos ad=0.1428p pd=1.52u as=79.8f ps=0.8u w=0.42u l=0.13u
X981 oa_sar8_acore18_opt_0.sw_tg_opt_0.bot.t3 oa_sar8_acore18_opt_0.sw_bitcell_opt_b6_0.bot.t54 cap_cmim l=2.14u w=2.14u
X982 VSS.t1027 VDD.t148 VSS.t1029 VSS.t1028 sg13_lv_nmos ad=79.8f pd=0.8u as=0 ps=0 w=0.42u l=1u
X983 VSS.t737 VDD.t44 VSS.t739 VSS.t738 sg13_lv_nmos ad=79.8f pd=0.8u as=0 ps=0 w=0.42u l=1u
X984 a_30902_36349# sar_ctrl_async_phys_0.sg13g2_buf_1$1_2.X.t3 VSS.t952 VSS.t1242 sg13_lv_nmos ad=37.8f pd=0.6u as=0.1701p ps=1.65u w=0.42u l=0.13u
X985 a_33652_43922# sar_ctrl_async_phys_0.sg13g2_nor2_1$1_2.Y a_33558_43922# VSS.t675 sg13_lv_nmos ad=60.89999f pd=0.71u as=0.1428p ps=1.52u w=0.42u l=0.13u
X986 VDD.t2 VSS.t46 VDD.t2 VDD.t0 sg13_lv_pmos ad=0.34p pd=2.68u as=0 ps=0 w=1u l=1u
X987 sar_ctrl_async_phys_0.sg13g2_nand3_1$1_0.Y sar_ctrl_async_phys_0.sg13g2_dlygate4sd3_1$1_9.X VDD.t328 VDD.t317 sg13_lv_pmos ad=0.3808p pd=2.92u as=0.2128p ps=1.5u w=1.12u l=0.13u
X988 VSS.t383 a_25596_41174# sar_ctrl_async_phys_0.cmp_fire VSS.t382 sg13_lv_nmos ad=0.14875p pd=1.16u as=0.2886p ps=2.26u w=0.74u l=0.13u
X989 VSS.t107 a_31716_38912# sar_ctrl_async_phys_0.sg13g2_nor2_1$1_18.A VSS.t562 sg13_lv_nmos ad=0.17255p pd=1.25u as=0.1406p ps=1.12u w=0.74u l=0.13u
X990 VSS.t1060 VDD.t90 VSS.t1061 VSS.t179 sg13_lv_nmos ad=79.8f pd=0.8u as=0 ps=0 w=0.42u l=1u
X991 VDD.t64 VSS.t792 VDD.t64 VDD.t10 sg13_lv_pmos ad=0.19p pd=1.38u as=0 ps=0 w=1u l=1u
X992 a_31490_33650# sar_ctrl_async_phys_0.sg13g2_buf_1$1_6.X VSS.t48 VSS.t176 sg13_lv_nmos ad=37.8f pd=0.6u as=79.8f ps=0.8u w=0.42u l=0.13u
X993 oa_sar8_acore18_opt_0.sw_tg_opt_1.bot.t3 oa_sar8_acore18_opt_0.sw_bitcell_opt_b7_1.bot.t100 cap_cmim l=2.14u w=2.14u
X994 VDD.t77 VSS.t1062 VDD.t97 VDD.t76 sg13_lv_pmos ad=0.19p pd=1.38u as=0 ps=0 w=1u l=1u
X995 a_30390_36362# a_31195_35935# a_30650_35892# VDD.t19 sg13_lv_pmos ad=0.1428p pd=1.52u as=79.8f ps=0.8u w=0.42u l=0.13u
X996 a_35053_40730# sar_ctrl_async_phys_0.sg13g2_nand2_1$1_2.B VSS.t87 VSS.t719 sg13_lv_nmos ad=0.187p pd=1.78u as=0.14505p ps=1.15u w=0.55u l=0.13u
X997 oa_sar8_acore18_opt_0.bstrap_opt_w2_c1200_1.out oa_sar8_acore18_opt_0.sw_bitcell_opt_term_0.trkb.t22 oa_sar8_acore18_opt_0.sw_bitcell_opt_b6_1.bot.t0 VDD.t778 sg13_lv_pmos ad=0.7p pd=4.7u as=0.39p ps=2.39u w=2u l=0.13u
X998 VDD.t317 a_31093_39677# a_31195_39820# VDD.t317 sg13_lv_pmos ad=1.6658p pd=10.66u as=0.3864p ps=2.93u w=1.12u l=0.13u
X999 a_30676_40016# a_31195_39820# a_31935_39775# VSS.t202 sg13_lv_nmos ad=0.3473p pd=2.71u as=0.12665p ps=1.145u w=0.74u l=0.13u
X1000 oa_sar8_acore18_opt_0.sw_tg_opt_1.bot.t3 oa_sar8_acore18_opt_0.sw_bitcell_opt_b6_1.bot.t10 cap_cmim l=2.14u w=2.14u
X1001 a_26550_41214# a_26280_41214# VDD.t156 VDD.t0 sg13_lv_pmos ad=0.34p pd=2.68u as=0.1523p ps=1.38u w=1u l=0.5u
X1002 VDD.t9 VSS.t780 VDD.t15 VDD.t5 sg13_lv_pmos ad=0.19p pd=1.38u as=0 ps=0 w=1u l=1u
X1003 oa_sar8_acore18_opt_0.sw_bitcell_opt_term_1.bot.t0 oa_sar8_acore18_opt_0.bstrap_opt_w2_c1200_1.gb oa_sar8_acore18_opt_0.bstrap_opt_w2_c1200_1.out VSS.t155 sg13_lv_nmos ad=0.195p pd=1.39u as=0.35p ps=2.7u w=1u l=0.13u
X1004 result[2] a_33080_31388# VDD.t4 VDD.t3 sg13_lv_pmos ad=0.42p pd=2.99u as=0.2114p ps=1.54u w=1.12u l=0.13u
X1005 a_35952_39901# sar_ctrl_async_phys_0.sg13g2_buf_1$1_3.A a_36089_39744# VSS.t89 sg13_lv_nmos ad=0.2176p pd=1.96u as=0.1216p ps=1.02u w=0.64u l=0.13u
X1006 oa_sar8_acore18_opt_0.sw_tg_opt_0.bot.t3 oa_sar8_acore18_opt_0.sw_bitcell_opt_b6_0.bot.t14 cap_cmim l=2.14u w=2.14u
X1007 a_31706_44964# a_32149_45007# a_31446_45434# VSS.t636 sg13_lv_nmos ad=79.8f pd=0.8u as=0.1296p ps=1.52u w=0.42u l=0.13u
X1008 oa_sar8_acore18_opt_0.sw_tg_opt_1.bot.t3 oa_sar8_acore18_opt_0.sw_bitcell_opt_b6_1.bot.t42 cap_cmim l=2.14u w=2.14u
X1009 VDD.t317 sar_ctrl_async_phys_0.sg13g2_a21oi_1$1_0.A1 a_35595_40460# VDD.t317 sg13_lv_pmos ad=0.2128p pd=1.5u as=0.2128p ps=1.5u w=1.12u l=0.13u
X1010 VSS.t210 sar_ctrl_async_phys_0.sg13g2_and2_1$1_1.B a_35313_37784# VSS.t14 sg13_lv_nmos ad=0.2516p pd=2.16u as=0.1406p ps=1.12u w=0.74u l=0.13u
X1011 oa_sar8_acore18_opt_0.sw_bitcell_opt_b7_1.VSS sar_ctrl_async_phys_0.dac_code_n[4] oa_sar8_acore18_opt_0.sw_bitcell_opt_b4_1.bot.t0 VSS.t491 sg13_lv_nmos ad=0.84p pd=5.5u as=0.468p ps=2.79u w=2.4u l=0.13u
X1012 oa_sar8_acore18_opt_0.sw_tg_opt_0.bot.t3 oa_sar8_acore18_opt_0.sw_bitcell_opt_b0_0.bot.t0 cap_cmim l=2.14u w=2.14u
X1013 a_35648_30846# sar_ctrl_async_phys_0.sg13g2_buf_1$1_6.X VDD.t3 VDD.t3 sg13_lv_pmos ad=79.8f pd=0.8u as=1.79957p ps=11.62u w=0.42u l=0.13u
X1014 a_33270_39698# sar_ctrl_async_phys_0.sg13g2_nor2b_1$1_3.Y VDD.t485 VDD.t317 sg13_lv_pmos ad=79.8f pd=0.8u as=0.1428p ps=1.52u w=0.42u l=0.13u
X1015 VSS.t344 VDD.t85 VSS.t344 VSS.t922 sg13_lv_nmos ad=0.1428p pd=1.52u as=0 ps=0 w=0.42u l=1u
X1016 VDD.t342 sar_ctrl_async_phys_0.sg13g2_a22oi_1$1_2.A2 a_31823_32876# VDD.t76 sg13_lv_pmos ad=0.3808p pd=2.92u as=0.2744p ps=1.61u w=1.12u l=0.13u
X1017 VSS.t13 a_35391_34773# a_36058_34412# VSS.t21 sg13_lv_nmos ad=0.1406p pd=1.12u as=0.2516p ps=2.16u w=0.74u l=0.13u
X1018 oa_sar8_acore18_opt_0.sw_tg_opt_1.bot.t3 oa_sar8_acore18_opt_0.sw_bitcell_opt_b5_1.bot.t20 cap_cmim l=2.14u w=2.14u
X1019 VDD.t233 VSS.t1031 VDD.t148 VDD.t147 sg13_lv_pmos ad=0.34p pd=2.68u as=0 ps=0 w=1u l=1u
X1020 VDD.t130 VSS.t118 VDD.t44 VDD.t42 sg13_lv_pmos ad=0.34p pd=2.68u as=0 ps=0 w=1u l=1u
X1021 VDD.t319 sar_ctrl_async_phys_0.sg13g2_buf_1$1_3.A a_35280_35365# VDD.t19 sg13_lv_pmos ad=0.2856p pd=2.36u as=0.1596p ps=1.22u w=0.84u l=0.13u
X1022 VDD.t22 a_35103_43845# a_35360_43726# VDD.t22 sg13_lv_pmos ad=2.48357p pd=16.205u as=79.8f ps=0.8u w=0.42u l=0.13u
X1023 VSS.t137 a_30879_43845# a_31546_43484# VSS.t1153 sg13_lv_nmos ad=0.1406p pd=1.12u as=0.2516p ps=2.16u w=0.74u l=0.13u
X1024 a_33366_41210# a_34171_41332# a_33626_41433# VDD.t0 sg13_lv_pmos ad=0.1428p pd=1.52u as=79.8f ps=0.8u w=0.42u l=0.13u
X1025 VSS.t169 VDD.t1088 VSS.t907 VSS.t908 sg13_lv_nmos ad=79.8f pd=0.8u as=0 ps=0 w=0.42u l=1u
X1026 sar_ctrl_async_phys_0.dac_code[0] a_36056_46508# VSS.t152 VSS.t125 sg13_lv_nmos ad=0.2886p pd=2.26u as=0.14875p ps=1.16u w=0.74u l=0.13u
X1027 a_34526_31826# a_34767_31359# a_34055_31352# VSS.t2 sg13_lv_nmos ad=0.1428p pd=1.52u as=0.12665p ps=1.145u w=0.42u l=0.13u
X1028 VDD.t4 sar_ctrl_async_phys_0.sg13g2_buf_1$1_8.A a_33464_31388# VDD.t3 sg13_lv_pmos ad=0.2114p pd=1.54u as=0.2856p ps=2.36u w=0.84u l=0.13u
X1029 a_26174_42911# a_26289_42912# VSS.t111 VSS.t634 sg13_lv_nmos ad=0.1428p pd=1.52u as=0.1426p ps=1.16u w=0.42u l=0.5u
X1030 a_28578_40460# sar_ctrl_async_phys_0.sg13g2_nand2b_1$1_0.Y sar_ctrl_async_phys_0.sg13g2_nor4_1$1_0.Y VDD.t317 sg13_lv_pmos ad=0.2128p pd=1.5u as=0.4368p ps=3.02u w=1.12u l=0.13u
X1031 VDD.t18 VSS.t952 VDD.t18 VDD.t16 sg13_lv_pmos ad=0.19p pd=1.38u as=0 ps=0 w=1u l=1u
X1032 a_29140_32138# sar_ctrl_async_phys_0.sg13g2_inv_1$1_5.Y a_29046_32138# VSS.t179 sg13_lv_nmos ad=60.89999f pd=0.71u as=0.1428p ps=1.52u w=0.42u l=0.13u
X1033 oa_sar8_acore18_opt_0.bstrap_opt_w2_c1200_1.out oa_sar8_acore18_opt_0.sw_bitcell_opt_term_0.trkb.t25 oa_sar8_acore18_opt_0.sw_bitcell_opt_b3_1.bot.t0 VDD.t953 sg13_lv_pmos ad=0.7p pd=4.7u as=0.39p ps=2.39u w=2u l=0.13u
X1034 oa_sar8_acore18_opt_0.sw_tg_opt_0.bot.t3 oa_sar8_acore18_opt_0.sw_bitcell_opt_b5_0.bot.t30 cap_cmim l=2.14u w=2.14u
X1035 a_31706_35385# a_32149_35141# a_31446_35162# VSS.t204 sg13_lv_nmos ad=79.8f pd=0.8u as=0.1296p ps=1.52u w=0.42u l=0.13u
X1036 VSS.t886 VDD.t1 VSS.t575 VSS.t885 sg13_lv_nmos ad=0.1428p pd=1.52u as=0 ps=0 w=0.42u l=1u
X1037 VDD.t320 a_33087_37797# a_33754_37436# VDD.t16 sg13_lv_pmos ad=0.2128p pd=1.5u as=0.3864p ps=2.93u w=1.12u l=0.13u
X1038 VSS.t941 VDD.t169 VSS.t943 VSS.t942 sg13_lv_nmos ad=79.8f pd=0.8u as=0 ps=0 w=0.42u l=1u
X1039 a_31732_35480# a_31706_35385# VSS.t1 VSS.t411 sg13_lv_nmos ad=0.2516p pd=2.16u as=0.1626p ps=1.415u w=0.74u l=0.13u
X1040 a_32245_37447# sar_ctrl_async_phys_0.sg13g2_dfrbpq_1$1_0.CLK.t14 VSS.t448 VSS.t447 sg13_lv_nmos ad=0.2516p pd=2.16u as=9.86937p ps=64.34499u w=0.74u l=0.13u
X1041 VSS.t13 sar_ctrl_async_phys_0.sg13g2_buf_1$1_14.A a_35672_35200# VSS.t12 sg13_lv_nmos ad=0.14875p pd=1.16u as=0.187p ps=1.78u w=0.55u l=0.13u
X1042 a_34308_37400# sar_ctrl_async_phys_0.sg13g2_buf_1$1_14.A VDD.t320 VDD.t16 sg13_lv_pmos ad=0.2856p pd=2.36u as=0.2618p ps=1.63u w=0.84u l=0.13u
X1043 oa_sar8_acore18_opt_0.sw_bitcell_opt_b7_1.bot.t0 oa_sar8_acore18_opt_0.sw_bitcell_opt_term_0.trkb.t21 oa_sar8_acore18_opt_0.bstrap_opt_w2_c1200_1.out VDD.t779 sg13_lv_pmos ad=0.39p pd=2.39u as=0.7p ps=4.7u w=2u l=0.13u
X1044 VSS.t333 VDD.t13 VSS.t775 VSS.t803 sg13_lv_nmos ad=79.8f pd=0.8u as=0 ps=0 w=0.42u l=1u
X1045 oa_sar8_acore18_opt_0.sw_bitcell_opt_term_1.bot.t0 VDD.t1084 oa_sar8_acore18_opt_0.sw_bitcell_opt_b7_1.VSS VSS.t1127 sg13_lv_nmos ad=0.2925p pd=1.89u as=0.525p ps=3.7u w=1.5u l=0.13u
X1046 a_29749_32117# sar_ctrl_async_phys_0.sg13g2_dfrbpq_1$1_0.CLK.t5 VSS.t532 VSS.t531 sg13_lv_nmos ad=0.2516p pd=2.16u as=3.35542p ps=21.09u w=0.74u l=0.13u
X1047 VSS.t146 a_27894_35924# a_28006_35948# VSS.t145 sg13_lv_nmos ad=0.1426p pd=1.16u as=0.1428p ps=1.52u w=0.42u l=0.5u
X1048 oa_sar8_acore18_opt_0.sw_tg_opt_0.bot.t3 oa_sar8_acore18_opt_0.sw_bitcell_opt_b6_0.bot.t24 cap_cmim l=2.14u w=2.14u
X1049 oa_sar8_acore18_opt_0.sw_tg_opt_0.bot.t3 oa_sar8_acore18_opt_0.sw_bitcell_opt_b7_0.bot.t20 cap_cmim l=2.14u w=2.14u
X1050 a_35497_36047# a_34555_35935# a_35295_36285# VDD.t19 sg13_lv_pmos ad=93.45f pd=0.865u as=0.2048p ps=1.63u w=0.42u l=0.13u
X1051 sar_ctrl_async_phys_0.sg13g2_nor2_1$1_10.Y sar_ctrl_async_phys_0.sg13g2_nor2_1$1_10.A VSS.t46 VSS.t677 sg13_lv_nmos ad=0.1406p pd=1.12u as=0.2516p ps=2.16u w=0.74u l=0.13u
X1052 oa_sar8_acore18_opt_0.sw_bitcell_opt_b7_1.VSS sar_ctrl_async_phys_0.dac_code_n[5] oa_sar8_acore18_opt_0.sw_bitcell_opt_b5_1.bot.t0 VSS.t97 sg13_lv_nmos ad=0.945p pd=6.1u as=0.5265p ps=3.09u w=2.7u l=0.13u
X1053 VSS.t118 VDD.t132 VSS.t118 VSS.t744 sg13_lv_nmos ad=0.1428p pd=1.52u as=0 ps=0 w=0.42u l=1u
X1054 a_35402_42726# sar_ctrl_async_phys_0.sg13g2_nand2_1$1_5.B VSS.t506 VSS.t688 sg13_lv_nmos ad=0.1406p pd=1.12u as=0.2516p ps=2.16u w=0.74u l=0.13u
X1055 a_30783_40821# a_29941_40471# a_30689_40821# VSS.t30 sg13_lv_nmos ad=0.12665p pd=1.145u as=0.1428p ps=1.52u w=0.42u l=0.13u
X1056 a_29593_38995# a_29236_38952# VDD.t82 VDD.t29 sg13_lv_pmos ad=63f pd=0.72u as=0.1563p ps=1.22u w=0.42u l=0.13u
X1057 VDD.t258 a_32991_35239# a_33658_35460# VDD.t19 sg13_lv_pmos ad=0.2128p pd=1.5u as=0.3864p ps=2.93u w=1.12u l=0.13u
X1058 VDD.t16 a_35103_36751# a_35360_36894# VDD.t16 sg13_lv_pmos ad=2.48357p pd=16.205u as=79.8f ps=0.8u w=0.42u l=0.13u
X1059 VSS.t851 VDD.t1 VSS.t851 VSS.t868 sg13_lv_nmos ad=0.1428p pd=1.52u as=0 ps=0 w=0.42u l=1u
X1060 VDD.t1 sar_ctrl_async_phys_0.sg13g2_nand2b_1$1_0.A_N a_28392_41214# VDD.t0 sg13_lv_pmos ad=0.1523p pd=1.38u as=0.1428p ps=1.52u w=0.42u l=0.13u
X1061 sar_ctrl_async_phys_0.sg13g2_nor2_1$1_14.A sar_ctrl_async_phys_0.sg13g2_nor2_1$1_3.B a_27304_38928# VDD.t29 sg13_lv_pmos ad=0.2128p pd=1.5u as=0.2128p ps=1.5u w=1.12u l=0.15u
X1062 a_28662_41214# a_28392_41214# VDD.t1 VDD.t0 sg13_lv_pmos ad=0.34p pd=2.68u as=0.1523p ps=1.38u w=1u l=0.5u
X1063 oa_sar8_acore18_opt_0.sw_tg_opt_1.bot.t2 oa_sar8_acore18_opt_0.sw_bitcell_opt_b7_1.bot.t153 cap_cmim l=2.14u w=2.14u
X1064 VDD.t148 VSS.t975 VDD.t148 VDD.t147 sg13_lv_pmos ad=0.19p pd=1.38u as=0 ps=0 w=1u l=1u
X1065 a_34765_42242# sar_ctrl_async_phys_0.sg13g2_a21oi_1$1_2.B1 VSS.t216 VSS.t496 sg13_lv_nmos ad=0.187p pd=1.78u as=0.14505p ps=1.15u w=0.55u l=0.13u
X1066 a_32580_36642# sar_ctrl_async_phys_0.sg13g2_buf_1$1_4.A VDD.t553 VDD.t16 sg13_lv_pmos ad=0.2856p pd=2.36u as=0.2618p ps=1.63u w=0.84u l=0.13u
X1067 VSS.t730 VDD.t51 VSS.t730 VSS.t761 sg13_lv_nmos ad=79.8f pd=0.8u as=0 ps=0 w=0.42u l=1u
X1068 oa_sar8_acore18_opt_0.sw_tg_opt_0.bot.t3 oa_sar8_acore18_opt_0.sw_bitcell_opt_b7_0.bot.t22 cap_cmim l=2.14u w=2.14u
X1069 VDD.t121 VSS.t1014 VDD.t121 VDD.t76 sg13_lv_pmos ad=0.19p pd=1.38u as=0 ps=0 w=1u l=1u
X1070 sar_ctrl_async_phys_0.sg13g2_buf_1$1_36.A sar_ctrl_async_phys_0.sg13g2_nand2_1$1_3.A a_35402_46878# VSS.t125 sg13_lv_nmos ad=0.2516p pd=2.16u as=0.1406p ps=1.12u w=0.74u l=0.13u
X1071 VSS.t87 a_34911_41287# a_35578_41508# VSS.t589 sg13_lv_nmos ad=0.1406p pd=1.12u as=0.2516p ps=2.16u w=0.74u l=0.13u
X1072 oa_sar8_acore18_opt_0.sw_tg_opt_1.bot.t3 oa_sar8_acore18_opt_0.sw_bitcell_opt_b7_1.bot.t36 cap_cmim l=2.14u w=2.14u
X1073 VDD.t218 sar_ctrl_async_phys_0.sg13g2_a21oi_1$1_0.A1 a_31563_43020# VDD.t22 sg13_lv_pmos ad=0.2128p pd=1.5u as=0.2128p ps=1.5u w=1.12u l=0.13u
X1074 VSS.t792 VDD.t8 VSS.t792 VSS.t815 sg13_lv_nmos ad=79.8f pd=0.8u as=0 ps=0 w=0.42u l=1u
X1075 VDD.t776 oa_sar8_acore18_opt_0.sw_bitcell_opt_term_0.gb.t2 w_39600_n9960# w_39600_n9960# sg13_lv_pmos ad=0.7p pd=4.7u as=0.7p ps=4.7u w=2u l=0.13u
X1076 sar_ctrl_async_phys_0.sg13g2_dlygate4sd3_1$1_11.X a_26566_39766# VSS.t341 VSS.t103 sg13_lv_nmos ad=0.2516p pd=2.16u as=0.1426p ps=1.16u w=0.74u l=0.13u
X1077 oa_sar8_acore18_opt_0.sw_tg_opt_0.bot.t3 oa_sar8_acore18_opt_0.sw_bitcell_opt_b6_0.bot.t9 cap_cmim l=2.14u w=2.14u
X1078 a_33085_43832# sar_ctrl_async_phys_0.sg13g2_buf_1$1_37.A VDD.t219 VDD.t22 sg13_lv_pmos ad=0.1596p pd=1.22u as=0.2856p ps=2.36u w=0.84u l=0.13u
X1079 oa_sar8_acore18_opt_0.sw_bitcell_opt_b1_1.bot.t1 sar_ctrl_async_phys_0.dac_code_n[1].t2 VDD.t718 VDD.t716 sg13_lv_pmos ad=0.663p pd=3.79u as=1.19p ps=7.5u w=3.4u l=0.13u
X1080 VDD.t342 sar_ctrl_async_phys_0.sg13g2_a22oi_1$1_4.Y sar_ctrl_async_phys_0.sg13g2_inv_1$1_3.Y VDD.t76 sg13_lv_pmos ad=0.3808p pd=2.92u as=0.3808p ps=2.92u w=1.12u l=0.13u
X1081 a_31261_38232# sar_ctrl_async_phys_0.sg13g2_and2_1$1_0.A VDD.t85 VDD.t29 sg13_lv_pmos ad=0.1596p pd=1.22u as=0.2856p ps=2.36u w=0.84u l=0.13u
X1082 VDD.t79 VSS.t1108 VDD.t79 VDD.t3 sg13_lv_pmos ad=0.19p pd=1.38u as=0 ps=0 w=1u l=1u
X1083 VDD.t76 a_33183_32215# a_33440_32358# VDD.t76 sg13_lv_pmos ad=1.96315p pd=12.675u as=79.8f ps=0.8u w=0.42u l=0.13u
X1084 VSS.t1059 VDD.t121 VSS.t1057 VSS.t179 sg13_lv_nmos ad=0.1428p pd=1.52u as=0 ps=0 w=0.42u l=1u
X1085 a_30676_35928# a_30650_35892# VSS.t583 VSS.t582 sg13_lv_nmos ad=0.2516p pd=2.16u as=0.1626p ps=1.415u w=0.74u l=0.13u
X1086 oa_sar8_acore18_opt_0.sw_tg_opt_0.bot.t3 oa_sar8_acore18_opt_0.sw_bitcell_opt_b7_0.bot.t146 cap_cmim l=2.14u w=2.14u
X1087 sar_ctrl_async_phys_0.sg13g2_a22oi_1$1_0.B2 a_36058_30924# VDD.t329 VDD.t3 sg13_lv_pmos ad=0.3808p pd=2.92u as=0.2128p ps=1.5u w=1.12u l=0.13u
X1088 VSS.t1086 VDD.t90 VSS.t1085 VSS.t1084 sg13_lv_nmos ad=0.1428p pd=1.52u as=0 ps=0 w=0.42u l=1u
X1089 VDD.t59 VSS.t1062 VDD.t59 VDD.t3 sg13_lv_pmos ad=0.34p pd=2.68u as=0 ps=0 w=1u l=1u
X1090 oa_sar8_acore18_opt_0.sw_tg_opt_0.bot.t3 oa_sar8_acore18_opt_0.sw_bitcell_opt_b5_0.bot.t35 cap_cmim l=2.14u w=2.14u
X1091 oa_sar8_acore18_opt_0.sw_tg_opt_0.bot.t3 oa_sar8_acore18_opt_0.sw_bitcell_opt_b7_0.bot.t52 cap_cmim l=2.14u w=2.14u
X1092 a_30985_40583# a_30043_40471# a_30783_40821# VDD.t317 sg13_lv_pmos ad=93.45f pd=0.865u as=0.2048p ps=1.63u w=0.42u l=0.13u
X1093 VDD.t692 a_32319_44311# a_32986_44532# VDD.t5 sg13_lv_pmos ad=0.2128p pd=1.5u as=0.3864p ps=2.93u w=1.12u l=0.13u
X1094 oa_sar8_acore18_opt_0.sw_bitcell_opt_b2_1.bot.t0 oa_sar8_acore18_opt_0.bstrap_opt_w2_c1200_1.gb oa_sar8_acore18_opt_0.bstrap_opt_w2_c1200_1.out VSS.t158 sg13_lv_nmos ad=0.195p pd=1.39u as=0.35p ps=2.7u w=1u l=0.13u
X1095 a_32354_36362# sar_ctrl_async_phys_0.sg13g2_buf_1$1_2.X.t2 VSS.t252 VSS.t74 sg13_lv_nmos ad=37.8f pd=0.6u as=79.8f ps=0.8u w=0.42u l=0.13u
X1096 VSS.t187 a_34069_41189# a_34171_41332# VSS.t186 sg13_lv_nmos ad=5.25845p pd=33.575u as=0.2516p ps=2.16u w=0.74u l=0.13u
X1097 a_29862_36682# sar_ctrl_async_phys_0.sg13g2_buf_1$1_2.X.t4 a_29760_36682# VSS.t1243 sg13_lv_nmos ad=0.1406p pd=1.12u as=0.1406p ps=1.12u w=0.74u l=0.13u
X1098 VDD.t51 VSS.t786 VDD.t51 VDD.t10 sg13_lv_pmos ad=0.19p pd=1.38u as=0 ps=0 w=1u l=1u
X1099 sar_ctrl_async_phys_0.sg13g2_a21oi_1$1_5.A2 a_32602_39996# VSS.t351 VSS.t202 sg13_lv_nmos ad=0.2516p pd=2.16u as=0.1406p ps=1.12u w=0.74u l=0.13u
X1100 oa_sar8_acore18_opt_0.sw_bitcell_opt_term_0.vin oa_sar8_acore18_opt_0.sw_bitcell_opt_term_0.trkb.t18 oa_sar8_acore18_opt_0.sw_bitcell_opt_b5_0.bot.t1 VDD.t882 sg13_lv_pmos ad=0.7p pd=4.7u as=0.39p ps=2.39u w=2u l=0.13u
X1101 a_29749_32117# sar_ctrl_async_phys_0.sg13g2_dfrbpq_1$1_0.CLK.t5 VDD.t76 VDD.t76 sg13_lv_pmos ad=0.4088p pd=2.97u as=1.79957p ps=11.62u w=1.12u l=0.13u
X1102 oa_sar8_acore18_opt_0.sw_tg_opt_1.bot.t3 oa_sar8_acore18_opt_0.sw_bitcell_opt_b1_1.bot.t4 cap_cmim l=2.14u w=2.14u
X1103 oa_sar8_acore18_opt_0.sw_tg_opt_1.bot.t3 oa_sar8_acore18_opt_0.sw_bitcell_opt_b7_1.bot.t44 cap_cmim l=2.14u w=2.14u
X1104 a_35618_44234# sar_ctrl_async_phys_0.sg13g2_buf_1$1_41.X VSS.t122 VSS.t60 sg13_lv_nmos ad=37.8f pd=0.6u as=79.8f ps=0.8u w=0.42u l=0.13u
X1105 sar_ctrl_async_phys_0.dac_code_n[1] a_34520_46508# VSS.t126 VSS.t125 sg13_lv_nmos ad=0.2886p pd=2.26u as=0.14875p ps=1.16u w=0.74u l=0.13u
X1106 VDD.t154 VSS.t111 VDD.t154 VDD.t0 sg13_lv_pmos ad=0.34p pd=2.68u as=0 ps=0 w=1u l=1u
X1107 VDD.t261 VSS.t169 VDD.t260 VDD.t29 sg13_lv_pmos ad=0.34p pd=2.68u as=0 ps=0 w=1u l=1u
X1108 VSS.t193 a_31381_46519# a_31483_46519# VSS.t192 sg13_lv_nmos ad=9.09497p pd=59.065u as=0.2516p ps=2.16u w=0.74u l=0.13u
X1109 VSS.t46 sar_ctrl_async_phys_0.sg13g2_a21oi_1$1_4.A2 a_31665_42748# VSS.t360 sg13_lv_nmos ad=0.2516p pd=2.16u as=0.1406p ps=1.12u w=0.74u l=0.13u
X1110 VDD.t649 a_33252_36642# a_33210_36972# VDD.t16 sg13_lv_pmos ad=0.2618p pd=1.63u as=0.1176p ps=1.33u w=1.12u l=0.13u
X1111 a_28758_35924# a_28488_35965# VSS.t146 VSS.t346 sg13_lv_nmos ad=0.1428p pd=1.52u as=79.8f ps=0.8u w=0.42u l=0.5u
X1112 oa_sar8_acore18_opt_0.sw_tg_opt_1.bot.t3 oa_sar8_acore18_opt_0.sw_bitcell_opt_b5_1.bot.t40 cap_cmim l=2.14u w=2.14u
X1113 VDD.t330 a_35103_43845# a_35770_43484# VDD.t22 sg13_lv_pmos ad=0.2128p pd=1.5u as=0.3864p ps=2.93u w=1.12u l=0.13u
X1114 VDD.t120 a_26544_38389# sar_ctrl_async_phys_0.sg13g2_and2_1$1_3.X VDD.t29 sg13_lv_pmos ad=0.1918p pd=1.5u as=0.3808p ps=2.92u w=1.12u l=0.13u
X1115 VDD.t19 sar_ctrl_async_phys_0.sg13g2_dfrbpq_1$1_3.RESET_B a_34010_35892# VDD.t19 sg13_lv_pmos ad=0.1563p pd=1.22u as=0.147p ps=1.54u w=0.42u l=0.13u
X1116 a_28853_39702# sar_ctrl_async_phys_0.sg13g2_nor2_1$1_6.Y VSS.t104 VSS.t103 sg13_lv_nmos ad=0.1406p pd=1.12u as=0.14505p ps=1.15u w=0.74u l=0.13u
X1117 VSS.t15 sar_ctrl_async_phys_0.sg13g2_a22oi_1$1_4.A2 sar_ctrl_async_phys_0.sg13g2_nor2_1$1_0.Y VSS.t1159 sg13_lv_nmos ad=0.2516p pd=2.16u as=0.1406p ps=1.12u w=0.74u l=0.13u
X1118 oa_sar8_acore18_opt_0.sw_tg_opt_0.bot.t3 oa_sar8_acore18_opt_0.sw_bitcell_opt_b6_0.bot.t44 cap_cmim l=2.14u w=2.14u
X1119 oa_sar8_acore18_opt_0.sw_tg_opt_1.bot.t3 oa_sar8_acore18_opt_0.sw_bitcell_opt_b7_1.bot.t132 cap_cmim l=2.14u w=2.14u
X1120 a_34132_30944# a_34651_30748# a_35391_30703# VSS.t190 sg13_lv_nmos ad=0.3473p pd=2.71u as=0.12665p ps=1.145u w=0.74u l=0.13u
X1121 oa_sar8_acore18_opt_0.sw_tg_opt_0.bot.t3 oa_sar8_acore18_opt_0.sw_bitcell_opt_b7_0.bot.t104 cap_cmim l=2.14u w=2.14u
X1122 VSS.t1116 VDD.t79 VSS.t1115 VSS.t1114 sg13_lv_nmos ad=0.1428p pd=1.52u as=0 ps=0 w=0.42u l=1u
X1123 sar_ctrl_async_phys_0.dac_code_n[3] a_34904_46508# VDD.t390 VDD.t10 sg13_lv_pmos ad=0.42p pd=2.99u as=0.2114p ps=1.54u w=1.12u l=0.13u
X1124 oa_sar8_acore18_opt_0.sw_bitcell_opt_b2_0.bot.t1 oa_sar8_acore18_opt_0.sw_bitcell_opt_term_0.gb.t7 oa_sar8_acore18_opt_0.sw_bitcell_opt_term_0.vin VSS.t560 sg13_lv_nmos ad=0.195p pd=1.39u as=0.35p ps=2.7u w=1u l=0.13u
X1125 VDD.t23 VSS.t851 VDD.t23 VDD.t22 sg13_lv_pmos ad=0.34p pd=2.68u as=0 ps=0 w=1u l=1u
X1126 VDD.t114 VSS.t99 VDD.t114 VDD.t0 sg13_lv_pmos ad=0.34p pd=2.68u as=0 ps=0 w=1u l=1u
X1127 VSS.t42 sar_ctrl_async_phys_0.sg13g2_a21oi_1$1_3.B1 a_34904_46508# VSS.t125 sg13_lv_nmos ad=0.14875p pd=1.16u as=0.187p ps=1.78u w=0.55u l=0.13u
X1128 a_33844_36992# a_34363_36796# a_35103_36751# VSS.t1289 sg13_lv_nmos ad=0.3473p pd=2.71u as=0.12665p ps=1.145u w=0.74u l=0.13u
X1129 VDD.t156 sar_ctrl_async_phys_0.sg13g2_dlygate4sd3_1$1_5.X a_26184_42013# VDD.t0 sg13_lv_pmos ad=0.1523p pd=1.38u as=0.1428p ps=1.52u w=0.42u l=0.13u
X1130 oa_sar8_acore18_opt_0.sw_tg_opt_1.bot.t3 oa_sar8_acore18_opt_0.sw_bitcell_opt_b6_1.bot.t62 cap_cmim l=2.14u w=2.14u
X1131 a_33750_36362# sar_ctrl_async_phys_0.sg13g2_nor2b_1$1_2.Y VDD.t258 VDD.t19 sg13_lv_pmos ad=79.8f pd=0.8u as=0.1428p ps=1.52u w=0.42u l=0.13u
X1132 VDD.t184 sar_ctrl_async_phys_0.sg13g2_o21ai_1$1_1.B1.t15 a_32406_45746# VDD.t10 sg13_lv_pmos ad=0.36237p pd=2.605u as=79.8f ps=0.8u w=0.42u l=0.13u
X1133 VDD.t22 a_26174_42911# sar_ctrl_async_phys_0.sg13g2_dlygate4sd3_1$1_5.X VDD.t22 sg13_lv_pmos ad=0.2254p pd=1.53u as=0.4256p ps=3u w=1.12u l=0.13u
X1134 oa_sar8_acore18_opt_0.sw_tg_opt_0.bot.t2 oa_sar8_acore18_opt_0.sw_bitcell_opt_b7_0.bot.t157 cap_cmim l=2.14u w=2.14u
X1135 a_31417_44625# a_31060_44552# VDD.t8 VDD.t5 sg13_lv_pmos ad=63f pd=0.72u as=0.1563p ps=1.22u w=0.42u l=0.13u
X1136 sar_ctrl_async_phys_0.sg13g2_nand2b_1$1_0.Y sar_ctrl_async_phys_0.sg13g2_nor2_1$1_6.Y VDD.t361 VDD.t317 sg13_lv_pmos ad=0.2128p pd=1.5u as=0.2198p ps=1.53u w=1.12u l=0.13u
X1137 VDD.t82 VSS.t344 VDD.t82 VDD.t29 sg13_lv_pmos ad=0.19p pd=1.38u as=0 ps=0 w=1u l=1u
X1138 VDD.t5 a_32576_44454# a_32521_44549# VDD.t5 sg13_lv_pmos ad=1.96315p pd=12.675u as=93.45f ps=0.865u w=0.42u l=0.13u
X1139 a_31190_46933# sar_ctrl_async_phys_0.sg13g2_buf_1$1_41.X VSS.t118 VSS.t117 sg13_lv_nmos ad=37.8f pd=0.6u as=0.1701p ps=1.65u w=0.42u l=0.13u
X1140 VSS.t449 a_32288_31630# a_31937_31749# VSS.t83 sg13_lv_nmos ad=79.8f pd=0.8u as=0.1428p ps=1.52u w=0.42u l=0.13u
X1141 VDD.t317 a_35952_39901# sar_ctrl_async_phys_0.sg13g2_buf_1$1_14.A VDD.t317 sg13_lv_pmos ad=0.1918p pd=1.5u as=0.3808p ps=2.92u w=1.12u l=0.13u
X1142 oa_sar8_acore18_opt_0.sw_tg_opt_0.bot.t3 oa_sar8_acore18_opt_0.sw_bitcell_opt_b7_0.bot.t115 cap_cmim l=2.14u w=2.14u
X1143 oa_sar8_acore18_opt_0.sw_bitcell_opt_b6_1.bot.t0 oa_sar8_acore18_opt_0.sw_bitcell_opt_term_0.trkb.t22 oa_sar8_acore18_opt_0.bstrap_opt_w2_c1200_1.out VDD.t778 sg13_lv_pmos ad=0.39p pd=2.39u as=0.7p ps=4.7u w=2u l=0.13u
X1144 VDD.t20 VSS.t62 VDD.t20 VDD.t19 sg13_lv_pmos ad=0.34p pd=2.68u as=0 ps=0 w=1u l=1u
X1145 oa_sar8_acore18_opt_0.sw_tg_opt_0.bot.t3 oa_sar8_acore18_opt_0.sw_bitcell_opt_b4_0.bot.t26 cap_cmim l=2.14u w=2.14u
X1146 a_35391_30703# a_34549_30605# a_35297_30703# VSS.t325 sg13_lv_nmos ad=0.12665p pd=1.145u as=0.1428p ps=1.52u w=0.42u l=0.13u
X1147 a_34489_32947# a_34132_32904# VDD.t343 VDD.t76 sg13_lv_pmos ad=63f pd=0.72u as=0.1563p ps=1.22u w=0.42u l=0.13u
X1148 a_33270_39698# a_34075_39820# a_33530_39921# VDD.t317 sg13_lv_pmos ad=0.1428p pd=1.52u as=79.8f ps=0.8u w=0.42u l=0.13u
X1149 VSS.t15 VDD.t1085 VSS.t15 VSS.t177 sg13_lv_nmos ad=0.1428p pd=1.52u as=0 ps=0 w=0.42u l=1u
X1150 VDD.t177 VSS.t126 VDD.t177 VDD.t10 sg13_lv_pmos ad=0.19p pd=1.38u as=0 ps=0 w=1u l=1u
X1151 a_31674_38948# sar_ctrl_async_phys_0.sg13g2_nor2b_1$1_0.A sar_ctrl_async_phys_0.sg13g2_nor2_1$1_18.A VDD.t29 sg13_lv_pmos ad=0.1176p pd=1.33u as=0.3808p ps=2.92u w=1.12u l=0.13u
X1152 sar_ctrl_async_phys_0.sg13g2_and2_1$1_3.A a_25496_34412# VSS.t95 VSS.t0 sg13_lv_nmos ad=0.2886p pd=2.26u as=0.14875p ps=1.16u w=0.74u l=0.13u
X1153 a_31924_32456# a_32443_32260# a_33183_32215# VSS.t58 sg13_lv_nmos ad=0.3473p pd=2.71u as=0.12665p ps=1.145u w=0.74u l=0.13u
X1154 VDD.t121 VSS.t1055 VDD.t121 VDD.t76 sg13_lv_pmos ad=0.34p pd=2.68u as=0 ps=0 w=1u l=1u
X1155 a_33844_36992# a_33818_36897# VDD.t649 VDD.t16 sg13_lv_pmos ad=0.34p pd=2.68u as=0.36237p ps=2.605u w=1u l=0.13u
X1156 VSS.t260 sar_ctrl_async_phys_0.sg13g2_a22oi_1$1_4.Y sar_ctrl_async_phys_0.sg13g2_inv_1$1_3.Y VSS.t57 sg13_lv_nmos ad=0.2516p pd=2.16u as=0.2516p ps=2.16u w=0.74u l=0.13u
X1157 VDD.t372 sar_ctrl_async_phys_0.sg13g2_buf_1$1_3.A a_35672_33688# VDD.t147 sg13_lv_pmos ad=0.2114p pd=1.54u as=0.2856p ps=2.36u w=0.84u l=0.13u
X1158 a_32991_35239# a_32149_35141# a_32897_35239# VSS.t207 sg13_lv_nmos ad=0.12665p pd=1.145u as=0.1428p ps=1.52u w=0.42u l=0.13u
X1159 a_35017_40013# a_34075_39820# a_34815_39775# VDD.t317 sg13_lv_pmos ad=93.45f pd=0.865u as=0.2048p ps=1.63u w=0.42u l=0.13u
X1160 VDD.t29 a_30752_39190# a_30697_39071# VDD.t29 sg13_lv_pmos ad=3.62845p pd=23.965u as=93.45f ps=0.865u w=0.42u l=0.13u
X1161 oa_sar8_acore18_opt_0.sw_tg_opt_0.bot.t3 oa_sar8_acore18_opt_0.sw_bitcell_opt_b6_0.bot.t34 cap_cmim l=2.14u w=2.14u
X1162 VSS.t38 a_35103_43845# a_35770_43484# VSS.t37 sg13_lv_nmos ad=0.1406p pd=1.12u as=0.2516p ps=2.16u w=0.74u l=0.13u
X1163 a_31129_31435# a_30772_31392# VDD.t4 VDD.t3 sg13_lv_pmos ad=63f pd=0.72u as=0.1563p ps=1.22u w=0.42u l=0.13u
X1164 VDD.t13 VSS.t802 VDD.t13 VDD.t5 sg13_lv_pmos ad=0.34p pd=2.68u as=0 ps=0 w=1u l=1u
X1165 a_35245_42242# sar_ctrl_async_phys_0.sg13g2_nand2b_1$1_2.A_N VSS.t506 VSS.t1164 sg13_lv_nmos ad=0.187p pd=1.78u as=0.14505p ps=1.15u w=0.55u l=0.13u
X1166 a_35103_36751# a_34261_36653# a_35009_36751# VSS.t1313 sg13_lv_nmos ad=0.12665p pd=1.145u as=0.1428p ps=1.52u w=0.42u l=0.13u
X1167 VSS.t85 sar_ctrl_async_phys_0.sg13g2_a21oi_1$1_5.A2 a_32049_41236# VSS.t639 sg13_lv_nmos ad=0.2516p pd=2.16u as=0.1406p ps=1.12u w=0.74u l=0.13u
X1168 a_34175_42726# a_34093_42912# sar_ctrl_async_phys_0.sg13g2_a21oi_1$1_4.B1 VSS.t655 sg13_lv_nmos ad=0.1406p pd=1.12u as=0.333p ps=2.38u w=0.74u l=0.13u
X1169 VSS.t946 VDD.t145 VSS.t948 VSS.t947 sg13_lv_nmos ad=79.8f pd=0.8u as=0 ps=0 w=0.42u l=1u
X1170 oa_sar8_acore18_opt_0.sw_tg_opt_0.bot.t3 oa_sar8_acore18_opt_0.sw_bitcell_opt_b7_0.bot.t44 cap_cmim l=2.14u w=2.14u
X1171 a_34319_32460# sar_ctrl_async_phys_0.sg13g2_a22oi_1$1_0.A1 VDD.t343 VDD.t76 sg13_lv_pmos ad=0.2716p pd=1.605u as=0.3808p ps=2.92u w=1.12u l=0.13u
X1172 VSS.t777 VDD.t13 VSS.t777 VSS.t805 sg13_lv_nmos ad=79.8f pd=0.8u as=0 ps=0 w=0.42u l=1u
X1173 a_33936_31675# a_34055_31352# VDD.t603 VDD.t3 sg13_lv_pmos ad=0.3864p pd=2.93u as=0.2128p ps=1.5u w=1.12u l=0.13u
X1174 VDD.t18 VSS.t222 VDD.t18 VDD.t16 sg13_lv_pmos ad=0.34p pd=2.68u as=0 ps=0 w=1u l=1u
X1175 a_30938_46476# a_31381_46519# a_30678_46946# VSS.t191 sg13_lv_nmos ad=79.8f pd=0.8u as=0.1296p ps=1.52u w=0.42u l=0.13u
X1176 a_30027_39996# sar_ctrl_async_phys_0.sg13g2_and2_1$1_0.B VDD.t361 VDD.t317 sg13_lv_pmos ad=0.3808p pd=2.92u as=0.2128p ps=1.5u w=1.12u l=0.13u
X1177 sar_ctrl_async_phys_0.sg13g2_buf_1$1_5.A a_36058_34412# VDD.t419 VDD.t147 sg13_lv_pmos ad=0.3808p pd=2.92u as=0.2128p ps=1.5u w=1.12u l=0.13u
X1178 VSS.t99 sar_ctrl_async_phys_0.sg13g2_buf_1$1_19.A a_33777_42748# VSS.t646 sg13_lv_nmos ad=0.2516p pd=2.16u as=0.1406p ps=1.12u w=0.74u l=0.13u
X1179 VSS.t1081 VDD.t81 VSS.t1083 VSS.t1082 sg13_lv_nmos ad=79.8f pd=0.8u as=0 ps=0 w=0.42u l=1u
X1180 a_33940_34850# sar_ctrl_async_phys_0.sg13g2_buf_1$1_17.A a_33846_34850# VSS.t682 sg13_lv_nmos ad=60.89999f pd=0.71u as=0.1428p ps=1.52u w=0.42u l=0.13u
X1181 oa_sar8_acore18_opt_0.sw_tg_opt_0.bot.t2 oa_sar8_acore18_opt_0.sw_bitcell_opt_b7_0.bot.t162 cap_cmim l=2.14u w=2.14u
X1182 VDD.t619 sar_ctrl_async_phys_0.sample oa_sar8_acore18_opt_0.sw_bitcell_opt_term_0.trkb.t1 VDD.t618 sg13_lv_pmos ad=0.7p pd=4.7u as=0.39p ps=2.39u w=2u l=0.13u
X1183 oa_sar8_acore18_opt_0.sw_bitcell_opt_b3_1.bot.t0 oa_sar8_acore18_opt_0.sw_bitcell_opt_term_0.trkb.t25 oa_sar8_acore18_opt_0.bstrap_opt_w2_c1200_1.out VDD.t953 sg13_lv_pmos ad=0.39p pd=2.39u as=0.7p ps=4.7u w=2u l=0.13u
X1184 oa_sar8_acore18_opt_0.sw_tg_opt_0.bot.t3 oa_sar8_acore18_opt_0.sw_bitcell_opt_b6_0.bot.t1 cap_cmim l=2.14u w=2.14u
X1185 oa_sar8_acore18_opt_0.sw_tg_opt_0.bot.t3 oa_sar8_acore18_opt_0.sw_bitcell_opt_b7_0.bot.t35 cap_cmim l=2.14u w=2.14u
X1186 a_34036_35928# a_34555_35935# a_35295_36285# VSS.t369 sg13_lv_nmos ad=0.3473p pd=2.71u as=0.12665p ps=1.145u w=0.74u l=0.13u
X1187 a_32020_45421# a_32251_45007# a_31706_44964# VSS.t1261 sg13_lv_nmos ad=0.2373p pd=1.97u as=79.8f ps=0.8u w=0.42u l=0.13u
X1188 oa_sar8_acore18_opt_0.sw_tg_opt_1.bot.t3 oa_sar8_acore18_opt_0.sw_bitcell_opt_b6_1.bot.t15 cap_cmim l=2.14u w=2.14u
X1189 sar_ctrl_async_phys_0.bit_active[4] a_36056_35200# VDD.t319 VDD.t19 sg13_lv_pmos ad=0.42p pd=2.99u as=0.2114p ps=1.54u w=1.12u l=0.13u
X1190 a_31446_45434# sar_ctrl_async_phys_0.sg13g2_dfrbpq_1$1_9.D VDD.t8 VDD.t5 sg13_lv_pmos ad=79.8f pd=0.8u as=0.1428p ps=1.52u w=0.42u l=0.13u
X1191 sar_ctrl_async_phys_0.sg13g2_and2_1$1_0.B a_31162_38948# VDD.t85 VDD.t29 sg13_lv_pmos ad=0.3808p pd=2.92u as=0.2128p ps=1.5u w=1.12u l=0.13u
X1192 VSS.t75 a_31935_36285# a_32602_35924# VSS.t74 sg13_lv_nmos ad=0.1406p pd=1.12u as=0.2516p ps=2.16u w=0.74u l=0.13u
X1193 VDD.t485 sar_ctrl_async_phys_0.sg13g2_o21ai_1$1_1.B1.t4 a_33270_39698# VDD.t317 sg13_lv_pmos ad=0.36237p pd=2.605u as=79.8f ps=0.8u w=0.42u l=0.13u
X1194 oa_sar8_acore18_opt_0.sw_tg_opt_1.bot.t3 oa_sar8_acore18_opt_0.sw_bitcell_opt_b6_1.bot.t50 cap_cmim l=2.14u w=2.14u
X1195 oa_sar8_acore18_opt_0.bstrap_opt_w2_c1200_1.out oa_sar8_acore18_opt_0.bstrap_opt_w2_c1200_1.gb oa_sar8_acore18_opt_0.sw_bitcell_opt_b5_1.bot.t0 VSS.t161 sg13_lv_nmos ad=0.35p pd=2.7u as=0.195p ps=1.39u w=1u l=0.13u
X1196 VSS.t895 VDD.t100 VSS.t894 VSS.t893 sg13_lv_nmos ad=0.1428p pd=1.52u as=0 ps=0 w=0.42u l=1u
X1197 a_34106_30849# a_34549_30605# a_33846_30626# VSS.t323 sg13_lv_nmos ad=79.8f pd=0.8u as=0.1296p ps=1.52u w=0.42u l=0.13u
X1198 oa_sar8_acore18_opt_0.sw_bitcell_opt_term_0.vin oa_sar8_acore18_opt_0.sw_bitcell_opt_term_0.trkb.t13 oa_sar8_acore18_opt_0.sw_bitcell_opt_b0_0.bot.t2 VDD.t781 sg13_lv_pmos ad=0.7p pd=4.7u as=0.39p ps=2.39u w=2u l=0.13u
X1199 a_31935_39775# a_31093_39677# a_31841_39775# VSS.t202 sg13_lv_nmos ad=0.12665p pd=1.145u as=0.1428p ps=1.52u w=0.42u l=0.13u
X1200 VDD.t121 VSS.t1019 VDD.t121 VDD.t76 sg13_lv_pmos ad=0.19p pd=1.38u as=0 ps=0 w=1u l=1u
X1201 VSS.t789 VDD.t64 VSS.t792 VSS.t791 sg13_lv_nmos ad=79.8f pd=0.8u as=0 ps=0 w=0.42u l=1u
X1202 oa_sar8_acore18_opt_0.sw_tg_opt_0.bot.t3 oa_sar8_acore18_opt_0.sw_bitcell_opt_b5_0.bot.t10 cap_cmim l=2.14u w=2.14u
X1203 oa_sar8_acore18_opt_0.sw_tg_opt_0.bot.t3 oa_sar8_acore18_opt_0.sw_bitcell_opt_b7_0.bot.t120 cap_cmim l=2.14u w=2.14u
X1204 sar_ctrl_async_phys_0.sg13g2_buf_1$1_13.A a_32602_35924# VDD.t258 VDD.t19 sg13_lv_pmos ad=0.3808p pd=2.92u as=0.2128p ps=1.5u w=1.12u l=0.13u
X1205 VDD.t11 VSS.t40 VDD.t11 VDD.t10 sg13_lv_pmos ad=0.19p pd=1.38u as=0 ps=0 w=1u l=1u
X1206 VDD.t11 VSS.t773 VDD.t11 VDD.t10 sg13_lv_pmos ad=0.19p pd=1.38u as=0 ps=0 w=1u l=1u
X1207 a_34420_30639# a_34132_30944# a_34358_30639# VSS.t365 sg13_lv_nmos ad=0.1428p pd=1.52u as=37.8f ps=0.6u w=0.42u l=0.13u
X1208 VSS.t514 sar_ctrl_async_phys_0.hold_req oa_sar8_acore18_opt_0.sw_bitcell_opt_term_0.VSS VSS.t516 sg13_lv_nmos ad=0.7p pd=4.7u as=0.39p ps=2.39u w=2u l=0.13u
X1209 VDD.t3 sar_ctrl_async_phys_0.sg13g2_buf_1$1_6.X a_34268_31826# VDD.t3 sg13_lv_pmos ad=1.79957p pd=11.62u as=79.8f ps=0.8u w=0.42u l=0.13u
X1210 a_32341_32117# sar_ctrl_async_phys_0.sg13g2_dfrbpq_1$1_0.CLK.t4 VSS.t82 VSS.t555 sg13_lv_nmos ad=0.2516p pd=2.16u as=3.35542p ps=21.09u w=0.74u l=0.13u
X1211 VDD.t11 VSS.t775 VDD.t11 VDD.t10 sg13_lv_pmos ad=0.34p pd=2.68u as=0 ps=0 w=1u l=1u
X1212 a_32404_40885# a_32116_40464# a_32342_40885# VSS.t357 sg13_lv_nmos ad=0.1428p pd=1.52u as=37.8f ps=0.6u w=0.42u l=0.13u
X1213 oa_sar8_acore18_opt_0.sw_tg_opt_1.bot.t3 oa_sar8_acore18_opt_0.sw_bitcell_opt_b5_1.bot.t2 cap_cmim l=2.14u w=2.14u
X1214 oa_sar8_acore18_opt_0.sw_tg_opt_1.bot.t3 oa_sar8_acore18_opt_0.sw_bitcell_opt_b7_1.bot.t86 cap_cmim l=2.14u w=2.14u
X1215 VDD.t79 VSS.t1105 VDD.t79 VDD.t3 sg13_lv_pmos ad=0.34p pd=2.68u as=0 ps=0 w=1u l=1u
X1216 VSS.t17 a_30591_32215# a_31258_32436# VSS.t1249 sg13_lv_nmos ad=0.1406p pd=1.12u as=0.2516p ps=2.16u w=0.74u l=0.13u
X1217 sar_ctrl_async_phys_0.bit_active[0] a_34424_35200# VDD.t19 VDD.t19 sg13_lv_pmos ad=0.42p pd=2.99u as=0.2114p ps=1.54u w=1.12u l=0.13u
X1218 VSS.t118 sar_ctrl_async_phys_0.sg13g2_buf_1$1_41.X a_30772_46946# VSS.t124 sg13_lv_nmos ad=0.1626p pd=1.415u as=60.89999f ps=0.71u w=0.42u l=0.13u
X1219 VSS.t85 a_32400_41413# sar_ctrl_async_phys_0.sg13g2_and2_1$1_6.X VSS.t629 sg13_lv_nmos ad=0.1331p pd=1.12u as=0.2516p ps=2.16u w=0.74u l=0.13u
X1220 a_28950_39386# sar_ctrl_async_phys_0.sg13g2_nor2_1$1_5.A VDD.t30 VDD.t29 sg13_lv_pmos ad=79.8f pd=0.8u as=0.1428p ps=1.52u w=0.42u l=0.13u
X1221 VSS.t344 sar_ctrl_async_phys_0.sg13g2_buf_1$1_2.X.t6 a_31636_37874# VSS.t1239 sg13_lv_nmos ad=0.1626p pd=1.415u as=60.89999f ps=0.71u w=0.42u l=0.13u
X1222 sar_ctrl_async_phys_0.sg13g2_buf_1$1_10.A a_33850_32436# VSS.t178 VSS.t58 sg13_lv_nmos ad=0.2516p pd=2.16u as=0.1406p ps=1.12u w=0.74u l=0.13u
X1223 VDD.t322 a_35391_34773# a_35648_34654# VDD.t147 sg13_lv_pmos ad=2.2076p pd=14.4u as=79.8f ps=0.8u w=0.42u l=0.13u
X1224 VDD.t114 VSS.t99 VDD.t114 VDD.t0 sg13_lv_pmos ad=0.19p pd=1.38u as=0 ps=0 w=1u l=1u
X1225 VSS.t62 a_28862_36863# sar_ctrl_async_phys_0.sg13g2_dlygate4sd3_1$1_0.X VSS.t328 sg13_lv_nmos ad=0.1426p pd=1.16u as=0.2516p ps=2.16u w=0.74u l=0.13u
X1226 VSS.t46 VDD.t114 VSS.t46 VSS.t875 sg13_lv_nmos ad=0.1428p pd=1.52u as=0 ps=0 w=0.42u l=1u
X1227 a_32020_35175# a_32251_35284# a_31706_35385# VSS.t520 sg13_lv_nmos ad=0.2373p pd=1.97u as=79.8f ps=0.8u w=0.42u l=0.13u
X1228 VSS.t131 sar_ctrl_async_phys_0.sg13g2_o21ai_1$1_1.B1.t15 a_32500_45746# VSS.t460 sg13_lv_nmos ad=0.1626p pd=1.415u as=60.89999f ps=0.71u w=0.42u l=0.13u
X1229 a_35772_41936# sar_ctrl_async_phys_0.sg13g2_buf_1$1_37.A VDD.t562 VDD.t0 sg13_lv_pmos ad=0.2856p pd=2.36u as=0.2114p ps=1.54u w=0.84u l=0.13u
X1230 VSS.t587 a_34453_35935# a_34555_35935# VSS.t292 sg13_lv_nmos ad=5.13525p pd=33.135u as=0.2516p ps=2.16u w=0.74u l=0.13u
X1231 oa_sar8_acore18_opt_0.sw_tg_opt_1.bot.t3 oa_sar8_acore18_opt_0.sw_bitcell_opt_b7_1.bot.t126 cap_cmim l=2.14u w=2.14u
X1232 VSS.t48 VDD.t150 VSS.t48 VSS.t47 sg13_lv_nmos ad=79.8f pd=0.8u as=0 ps=0 w=0.42u l=1u
X1233 a_29498_40428# a_29941_40471# a_29881_40507# VDD.t317 sg13_lv_pmos ad=79.8f pd=0.8u as=63f ps=0.72u w=0.42u l=0.13u
X1234 oa_sar8_acore18_opt_0.sw_tg_opt_0.bot.t3 oa_sar8_acore18_opt_0.sw_bitcell_opt_b7_0.bot.t131 cap_cmim l=2.14u w=2.14u
X1235 VSS.t137 a_31136_43726# a_30785_43845# VSS.t619 sg13_lv_nmos ad=79.8f pd=0.8u as=0.1428p ps=1.52u w=0.42u l=0.13u
X1236 oa_sar8_acore18_opt_0.sw_tg_opt_1.bot.t4 oa_sar8_acore18_opt_0.sw_bitcell_opt_b7_1.bot.t20 cap_cmim l=2.14u w=2.14u
X1237 VDD.t611 sar_ctrl_async_phys_0.sg13g2_nand2_1$1_5.Y a_36056_38948# VDD.t29 sg13_lv_pmos ad=0.2114p pd=1.54u as=0.2856p ps=2.36u w=0.84u l=0.13u
X1238 a_32223_46869# a_31381_46519# a_30964_46512# VDD.t10 sg13_lv_pmos ad=0.2048p pd=1.63u as=0.34p ps=2.68u w=1u l=0.13u
X1239 VSS.t46 sar_ctrl_async_phys_0.sg13g2_nor2_1$1_10.B sar_ctrl_async_phys_0.sg13g2_nor2_1$1_10.Y VSS.t1297 sg13_lv_nmos ad=0.2516p pd=2.16u as=0.1406p ps=1.12u w=0.74u l=0.13u
X1240 oa_sar8_acore18_opt_0.sw_tg_opt_0.bot.t3 oa_sar8_acore18_opt_0.sw_bitcell_opt_b6_0.bot.t74 cap_cmim l=2.14u w=2.14u
X1241 VSS.t698 oa_sar8_acore18_opt_0.sw_bitcell_opt_term_0.trkb.t5 a_35948_n9612# VSS.t697 sg13_lv_nmos ad=0.345p pd=2.69u as=0.19p ps=1.38u w=1u l=0.15u
X1242 oa_sar8_acore18_opt_0.sw_bitcell_opt_term_0.vin oa_sar8_acore18_opt_0.sw_bitcell_opt_term_0.gb.t4 oa_sar8_acore18_opt_0.sw_bitcell_opt_term_0.bot.t0 VSS.t590 sg13_lv_nmos ad=0.35p pd=2.7u as=0.195p ps=1.39u w=1u l=0.13u
X1243 VDD.t468 sar_ctrl_async_phys_0.dac_code[5] oa_sar8_acore18_opt_0.sw_bitcell_opt_b5_0.bot.t0 VDD.t467 sg13_lv_pmos ad=1.89p pd=11.5u as=1.053p ps=5.79u w=5.4u l=0.13u
X1244 a_31924_32456# a_31898_32361# VSS.t17 VSS.t100 sg13_lv_nmos ad=0.2516p pd=2.16u as=0.1626p ps=1.415u w=0.74u l=0.13u
X1245 VSS.t1012 VDD.t270 VSS.t1014 VSS.t1013 sg13_lv_nmos ad=79.8f pd=0.8u as=0 ps=0 w=0.42u l=1u
X1246 VSS.t290 a_34549_30605# a_34651_30748# VSS.t324 sg13_lv_nmos ad=8.77817p pd=57.305u as=0.2516p ps=2.16u w=0.74u l=0.13u
X1247 a_35801_37784# sar_ctrl_async_phys_0.sg13g2_and2_1$1_1.B VSS.t210 VSS.t14 sg13_lv_nmos ad=0.1216p pd=1.02u as=0.1331p ps=1.12u w=0.64u l=0.13u
X1248 VDD.t25 sar_ctrl_async_phys_0.sg13g2_buf_1$1_41.X a_29334_43922# VDD.t22 sg13_lv_pmos ad=0.36237p pd=2.605u as=79.8f ps=0.8u w=0.42u l=0.13u
X1249 a_32116_37861# a_31828_37440# a_32054_37861# VSS.t288 sg13_lv_nmos ad=0.1428p pd=1.52u as=37.8f ps=0.6u w=0.42u l=0.13u
X1250 a_29689_32529# a_29332_32456# VDD.t150 VDD.t76 sg13_lv_pmos ad=63f pd=0.72u as=0.1563p ps=1.22u w=0.42u l=0.13u
X1251 oa_sar8_acore18_opt_0.sw_bitcell_opt_term_0.vin oa_sar8_acore18_opt_0.sw_bitcell_opt_term_0.trkb.t20 oa_sar8_acore18_opt_0.sw_bitcell_opt_b7_0.bot.t1 VDD.t519 sg13_lv_pmos ad=0.7p pd=4.7u as=0.39p ps=2.39u w=2u l=0.13u
X1252 a_31732_45000# a_32251_45007# a_32991_45357# VSS.t1262 sg13_lv_nmos ad=0.3473p pd=2.71u as=0.12665p ps=1.145u w=0.74u l=0.13u
X1253 a_32212_32151# a_31924_32456# a_32150_32151# VSS.t100 sg13_lv_nmos ad=0.1428p pd=1.52u as=37.8f ps=0.6u w=0.42u l=0.13u
X1254 VDD.t121 VSS.t1054 VDD.t121 VDD.t76 sg13_lv_pmos ad=0.19p pd=1.38u as=0 ps=0 w=1u l=1u
X1255 VDD.t562 sar_ctrl_async_phys_0.sg13g2_nand2b_1$1_1.B sar_ctrl_async_phys_0.sg13g2_a21oi_1$1_3.B1 VDD.t0 sg13_lv_pmos ad=0.2198p pd=1.53u as=0.2128p ps=1.5u w=1.12u l=0.13u
X1256 VSS.t1007 VDD.t121 VSS.t1006 VSS.t1005 sg13_lv_nmos ad=0.1428p pd=1.52u as=0 ps=0 w=0.42u l=1u
X1257 VDD.t4 VSS.t372 VDD.t4 VDD.t3 sg13_lv_pmos ad=0.34p pd=2.68u as=0 ps=0 w=1u l=1u
X1258 a_29812_33968# a_29786_33873# VSS.t48 VSS.t173 sg13_lv_nmos ad=0.2516p pd=2.16u as=0.1626p ps=1.415u w=0.74u l=0.13u
X1259 VSS.t340 VDD.t20 VSS.t340 VSS.t965 sg13_lv_nmos ad=0.1428p pd=1.52u as=0 ps=0 w=0.42u l=1u
X1260 oa_sar8_acore18_opt_0.sw_bitcell_opt_b5_0.bot.t1 oa_sar8_acore18_opt_0.sw_bitcell_opt_term_0.trkb.t18 oa_sar8_acore18_opt_0.sw_bitcell_opt_term_0.vin VDD.t882 sg13_lv_pmos ad=0.39p pd=2.39u as=0.7p ps=4.7u w=2u l=0.13u
X1261 VSS.t293 a_34261_36653# a_34363_36796# VSS.t292 sg13_lv_nmos ad=5.13525p pd=33.135u as=0.2516p ps=2.16u w=0.74u l=0.13u
X1262 VDD.t13 VSS.t773 VDD.t13 VDD.t5 sg13_lv_pmos ad=0.19p pd=1.38u as=0 ps=0 w=1u l=1u
X1263 a_36210_31826# sar_ctrl_async_phys_0.sg13g2_buf_1$1_6.X VSS.t116 VSS.t1305 sg13_lv_nmos ad=60.89999f pd=0.71u as=0.1626p ps=1.415u w=0.42u l=0.13u
X1264 VDD.t20 sar_ctrl_async_phys_0.sg13g2_buf_1$1_6.X.t2 a_31446_35162# VDD.t19 sg13_lv_pmos ad=0.36237p pd=2.605u as=79.8f ps=0.8u w=0.42u l=0.13u
X1265 a_31563_43020# sar_ctrl_async_phys_0.sg13g2_a21oi_1$1_4.A2 VDD.t218 VDD.t22 sg13_lv_pmos ad=0.3808p pd=2.92u as=0.2128p ps=1.5u w=1.12u l=0.13u
X1266 oa_sar8_acore18_opt_0.sw_tg_opt_1.bot.t3 oa_sar8_acore18_opt_0.sw_bitcell_opt_b7_1.bot.t65 cap_cmim l=2.14u w=2.14u
X1267 sar_ctrl_async_phys_0.sg13g2_a22oi_1$1_4.Y sar_ctrl_async_phys_0.sg13g2_a22oi_1$1_0.B1 a_32687_32876# VDD.t76 sg13_lv_pmos ad=0.2128p pd=1.5u as=0.2716p ps=1.605u w=1.12u l=0.13u
X1268 oa_sar8_acore18_opt_0.sw_tg_opt_0.bot.t3 oa_sar8_acore18_opt_0.sw_bitcell_opt_b7_0.bot.t89 cap_cmim l=2.14u w=2.14u
X1269 oa_sar8_acore18_opt_0.sw_bitcell_opt_b4_1.bot.t0 oa_sar8_acore18_opt_0.bstrap_opt_w2_c1200_1.gb oa_sar8_acore18_opt_0.bstrap_opt_w2_c1200_1.out VSS.t160 sg13_lv_nmos ad=0.195p pd=1.39u as=0.35p ps=2.7u w=1u l=0.13u
X1270 VDD.t104 VSS.t901 VDD.t103 VDD.t29 sg13_lv_pmos ad=0.34p pd=2.68u as=0 ps=0 w=1u l=1u
X1271 oa_sar8_acore18_opt_0.sw_tg_opt_0.bot.t3 oa_sar8_acore18_opt_0.sw_bitcell_opt_b7_0.bot.t25 cap_cmim l=2.14u w=2.14u
X1272 a_32533_40471# sar_ctrl_async_phys_0.sg13g2_dfrbpq_1$1_0.CLK.t19 VDD.t317 VDD.t317 sg13_lv_pmos ad=0.4088p pd=2.97u as=1.55472p ps=9.945u w=1.12u l=0.13u
X1273 sar_ctrl_async_phys_0.sg13g2_nand2_1$1_1.B sar_ctrl_async_phys_0.sg13g2_dfrbpq_1$1_0.CLK.t15 VSS.t102 VSS.t281 sg13_lv_nmos ad=0.1406p pd=1.12u as=0.2516p ps=2.16u w=0.74u l=0.13u
X1274 a_32341_32117# sar_ctrl_async_phys_0.sg13g2_dfrbpq_1$1_0.CLK.t4 VDD.t76 VDD.t76 sg13_lv_pmos ad=0.4088p pd=2.97u as=1.79957p ps=11.62u w=1.12u l=0.13u
X1275 a_30868_44234# sar_ctrl_async_phys_0.sg13g2_nor2_1$1_10.Y a_30774_44234# VSS.t1139 sg13_lv_nmos ad=60.89999f pd=0.71u as=0.1428p ps=1.52u w=0.42u l=0.13u
X1276 VDD.t85 sar_ctrl_async_phys_0.sg13g2_and2_1$1_0.B a_31261_38232# VDD.t29 sg13_lv_pmos ad=0.1918p pd=1.5u as=0.1596p ps=1.22u w=0.84u l=0.13u
X1277 VDD.t270 VSS.t1016 VDD.t270 VDD.t147 sg13_lv_pmos ad=0.34p pd=2.68u as=0 ps=0 w=1u l=1u
X1278 VSS.t118 VDD.t132 VSS.t118 VSS.t745 sg13_lv_nmos ad=79.8f pd=0.8u as=0 ps=0 w=0.42u l=1u
X1279 sar_ctrl_async_phys_0.sg13g2_a22oi_1$1_3.B1 sar_ctrl_async_phys_0.sg13g2_nor2b_1$1_0.A VDD.t233 VDD.t147 sg13_lv_pmos ad=0.2128p pd=1.5u as=0.3808p ps=2.92u w=1.12u l=0.13u
X1280 VSS.t126 VDD.t177 VSS.t126 VSS.t125 sg13_lv_nmos ad=79.8f pd=0.8u as=0 ps=0 w=0.42u l=1u
X1281 VSS.t44 a_33248_35382# a_32897_35239# VSS.t408 sg13_lv_nmos ad=79.8f pd=0.8u as=0.1428p ps=1.52u w=0.42u l=0.13u
X1282 oa_sar8_acore18_opt_0.sw_tg_opt_0.bot.t2 oa_sar8_acore18_opt_0.sw_bitcell_opt_b7_0.bot.t152 cap_cmim l=2.14u w=2.14u
X1283 VSS.t514 sar_ctrl_async_phys_0.hold_req oa_sar8_acore18_opt_0.sw_bitcell_opt_term_0.VSS VSS.t513 sg13_lv_nmos ad=0.7p pd=4.7u as=0.39p ps=2.39u w=2u l=0.13u
X1284 a_35113_41525# a_34171_41332# a_34911_41287# VDD.t0 sg13_lv_pmos ad=93.45f pd=0.865u as=0.2048p ps=1.63u w=0.42u l=0.13u
X1285 VSS.t283 a_32149_45007# a_32251_45007# VSS.t637 sg13_lv_nmos ad=6.70155p pd=42.66u as=0.2516p ps=2.16u w=0.74u l=0.13u
X1286 oa_sar8_acore18_opt_0.sw_tg_opt_0.bot.t3 oa_sar8_acore18_opt_0.sw_bitcell_opt_b5_0.bot.t2 cap_cmim l=2.14u w=2.14u
X1287 a_34132_32904# a_34106_32868# VDD.t561 VDD.t76 sg13_lv_pmos ad=0.34p pd=2.68u as=0.36237p ps=2.605u w=1u l=0.13u
X1288 VDD.t340 a_26954_40424# a_26673_40726# VDD.t317 sg13_lv_pmos ad=0.1523p pd=1.38u as=0.34p ps=2.68u w=1u l=0.5u
X1289 VDD.t252 VSS.t15 VDD.t253 VDD.t29 sg13_lv_pmos ad=0.19p pd=1.38u as=0 ps=0 w=1u l=1u
X1290 VSS.t92 a_35648_33142# a_35297_33261# VSS.t607 sg13_lv_nmos ad=79.8f pd=0.8u as=0.1428p ps=1.52u w=0.42u l=0.13u
X1291 VSS.t15 a_34308_37400# sar_ctrl_async_phys_0.sg13g2_nor2b_1$1_2.Y VSS.t14 sg13_lv_nmos ad=0.17255p pd=1.25u as=0.1406p ps=1.12u w=0.74u l=0.13u
X1292 a_32473_40507# a_32116_40464# VDD.t326 VDD.t317 sg13_lv_pmos ad=63f pd=0.72u as=0.1563p ps=1.22u w=0.42u l=0.13u
X1293 VSS.t65 a_26544_38389# sar_ctrl_async_phys_0.sg13g2_and2_1$1_3.X VSS.t1235 sg13_lv_nmos ad=0.1331p pd=1.12u as=0.2516p ps=2.16u w=0.74u l=0.13u
X1294 VDD.t3 a_34549_30605# a_34651_30748# VDD.t3 sg13_lv_pmos ad=1.96315p pd=12.675u as=0.3864p ps=2.93u w=1.12u l=0.13u
X1295 sar_ctrl_async_phys_0.sg13g2_nand2b_1$1_4.A_N a_35770_43484# VDD.t330 VDD.t22 sg13_lv_pmos ad=0.3808p pd=2.92u as=0.2128p ps=1.5u w=1.12u l=0.13u
X1296 oa_sar8_acore18_opt_0.sw_tg_opt_0.bot.t3 oa_sar8_acore18_opt_0.sw_bitcell_opt_b6_0.bot.t14 cap_cmim l=2.14u w=2.14u
X1297 VSS.t970 VDD.t270 VSS.t970 VSS.t0 sg13_lv_nmos ad=79.8f pd=0.8u as=0 ps=0 w=0.42u l=1u
X1298 sar_ctrl_async_phys_0.sg13g2_buf_1$1_26.X a_25496_31388# VDD.t81 VDD.t3 sg13_lv_pmos ad=0.42p pd=2.99u as=0.2114p ps=1.54u w=1.12u l=0.13u
X1299 VDD.t424 sar_ctrl_async_phys_0.sg13g2_a21oi_1$1_4.B1 a_36056_47296# VDD.t42 sg13_lv_pmos ad=0.2114p pd=1.54u as=0.2856p ps=2.36u w=0.84u l=0.13u
X1300 a_26454_39702# a_26184_39702# VDD.t328 VDD.t317 sg13_lv_pmos ad=0.34p pd=2.68u as=0.1523p ps=1.38u w=1u l=0.5u
X1301 VSS.t17 sar_ctrl_async_phys_0.sg13g2_buf_1$1_6.X a_31732_32138# VSS.t100 sg13_lv_nmos ad=0.1626p pd=1.415u as=60.89999f ps=0.71u w=0.42u l=0.13u
X1302 VDD.t159 VSS.t970 VDD.t159 VDD.t19 sg13_lv_pmos ad=0.19p pd=1.38u as=0 ps=0 w=1u l=1u
X1303 sar_ctrl_async_phys_0.sg13g2_a21oi_1$1_1.B1 a_35725_45266# VDD.t349 VDD.t5 sg13_lv_pmos ad=0.2128p pd=1.5u as=0.3808p ps=2.92u w=1.12u l=0.13u
X1304 oa_sar8_acore18_opt_0.sw_tg_opt_0.bot.t3 oa_sar8_acore18_opt_0.sw_bitcell_opt_b5_0.bot.t35 cap_cmim l=2.14u w=2.14u
X1305 oa_sar8_acore18_opt_0.sw_tg_opt_1.bot.t3 oa_sar8_acore18_opt_0.sw_bitcell_opt_b7_1.bot.t137 cap_cmim l=2.14u w=2.14u
X1306 VSS.t941 VDD.t159 VSS.t940 VSS.t939 sg13_lv_nmos ad=0.1428p pd=1.52u as=0 ps=0 w=0.42u l=1u
X1307 VDD.t16 a_34261_36653# a_34363_36796# VDD.t16 sg13_lv_pmos ad=2.48357p pd=16.205u as=0.3864p ps=2.93u w=1.12u l=0.13u
X1308 VDD.t22 VSS.t820 VDD.t22 VDD.t22 sg13_lv_pmos ad=0.19p pd=1.38u as=0 ps=0 w=1u l=1u
X1309 a_26544_38389# sar_ctrl_async_phys_0.sg13g2_and2_1$1_3.A a_26681_38232# VSS.t63 sg13_lv_nmos ad=0.2176p pd=1.96u as=0.1216p ps=1.02u w=0.64u l=0.13u
X1310 VDD.t169 VSS.t935 VDD.t169 VDD.t16 sg13_lv_pmos ad=0.34p pd=2.68u as=0 ps=0 w=1u l=1u
X1311 VDD.t258 sar_ctrl_async_phys_0.sg13g2_dfrbpq_1$1_3.RESET_B a_33750_36362# VDD.t19 sg13_lv_pmos ad=0.36237p pd=2.605u as=79.8f ps=0.8u w=0.42u l=0.13u
X1312 a_31732_45000# a_31706_44964# VDD.t8 VDD.t5 sg13_lv_pmos ad=0.34p pd=2.68u as=0.36237p ps=2.605u w=1u l=0.13u
X1313 sar_ctrl_async_phys_0.sg13g2_buf_1$1_21.A sar_ctrl_async_phys_0.sg13g2_a21oi_1$1_2.B1 VDD.t705 VDD.t29 sg13_lv_pmos ad=0.2128p pd=1.5u as=0.3808p ps=2.92u w=1.12u l=0.13u
X1314 a_35948_n9612# oa_sar8_acore18_opt_0.sw_bitcell_opt_term_0.trkb.t5 VSS.t698 VSS.t697 sg13_lv_nmos ad=0.19p pd=1.38u as=0.345p ps=2.69u w=1u l=0.15u
X1315 oa_sar8_acore18_opt_0.sw_tg_opt_1.bot.t3 oa_sar8_acore18_opt_0.sw_bitcell_opt_b6_1.bot.t75 cap_cmim l=2.14u w=2.14u
X1316 VSS.t79 a_35952_39901# sar_ctrl_async_phys_0.sg13g2_buf_1$1_14.A VSS.t295 sg13_lv_nmos ad=0.1331p pd=1.12u as=0.2516p ps=2.16u w=0.74u l=0.13u
X1317 oa_sar8_acore18_opt_0.sw_tg_opt_0.bot.t2 oa_sar8_acore18_opt_0.sw_bitcell_opt_b7_0.bot.t157 cap_cmim l=2.14u w=2.14u
X1318 VSS.t40 VDD.t11 VSS.t40 VSS.t755 sg13_lv_nmos ad=79.8f pd=0.8u as=0 ps=0 w=0.42u l=1u
X1319 VDD.t148 VSS.t979 VDD.t148 VDD.t147 sg13_lv_pmos ad=0.34p pd=2.68u as=0 ps=0 w=1u l=1u
X1320 VSS.t111 sar_ctrl_async_phys_0.sg13g2_dlygate4sd3_1$1_5.X a_26184_42013# VSS.t326 sg13_lv_nmos ad=79.8f pd=0.8u as=0.1428p ps=1.52u w=0.42u l=0.13u
X1321 sar_ctrl_async_phys_0.dac_code[5] a_36056_38948# VSS.t79 VSS.t644 sg13_lv_nmos ad=0.2886p pd=2.26u as=0.14875p ps=1.16u w=0.74u l=0.13u
X1322 VDD.t475 sar_ctrl_async_phys_0.sg13g2_buf_1$1_13.A a_35288_38224# VDD.t29 sg13_lv_pmos ad=0.2114p pd=1.54u as=0.2856p ps=2.36u w=0.84u l=0.13u
X1323 a_31638_32138# a_32443_32260# a_31898_32361# VDD.t76 sg13_lv_pmos ad=0.1428p pd=1.52u as=79.8f ps=0.8u w=0.42u l=0.13u
X1324 a_33675_43020# sar_ctrl_async_phys_0.sg13g2_buf_1$1_19.A VDD.t359 VDD.t22 sg13_lv_pmos ad=0.3808p pd=2.92u as=0.2128p ps=1.5u w=1.12u l=0.13u
X1325 busy a_35672_33688# VDD.t372 VDD.t147 sg13_lv_pmos ad=0.42p pd=2.99u as=0.2114p ps=1.54u w=1.12u l=0.13u
X1326 a_34911_41287# a_34069_41189# a_33652_41528# VDD.t0 sg13_lv_pmos ad=0.2048p pd=1.63u as=0.34p ps=2.68u w=1u l=0.13u
X1327 oa_sar8_acore18_opt_0.sw_tg_opt_0.bot.t3 oa_sar8_acore18_opt_0.sw_bitcell_opt_b6_0.bot.t49 cap_cmim l=2.14u w=2.14u
X1328 VSS.t1 VDD.t233 VSS.t1 VSS.t0 sg13_lv_nmos ad=79.8f pd=0.8u as=0 ps=0 w=0.42u l=1u
X1329 VSS.t99 sar_ctrl_async_phys_0.sg13g2_a21oi_1$1_6.A2 a_32817_42748# VSS.t439 sg13_lv_nmos ad=0.2516p pd=2.16u as=0.1406p ps=1.12u w=0.74u l=0.13u
X1330 oa_sar8_acore18_opt_0.sw_tg_opt_1.bot.t3 oa_sar8_acore18_opt_0.sw_bitcell_opt_b5_1.bot.t22 cap_cmim l=2.14u w=2.14u
X1331 oa_sar8_acore18_opt_0.sw_bitcell_opt_term_0.trkb.t1 sar_ctrl_async_phys_0.sample VDD.t620 VDD.t618 sg13_lv_pmos ad=0.39p pd=2.39u as=0.7p ps=4.7u w=2u l=0.13u
X1332 VDD.t11 VSS.t40 VDD.t11 VDD.t10 sg13_lv_pmos ad=0.19p pd=1.38u as=0 ps=0 w=1u l=1u
X1333 VDD.t562 sar_ctrl_async_phys_0.sg13g2_nand2b_1$1_1.Y a_34328_41972# VDD.t0 sg13_lv_pmos ad=0.2114p pd=1.54u as=0.2856p ps=2.36u w=0.84u l=0.13u
X1334 a_30772_31392# a_30746_31356# VDD.t79 VDD.t3 sg13_lv_pmos ad=0.34p pd=2.68u as=0.36237p ps=2.605u w=1u l=0.13u
X1335 a_35168_41430# a_34911_41287# a_35330_41210# VSS.t588 sg13_lv_nmos ad=0.1428p pd=1.52u as=37.8f ps=0.6u w=0.42u l=0.13u
X1336 a_29332_32456# a_29851_32260# a_30591_32215# VSS.t1146 sg13_lv_nmos ad=0.3473p pd=2.71u as=0.12665p ps=1.145u w=0.74u l=0.13u
X1337 a_34833_37784# sar_ctrl_async_phys_0.sg13g2_a21oi_1$1_0.A1 sar_ctrl_async_phys_0.sg13g2_a22oi_1$1_1.A2 VSS.t14 sg13_lv_nmos ad=0.1406p pd=1.12u as=0.1406p ps=1.12u w=0.74u l=0.13u
X1338 VDD.t79 VSS.t1110 VDD.t79 VDD.t3 sg13_lv_pmos ad=0.34p pd=2.68u as=0 ps=0 w=1u l=1u
X1339 VSS.t92 sar_ctrl_async_phys_0.sg13g2_buf_1$1_3.A a_35672_33688# VSS.t91 sg13_lv_nmos ad=0.14875p pd=1.16u as=0.187p ps=1.78u w=0.55u l=0.13u
X1340 oa_sar8_acore18_opt_0.sw_tg_opt_1.bot.t3 oa_sar8_acore18_opt_0.sw_bitcell_opt_b6_1.bot.t40 cap_cmim l=2.14u w=2.14u
X1341 VDD.t80 VSS.t1054 VDD.t80 VDD.t3 sg13_lv_pmos ad=0.34p pd=2.68u as=0 ps=0 w=1u l=1u
X1342 sar_ctrl_async_phys_0.sg13g2_nand2b_1$1_4.A_N a_35770_43484# VSS.t38 VSS.t37 sg13_lv_nmos ad=0.2516p pd=2.16u as=0.1406p ps=1.12u w=0.74u l=0.13u
X1343 VSS.t99 VDD.t114 VSS.t99 VSS.t878 sg13_lv_nmos ad=79.8f pd=0.8u as=0 ps=0 w=0.42u l=1u
X1344 VDD.t902 VDD.t900 oa_sar8_acore18_opt_0.sw_bitcell_opt_term_0.bot.t3 VDD.t901 sg13_lv_pmos ad=1.05p pd=6.7u as=0.585p ps=3.39u w=3u l=0.13u
X1345 oa_sar8_acore18_opt_0.sw_bitcell_opt_term_0.VSS sar_ctrl_async_phys_0.dac_code[0] oa_sar8_acore18_opt_0.sw_bitcell_opt_b0_0.bot.t2 VSS.t1196 sg13_lv_nmos ad=0.525p pd=3.7u as=0.2925p ps=1.89u w=1.5u l=0.13u
X1346 oa_sar8_acore18_opt_0.sw_bitcell_opt_b0_0.bot.t2 oa_sar8_acore18_opt_0.sw_bitcell_opt_term_0.trkb.t13 oa_sar8_acore18_opt_0.sw_bitcell_opt_term_0.vin VDD.t781 sg13_lv_pmos ad=0.39p pd=2.39u as=0.7p ps=4.7u w=2u l=0.13u
X1347 VSS.t99 sar_ctrl_async_phys_0.sg13g2_buf_1$1_37.A a_34175_42726# VSS.t502 sg13_lv_nmos ad=0.14505p pd=1.15u as=0.1406p ps=1.12u w=0.74u l=0.13u
X1348 sar_ctrl_async_phys_0.dac_code_n[7].t0 a_34328_41972# VDD.t562 VDD.t0 sg13_lv_pmos ad=0.42p pd=2.99u as=0.2114p ps=1.54u w=1.12u l=0.13u
X1349 a_32354_39698# sar_ctrl_async_phys_0.sg13g2_o21ai_1$1_1.B1.t5 VSS.t554 VSS.t202 sg13_lv_nmos ad=37.8f pd=0.6u as=79.8f ps=0.8u w=0.42u l=0.13u
X1350 VSS.t243 sar_ctrl_async_phys_0.sg13g2_and2_1$1_0.B a_30129_39724# VSS.t714 sg13_lv_nmos ad=0.2516p pd=2.16u as=0.1406p ps=1.12u w=0.74u l=0.13u
X1351 VDD.t191 VSS.t65 VDD.t191 VDD.t29 sg13_lv_pmos ad=0.19p pd=1.38u as=0 ps=0 w=1u l=1u
X1352 a_35327_45366# a_35245_45266# sar_ctrl_async_phys_0.sg13g2_a21oi_1$1_0.B1 VSS.t76 sg13_lv_nmos ad=0.1406p pd=1.12u as=0.333p ps=2.38u w=0.74u l=0.13u
X1353 VSS.t107 a_30495_39309# a_31162_38948# VSS.t106 sg13_lv_nmos ad=0.1406p pd=1.12u as=0.2516p ps=2.16u w=0.74u l=0.13u
X1354 VDD.t25 VSS.t46 VDD.t25 VDD.t22 sg13_lv_pmos ad=0.19p pd=1.38u as=0 ps=0 w=1u l=1u
X1355 sar_ctrl_async_phys_0.sg13g2_nand2b_1$1_5.A_N a_33658_44996# VDD.t407 VDD.t5 sg13_lv_pmos ad=0.3808p pd=2.92u as=0.2128p ps=1.5u w=1.12u l=0.13u
X1356 oa_sar8_acore18_opt_0.sw_tg_opt_0.bot.t3 oa_sar8_acore18_opt_0.sw_bitcell_opt_b3_0.bot.t10 cap_cmim l=2.14u w=2.14u
X1357 VSS.t109 sar_ctrl_async_phys_0.sg13g2_nand2b_1$1_1.B a_35807_45366# VSS.t1168 sg13_lv_nmos ad=0.14505p pd=1.15u as=0.1406p ps=1.12u w=0.74u l=0.13u
X1358 VSS.t1017 VDD.t270 VSS.t1019 VSS.t1018 sg13_lv_nmos ad=79.8f pd=0.8u as=0 ps=0 w=0.42u l=1u
X1359 a_32156_38948# sar_ctrl_async_phys_0.sg13g2_a21oi_1$1_5.Y sar_ctrl_async_phys_0.sg13g2_dfrbpq_1$1_11.D VDD.t29 sg13_lv_pmos ad=0.1176p pd=1.33u as=0.3808p ps=2.92u w=1.12u l=0.13u
X1360 a_31381_46519# sar_ctrl_async_phys_0.sg13g2_dfrbpq_1$1_0.CLK.t30 VDD.t10 VDD.t10 sg13_lv_pmos ad=0.4088p pd=2.97u as=1.98685p ps=12.96u w=1.12u l=0.13u
X1361 a_34236_46472# sar_ctrl_async_phys_0.sg13g2_buf_1$1_2.A VSS.t126 VSS.t125 sg13_lv_nmos ad=0.187p pd=1.78u as=0.14875p ps=1.16u w=0.55u l=0.13u
X1362 VSS.t122 a_35360_43726# a_35009_43845# VSS.t121 sg13_lv_nmos ad=79.8f pd=0.8u as=0.1428p ps=1.52u w=0.42u l=0.13u
X1363 VDD.t154 a_25596_41174# sar_ctrl_async_phys_0.cmp_fire VDD.t0 sg13_lv_pmos ad=0.2114p pd=1.54u as=0.42p ps=2.99u w=1.12u l=0.13u
X1364 VSS.t111 VDD.t157 VSS.t111 VSS.t865 sg13_lv_nmos ad=79.8f pd=0.8u as=0 ps=0 w=0.42u l=1u
X1365 oa_sar8_acore18_opt_0.sw_tg_opt_1.bot.t3 oa_sar8_acore18_opt_0.sw_bitcell_opt_b4_1.bot.t6 cap_cmim l=2.14u w=2.14u
X1366 sar_ctrl_async_phys_0.sg13g2_buf_1$1_21.A sar_ctrl_async_phys_0.sg13g2_buf_1$1_3.A a_35402_39318# VSS.t90 sg13_lv_nmos ad=0.2516p pd=2.16u as=0.1406p ps=1.12u w=0.74u l=0.13u
X1367 oa_sar8_acore18_opt_0.sw_tg_opt_0.bot.t3 oa_sar8_acore18_opt_0.sw_bitcell_opt_b6_0.bot.t4 cap_cmim l=2.14u w=2.14u
X1368 sar_ctrl_async_phys_0.sg13g2_dlygate4sd3_1$1_1.A a_28006_35948# VSS.t146 VSS.t1213 sg13_lv_nmos ad=0.2516p pd=2.16u as=0.1426p ps=1.16u w=0.74u l=0.13u
X1369 oa_sar8_acore18_opt_0.sw_tg_opt_1.bot.t2 oa_sar8_acore18_opt_0.sw_bitcell_opt_b7_1.bot.t158 cap_cmim l=2.14u w=2.14u
X1370 VSS.t979 VDD.t20 VSS.t1 VSS.t0 sg13_lv_nmos ad=79.8f pd=0.8u as=0 ps=0 w=0.42u l=1u
X1371 a_30772_46946# sar_ctrl_async_phys_0.sg13g2_nor2b_1$1_4.Y a_30678_46946# VSS.t170 sg13_lv_nmos ad=60.89999f pd=0.71u as=0.1428p ps=1.52u w=0.42u l=0.13u
X1372 oa_sar8_acore18_opt_0.sw_tg_opt_0.bot.t3 oa_sar8_acore18_opt_0.sw_bitcell_opt_b7_0.bot.t40 cap_cmim l=2.14u w=2.14u
X1373 oa_sar8_acore18_opt_0.sw_bitcell_opt_b2_0.bot.t1 sar_ctrl_async_phys_0.dac_code[2] oa_sar8_acore18_opt_0.sw_bitcell_opt_term_0.VSS VSS.t200 sg13_lv_nmos ad=0.3705p pd=2.29u as=0.665p ps=4.5u w=1.9u l=0.13u
X1374 a_34420_30639# a_34651_30748# a_34106_30849# VSS.t189 sg13_lv_nmos ad=0.2373p pd=1.97u as=79.8f ps=0.8u w=0.42u l=0.13u
X1375 a_34358_30639# sar_ctrl_async_phys_0.sg13g2_buf_1$1_6.X VSS.t311 VSS.t602 sg13_lv_nmos ad=37.8f pd=0.6u as=0.1701p ps=1.65u w=0.42u l=0.13u
X1376 VDD.t4 VSS.t1124 VDD.t4 VDD.t3 sg13_lv_pmos ad=0.34p pd=2.68u as=0 ps=0 w=1u l=1u
X1377 VSS.t178 a_33183_32215# a_33850_32436# VSS.t58 sg13_lv_nmos ad=0.1406p pd=1.12u as=0.2516p ps=2.16u w=0.74u l=0.13u
X1378 VDD.t175 sar_ctrl_async_phys_0.sg13g2_nor4_1$1_0.C a_34520_47296# VDD.t42 sg13_lv_pmos ad=0.2114p pd=1.54u as=0.2856p ps=2.36u w=0.84u l=0.13u
X1379 VDD.t416 sar_ctrl_async_phys_0.sg13g2_nand2_1$1_3.A sar_ctrl_async_phys_0.sg13g2_buf_1$1_36.A VDD.t10 sg13_lv_pmos ad=0.3808p pd=2.92u as=0.2128p ps=1.5u w=1.12u l=0.13u
X1380 VDD.t114 VSS.t46 VDD.t114 VDD.t0 sg13_lv_pmos ad=0.34p pd=2.68u as=0 ps=0 w=1u l=1u
X1381 VSS.t1063 VDD.t59 VSS.t1064 VSS.t179 sg13_lv_nmos ad=79.8f pd=0.8u as=0 ps=0 w=0.42u l=1u
X1382 VDD.t43 VSS.t40 VDD.t43 VDD.t42 sg13_lv_pmos ad=0.19p pd=1.38u as=0 ps=0 w=1u l=1u
X1383 result[6] a_36056_32176# VDD.t394 VDD.t76 sg13_lv_pmos ad=0.42p pd=2.99u as=0.2114p ps=1.54u w=1.12u l=0.13u
X1384 VSS.t783 VDD.t51 VSS.t786 VSS.t785 sg13_lv_nmos ad=79.8f pd=0.8u as=0 ps=0 w=0.42u l=1u
X1385 a_32342_40885# sar_ctrl_async_phys_0.sg13g2_o21ai_1$1_1.B1.t8 VSS.t85 VSS.t540 sg13_lv_nmos ad=37.8f pd=0.6u as=0.1701p ps=1.65u w=0.42u l=0.13u
X1386 a_31194_44996# sar_ctrl_async_phys_0.sg13g2_nor2b_1$1_4.Y VDD.t8 VDD.t5 sg13_lv_pmos ad=0.1176p pd=1.33u as=0.4032p ps=2.96u w=1.12u l=0.13u
X1387 oa_sar8_acore18_opt_0.sw_tg_opt_0.bot.t3 oa_sar8_acore18_opt_0.sw_bitcell_opt_b6_0.bot.t49 cap_cmim l=2.14u w=2.14u
X1388 oa_sar8_acore18_opt_0.sw_bitcell_opt_b5_0.bot.t0 sar_ctrl_async_phys_0.dac_code[5] VDD.t469 VDD.t467 sg13_lv_pmos ad=1.053p pd=5.79u as=1.89p ps=11.5u w=5.4u l=0.13u
X1389 a_34201_43531# a_33844_43488# VDD.t359 VDD.t22 sg13_lv_pmos ad=63f pd=0.72u as=0.1563p ps=1.22u w=0.42u l=0.13u
X1390 VDD.t77 VSS.t1065 VDD.t77 VDD.t76 sg13_lv_pmos ad=0.19p pd=1.38u as=0 ps=0 w=1u l=1u
X1391 VDD.t309 sar_ctrl_async_phys_0.cmp_n a_25496_34412# VDD.t147 sg13_lv_pmos ad=0.2114p pd=1.54u as=0.2856p ps=2.36u w=0.84u l=0.13u
X1392 VSS.t1027 VDD.t77 VSS.t1026 VSS.t1025 sg13_lv_nmos ad=0.1428p pd=1.52u as=0 ps=0 w=0.42u l=1u
X1393 a_34070_36687# sar_ctrl_async_phys_0.sg13g2_dfrbpq_1$1_8.RESET_B VSS.t219 VSS.t1247 sg13_lv_nmos ad=37.8f pd=0.6u as=0.1701p ps=1.65u w=0.42u l=0.13u
X1394 oa_sar8_acore18_opt_0.sw_bitcell_opt_b7_0.bot.t1 oa_sar8_acore18_opt_0.sw_bitcell_opt_term_0.trkb.t20 oa_sar8_acore18_opt_0.sw_bitcell_opt_term_0.vin VDD.t519 sg13_lv_pmos ad=0.39p pd=2.39u as=0.7p ps=4.7u w=2u l=0.13u
X1395 VSS.t936 VDD.t159 VSS.t938 VSS.t937 sg13_lv_nmos ad=79.8f pd=0.8u as=0 ps=0 w=0.42u l=1u
X1396 VSS.t583 VDD.t18 VSS.t952 VSS.t951 sg13_lv_nmos ad=79.8f pd=0.8u as=0 ps=0 w=0.42u l=1u
X1397 VDD.t9 VSS.t783 VDD.t9 VDD.t5 sg13_lv_pmos ad=0.19p pd=1.38u as=0 ps=0 w=1u l=1u
X1398 a_27206_39326# sar_ctrl_async_phys_0.sg13g2_nor2_1$1_3.B VSS.t649 VSS.t103 sg13_lv_nmos ad=0.1406p pd=1.12u as=0.1406p ps=1.12u w=0.74u l=0.15u
X1399 VSS.t593 oa_sar8_acore18_opt_0.sw_bitcell_opt_term_0.trkb.t8 a_20412_n9612# VSS.t592 sg13_lv_nmos ad=0.345p pd=2.69u as=0.19p ps=1.38u w=1u l=0.15u
X1400 VDD.t247 sar_ctrl_async_phys_0.sg13g2_buf_1$1_6.X a_29046_32138# VDD.t76 sg13_lv_pmos ad=0.36237p pd=2.605u as=79.8f ps=0.8u w=0.42u l=0.13u
X1401 VSS.t51 sar_ctrl_async_phys_0.sg13g2_dlygate4sd3_1$1_8.X a_26280_41214# VSS.t403 sg13_lv_nmos ad=79.8f pd=0.8u as=0.1428p ps=1.52u w=0.42u l=0.13u
X1402 VDD.t30 sar_ctrl_async_phys_0.sg13g2_o21ai_1$1_1.B1.t2 a_28950_39386# VDD.t29 sg13_lv_pmos ad=0.36237p pd=2.605u as=79.8f ps=0.8u w=0.42u l=0.13u
X1403 VDD.t17 a_29701_36874# sar_ctrl_async_phys_0.sg13g2_nor2_1$1_8.A VDD.t16 sg13_lv_pmos ad=0.2128p pd=1.5u as=0.3808p ps=2.92u w=1.12u l=0.13u
X1404 VSS.t970 VDD.t159 VSS.t95 VSS.t0 sg13_lv_nmos ad=0.1428p pd=1.52u as=0 ps=0 w=0.42u l=1u
X1405 VDD.t270 VSS.t1021 VDD.t270 VDD.t147 sg13_lv_pmos ad=0.34p pd=2.68u as=0 ps=0 w=1u l=1u
X1406 VDD.t44 VSS.t730 VDD.t44 VDD.t42 sg13_lv_pmos ad=0.19p pd=1.38u as=0 ps=0 w=1u l=1u
X1407 VSS.t116 sar_ctrl_async_phys_0.sg13g2_buf_1$1_7.A a_36056_32176# VSS.t115 sg13_lv_nmos ad=0.14875p pd=1.16u as=0.187p ps=1.78u w=0.55u l=0.13u
X1408 a_30714_43020# sar_ctrl_async_phys_0.sg13g2_nor2_1$1_10.A VDD.t25 VDD.t22 sg13_lv_pmos ad=0.1176p pd=1.33u as=0.4032p ps=2.96u w=1.12u l=0.13u
X1409 VSS.t1 VDD.t233 VSS.t1 VSS.t0 sg13_lv_nmos ad=0.1428p pd=1.52u as=0 ps=0 w=0.42u l=1u
X1410 oa_sar8_acore18_opt_0.sw_tg_opt_1.bot.t3 oa_sar8_acore18_opt_0.sw_bitcell_opt_b6_1.bot.t55 cap_cmim l=2.14u w=2.14u
X1411 sar_ctrl_async_phys_0.sg13g2_nand2_1$1_5.Y sar_ctrl_async_phys_0.sg13g2_nand2_1$1_5.B VDD.t330 VDD.t22 sg13_lv_pmos ad=0.2128p pd=1.5u as=0.3808p ps=2.92u w=1.12u l=0.13u
X1412 VDD.t361 sar_ctrl_async_phys_0.sg13g2_o21ai_1$1_1.B1.t10 a_29498_40428# VDD.t317 sg13_lv_pmos ad=0.1563p pd=1.22u as=0.147p ps=1.54u w=0.42u l=0.13u
X1413 VDD.t375 a_34596_40424# a_34554_40460# VDD.t317 sg13_lv_pmos ad=0.2618p pd=1.63u as=0.1176p ps=1.33u w=1.12u l=0.13u
X1414 a_33940_41223# a_33652_41528# a_33878_41223# VSS.t1286 sg13_lv_nmos ad=0.1428p pd=1.52u as=37.8f ps=0.6u w=0.42u l=0.13u
X1415 VDD.t120 sar_ctrl_async_phys_0.sg13g2_nand3_1$1_0.Y sar_ctrl_async_phys_0.sg13g2_nor2_1$1_14.A VDD.t29 sg13_lv_pmos ad=0.3808p pd=2.92u as=0.2128p ps=1.5u w=1.12u l=0.15u
X1416 a_29594_43452# a_30037_43495# a_29334_43922# VSS.t1293 sg13_lv_nmos ad=79.8f pd=0.8u as=0.1296p ps=1.52u w=0.42u l=0.13u
X1417 a_33818_36897# a_34261_36653# a_34201_37065# VDD.t16 sg13_lv_pmos ad=79.8f pd=0.8u as=63f ps=0.72u w=0.42u l=0.13u
X1418 VSS.t771 VDD.t11 VSS.t773 VSS.t772 sg13_lv_nmos ad=79.8f pd=0.8u as=0 ps=0 w=0.42u l=1u
X1419 a_33882_38484# sar_ctrl_async_phys_0.sg13g2_nor2b_1$1_1.Y VDD.t1058 VDD.t29 sg13_lv_pmos ad=0.1176p pd=1.33u as=0.4032p ps=2.96u w=1.12u l=0.13u
X1420 oa_sar8_acore18_opt_0.sw_tg_opt_0.bot.t3 oa_sar8_acore18_opt_0.sw_bitcell_opt_b7_0.bot.t125 cap_cmim l=2.14u w=2.14u
X1421 a_32150_32151# sar_ctrl_async_phys_0.sg13g2_buf_1$1_6.X VSS.t17 VSS.t100 sg13_lv_nmos ad=37.8f pd=0.6u as=0.1701p ps=1.65u w=0.42u l=0.13u
X1422 a_30650_39921# a_31093_39677# a_30390_39698# VSS.t320 sg13_lv_nmos ad=79.8f pd=0.8u as=0.1296p ps=1.52u w=0.42u l=0.13u
X1423 oa_sar8_acore18_opt_0.sw_tg_opt_0.bot.t3 oa_sar8_acore18_opt_0.sw_bitcell_opt_b3_0.bot.t14 cap_cmim l=2.14u w=2.14u
X1424 oa_sar8_acore18_opt_0.sw_tg_opt_0.bot.t4 oa_sar8_acore18_opt_0.sw_bitcell_opt_b7_0.bot.t10 cap_cmim l=2.14u w=2.14u
X1425 a_30229_33629# sar_ctrl_async_phys_0.sg13g2_dfrbpq_1$1_0.CLK.t7 VSS.t175 VSS.t444 sg13_lv_nmos ad=0.2516p pd=2.16u as=4.49817p ps=29.795u w=0.74u l=0.13u
X1426 VSS.t824 VDD.t23 VSS.t825 VSS.t224 sg13_lv_nmos ad=79.8f pd=0.8u as=0 ps=0 w=0.42u l=1u
X1427 VDD.t30 VSS.t102 VDD.t120 VDD.t29 sg13_lv_pmos ad=0.19p pd=1.38u as=0 ps=0 w=1u l=1u
X1428 oa_sar8_acore18_opt_0.sw_tg_opt_1.bot.t2 oa_sar8_acore18_opt_0.sw_bitcell_opt_b7_1.bot.t163 cap_cmim l=2.14u w=2.14u
X1429 VSS.t775 VDD.t11 VSS.t775 VSS.t774 sg13_lv_nmos ad=0.1428p pd=1.52u as=0 ps=0 w=0.42u l=1u
X1430 a_35772_41936# sar_ctrl_async_phys_0.sg13g2_buf_1$1_37.A VSS.t506 VSS.t505 sg13_lv_nmos ad=0.187p pd=1.78u as=0.14875p ps=1.16u w=0.55u l=0.13u
X1431 VSS.t393 sar_ctrl_async_phys_0.sample oa_sar8_acore18_opt_0.sw_bitcell_opt_term_0.trkb.t0 VSS.t392 sg13_lv_nmos ad=0.35p pd=2.7u as=0.195p ps=1.39u w=1u l=0.13u
X1432 VDD.t79 sar_ctrl_async_phys_0.sg13g2_buf_1$1_6.X a_30486_31826# VDD.t3 sg13_lv_pmos ad=0.36237p pd=2.605u as=79.8f ps=0.8u w=0.42u l=0.13u
X1433 VDD.t11 VSS.t777 VDD.t11 VDD.t10 sg13_lv_pmos ad=0.19p pd=1.38u as=0 ps=0 w=1u l=1u
X1434 VDD.t9 VSS.t826 VDD.t15 VDD.t5 sg13_lv_pmos ad=0.19p pd=1.38u as=0 ps=0 w=1u l=1u
X1435 VSS.t313 VDD.t25 VSS.t46 VSS.t859 sg13_lv_nmos ad=79.8f pd=0.8u as=0 ps=0 w=0.42u l=1u
X1436 a_30964_39711# a_30676_40016# a_30902_39711# VSS.t196 sg13_lv_nmos ad=0.1428p pd=1.52u as=37.8f ps=0.6u w=0.42u l=0.13u
X1437 oa_sar8_acore18_opt_0.sw_tg_opt_1.bot.t4 oa_sar8_acore18_opt_0.sw_bitcell_opt_b7_1.bot.t2 cap_cmim l=2.14u w=2.14u
X1438 VDD.t202 VSS.t44 VDD.t238 VDD.t147 sg13_lv_pmos ad=0.34p pd=2.68u as=0 ps=0 w=1u l=1u
X1439 VSS.t118 VDD.t64 VSS.t118 VSS.t766 sg13_lv_nmos ad=0.1428p pd=1.52u as=0 ps=0 w=0.42u l=1u
X1440 VSS.t169 sar_ctrl_async_phys_0.sg13g2_and2_1$1_6.X a_34904_38948# VSS.t168 sg13_lv_nmos ad=0.14875p pd=1.16u as=0.187p ps=1.78u w=0.55u l=0.13u
X1441 VDD.t159 VSS.t975 VDD.t159 VDD.t19 sg13_lv_pmos ad=0.19p pd=1.38u as=0 ps=0 w=1u l=1u
X1442 VDD.t132 VSS.t126 VDD.t132 VDD.t42 sg13_lv_pmos ad=0.19p pd=1.38u as=0 ps=0 w=1u l=1u
X1443 oa_sar8_acore18_opt_0.sw_tg_opt_1.bot.t3 oa_sar8_acore18_opt_0.sw_bitcell_opt_b4_1.bot.t32 cap_cmim l=2.14u w=2.14u
X1444 VDD.t326 a_31935_39775# a_32602_39996# VDD.t317 sg13_lv_pmos ad=0.2128p pd=1.5u as=0.3864p ps=2.93u w=1.12u l=0.13u
X1445 oa_sar8_acore18_opt_0.sw_tg_opt_0.bot.t3 oa_sar8_acore18_opt_0.sw_bitcell_opt_b7_0.bot.t136 cap_cmim l=2.14u w=2.14u
X1446 oa_sar8_acore18_opt_0.sw_tg_opt_0.bot.t3 oa_sar8_acore18_opt_0.sw_bitcell_opt_b5_0.bot.t25 cap_cmim l=2.14u w=2.14u
X1447 a_29941_40471# sar_ctrl_async_phys_0.sg13g2_dfrbpq_1$1_0.CLK.t20 VDD.t317 VDD.t317 sg13_lv_pmos ad=0.4088p pd=2.97u as=1.55472p ps=9.945u w=1.12u l=0.13u
X1448 oa_sar8_acore18_opt_0.sw_tg_opt_1.bot.t3 oa_sar8_acore18_opt_0.sw_bitcell_opt_b7_1.bot.t111 cap_cmim l=2.14u w=2.14u
X1449 oa_sar8_acore18_opt_0.sw_tg_opt_0.bot.t3 oa_sar8_acore18_opt_0.sw_bitcell_opt_b6_0.bot.t74 cap_cmim l=2.14u w=2.14u
X1450 a_31040_40702# sar_ctrl_async_phys_0.sg13g2_o21ai_1$1_1.B1.t9 VDD.t317 VDD.t317 sg13_lv_pmos ad=79.8f pd=0.8u as=1.55472p ps=9.945u w=0.42u l=0.13u
X1451 oa_sar8_acore18_opt_0.sw_tg_opt_1.bot.t3 oa_sar8_acore18_opt_0.sw_bitcell_opt_b7_1.bot.t69 cap_cmim l=2.14u w=2.14u
X1452 VSS.t1108 VDD.t79 VSS.t1106 VSS.t1107 sg13_lv_nmos ad=79.8f pd=0.8u as=0 ps=0 w=0.42u l=1u
X1453 VSS.t40 VDD.t11 VSS.t40 VSS.t757 sg13_lv_nmos ad=79.8f pd=0.8u as=0 ps=0 w=0.42u l=1u
X1454 VDD.t562 a_34911_41287# a_35578_41508# VDD.t0 sg13_lv_pmos ad=0.2128p pd=1.5u as=0.3864p ps=2.93u w=1.12u l=0.13u
X1455 VSS.t794 VDD.t64 VSS.t792 VSS.t793 sg13_lv_nmos ad=0.1428p pd=1.52u as=0 ps=0 w=0.42u l=1u
X1456 VDD.t10 a_32480_46750# a_32425_46631# VDD.t10 sg13_lv_pmos ad=2.2076p pd=14.4u as=93.45f ps=0.865u w=0.42u l=0.13u
X1457 oa_sar8_acore18_opt_0.sw_bitcell_opt_term_0.vin oa_sar8_acore18_opt_0.sw_bitcell_opt_term_0.trkb.t12 oa_sar8_acore18_opt_0.sw_bitcell_opt_term_0.bot.t0 VDD.t517 sg13_lv_pmos ad=0.7p pd=4.7u as=0.39p ps=2.39u w=2u l=0.13u
X1458 VDD.t452 sar_ctrl_async_phys_0.sg13g2_o21ai_1$1_1.B1.t6 a_30650_39921# VDD.t317 sg13_lv_pmos ad=0.1563p pd=1.22u as=0.147p ps=1.54u w=0.42u l=0.13u
X1459 a_35327_45750# a_35245_45936# sar_ctrl_async_phys_0.sg13g2_buf_1$1_42.A VSS.t76 sg13_lv_nmos ad=0.1406p pd=1.12u as=0.333p ps=2.38u w=0.74u l=0.13u
X1460 oa_sar8_acore18_opt_0.sw_bitcell_opt_b7_1.VSS sar_ctrl_async_phys_0.dac_code_n[1].t1 oa_sar8_acore18_opt_0.sw_bitcell_opt_b1_1.bot.t0 VSS.t52 sg13_lv_nmos ad=0.595p pd=4.1u as=0.3315p ps=2.09u w=1.7u l=0.13u
X1461 VDD.t90 VSS.t1090 VDD.t90 VDD.t3 sg13_lv_pmos ad=0.34p pd=2.68u as=0 ps=0 w=1u l=1u
X1462 sar_ctrl_async_phys_0.sg13g2_inv_1$1_0.Y sar_ctrl_async_phys_0.sg13g2_inv_1$1_0.A VSS.t309 VSS.t350 sg13_lv_nmos ad=0.2516p pd=2.16u as=0.2516p ps=2.16u w=0.74u l=0.13u
X1463 a_33914_44457# a_34357_44213# a_34297_44625# VDD.t5 sg13_lv_pmos ad=79.8f pd=0.8u as=63f ps=0.72u w=0.42u l=0.13u
X1464 oa_sar8_acore18_opt_0.sw_tg_opt_0.bot.t3 oa_sar8_acore18_opt_0.sw_bitcell_opt_b7_0.bot.t94 cap_cmim l=2.14u w=2.14u
X1465 oa_sar8_acore18_opt_0.bstrap_opt_w2_c1200_1.out oa_sar8_acore18_opt_0.bstrap_opt_w2_c1200_1.gb oa_sar8_acore18_opt_0.sw_bitcell_opt_b0_1.bot.t0 VSS.t156 sg13_lv_nmos ad=0.35p pd=2.7u as=0.195p ps=1.39u w=1u l=0.13u
X1466 a_31802_37404# a_32245_37447# a_31542_37874# VSS.t471 sg13_lv_nmos ad=79.8f pd=0.8u as=0.1296p ps=1.52u w=0.42u l=0.13u
X1467 a_20412_n9612# oa_sar8_acore18_opt_0.sw_bitcell_opt_term_0.trkb.t8 VSS.t593 VSS.t592 sg13_lv_nmos ad=0.19p pd=1.38u as=0.345p ps=2.69u w=1u l=0.15u
X1468 a_30848_32358# a_30591_32215# a_31010_32138# VSS.t1248 sg13_lv_nmos ad=0.1428p pd=1.52u as=37.8f ps=0.6u w=0.42u l=0.13u
X1469 a_32715_43020# sar_ctrl_async_phys_0.sg13g2_a21oi_1$1_6.A2 VDD.t219 VDD.t22 sg13_lv_pmos ad=0.3808p pd=2.92u as=0.2128p ps=1.5u w=1.12u l=0.13u
X1470 a_27304_38928# sar_ctrl_async_phys_0.sg13g2_and2_1$1_3.X VDD.t120 VDD.t29 sg13_lv_pmos ad=0.2128p pd=1.5u as=0.3808p ps=2.92u w=1.12u l=0.15u
X1471 a_26570_42690# sar_ctrl_async_phys_0.sg13g2_dlygate4sd3_1$1_5.A VSS.t111 VSS.t1283 sg13_lv_nmos ad=0.1428p pd=1.52u as=79.8f ps=0.8u w=0.42u l=0.13u
X1472 sar_ctrl_async_phys_0.sg13g2_nor2_1$1_6.Y sar_ctrl_async_phys_0.sg13g2_nand2_1$1_1.Y VSS.t102 VSS.t722 sg13_lv_nmos ad=0.1406p pd=1.12u as=0.2516p ps=2.16u w=0.74u l=0.13u
X1473 VSS.t1061 VDD.t97 VSS.t1061 VSS.t179 sg13_lv_nmos ad=0.1428p pd=1.52u as=0 ps=0 w=0.42u l=1u
X1474 sar_ctrl_async_phys_0.sg13g2_a21oi_1$1_0.A1 sar_ctrl_async_phys_0.sg13g2_inv_1$1_7.A VDD.t17 VDD.t16 sg13_lv_pmos ad=0.3808p pd=2.92u as=0.3808p ps=2.92u w=1.12u l=0.13u
X1475 oa_sar8_acore18_opt_0.sw_tg_opt_0.bot.t3 oa_sar8_acore18_opt_0.sw_bitcell_opt_b6_0.bot.t14 cap_cmim l=2.14u w=2.14u
X1476 sar_ctrl_async_phys_0.sg13g2_nand2_1$1_2.Y sar_ctrl_async_phys_0.sg13g2_buf_1$1_3.A VDD.t317 VDD.t317 sg13_lv_pmos ad=0.2128p pd=1.5u as=0.3808p ps=2.92u w=1.12u l=0.13u
X1477 a_32245_37447# sar_ctrl_async_phys_0.sg13g2_dfrbpq_1$1_0.CLK.t14 VDD.t16 VDD.t16 sg13_lv_pmos ad=0.4088p pd=2.97u as=2.2076p ps=14.4u w=1.12u l=0.13u
X1478 VSS.t730 VDD.t44 VSS.t730 VSS.t732 sg13_lv_nmos ad=0.1428p pd=1.52u as=0 ps=0 w=0.42u l=1u
X1479 oa_sar8_acore18_opt_0.sw_tg_opt_0.bot.t4 oa_sar8_acore18_opt_0.sw_bitcell_opt_b7_0.bot.t2 cap_cmim l=2.14u w=2.14u
X1480 VSS.t44 VDD.t238 VSS.t44 VSS.t1002 sg13_lv_nmos ad=79.8f pd=0.8u as=0 ps=0 w=0.42u l=1u
X1481 VDD.t562 sar_ctrl_async_phys_0.sg13g2_nand2b_1$1_1.B sar_ctrl_async_phys_0.sg13g2_nand2b_1$1_1.Y VDD.t0 sg13_lv_pmos ad=0.2198p pd=1.53u as=0.2128p ps=1.5u w=1.12u l=0.13u
X1482 oa_sar8_acore18_opt_0.sw_bitcell_opt_term_0.bot.t3 VDD.t900 VDD.t909 VDD.t901 sg13_lv_pmos ad=0.585p pd=3.39u as=1.05p ps=6.7u w=3u l=0.13u
X1483 VSS.t1054 VDD.t80 VSS.t1054 VSS.t179 sg13_lv_nmos ad=0.1428p pd=1.52u as=0 ps=0 w=0.42u l=1u
X1484 VDD.t69 VSS.t851 VDD.t68 VDD.t0 sg13_lv_pmos ad=0.34p pd=2.68u as=0 ps=0 w=1u l=1u
X1485 oa_sar8_acore18_opt_0.sw_tg_opt_0.bot.t3 oa_sar8_acore18_opt_0.sw_bitcell_opt_b7_0.bot.t136 cap_cmim l=2.14u w=2.14u
X1486 VDD.t30 sar_ctrl_async_phys_0.sg13g2_nor2_1$1_5.A a_29084_38484# VDD.t29 sg13_lv_pmos ad=0.4032p pd=2.96u as=0.1176p ps=1.33u w=1.12u l=0.13u
X1487 VSS.t348 VDD.t82 VSS.t344 VSS.t921 sg13_lv_nmos ad=79.8f pd=0.8u as=0 ps=0 w=0.42u l=1u
X1488 VSS.t210 sar_ctrl_async_phys_0.sg13g2_nor2b_1$1_0.A a_34904_38224# VSS.t177 sg13_lv_nmos ad=0.14875p pd=1.16u as=0.187p ps=1.78u w=0.55u l=0.13u
X1489 oa_sar8_acore18_opt_0.sw_bitcell_opt_term_0.VSS sar_ctrl_async_phys_0.dac_code[5] oa_sar8_acore18_opt_0.sw_bitcell_opt_b5_0.bot.t1 VSS.t214 sg13_lv_nmos ad=0.945p pd=6.1u as=0.5265p ps=3.09u w=2.7u l=0.13u
X1490 a_33087_37797# a_32245_37447# a_31828_37440# VDD.t16 sg13_lv_pmos ad=0.2048p pd=1.63u as=0.34p ps=2.68u w=1u l=0.13u
X1491 VDD.t229 VSS.t194 VDD.t229 VDD.t147 sg13_lv_pmos ad=0.34p pd=2.68u as=0 ps=0 w=1u l=1u
X1492 a_29786_33873# a_30229_33629# a_30169_34041# VDD.t147 sg13_lv_pmos ad=79.8f pd=0.8u as=63f ps=0.72u w=0.42u l=0.13u
X1493 a_35330_41210# sar_ctrl_async_phys_0.sg13g2_o21ai_1$1_1.B1.t12 VSS.t87 VSS.t551 sg13_lv_nmos ad=37.8f pd=0.6u as=79.8f ps=0.8u w=0.42u l=0.13u
X1494 VDD.t157 VSS.t51 VDD.t157 VDD.t0 sg13_lv_pmos ad=0.34p pd=2.68u as=0 ps=0 w=1u l=1u
X1495 VSS.t46 VDD.t114 VSS.t46 VSS.t873 sg13_lv_nmos ad=0.1428p pd=1.52u as=0 ps=0 w=0.42u l=1u
X1496 sar_ctrl_async_phys_0.sg13g2_buf_1$1_20.A a_31933_43832# VSS.t137 VSS.t579 sg13_lv_nmos ad=0.2516p pd=2.16u as=0.1331p ps=1.12u w=0.74u l=0.13u
X1497 sar_ctrl_async_phys_0.sg13g2_dlygate4sd3_1$1_6.A a_25990_40484# VDD.t328 VDD.t317 sg13_lv_pmos ad=0.4256p pd=3u as=0.2254p ps=1.53u w=1.12u l=0.13u
X1498 a_35211_37436# sar_ctrl_async_phys_0.sg13g2_and2_1$1_1.B VDD.t362 VDD.t16 sg13_lv_pmos ad=0.3808p pd=2.92u as=0.2128p ps=1.5u w=1.12u l=0.13u
X1499 sar_ctrl_async_phys_0.sg13g2_a21oi_1$1_4.B1 a_34093_42912# VDD.t359 VDD.t22 sg13_lv_pmos ad=0.2128p pd=1.5u as=0.3808p ps=2.92u w=1.12u l=0.13u
X1500 VDD.t157 a_26550_41214# a_26662_41278# VDD.t0 sg13_lv_pmos ad=0.2254p pd=1.53u as=0.34p ps=2.68u w=1u l=0.5u
X1501 oa_sar8_acore18_opt_0.sw_tg_opt_1.bot.t3 oa_sar8_acore18_opt_0.sw_bitcell_opt_b7_1.bot.t142 cap_cmim l=2.14u w=2.14u
X1502 VDD.t238 VSS.t44 VDD.t238 VDD.t147 sg13_lv_pmos ad=0.19p pd=1.38u as=0 ps=0 w=1u l=1u
X1503 oa_sar8_acore18_opt_0.sw_tg_opt_1.bot.t3 oa_sar8_acore18_opt_0.sw_bitcell_opt_b5_1.bot.t30 cap_cmim l=2.14u w=2.14u
X1504 VDD.t19 a_34453_35935# a_34555_35935# VDD.t19 sg13_lv_pmos ad=1.79957p pd=11.62u as=0.3864p ps=2.93u w=1.12u l=0.13u
X1505 VDD.t6 VSS.t786 VDD.t6 VDD.t5 sg13_lv_pmos ad=0.19p pd=1.38u as=0 ps=0 w=1u l=1u
X1506 VSS.t7 a_32991_45357# a_33658_44996# VSS.t1132 sg13_lv_nmos ad=0.1406p pd=1.12u as=0.2516p ps=2.16u w=0.74u l=0.13u
X1507 VDD.t23 VSS.t851 VDD.t24 VDD.t22 sg13_lv_pmos ad=0.34p pd=2.68u as=0 ps=0 w=1u l=1u
X1508 VSS.t118 VDD.t132 VSS.t118 VSS.t746 sg13_lv_nmos ad=0.1428p pd=1.52u as=0 ps=0 w=0.42u l=1u
X1509 VDD.t44 VSS.t739 VDD.t44 VDD.t42 sg13_lv_pmos ad=0.19p pd=1.38u as=0 ps=0 w=1u l=1u
X1510 VSS.t178 a_33936_31675# sar_ctrl_async_phys_0.sg13g2_buf_1$1_8.A VSS.t2 sg13_lv_nmos ad=0.1406p pd=1.12u as=0.2516p ps=2.16u w=0.74u l=0.13u
X1511 VDD.t19 VSS.t270 VDD.t201 VDD.t19 sg13_lv_pmos ad=0.34p pd=2.68u as=0 ps=0 w=1u l=1u
X1512 oa_sar8_acore18_opt_0.sw_tg_opt_0.bot.t3 oa_sar8_acore18_opt_0.sw_bitcell_opt_b6_0.bot.t29 cap_cmim l=2.14u w=2.14u
X1513 oa_sar8_acore18_opt_0.sw_tg_opt_0.bot.t3 oa_sar8_acore18_opt_0.sw_bitcell_opt_b7_0.bot.t99 cap_cmim l=2.14u w=2.14u
X1514 VSS.t351 VDD.t1090 VSS.t901 VSS.t549 sg13_lv_nmos ad=0.1428p pd=1.52u as=0 ps=0 w=0.42u l=1u
X1515 VDD.t328 sar_ctrl_async_phys_0.sg13g2_dlygate4sd3_1$1_7.A a_25608_40501# VDD.t317 sg13_lv_pmos ad=0.1523p pd=1.38u as=0.1428p ps=1.52u w=0.42u l=0.13u
X1516 a_34357_44213# sar_ctrl_async_phys_0.sg13g2_dfrbpq_1$1_0.CLK.t26 VSS.t26 VSS.t493 sg13_lv_nmos ad=0.2516p pd=2.16u as=3.64875p ps=22.56u w=0.74u l=0.13u
X1517 VDD.t25 sar_ctrl_async_phys_0.sg13g2_buf_1$1_41.X a_29594_43452# VDD.t22 sg13_lv_pmos ad=0.1563p pd=1.22u as=0.147p ps=1.54u w=0.42u l=0.13u
X1518 sar_ctrl_async_phys_0.sg13g2_nor2_1$1_13.B sar_ctrl_async_phys_0.sg13g2_nand2b_1$1_0.A_N a_28410_39996# VDD.t317 sg13_lv_pmos ad=0.3808p pd=2.92u as=0.1176p ps=1.33u w=1.12u l=0.13u
X1519 VSS.t99 sar_ctrl_async_phys_0.sg13g2_nand2b_1$1_1.Y a_34328_41972# VSS.t1287 sg13_lv_nmos ad=0.14875p pd=1.16u as=0.187p ps=1.78u w=0.55u l=0.13u
X1520 VDD.t82 sar_ctrl_async_phys_0.sg13g2_o21ai_1$1_1.B1.t2 a_29210_38916# VDD.t29 sg13_lv_pmos ad=0.1563p pd=1.22u as=0.147p ps=1.54u w=0.42u l=0.13u
X1521 w_16692_n9960# a_20412_n9612# cap_cmim l=9.94u w=39.8u
X1522 VSS.t975 VDD.t289 VSS.t975 VSS.t0 sg13_lv_nmos ad=0.1428p pd=1.52u as=0 ps=0 w=0.42u l=1u
X1523 oa_sar8_acore18_opt_0.sw_tg_opt_1.bot.t3 oa_sar8_acore18_opt_0.sw_bitcell_opt_b6_1.bot.t22 cap_cmim l=2.14u w=2.14u
X1524 oa_sar8_acore18_opt_0.sw_tg_opt_1.bot.t3 oa_sar8_acore18_opt_0.sw_bitcell_opt_b6_1.bot.t62 cap_cmim l=2.14u w=2.14u
X1525 VDD.t10 a_34208_45966# a_34153_46061# VDD.t10 sg13_lv_pmos ad=2.2076p pd=14.4u as=93.45f ps=0.865u w=0.42u l=0.13u
X1526 VDD.t147 a_31328_33870# a_31273_33965# VDD.t147 sg13_lv_pmos ad=2.2076p pd=14.4u as=93.45f ps=0.865u w=0.42u l=0.13u
X1527 oa_sar8_acore18_opt_0.sw_tg_opt_1.bot.t3 oa_sar8_acore18_opt_0.sw_bitcell_opt_b7_1.bot.t105 cap_cmim l=2.14u w=2.14u
X1528 a_34319_32120# sar_ctrl_async_phys_0.sg13g2_a22oi_1$1_0.B1 VSS.t178 VSS.t58 sg13_lv_nmos ad=0.13875p pd=1.115u as=0.2553p ps=2.17u w=0.74u l=0.13u
X1529 VSS.t777 VDD.t11 VSS.t777 VSS.t778 sg13_lv_nmos ad=0.1428p pd=1.52u as=0 ps=0 w=0.42u l=1u
X1530 sar_ctrl_async_phys_0.dac_code_n[7] a_34328_41972# VSS.t99 VSS.t611 sg13_lv_nmos ad=0.2886p pd=2.26u as=0.14875p ps=1.16u w=0.74u l=0.13u
X1531 VDD.t169 VSS.t65 VDD.t169 VDD.t16 sg13_lv_pmos ad=0.19p pd=1.38u as=0 ps=0 w=1u l=1u
X1532 oa_sar8_acore18_opt_0.sw_tg_opt_0.bot.t3 oa_sar8_acore18_opt_0.sw_bitcell_opt_b7_0.bot.t110 cap_cmim l=2.14u w=2.14u
X1533 oa_sar8_acore18_opt_0.sw_tg_opt_1.bot.t3 oa_sar8_acore18_opt_0.sw_bitcell_opt_b7_1.bot.t41 cap_cmim l=2.14u w=2.14u
X1534 VDD.t10 a_31381_46519# a_31483_46519# VDD.t10 sg13_lv_pmos ad=2.2076p pd=14.4u as=0.3864p ps=2.93u w=1.12u l=0.13u
X1535 oa_sar8_acore18_opt_0.sw_tg_opt_1.bot.t3 oa_sar8_acore18_opt_0.sw_bitcell_opt_b4_1.bot.t14 cap_cmim l=2.14u w=2.14u
X1536 VSS.t899 a_27530_39666# a_27249_39888# VSS.t103 sg13_lv_nmos ad=79.8f pd=0.8u as=0.1428p ps=1.52u w=0.42u l=0.5u
X1537 VSS.t1091 VDD.t90 VSS.t1090 VSS.t1089 sg13_lv_nmos ad=0.1428p pd=1.52u as=0 ps=0 w=0.42u l=1u
X1538 VSS.t13 a_35648_34654# a_35297_34773# VSS.t21 sg13_lv_nmos ad=79.8f pd=0.8u as=0.1428p ps=1.52u w=0.42u l=0.13u
X1539 VDD.t319 a_35295_36285# a_35962_35924# VDD.t19 sg13_lv_pmos ad=0.2128p pd=1.5u as=0.3864p ps=2.93u w=1.12u l=0.13u
X1540 a_30772_31392# a_31291_31399# a_32031_31749# VSS.t83 sg13_lv_nmos ad=0.3473p pd=2.71u as=0.12665p ps=1.145u w=0.74u l=0.13u
X1541 sar_ctrl_async_phys_0.sg13g2_nor2_1$1_1.Y sar_ctrl_async_phys_0.sg13g2_a22oi_1$1_1.A2 a_34266_38484# VDD.t29 sg13_lv_pmos ad=0.3808p pd=2.92u as=0.1176p ps=1.33u w=1.12u l=0.13u
X1542 VDD.t2 VSS.t313 VDD.t2 VDD.t0 sg13_lv_pmos ad=0.34p pd=2.68u as=0 ps=0 w=1u l=1u
X1543 VDD.t64 VSS.t789 VDD.t51 VDD.t10 sg13_lv_pmos ad=0.19p pd=1.38u as=0 ps=0 w=1u l=1u
X1544 VDD.t19 a_35552_36166# a_35497_36047# VDD.t19 sg13_lv_pmos ad=1.79957p pd=11.62u as=93.45f ps=0.865u w=0.42u l=0.13u
X1545 a_33973_39677# sar_ctrl_async_phys_0.sg13g2_dfrbpq_1$1_0.CLK.t17 VSS.t10 VSS.t9 sg13_lv_nmos ad=0.2516p pd=2.16u as=4.48835p ps=28.62u w=0.74u l=0.13u
X1546 a_35103_43845# a_34261_43495# a_33844_43488# VDD.t22 sg13_lv_pmos ad=0.2048p pd=1.63u as=0.34p ps=2.68u w=1u l=0.13u
X1547 VSS.t1106 VDD.t79 VSS.t1105 VSS.t1104 sg13_lv_nmos ad=0.1428p pd=1.52u as=0 ps=0 w=0.42u l=1u
X1548 VDD.t270 VSS.t970 VDD.t270 VDD.t147 sg13_lv_pmos ad=0.34p pd=2.68u as=0 ps=0 w=1u l=1u
X1549 a_26550_41214# a_26280_41214# VSS.t51 VSS.t659 sg13_lv_nmos ad=0.1428p pd=1.52u as=79.8f ps=0.8u w=0.42u l=0.5u
X1550 VDD.t592 sar_ctrl_async_phys_0.sg13g2_buf_1$1_6.X a_34106_30849# VDD.t3 sg13_lv_pmos ad=0.1563p pd=1.22u as=0.147p ps=1.54u w=0.42u l=0.13u
X1551 oa_sar8_acore18_opt_0.sw_bitcell_opt_b3_0.bot.t1 sar_ctrl_async_phys_0.dac_code[3] oa_sar8_acore18_opt_0.sw_bitcell_opt_term_0.VSS VSS.t303 sg13_lv_nmos ad=0.4095p pd=2.49u as=0.735p ps=4.9u w=2.1u l=0.13u
X1552 a_27894_35924# a_27624_35965# VSS.t146 VSS.t388 sg13_lv_nmos ad=0.1428p pd=1.52u as=79.8f ps=0.8u w=0.42u l=0.5u
X1553 oa_sar8_acore18_opt_0.sw_tg_opt_1.bot.t3 oa_sar8_acore18_opt_0.sw_bitcell_opt_b7_1.bot.t44 cap_cmim l=2.14u w=2.14u
X1554 VDD.t1 a_28662_41214# a_28774_41278# VDD.t0 sg13_lv_pmos ad=0.2254p pd=1.53u as=0.34p ps=2.68u w=1u l=0.5u
X1555 oa_sar8_acore18_opt_0.sw_tg_opt_0.bot.t3 oa_sar8_acore18_opt_0.sw_bitcell_opt_b6_0.bot.t64 cap_cmim l=2.14u w=2.14u
X1556 VSS.t194 a_31071_33727# a_31738_33948# VSS.t176 sg13_lv_nmos ad=0.1406p pd=1.12u as=0.2516p ps=2.16u w=0.74u l=0.13u
X1557 a_34055_31352# a_34615_31475# a_34636_31749# VSS.t2 sg13_lv_nmos ad=0.12665p pd=1.145u as=0.3473p ps=2.71u w=0.74u l=0.13u
X1558 a_34357_44213# sar_ctrl_async_phys_0.sg13g2_dfrbpq_1$1_0.CLK.t26 VDD.t5 VDD.t5 sg13_lv_pmos ad=0.4088p pd=2.97u as=1.79957p ps=11.62u w=1.12u l=0.13u
X1559 VDD.t13 VSS.t819 VDD.t13 VDD.t5 sg13_lv_pmos ad=0.34p pd=2.68u as=0 ps=0 w=1u l=1u
X1560 a_32090_40428# a_32533_40471# a_31830_40898# VSS.t420 sg13_lv_nmos ad=79.8f pd=0.8u as=0.1296p ps=1.52u w=0.42u l=0.13u
X1561 VSS.t851 VDD.t24 VSS.t851 VSS.t853 sg13_lv_nmos ad=0.1428p pd=1.52u as=0 ps=0 w=0.42u l=1u
X1562 VDD.t90 VSS.t1095 VDD.t59 VDD.t3 sg13_lv_pmos ad=0.34p pd=2.68u as=0 ps=0 w=1u l=1u
X1563 sar_ctrl_async_phys_0.dac_code_n[6] a_35672_46508# VSS.t42 VSS.t125 sg13_lv_nmos ad=0.2886p pd=2.26u as=0.14875p ps=1.16u w=0.74u l=0.13u
X1564 a_32692_46064# a_32666_45969# VDD.t184 VDD.t10 sg13_lv_pmos ad=0.34p pd=2.68u as=0.36237p ps=2.605u w=1u l=0.13u
X1565 VDD.t320 sar_ctrl_async_phys_0.sg13g2_dfrbpq_1$1_8.RESET_B a_33818_36897# VDD.t16 sg13_lv_pmos ad=0.1563p pd=1.22u as=0.147p ps=1.54u w=0.42u l=0.13u
X1566 VDD.t132 VSS.t118 VDD.t132 VDD.t42 sg13_lv_pmos ad=0.34p pd=2.68u as=0 ps=0 w=1u l=1u
X1567 a_34228_44247# a_34459_44356# a_33914_44457# VSS.t683 sg13_lv_nmos ad=0.2373p pd=1.97u as=79.8f ps=0.8u w=0.42u l=0.13u
X1568 a_33556_40016# a_33530_39921# VSS.t248 VSS.t398 sg13_lv_nmos ad=0.2516p pd=2.16u as=0.1626p ps=1.415u w=0.74u l=0.13u
X1569 VSS.t46 VDD.t2 VSS.t46 VSS.t872 sg13_lv_nmos ad=79.8f pd=0.8u as=0 ps=0 w=0.42u l=1u
X1570 oa_sar8_acore18_opt_0.sw_tg_opt_0.bot.t3 oa_sar8_acore18_opt_0.sw_bitcell_opt_b6_0.bot.t54 cap_cmim l=2.14u w=2.14u
X1571 a_34847_45366# a_34765_45266# sar_ctrl_async_phys_0.sg13g2_a21oi_1$1_6.B1 VSS.t413 sg13_lv_nmos ad=0.1406p pd=1.12u as=0.333p ps=2.38u w=0.74u l=0.13u
X1572 a_29653_38959# sar_ctrl_async_phys_0.sg13g2_dfrbpq_1$1_0.CLK.t16 VDD.t29 VDD.t29 sg13_lv_pmos ad=0.4088p pd=2.97u as=3.62845p ps=23.965u w=1.12u l=0.13u
X1573 oa_sar8_acore18_opt_0.sw_tg_opt_0.bot.t3 oa_sar8_acore18_opt_0.sw_bitcell_opt_b6_0.bot.t21 cap_cmim l=2.14u w=2.14u
X1574 VDD.t233 VSS.t1 VDD.t233 VDD.t147 sg13_lv_pmos ad=0.34p pd=2.68u as=0 ps=0 w=1u l=1u
X1575 oa_sar8_acore18_opt_0.sw_tg_opt_0.bot.t0 sar_ctrl_async_phys_0.sample vcm VSS.t396 sg13_lv_nmos ad=0.195p pd=1.39u as=0.35p ps=2.7u w=1u l=0.13u
X1576 oa_sar8_acore18_opt_0.sw_bitcell_opt_term_0.bot.t0 oa_sar8_acore18_opt_0.sw_bitcell_opt_term_0.trkb.t12 oa_sar8_acore18_opt_0.sw_bitcell_opt_term_0.vin VDD.t517 sg13_lv_pmos ad=0.39p pd=2.39u as=0.7p ps=4.7u w=2u l=0.13u
X1577 VSS.t1064 VDD.t77 VSS.t1065 VSS.t179 sg13_lv_nmos ad=79.8f pd=0.8u as=0 ps=0 w=0.42u l=1u
X1578 a_35199_44311# a_34357_44213# a_33940_44552# VDD.t5 sg13_lv_pmos ad=0.2048p pd=1.63u as=0.34p ps=2.68u w=1u l=0.13u
X1579 a_33632_40702# sar_ctrl_async_phys_0.sg13g2_o21ai_1$1_1.B1.t7 VDD.t317 VDD.t317 sg13_lv_pmos ad=79.8f pd=0.8u as=1.55472p ps=9.945u w=0.42u l=0.13u
X1580 VSS.t1120 VDD.t4 VSS.t372 VSS.t1119 sg13_lv_nmos ad=0.1428p pd=1.52u as=0 ps=0 w=0.42u l=1u
X1581 VDD.t501 a_33948_41936# sar_ctrl_async_phys_0.sg13g2_o21ai_1$1_1.B1.t0 VDD.t0 sg13_lv_pmos ad=0.2114p pd=1.54u as=0.42p ps=2.99u w=1.12u l=0.13u
X1582 VSS.t583 sar_ctrl_async_phys_0.sg13g2_buf_1$1_2.X.t3 a_30484_36362# VSS.t1241 sg13_lv_nmos ad=0.1626p pd=1.415u as=60.89999f ps=0.71u w=0.42u l=0.13u
X1583 VDD.t146 VSS.t102 VDD.t145 VDD.t16 sg13_lv_pmos ad=0.19p pd=1.38u as=0 ps=0 w=1u l=1u
X1584 VDD.t19 a_32991_35239# a_33248_35382# VDD.t19 sg13_lv_pmos ad=1.79957p pd=11.62u as=79.8f ps=0.8u w=0.42u l=0.13u
X1585 sar_ctrl_async_phys_0.dac_code_n[5] a_36056_47296# VDD.t424 VDD.t42 sg13_lv_pmos ad=0.42p pd=2.99u as=0.2114p ps=1.54u w=1.12u l=0.13u
X1586 a_29908_43909# a_29620_43488# a_29846_43909# VSS.t93 sg13_lv_nmos ad=0.1428p pd=1.52u as=37.8f ps=0.6u w=0.42u l=0.13u
X1587 VDD.t343 sar_ctrl_async_phys_0.sg13g2_a22oi_1$1_1.A2 a_34319_32460# VDD.t76 sg13_lv_pmos ad=0.3808p pd=2.92u as=0.2744p ps=1.61u w=1.12u l=0.13u
X1588 oa_sar8_acore18_opt_0.sw_tg_opt_1.bot.t3 oa_sar8_acore18_opt_0.sw_bitcell_opt_b6_1.bot.t42 cap_cmim l=2.14u w=2.14u
X1589 VDD.t5 a_33248_45238# a_33193_45119# VDD.t5 sg13_lv_pmos ad=1.96315p pd=12.675u as=93.45f ps=0.865u w=0.42u l=0.13u
X1590 a_35018_42726# sar_ctrl_async_phys_0.sg13g2_nand2_1$1_3.A sar_ctrl_async_phys_0.sg13g2_nand2_1$1_3.Y VSS.t149 sg13_lv_nmos ad=0.1406p pd=1.12u as=0.2516p ps=2.16u w=0.74u l=0.13u
X1591 oa_sar8_acore18_opt_0.sw_tg_opt_0.bot.t3 oa_sar8_acore18_opt_0.sw_bitcell_opt_b1_0.bot.t2 cap_cmim l=2.14u w=2.14u
X1592 oa_sar8_acore18_opt_0.sw_tg_opt_1.bot.t3 oa_sar8_acore18_opt_0.sw_bitcell_opt_b7_1.bot.t116 cap_cmim l=2.14u w=2.14u
X1593 VDD.t8 sar_ctrl_async_phys_0.sg13g2_buf_1$1_41.X a_30774_44234# VDD.t5 sg13_lv_pmos ad=0.36237p pd=2.605u as=79.8f ps=0.8u w=0.42u l=0.13u
X1594 a_34815_39775# a_33973_39677# a_33556_40016# VDD.t317 sg13_lv_pmos ad=0.2048p pd=1.63u as=0.34p ps=2.68u w=1u l=0.13u
X1595 VSS.t102 sar_ctrl_async_phys_0.sg13g2_nor2_1$1_8.A sar_ctrl_async_phys_0.sg13g2_inv_1$1_7.A VSS.t1178 sg13_lv_nmos ad=0.2516p pd=2.16u as=0.1406p ps=1.12u w=0.74u l=0.13u
X1596 VSS.t152 sar_ctrl_async_phys_0.sg13g2_a21oi_1$1_4.B1 a_36056_47296# VSS.t41 sg13_lv_nmos ad=0.14875p pd=1.16u as=0.187p ps=1.78u w=0.55u l=0.13u
X1597 VSS.t775 VDD.t11 VSS.t777 VSS.t776 sg13_lv_nmos ad=79.8f pd=0.8u as=0 ps=0 w=0.42u l=1u
X1598 VSS.t1075 VDD.t79 VSS.t1065 VSS.t179 sg13_lv_nmos ad=0.1428p pd=1.52u as=0 ps=0 w=0.42u l=1u
X1599 VDD.t184 VSS.t172 VDD.t64 VDD.t10 sg13_lv_pmos ad=0.34p pd=2.68u as=0 ps=0 w=1u l=1u
X1600 oa_sar8_acore18_opt_0.sw_bitcell_opt_term_0.vin oa_sar8_acore18_opt_0.sw_bitcell_opt_term_0.gb.t10 oa_sar8_acore18_opt_0.sw_bitcell_opt_b5_0.bot.t1 VSS.t1314 sg13_lv_nmos ad=0.35p pd=2.7u as=0.195p ps=1.39u w=1u l=0.13u
X1601 a_33440_32358# a_33183_32215# a_33602_32138# VSS.t58 sg13_lv_nmos ad=0.1428p pd=1.52u as=37.8f ps=0.6u w=0.42u l=0.13u
X1602 VSS.t92 a_35391_33261# a_36058_32900# VSS.t607 sg13_lv_nmos ad=0.1406p pd=1.12u as=0.2516p ps=2.16u w=0.74u l=0.13u
X1603 VSS.t15 VDD.t1086 VSS.t15 VSS.t177 sg13_lv_nmos ad=79.8f pd=0.8u as=0 ps=0 w=0.42u l=1u
X1604 a_31636_37874# sar_ctrl_async_phys_0.sg13g2_nor2b_1$1_0.Y a_31542_37874# VSS.t1176 sg13_lv_nmos ad=60.89999f pd=0.71u as=0.1428p ps=1.52u w=0.42u l=0.13u
X1605 oa_sar8_acore18_opt_0.sw_tg_opt_1.bot.t2 oa_sar8_acore18_opt_0.sw_bitcell_opt_b7_1.bot.t153 cap_cmim l=2.14u w=2.14u
X1606 sar_ctrl_async_phys_0.dac_code[4] a_36056_41972# VDD.t562 VDD.t0 sg13_lv_pmos ad=0.42p pd=2.99u as=0.2114p ps=1.54u w=1.12u l=0.13u
X1607 oa_sar8_acore18_opt_0.sw_tg_opt_1.bot.t3 oa_sar8_acore18_opt_0.sw_bitcell_opt_b6_1.bot.t42 cap_cmim l=2.14u w=2.14u
X1608 a_35810_30626# sar_ctrl_async_phys_0.sg13g2_buf_1$1_6.X VSS.t501 VSS.t601 sg13_lv_nmos ad=37.8f pd=0.6u as=79.8f ps=0.8u w=0.42u l=0.13u
X1609 a_28662_41214# a_28392_41214# VSS.t29 VSS.t429 sg13_lv_nmos ad=0.1428p pd=1.52u as=79.8f ps=0.8u w=0.42u l=0.5u
X1610 sar_ctrl_async_phys_0.sg13g2_buf_1$1_3.A a_35288_38224# VDD.t475 VDD.t29 sg13_lv_pmos ad=0.42p pd=2.99u as=0.2114p ps=1.54u w=1.12u l=0.13u
X1611 VDD.t6 VSS.t783 VDD.t9 VDD.t5 sg13_lv_pmos ad=0.34p pd=2.68u as=0 ps=0 w=1u l=1u
X1612 VDD.t114 sar_ctrl_async_phys_0.sg13g2_o21ai_1$1_1.B1.t13 a_33366_41210# VDD.t0 sg13_lv_pmos ad=0.36237p pd=2.605u as=79.8f ps=0.8u w=0.42u l=0.13u
X1613 sar_ctrl_async_phys_0.sg13g2_a22oi_1$1_1.B2 a_36058_32900# VDD.t394 VDD.t76 sg13_lv_pmos ad=0.3808p pd=2.92u as=0.2128p ps=1.5u w=1.12u l=0.13u
X1614 a_30783_40821# a_29941_40471# a_29524_40464# VDD.t317 sg13_lv_pmos ad=0.2048p pd=1.63u as=0.34p ps=2.68u w=1u l=0.13u
X1615 a_33556_40016# a_33530_39921# VDD.t485 VDD.t317 sg13_lv_pmos ad=0.34p pd=2.68u as=0.36237p ps=2.605u w=1u l=0.13u
X1616 oa_sar8_acore18_opt_0.sw_tg_opt_0.bot.t3 oa_sar8_acore18_opt_0.sw_bitcell_opt_b5_0.bot.t30 cap_cmim l=2.14u w=2.14u
X1617 VDD.t242 VSS.t903 VDD.t262 VDD.t29 sg13_lv_pmos ad=0.34p pd=2.68u as=0 ps=0 w=1u l=1u
X1618 VDD.t5 a_35456_44454# a_35401_44549# VDD.t5 sg13_lv_pmos ad=1.96315p pd=12.675u as=93.45f ps=0.865u w=0.42u l=0.13u
X1619 oa_sar8_acore18_opt_0.sw_tg_opt_1.bot.t3 oa_sar8_acore18_opt_0.sw_bitcell_opt_b3_1.bot.t11 cap_cmim l=2.14u w=2.14u
X1620 VSS.t789 VDD.t6 VSS.t789 VSS.t813 sg13_lv_nmos ad=79.8f pd=0.8u as=0 ps=0 w=0.42u l=1u
X1621 a_35463_31435# sar_ctrl_async_phys_0.sg13g2_buf_1$1_6.X VDD.t329 VDD.t3 sg13_lv_pmos ad=79.8f pd=0.8u as=0.36237p ps=2.605u w=0.42u l=0.13u
X1622 a_35522_36674# sar_ctrl_async_phys_0.sg13g2_dfrbpq_1$1_8.RESET_B VSS.t373 VSS.t275 sg13_lv_nmos ad=37.8f pd=0.6u as=79.8f ps=0.8u w=0.42u l=0.13u
X1623 VDD.t120 sar_ctrl_async_phys_0.sg13g2_and2_1$1_3.A a_26544_38389# VDD.t29 sg13_lv_pmos ad=0.2856p pd=2.36u as=0.1596p ps=1.22u w=0.84u l=0.13u
X1624 a_33049_46137# a_32692_46064# VDD.t176 VDD.t10 sg13_lv_pmos ad=63f pd=0.72u as=0.1563p ps=1.22u w=0.42u l=0.13u
X1625 VDD.t317 sar_ctrl_async_phys_0.sg13g2_nand2_1$1_2.B sar_ctrl_async_phys_0.sg13g2_nand2_1$1_2.Y VDD.t317 sg13_lv_pmos ad=0.3808p pd=2.92u as=0.2128p ps=1.5u w=1.12u l=0.13u
X1626 a_31033_40089# a_30676_40016# VDD.t452 VDD.t317 sg13_lv_pmos ad=63f pd=0.72u as=0.1563p ps=1.22u w=0.42u l=0.13u
X1627 oa_sar8_acore18_opt_0.sw_tg_opt_1.bot.t3 oa_sar8_acore18_opt_0.sw_bitcell_opt_b6_1.bot.t20 cap_cmim l=2.14u w=2.14u
X1628 sar_ctrl_async_phys_0.cmp_p sar_ctrl_async_phys_0.cmp_fire VDD.t442 VDD.t441 sg13_lv_pmos ad=0.7p pd=4.7u as=0.7p ps=4.7u w=2u l=0.13u
X1629 oa_sar8_acore18_opt_0.bstrap_opt_w2_c1200_1.out oa_sar8_acore18_opt_0.sw_bitcell_opt_term_0.trkb.t27 oa_sar8_acore18_opt_0.sw_bitcell_opt_b1_1.bot.t0 VDD.t609 sg13_lv_pmos ad=0.7p pd=4.7u as=0.39p ps=2.39u w=2u l=0.13u
X1630 sar_ctrl_async_phys_0.cmp_fault a_34136_47296# VSS.t126 VSS.t41 sg13_lv_nmos ad=0.2886p pd=2.26u as=0.14875p ps=1.16u w=0.74u l=0.13u
X1631 oa_sar8_acore18_opt_0.bstrap_opt_w2_c1200_1.out oa_sar8_acore18_opt_0.sw_bitcell_opt_term_0.trkb.t24 oa_sar8_acore18_opt_0.sw_bitcell_opt_b4_1.bot.t0 VDD.t780 sg13_lv_pmos ad=0.7p pd=4.7u as=0.39p ps=2.39u w=2u l=0.13u
X1632 VSS.t936 VDD.t169 VSS.t935 VSS.t934 sg13_lv_nmos ad=0.1428p pd=1.52u as=0 ps=0 w=0.42u l=1u
X1633 VDD.t16 a_33087_37797# a_33344_37678# VDD.t16 sg13_lv_pmos ad=2.48357p pd=16.205u as=79.8f ps=0.8u w=0.42u l=0.13u
X1634 VDD.t13 VSS.t818 VDD.t13 VDD.t5 sg13_lv_pmos ad=0.19p pd=1.38u as=0 ps=0 w=1u l=1u
X1635 VSS.t771 VDD.t13 VSS.t770 VSS.t769 sg13_lv_nmos ad=0.1428p pd=1.52u as=0 ps=0 w=0.42u l=1u
X1636 VSS.t851 VDD.t23 VSS.t851 VSS.t852 sg13_lv_nmos ad=79.8f pd=0.8u as=0 ps=0 w=0.42u l=1u
X1637 sar_ctrl_async_phys_0.sg13g2_nor2_1$1_6.B sar_ctrl_async_phys_0.sg13g2_nor2_1$1_6.Y VSS.t102 VSS.t101 sg13_lv_nmos ad=0.1406p pd=1.12u as=0.2516p ps=2.16u w=0.74u l=0.13u
X1638 VDD.t132 VSS.t118 VDD.t132 VDD.t42 sg13_lv_pmos ad=0.19p pd=1.38u as=0 ps=0 w=1u l=1u
X1639 VSS.t443 a_30037_43495# a_30139_43495# VSS.t1294 sg13_lv_nmos ad=4.3785p pd=27.07u as=0.2516p ps=2.16u w=0.74u l=0.13u
X1640 a_33844_43488# a_33818_43452# VDD.t359 VDD.t22 sg13_lv_pmos ad=0.34p pd=2.68u as=0.36237p ps=2.605u w=1u l=0.13u
X1641 VDD.t150 VSS.t48 VDD.t150 VDD.t76 sg13_lv_pmos ad=0.19p pd=1.38u as=0 ps=0 w=1u l=1u
X1642 oa_sar8_acore18_opt_0.sw_bitcell_opt_term_0.vin oa_sar8_acore18_opt_0.sw_bitcell_opt_term_0.gb.t9 oa_sar8_acore18_opt_0.sw_bitcell_opt_b4_0.bot.t1 VSS.t406 sg13_lv_nmos ad=0.35p pd=2.7u as=0.195p ps=1.39u w=1u l=0.13u
X1643 oa_sar8_acore18_opt_0.sw_bitcell_opt_b2_1.bot.t0 sar_ctrl_async_phys_0.dac_code_n[2] oa_sar8_acore18_opt_0.sw_bitcell_opt_b7_1.VSS VSS.t415 sg13_lv_nmos ad=0.3705p pd=2.29u as=0.665p ps=4.5u w=1.9u l=0.13u
X1644 a_29526_33650# a_30331_33772# a_29786_33873# VDD.t147 sg13_lv_pmos ad=0.1428p pd=1.52u as=79.8f ps=0.8u w=0.42u l=0.13u
X1645 a_31732_35480# a_32251_35284# a_32991_35239# VSS.t521 sg13_lv_nmos ad=0.3473p pd=2.71u as=0.12665p ps=1.145u w=0.74u l=0.13u
X1646 VDD.t114 VSS.t898 VDD.t114 VDD.t0 sg13_lv_pmos ad=0.34p pd=2.68u as=0 ps=0 w=1u l=1u
X1647 oa_sar8_acore18_opt_0.sw_tg_opt_1.bot.t3 oa_sar8_acore18_opt_0.sw_bitcell_opt_b7_1.bot.t79 cap_cmim l=2.14u w=2.14u
X1648 a_34228_44247# a_33940_44552# a_34166_44247# VSS.t1180 sg13_lv_nmos ad=0.1428p pd=1.52u as=37.8f ps=0.6u w=0.42u l=0.13u
X1649 a_34010_35892# a_34453_35935# a_34393_35971# VDD.t19 sg13_lv_pmos ad=79.8f pd=0.8u as=63f ps=0.72u w=0.42u l=0.13u
X1650 sar_ctrl_async_phys_0.sg13g2_dlygate4sd3_1$1_6.A a_25990_40484# VSS.t35 VSS.t34 sg13_lv_nmos ad=0.2516p pd=2.16u as=0.1426p ps=1.16u w=0.74u l=0.13u
X1651 oa_sar8_acore18_opt_0.sw_tg_opt_1.bot.t3 oa_sar8_acore18_opt_0.sw_bitcell_opt_b5_1.bot.t2 cap_cmim l=2.14u w=2.14u
X1652 VDD.t359 sar_ctrl_async_phys_0.sg13g2_buf_1$1_37.A sar_ctrl_async_phys_0.sg13g2_a21oi_1$1_4.B1 VDD.t22 sg13_lv_pmos ad=0.2198p pd=1.53u as=0.2128p ps=1.5u w=1.12u l=0.13u
X1653 VSS.t102 VDD.t30 VSS.t102 VSS.t916 sg13_lv_nmos ad=0.1428p pd=1.52u as=0 ps=0 w=0.42u l=1u
X1654 a_30650_39921# a_31093_39677# a_31033_40089# VDD.t317 sg13_lv_pmos ad=79.8f pd=0.8u as=63f ps=0.72u w=0.42u l=0.13u
X1655 a_34319_32460# sar_ctrl_async_phys_0.sg13g2_a22oi_1$1_1.B2 sar_ctrl_async_phys_0.sg13g2_a22oi_1$1_1.Y VDD.t76 sg13_lv_pmos ad=0.2744p pd=1.61u as=0.2128p ps=1.5u w=1.12u l=0.13u
X1656 VSS.t38 a_35199_44311# a_35866_44532# VSS.t60 sg13_lv_nmos ad=0.1406p pd=1.12u as=0.2516p ps=2.16u w=0.74u l=0.13u
X1657 oa_sar8_acore18_opt_0.bstrap_opt_w2_c1200_1.out oa_sar8_acore18_opt_0.bstrap_opt_w2_c1200_1.gb oa_sar8_acore18_opt_0.sw_bitcell_opt_b7_1.bot.t0 VSS.t163 sg13_lv_nmos ad=0.35p pd=2.7u as=0.195p ps=1.39u w=1u l=0.13u
X1658 sar_ctrl_async_phys_0.cmp_valid a_34520_47296# VDD.t175 VDD.t42 sg13_lv_pmos ad=0.42p pd=2.99u as=0.2114p ps=1.54u w=1.12u l=0.13u
X1659 VSS.t890 VDD.t2 VSS.t892 VSS.t891 sg13_lv_nmos ad=79.8f pd=0.8u as=0 ps=0 w=0.42u l=1u
X1660 VDD.t3 a_32031_31749# a_32288_31630# VDD.t3 sg13_lv_pmos ad=1.96315p pd=12.675u as=79.8f ps=0.8u w=0.42u l=0.13u
X1661 VDD.t270 VSS.t975 VDD.t270 VDD.t147 sg13_lv_pmos ad=0.34p pd=2.68u as=0 ps=0 w=1u l=1u
X1662 VSS.t79 a_34815_39775# a_35482_39996# VSS.t298 sg13_lv_nmos ad=0.1406p pd=1.12u as=0.2516p ps=2.16u w=0.74u l=0.13u
X1663 VSS.t1111 VDD.t79 VSS.t1110 VSS.t1109 sg13_lv_nmos ad=0.1428p pd=1.52u as=0 ps=0 w=0.42u l=1u
X1664 oa_sar8_acore18_opt_0.sw_bitcell_opt_b6_0.bot.t0 oa_sar8_acore18_opt_0.sw_bitcell_opt_term_0.gb.t11 oa_sar8_acore18_opt_0.sw_bitcell_opt_term_0.vin VSS.t407 sg13_lv_nmos ad=0.195p pd=1.39u as=0.35p ps=2.7u w=1u l=0.13u
X1665 VDD.t121 VSS.t1006 VDD.t121 VDD.t76 sg13_lv_pmos ad=0.34p pd=2.68u as=0 ps=0 w=1u l=1u
X1666 oa_sar8_acore18_opt_0.sw_tg_opt_0.bot.t2 oa_sar8_acore18_opt_0.sw_bitcell_opt_b7_0.bot.t162 cap_cmim l=2.14u w=2.14u
X1667 a_35714_36362# sar_ctrl_async_phys_0.sg13g2_dfrbpq_1$1_3.RESET_B VSS.t373 VSS.t369 sg13_lv_nmos ad=37.8f pd=0.6u as=79.8f ps=0.8u w=0.42u l=0.13u
X1668 oa_sar8_acore18_opt_0.sw_tg_opt_0.bot.t3 oa_sar8_acore18_opt_0.sw_bitcell_opt_b7_0.bot.t141 cap_cmim l=2.14u w=2.14u
X1669 a_35463_31435# a_34767_31359# a_35557_31435# VSS.t1148 sg13_lv_nmos ad=0.1296p pd=1.52u as=79.8f ps=0.8u w=0.42u l=0.13u
X1670 sar_ctrl_async_phys_0.bit_active[2] a_34808_35200# VSS.t33 VSS.t32 sg13_lv_nmos ad=0.2886p pd=2.26u as=0.14875p ps=1.16u w=0.74u l=0.13u
X1671 oa_sar8_acore18_opt_0.sw_tg_opt_0.bot.t3 oa_sar8_acore18_opt_0.sw_bitcell_opt_b5_0.bot.t30 cap_cmim l=2.14u w=2.14u
X1672 oa_sar8_acore18_opt_0.sw_tg_opt_1.bot.t0 sar_ctrl_async_phys_0.sample vcm VSS.t395 sg13_lv_nmos ad=0.195p pd=1.39u as=0.35p ps=2.7u w=1u l=0.13u
X1673 VSS.t65 VDD.t191 VSS.t65 VSS.t911 sg13_lv_nmos ad=79.8f pd=0.8u as=0 ps=0 w=0.42u l=1u
X1674 result[5] a_34136_33688# VSS.t260 VSS.t267 sg13_lv_nmos ad=0.2886p pd=2.26u as=0.14875p ps=1.16u w=0.74u l=0.13u
X1675 a_34453_35935# sar_ctrl_async_phys_0.sg13g2_dfrbpq_1$1_0.CLK.t10 VSS.t587 VSS.t292 sg13_lv_nmos ad=0.2516p pd=2.16u as=4.1082p ps=26.51u w=0.74u l=0.13u
X1676 VSS.t126 sar_ctrl_async_phys_0.sg13g2_nor4_1$1_0.C a_34520_47296# VSS.t41 sg13_lv_nmos ad=0.14875p pd=1.16u as=0.187p ps=1.78u w=0.55u l=0.13u
X1677 VSS.t111 VDD.t154 VSS.t111 VSS.t863 sg13_lv_nmos ad=79.8f pd=0.8u as=0 ps=0 w=0.42u l=1u
X1678 a_34815_39775# a_33973_39677# a_34721_39775# VSS.t11 sg13_lv_nmos ad=0.12665p pd=1.145u as=0.1428p ps=1.52u w=0.42u l=0.13u
X1679 VDD.t82 VSS.t102 VDD.t82 VDD.t29 sg13_lv_pmos ad=0.19p pd=1.38u as=0 ps=0 w=1u l=1u
X1680 VDD.t4 sar_ctrl_async_phys_0.sg13g2_buf_1$1_6.X a_30746_31356# VDD.t3 sg13_lv_pmos ad=0.1563p pd=1.22u as=0.147p ps=1.54u w=0.42u l=0.13u
X1681 VDD.t233 VSS.t979 VDD.t233 VDD.t147 sg13_lv_pmos ad=0.34p pd=2.68u as=0 ps=0 w=1u l=1u
X1682 a_31732_35480# a_31706_35385# VDD.t20 VDD.t19 sg13_lv_pmos ad=0.34p pd=2.68u as=0.36237p ps=2.605u w=1u l=0.13u
X1683 a_34554_40460# sar_ctrl_async_phys_0.sg13g2_nor2b_1$1_0.A sar_ctrl_async_phys_0.sg13g2_nor2b_1$1_3.Y VDD.t317 sg13_lv_pmos ad=0.1176p pd=1.33u as=0.3808p ps=2.92u w=1.12u l=0.13u
X1684 sar_ctrl_async_phys_0.sg13g2_a22oi_1$1_3.A2 sar_ctrl_async_phys_0.sg13g2_a21oi_1$1_3.B1 VSS.t87 VSS.t657 sg13_lv_nmos ad=0.1406p pd=1.12u as=0.2516p ps=2.16u w=0.74u l=0.13u
X1685 VSS.t194 VDD.t229 VSS.t194 VSS.t176 sg13_lv_nmos ad=0.1428p pd=1.52u as=0 ps=0 w=0.42u l=1u
X1686 VSS.t46 VDD.t114 VSS.t46 VSS.t874 sg13_lv_nmos ad=79.8f pd=0.8u as=0 ps=0 w=0.42u l=1u
X1687 VSS.t344 VDD.t18 VSS.t344 VSS.t933 sg13_lv_nmos ad=79.8f pd=0.8u as=0 ps=0 w=0.42u l=1u
X1688 oa_sar8_acore18_opt_0.sw_tg_opt_1.bot.t3 oa_sar8_acore18_opt_0.sw_bitcell_opt_b5_1.bot.t35 cap_cmim l=2.14u w=2.14u
X1689 VDD.t991 sar_ctrl_async_phys_0.dac_code_n[3] oa_sar8_acore18_opt_0.sw_bitcell_opt_b3_1.bot.t17 VDD.t990 sg13_lv_pmos ad=1.47p pd=9.1u as=0.819p ps=4.59u w=4.2u l=0.13u
X1690 a_34132_43909# a_34363_43495# a_33818_43452# VSS.t1290 sg13_lv_nmos ad=0.2373p pd=1.97u as=79.8f ps=0.8u w=0.42u l=0.13u
X1691 a_34549_30605# sar_ctrl_async_phys_0.sg13g2_dfrbpq_1$1_0.CLK.t1 VSS.t290 VSS.t289 sg13_lv_nmos ad=0.2516p pd=2.16u as=8.77817p ps=57.305u w=0.74u l=0.13u
X1692 VDD.t49 VSS.t780 VDD.t51 VDD.t10 sg13_lv_pmos ad=0.34p pd=2.68u as=0 ps=0 w=1u l=1u
X1693 a_33558_43922# sar_ctrl_async_phys_0.sg13g2_nor2_1$1_2.Y VDD.t359 VDD.t22 sg13_lv_pmos ad=79.8f pd=0.8u as=0.1428p ps=1.52u w=0.42u l=0.13u
X1694 VDD.t100 VSS.t894 VDD.t2 VDD.t0 sg13_lv_pmos ad=0.34p pd=2.68u as=0 ps=0 w=1u l=1u
X1695 sar_ctrl_async_phys_0.sg13g2_buf_1$1_15.A a_33085_43832# VSS.t128 VSS.t1195 sg13_lv_nmos ad=0.2516p pd=2.16u as=0.1331p ps=1.12u w=0.74u l=0.13u
X1696 VSS.t15 sar_ctrl_async_phys_0.sg13g2_a22oi_1$1_1.A2 sar_ctrl_async_phys_0.sg13g2_nor2_1$1_1.Y VSS.t177 sg13_lv_nmos ad=0.2516p pd=2.16u as=0.1406p ps=1.12u w=0.74u l=0.13u
X1697 vinn oa_sar8_acore18_opt_0.sw_bitcell_opt_term_0.gb.t0 a_35948_n9612# VSS.t1181 sg13_lv_nmos ad=0.345p pd=2.69u as=0.19p ps=1.38u w=1u l=0.15u
X1698 oa_sar8_acore18_opt_0.sw_bitcell_opt_term_0.vin oa_sar8_acore18_opt_0.sw_bitcell_opt_term_0.gb.t5 oa_sar8_acore18_opt_0.sw_bitcell_opt_b0_0.bot.t2 VSS.t591 sg13_lv_nmos ad=0.35p pd=2.7u as=0.195p ps=1.39u w=1u l=0.13u
X1699 VSS.t362 sar_ctrl_async_phys_0.sg13g2_nand2b_1$1_0.A_N sar_ctrl_async_phys_0.sg13g2_nor2_1$1_13.B VSS.t103 sg13_lv_nmos ad=0.2516p pd=2.16u as=0.1406p ps=1.12u w=0.74u l=0.13u
X1700 oa_sar8_acore18_opt_0.sw_tg_opt_0.bot.t3 oa_sar8_acore18_opt_0.sw_bitcell_opt_b6_0.bot.t44 cap_cmim l=2.14u w=2.14u
X1701 a_31007_35460# sar_ctrl_async_phys_0.sg13g2_a21oi_1$1_2.Y a_30830_35166# VDD.t19 sg13_lv_pmos ad=0.2975p pd=1.595u as=0.2225p ps=1.445u w=1u l=0.13u
X1702 oa_sar8_acore18_opt_0.sw_tg_opt_1.bot.t3 oa_sar8_acore18_opt_0.sw_bitcell_opt_b7_1.bot.t132 cap_cmim l=2.14u w=2.14u
X1703 VSS.t99 VDD.t114 VSS.t99 VSS.t880 sg13_lv_nmos ad=79.8f pd=0.8u as=0 ps=0 w=0.42u l=1u
X1704 oa_sar8_acore18_opt_0.sw_tg_opt_1.bot.t3 oa_sar8_acore18_opt_0.sw_bitcell_opt_b7_1.bot.t69 cap_cmim l=2.14u w=2.14u
X1705 VSS.t1125 VDD.t4 VSS.t1124 VSS.t1123 sg13_lv_nmos ad=0.1428p pd=1.52u as=0 ps=0 w=0.42u l=1u
X1706 sar_ctrl_async_phys_0.sg13g2_nor2_1$1_14.A sar_ctrl_async_phys_0.sg13g2_nand3_1$1_0.Y a_27206_39326# VSS.t103 sg13_lv_nmos ad=0.2516p pd=2.16u as=0.1406p ps=1.12u w=0.74u l=0.15u
X1707 oa_sar8_acore18_opt_0.sw_tg_opt_0.bot.t3 oa_sar8_acore18_opt_0.sw_bitcell_opt_b7_0.bot.t104 cap_cmim l=2.14u w=2.14u
X1708 result[0] a_33080_30664# VSS.t311 VSS.t410 sg13_lv_nmos ad=0.2886p pd=2.26u as=0.14875p ps=1.16u w=0.74u l=0.13u
X1709 a_34106_34380# a_34549_34423# a_33846_34850# VSS.t18 sg13_lv_nmos ad=79.8f pd=0.8u as=0.1296p ps=1.52u w=0.42u l=0.13u
X1710 oa_sar8_acore18_opt_0.sw_tg_opt_0.bot.t3 oa_sar8_acore18_opt_0.sw_bitcell_opt_b7_0.bot.t30 cap_cmim l=2.14u w=2.14u
X1711 a_35664_37695# sar_ctrl_async_phys_0.sg13g2_and2_1$1_1.B VDD.t362 VDD.t16 sg13_lv_pmos ad=0.1596p pd=1.22u as=0.1918p ps=1.5u w=0.84u l=0.13u
X1712 oa_sar8_acore18_opt_0.sw_bitcell_opt_term_0.vin oa_sar8_acore18_opt_0.sw_bitcell_opt_term_0.gb.t8 oa_sar8_acore18_opt_0.sw_bitcell_opt_b3_0.bot.t1 VSS.t1316 sg13_lv_nmos ad=0.35p pd=2.7u as=0.195p ps=1.39u w=1u l=0.13u
X1713 a_31060_44552# a_31034_44457# VDD.t8 VDD.t5 sg13_lv_pmos ad=0.34p pd=2.68u as=0.36237p ps=2.605u w=1u l=0.13u
X1714 a_31947_41508# sar_ctrl_async_phys_0.sg13g2_nand2b_1$1_3.Y sar_ctrl_async_phys_0.sg13g2_a21oi_1$1_5.Y VDD.t0 sg13_lv_pmos ad=0.2128p pd=1.5u as=0.3808p ps=2.92u w=1.12u l=0.13u
X1715 VDD.t326 a_30783_40821# a_31450_40460# VDD.t317 sg13_lv_pmos ad=0.2128p pd=1.5u as=0.3864p ps=2.93u w=1.12u l=0.13u
X1716 VDD.t18 VSS.t344 VDD.t18 VDD.t16 sg13_lv_pmos ad=0.19p pd=1.38u as=0 ps=0 w=1u l=1u
X1717 oa_sar8_acore18_opt_0.sw_tg_opt_1.bot.t3 oa_sar8_acore18_opt_0.sw_bitcell_opt_b7_1.bot.t22 cap_cmim l=2.14u w=2.14u
X1718 sar_ctrl_async_phys_0.sg13g2_nand2_1$1_2.B a_34042_40460# VDD.t392 VDD.t317 sg13_lv_pmos ad=0.3808p pd=2.92u as=0.2128p ps=1.5u w=1.12u l=0.13u
X1719 oa_sar8_acore18_opt_0.sw_tg_opt_0.bot.t2 oa_sar8_acore18_opt_0.sw_bitcell_opt_b7_0.bot.t167 cap_cmim l=2.14u w=2.14u
X1720 sar_ctrl_async_phys_0.sg13g2_a22oi_1$1_2.B2 a_32698_31388# VSS.t212 VSS.t211 sg13_lv_nmos ad=0.2516p pd=2.16u as=0.1406p ps=1.12u w=0.74u l=0.13u
X1721 VSS.t963 VDD.t20 VSS.t340 VSS.t964 sg13_lv_nmos ad=79.8f pd=0.8u as=0 ps=0 w=0.42u l=1u
X1722 VDD.t156 sar_ctrl_async_phys_0.sg13g2_dlygate4sd3_1$1_8.X a_26280_41214# VDD.t0 sg13_lv_pmos ad=0.1523p pd=1.38u as=0.1428p ps=1.52u w=0.42u l=0.13u
X1723 oa_sar8_acore18_opt_0.sw_tg_opt_1.bot.t3 oa_sar8_acore18_opt_0.sw_bitcell_opt_b7_1.bot.t128 cap_cmim l=2.14u w=2.14u
X1724 a_34132_30944# a_34106_30849# VSS.t311 VSS.t690 sg13_lv_nmos ad=0.2516p pd=2.16u as=0.1626p ps=1.415u w=0.74u l=0.13u
X1725 sar_ctrl_async_phys_0.bit_active[3] a_35672_35200# VDD.t319 VDD.t19 sg13_lv_pmos ad=0.42p pd=2.99u as=0.2114p ps=1.54u w=1.12u l=0.13u
X1726 a_32192_39918# sar_ctrl_async_phys_0.sg13g2_o21ai_1$1_1.B1.t5 VDD.t317 VDD.t317 sg13_lv_pmos ad=79.8f pd=0.8u as=1.55472p ps=9.945u w=0.42u l=0.13u
X1727 VSS.t10 a_33973_39677# a_34075_39820# VSS.t9 sg13_lv_nmos ad=5.61045p pd=35.775u as=0.2516p ps=2.16u w=0.74u l=0.13u
X1728 VSS.t455 VDD.t79 VSS.t23 VSS.t1077 sg13_lv_nmos ad=0.1428p pd=1.52u as=0 ps=0 w=0.42u l=1u
X1729 VDD.t326 sar_ctrl_async_phys_0.sg13g2_o21ai_1$1_1.B1.t8 a_32090_40428# VDD.t317 sg13_lv_pmos ad=0.1563p pd=1.22u as=0.147p ps=1.54u w=0.42u l=0.13u
X1730 oa_sar8_acore18_opt_0.sw_tg_opt_0.bot.t3 oa_sar8_acore18_opt_0.sw_bitcell_opt_b7_0.bot.t115 cap_cmim l=2.14u w=2.14u
X1731 VSS.t970 VDD.t270 VSS.t970 VSS.t0 sg13_lv_nmos ad=79.8f pd=0.8u as=0 ps=0 w=0.42u l=1u
X1732 a_33410_45434# sar_ctrl_async_phys_0.sg13g2_buf_1$1_41.X VSS.t7 VSS.t123 sg13_lv_nmos ad=37.8f pd=0.6u as=79.8f ps=0.8u w=0.42u l=0.13u
X1733 oa_sar8_acore18_opt_0.sw_tg_opt_0.bot.t3 oa_sar8_acore18_opt_0.sw_bitcell_opt_b4_0.bot.t24 cap_cmim l=2.14u w=2.14u
X1734 oa_sar8_acore18_opt_0.sw_tg_opt_1.bot.t3 oa_sar8_acore18_opt_0.sw_bitcell_opt_b7_1.bot.t90 cap_cmim l=2.14u w=2.14u
X1735 a_34636_31749# a_34767_31359# a_34055_31352# VDD.t3 sg13_lv_pmos ad=0.34p pd=2.68u as=0.2048p ps=1.63u w=1u l=0.13u
X1736 a_31542_37874# a_32347_37447# a_31802_37404# VDD.t16 sg13_lv_pmos ad=0.1428p pd=1.52u as=79.8f ps=0.8u w=0.42u l=0.13u
X1737 VDD.t19 sar_ctrl_async_phys_0.sg13g2_nor2b_1$1_1.B_N a_34808_35200# VDD.t19 sg13_lv_pmos ad=0.2114p pd=1.54u as=0.2856p ps=2.36u w=0.84u l=0.13u
X1738 VSS.t890 VDD.t2 VSS.t889 VSS.t888 sg13_lv_nmos ad=0.1428p pd=1.52u as=0 ps=0 w=0.42u l=1u
X1739 oa_sar8_acore18_opt_0.sw_tg_opt_1.bot.t3 oa_sar8_acore18_opt_0.sw_bitcell_opt_b7_1.bot.t48 cap_cmim l=2.14u w=2.14u
X1740 VSS.t946 VDD.t159 VSS.t945 VSS.t944 sg13_lv_nmos ad=0.1428p pd=1.52u as=0 ps=0 w=0.42u l=1u
X1741 a_31321_46555# a_30964_46512# VDD.t64 VDD.t10 sg13_lv_pmos ad=63f pd=0.72u as=0.1563p ps=1.22u w=0.42u l=0.13u
X1742 VDD.t6 VSS.t786 VDD.t6 VDD.t5 sg13_lv_pmos ad=0.34p pd=2.68u as=0 ps=0 w=1u l=1u
X1743 VDD.t270 VSS.t1014 VDD.t270 VDD.t147 sg13_lv_pmos ad=0.19p pd=1.38u as=0 ps=0 w=1u l=1u
X1744 VDD.t43 VSS.t730 VDD.t43 VDD.t42 sg13_lv_pmos ad=0.19p pd=1.38u as=0 ps=0 w=1u l=1u
X1745 VDD.t33 VSS.t823 VDD.t33 VDD.t22 sg13_lv_pmos ad=0.19p pd=1.38u as=0 ps=0 w=1u l=1u
X1746 a_30484_36362# sar_ctrl_async_phys_0.sg13g2_a22oi_1$1_0.B1 a_30390_36362# VSS.t480 sg13_lv_nmos ad=60.89999f pd=0.71u as=0.1428p ps=1.52u w=0.42u l=0.13u
X1747 a_30879_43845# a_30037_43495# a_29620_43488# VDD.t22 sg13_lv_pmos ad=0.2048p pd=1.63u as=0.34p ps=2.68u w=1u l=0.13u
X1748 oa_sar8_acore18_opt_0.sw_bitcell_opt_term_0.vin oa_sar8_acore18_opt_0.sw_bitcell_opt_term_0.gb.t12 oa_sar8_acore18_opt_0.sw_bitcell_opt_b7_0.bot.t1 VSS.t1315 sg13_lv_nmos ad=0.35p pd=2.7u as=0.195p ps=1.39u w=1u l=0.13u
X1749 VSS.t786 VDD.t51 VSS.t789 VSS.t788 sg13_lv_nmos ad=79.8f pd=0.8u as=0 ps=0 w=0.42u l=1u
X1750 VSS.t979 VDD.t148 VSS.t979 VSS.t0 sg13_lv_nmos ad=79.8f pd=0.8u as=0 ps=0 w=0.42u l=1u
X1751 VSS.t102 VDD.t120 VSS.t102 VSS.t915 sg13_lv_nmos ad=79.8f pd=0.8u as=0 ps=0 w=0.42u l=1u
X1752 a_33844_43488# a_34363_43495# a_35103_43845# VSS.t1291 sg13_lv_nmos ad=0.3473p pd=2.71u as=0.12665p ps=1.145u w=0.74u l=0.13u
X1753 a_34549_30605# sar_ctrl_async_phys_0.sg13g2_dfrbpq_1$1_0.CLK.t1 VDD.t3 VDD.t3 sg13_lv_pmos ad=0.4088p pd=2.97u as=1.79957p ps=11.62u w=1.12u l=0.13u
X1754 a_34153_46061# a_33211_45868# a_33951_45823# VDD.t10 sg13_lv_pmos ad=93.45f pd=0.865u as=0.2048p ps=1.63u w=0.42u l=0.13u
X1755 VSS.t825 VDD.t15 VSS.t826 VSS.t224 sg13_lv_nmos ad=79.8f pd=0.8u as=0 ps=0 w=0.42u l=1u
X1756 a_31273_33965# a_30331_33772# a_31071_33727# VDD.t147 sg13_lv_pmos ad=93.45f pd=0.865u as=0.2048p ps=1.63u w=0.42u l=0.13u
X1757 a_25596_47222# sar_ctrl_async_phys_0.sg13g2_buf_1$1_29.X VDD.t43 VDD.t42 sg13_lv_pmos ad=0.2856p pd=2.36u as=0.2114p ps=1.54u w=0.84u l=0.13u
X1758 a_32666_45969# a_33109_45725# a_32406_45746# VSS.t1140 sg13_lv_nmos ad=79.8f pd=0.8u as=0.1296p ps=1.52u w=0.42u l=0.13u
X1759 oa_sar8_acore18_opt_0.sw_bitcell_opt_b7_1.VSS sar_ctrl_async_phys_0.dac_code_n[0] oa_sar8_acore18_opt_0.sw_bitcell_opt_b0_1.bot.t0 VSS.t356 sg13_lv_nmos ad=0.525p pd=3.7u as=0.2925p ps=1.89u w=1.5u l=0.13u
X1760 a_30964_36349# a_31195_35935# a_30650_35892# VSS.t622 sg13_lv_nmos ad=0.2373p pd=1.97u as=79.8f ps=0.8u w=0.42u l=0.13u
X1761 VDD.t25 VSS.t831 VDD.t25 VDD.t22 sg13_lv_pmos ad=0.19p pd=1.38u as=0 ps=0 w=1u l=1u
X1762 a_29846_43909# sar_ctrl_async_phys_0.sg13g2_buf_1$1_41.X VSS.t120 VSS.t141 sg13_lv_nmos ad=37.8f pd=0.6u as=0.1701p ps=1.65u w=0.42u l=0.13u
X1763 VDD.t317 a_33375_40821# a_33632_40702# VDD.t317 sg13_lv_pmos ad=1.6658p pd=10.66u as=79.8f ps=0.8u w=0.42u l=0.13u
X1764 VDD.t394 sar_ctrl_async_phys_0.sg13g2_buf_1$1_7.A a_36056_32176# VDD.t76 sg13_lv_pmos ad=0.2114p pd=1.54u as=0.2856p ps=2.36u w=0.84u l=0.13u
X1765 sar_ctrl_async_phys_0.sg13g2_nor2_1$1_5.A sar_ctrl_async_phys_0.sg13g2_and2_1$1_0.A VSS.t104 VSS.t103 sg13_lv_nmos ad=0.2516p pd=2.16u as=0.2516p ps=2.16u w=0.74u l=0.13u
X1766 oa_sar8_acore18_opt_0.sw_tg_opt_0.bot.t3 oa_sar8_acore18_opt_0.sw_bitcell_opt_b6_0.bot.t69 cap_cmim l=2.14u w=2.14u
X1767 a_32149_35141# sar_ctrl_async_phys_0.sg13g2_dfrbpq_1$1_0.CLK.t9 VDD.t19 VDD.t19 sg13_lv_pmos ad=0.4088p pd=2.97u as=1.66112p ps=10.725u w=1.12u l=0.13u
X1768 sar_ctrl_async_phys_0.bit_active[5] a_36056_37436# VSS.t114 VSS.t14 sg13_lv_nmos ad=0.2886p pd=2.26u as=0.14875p ps=1.16u w=0.74u l=0.13u
X1769 oa_sar8_acore18_opt_0.sw_tg_opt_1.bot.t3 oa_sar8_acore18_opt_0.sw_bitcell_opt_b3_1.bot.t7 cap_cmim l=2.14u w=2.14u
X1770 oa_sar8_acore18_opt_0.sw_tg_opt_0.bot.t2 oa_sar8_acore18_opt_0.sw_bitcell_opt_b7_0.bot.t149 cap_cmim l=2.14u w=2.14u
X1771 VDD.t238 VSS.t260 VDD.t238 VDD.t147 sg13_lv_pmos ad=0.34p pd=2.68u as=0 ps=0 w=1u l=1u
X1772 VSS.t431 VDD.t258 VSS.t237 VSS.t74 sg13_lv_nmos ad=0.1428p pd=1.52u as=0 ps=0 w=0.42u l=1u
X1773 a_31060_44552# a_31034_44457# VSS.t133 VSS.t301 sg13_lv_nmos ad=0.2516p pd=2.16u as=0.1626p ps=1.415u w=0.74u l=0.13u
X1774 VSS.t31 a_30783_40821# a_31450_40460# VSS.t30 sg13_lv_nmos ad=0.1406p pd=1.12u as=0.2516p ps=2.16u w=0.74u l=0.13u
X1775 VDD.t678 sar_ctrl_async_phys_0.sg13g2_nand2_1$1_2.Y a_35672_38948# VDD.t29 sg13_lv_pmos ad=0.2114p pd=1.54u as=0.2856p ps=2.36u w=0.84u l=0.13u
X1776 a_35552_36166# a_35295_36285# a_35714_36362# VSS.t369 sg13_lv_nmos ad=0.1428p pd=1.52u as=37.8f ps=0.6u w=0.42u l=0.13u
X1777 VDD.t219 sar_ctrl_async_phys_0.sg13g2_and2_1$1_0.A a_31933_43832# VDD.t22 sg13_lv_pmos ad=0.1918p pd=1.5u as=0.1596p ps=1.22u w=0.84u l=0.13u
X1778 a_29238_40898# sar_ctrl_async_phys_0.sg13g2_nor2_1$1_11.Y VDD.t361 VDD.t317 sg13_lv_pmos ad=79.8f pd=0.8u as=0.1428p ps=1.52u w=0.42u l=0.13u
X1779 sar_ctrl_async_phys_0.sg13g2_nand2_1$1_2.B a_34042_40460# VSS.t113 VSS.t112 sg13_lv_nmos ad=0.2516p pd=2.16u as=0.1406p ps=1.12u w=0.74u l=0.13u
X1780 sar_ctrl_async_phys_0.sg13g2_a22oi_1$1_0.B1 a_31832_34412# VDD.t229 VDD.t147 sg13_lv_pmos ad=0.42p pd=2.99u as=0.2114p ps=1.54u w=1.12u l=0.13u
X1781 VDD.t33 a_26570_42690# a_26289_42912# VDD.t22 sg13_lv_pmos ad=0.1523p pd=1.38u as=0.34p ps=2.68u w=1u l=0.5u
X1782 VSS.t206 a_32149_35141# a_32251_35284# VSS.t205 sg13_lv_nmos ad=6.27915p pd=40.31u as=0.2516p ps=2.16u w=0.74u l=0.13u
X1783 VDD.t132 VSS.t118 VDD.t132 VDD.t42 sg13_lv_pmos ad=0.19p pd=1.38u as=0 ps=0 w=1u l=1u
X1784 VSS.t649 sar_ctrl_async_phys_0.sg13g2_and2_1$1_3.X a_27206_39326# VSS.t103 sg13_lv_nmos ad=0.1406p pd=1.12u as=0.2516p ps=2.16u w=0.74u l=0.15u
X1785 oa_sar8_acore18_opt_0.sw_tg_opt_1.bot.t3 oa_sar8_acore18_opt_0.sw_bitcell_opt_b6_1.bot.t50 cap_cmim l=2.14u w=2.14u
X1786 VSS.t51 a_26954_40424# a_26673_40726# VSS.t50 sg13_lv_nmos ad=79.8f pd=0.8u as=0.1428p ps=1.52u w=0.42u l=0.5u
X1787 VSS.t827 VDD.t23 VSS.t828 VSS.t224 sg13_lv_nmos ad=79.8f pd=0.8u as=0 ps=0 w=0.42u l=1u
X1788 a_30495_39309# a_29653_38959# a_29236_38952# VDD.t29 sg13_lv_pmos ad=0.2048p pd=1.63u as=0.34p ps=2.68u w=1u l=0.13u
X1789 VDD.t926 sar_ctrl_async_phys_0.sg13g2_nor2_1$1_18.A a_32156_38948# VDD.t29 sg13_lv_pmos ad=0.4032p pd=2.96u as=0.1176p ps=1.33u w=1.12u l=0.13u
X1790 a_35948_n9612# oa_sar8_acore18_opt_0.sw_bitcell_opt_term_0.gb.t0 vinn VSS.t1181 sg13_lv_nmos ad=0.19p pd=1.38u as=0.345p ps=2.69u w=1u l=0.15u
X1791 VDD.t64 VSS.t118 VDD.t64 VDD.t10 sg13_lv_pmos ad=0.19p pd=1.38u as=0 ps=0 w=1u l=1u
X1792 VSS.t99 a_33948_41936# sar_ctrl_async_phys_0.sg13g2_o21ai_1$1_1.B1 VSS.t380 sg13_lv_nmos ad=0.14875p pd=1.16u as=0.2886p ps=2.26u w=0.74u l=0.13u
X1793 oa_sar8_acore18_opt_0.sw_tg_opt_0.bot.t3 oa_sar8_acore18_opt_0.sw_bitcell_opt_b7_0.bot.t22 cap_cmim l=2.14u w=2.14u
X1794 VDD.t219 a_33276_42686# sar_ctrl_async_phys_0.sg13g2_buf_1$1_37.A VDD.t22 sg13_lv_pmos ad=0.2114p pd=1.54u as=0.42p ps=2.99u w=1.12u l=0.13u
X1795 VDD.t9 VSS.t829 VDD.t9 VDD.t5 sg13_lv_pmos ad=0.19p pd=1.38u as=0 ps=0 w=1u l=1u
X1796 a_28368_36877# sar_ctrl_async_phys_0.sg13g2_nand2_1$1_1.B VDD.t146 VDD.t16 sg13_lv_pmos ad=0.1596p pd=1.22u as=0.1918p ps=1.5u w=0.84u l=0.13u
X1797 oa_sar8_acore18_opt_0.sw_bitcell_opt_b1_1.bot.t0 oa_sar8_acore18_opt_0.sw_bitcell_opt_term_0.trkb.t27 oa_sar8_acore18_opt_0.bstrap_opt_w2_c1200_1.out VDD.t609 sg13_lv_pmos ad=0.39p pd=2.39u as=0.7p ps=4.7u w=2u l=0.13u
X1798 VSS.t783 VDD.t9 VSS.t780 VSS.t808 sg13_lv_nmos ad=0.1428p pd=1.52u as=0 ps=0 w=0.42u l=1u
X1799 VSS.t26 a_34261_43495# a_34363_43495# VSS.t227 sg13_lv_nmos ad=4.3785p pd=27.07u as=0.2516p ps=2.16u w=0.74u l=0.13u
X1800 oa_sar8_acore18_opt_0.sw_bitcell_opt_b4_1.bot.t0 oa_sar8_acore18_opt_0.sw_bitcell_opt_term_0.trkb.t24 oa_sar8_acore18_opt_0.bstrap_opt_w2_c1200_1.out VDD.t780 sg13_lv_pmos ad=0.39p pd=2.39u as=0.7p ps=4.7u w=2u l=0.13u
X1801 VSS.t40 a_25596_47222# sar_ctrl_async_phys_0.hold_req VSS.t39 sg13_lv_nmos ad=0.14875p pd=1.16u as=0.2886p ps=2.26u w=0.74u l=0.13u
X1802 oa_sar8_acore18_opt_0.sw_tg_opt_0.bot.t3 oa_sar8_acore18_opt_0.sw_bitcell_opt_b7_0.bot.t115 cap_cmim l=2.14u w=2.14u
X1803 oa_sar8_acore18_opt_0.sw_bitcell_opt_b6_1.bot.t0 oa_sar8_acore18_opt_0.bstrap_opt_w2_c1200_1.gb oa_sar8_acore18_opt_0.bstrap_opt_w2_c1200_1.out VSS.t162 sg13_lv_nmos ad=0.195p pd=1.39u as=0.35p ps=2.7u w=1u l=0.13u
X1804 a_31935_36285# a_31093_35935# a_30676_35928# VDD.t19 sg13_lv_pmos ad=0.2048p pd=1.63u as=0.34p ps=2.68u w=1u l=0.13u
X1805 VSS.t462 a_31040_40702# a_30689_40821# VSS.t30 sg13_lv_nmos ad=79.8f pd=0.8u as=0.1428p ps=1.52u w=0.42u l=0.13u
X1806 VDD.t11 VSS.t40 VDD.t11 VDD.t10 sg13_lv_pmos ad=0.34p pd=2.68u as=0 ps=0 w=1u l=1u
X1807 sar_ctrl_async_phys_0.dac_code[7] a_36056_38224# VSS.t114 VSS.t177 sg13_lv_nmos ad=0.2886p pd=2.26u as=0.14875p ps=1.16u w=0.74u l=0.13u
X1808 VDD.t76 a_35391_33261# a_35648_33142# VDD.t76 sg13_lv_pmos ad=1.96315p pd=12.675u as=79.8f ps=0.8u w=0.42u l=0.13u
X1809 oa_sar8_acore18_opt_0.sw_tg_opt_1.bot.t3 oa_sar8_acore18_opt_0.sw_bitcell_opt_b7_1.bot.t121 cap_cmim l=2.14u w=2.14u
X1810 oa_sar8_acore18_opt_0.sw_tg_opt_1.bot.t3 oa_sar8_acore18_opt_0.sw_bitcell_opt_b4_1.bot.t22 cap_cmim l=2.14u w=2.14u
X1811 VSS.t393 oa_sar8_acore18_opt_0.sw_bitcell_opt_term_0.trkb.t2 oa_sar8_acore18_opt_0.sw_bitcell_opt_term_0.trkb.t0 VDD.t880 sg13_lv_pmos ad=0.7p pd=4.7u as=0.39p ps=2.39u w=2u l=0.13u
X1812 a_30964_36349# a_30676_35928# a_30902_36349# VSS.t1292 sg13_lv_nmos ad=0.1428p pd=1.52u as=37.8f ps=0.6u w=0.42u l=0.13u
X1813 VDD.t1 VSS.t575 VDD.t1 VDD.t0 sg13_lv_pmos ad=0.34p pd=2.68u as=0 ps=0 w=1u l=1u
X1814 sar_ctrl_async_phys_0.dac_code[4] a_36056_41972# VSS.t331 VSS.t416 sg13_lv_nmos ad=0.2886p pd=2.26u as=0.14875p ps=1.16u w=0.74u l=0.13u
X1815 VDD.t320 sar_ctrl_async_phys_0.sg13g2_a21oi_1$1_0.A1 a_34731_37436# VDD.t16 sg13_lv_pmos ad=0.2128p pd=1.5u as=0.2128p ps=1.5u w=1.12u l=0.13u
X1816 oa_sar8_acore18_opt_0.sw_tg_opt_0.bot.t2 oa_sar8_acore18_opt_0.sw_bitcell_opt_b7_0.bot.t152 cap_cmim l=2.14u w=2.14u
X1817 VDD.t77 VSS.t1026 VDD.t77 VDD.t76 sg13_lv_pmos ad=0.34p pd=2.68u as=0 ps=0 w=1u l=1u
X1818 a_31328_33870# a_31071_33727# a_31490_33650# VSS.t176 sg13_lv_nmos ad=0.1428p pd=1.52u as=37.8f ps=0.6u w=0.42u l=0.13u
X1819 VSS.t135 VDD.t184 VSS.t172 VSS.t796 sg13_lv_nmos ad=0.1428p pd=1.52u as=0 ps=0 w=0.42u l=1u
X1820 VDD.t416 sar_ctrl_async_phys_0.sg13g2_nand2b_1$1_1.B sar_ctrl_async_phys_0.sg13g2_buf_1$1_42.A VDD.t10 sg13_lv_pmos ad=0.2198p pd=1.53u as=0.2128p ps=1.5u w=1.12u l=0.13u
X1821 oa_sar8_acore18_opt_0.sw_tg_opt_0.bot.t3 oa_sar8_acore18_opt_0.sw_bitcell_opt_b7_0.bot.t131 cap_cmim l=2.14u w=2.14u
X1822 VDD.t114 VSS.t46 VDD.t114 VDD.t0 sg13_lv_pmos ad=0.34p pd=2.68u as=0 ps=0 w=1u l=1u
X1823 oa_sar8_acore18_opt_0.sw_tg_opt_1.bot.t3 oa_sar8_acore18_opt_0.sw_bitcell_opt_b4_1.bot.t8 cap_cmim l=2.14u w=2.14u
X1824 VSS.t252 VDD.t18 VSS.t222 VSS.t234 sg13_lv_nmos ad=0.1428p pd=1.52u as=0 ps=0 w=0.42u l=1u
X1825 oa_sar8_acore18_opt_0.sw_tg_opt_0.bot.t3 oa_sar8_acore18_opt_0.sw_bitcell_opt_b6_0.bot.t9 cap_cmim l=2.14u w=2.14u
X1826 oa_sar8_acore18_opt_0.sw_tg_opt_0.bot.t3 oa_sar8_acore18_opt_0.sw_bitcell_opt_b6_0.bot.t74 cap_cmim l=2.14u w=2.14u
X1827 a_35463_31435# sar_ctrl_async_phys_0.sg13g2_inv_1$1_0.Y a_36210_31826# VSS.t36 sg13_lv_nmos ad=0.1428p pd=1.52u as=60.89999f ps=0.71u w=0.42u l=0.13u
X1828 a_29332_32456# a_29306_32361# VDD.t247 VDD.t76 sg13_lv_pmos ad=0.34p pd=2.68u as=0.36237p ps=2.605u w=1u l=0.13u
X1829 a_25794_39706# sar_ctrl_async_phys_0.sg13g2_nand3_1$1_0.C VSS.t665 VSS.t103 sg13_lv_nmos ad=0.1406p pd=1.12u as=0.2886p ps=2.26u w=0.74u l=0.13u
X1830 a_33556_40016# a_34075_39820# a_34815_39775# VSS.t300 sg13_lv_nmos ad=0.3473p pd=2.71u as=0.12665p ps=1.145u w=0.74u l=0.13u
X1831 VDD.t362 sar_ctrl_async_phys_0.sg13g2_buf_1$1_20.A a_36056_37436# VDD.t16 sg13_lv_pmos ad=0.2114p pd=1.54u as=0.2856p ps=2.36u w=0.84u l=0.13u
X1832 VSS.t1056 VDD.t121 VSS.t1057 VSS.t179 sg13_lv_nmos ad=79.8f pd=0.8u as=0 ps=0 w=0.42u l=1u
X1833 oa_sar8_acore18_opt_0.sw_tg_opt_1.bot.t3 oa_sar8_acore18_opt_0.sw_bitcell_opt_b6_1.bot.t2 cap_cmim l=2.14u w=2.14u
X1834 sar_ctrl_async_phys_0.cmp_p sar_ctrl_async_phys_0.cmp_n VDD.t382 VDD.t380 sg13_lv_pmos ad=0.585p pd=3.39u as=1.05p ps=6.7u w=3u l=0.13u
X1835 a_35725_45266# sar_ctrl_async_phys_0.sg13g2_nand2b_1$1_4.A_N VDD.t349 VDD.t5 sg13_lv_pmos ad=0.2856p pd=2.36u as=0.2198p ps=1.53u w=0.84u l=0.13u
X1836 VSS.t133 sar_ctrl_async_phys_0.sg13g2_buf_1$1_41.X a_30868_44234# VSS.t132 sg13_lv_nmos ad=0.1626p pd=1.415u as=60.89999f ps=0.71u w=0.42u l=0.13u
X1837 VDD.t146 a_28862_36863# sar_ctrl_async_phys_0.sg13g2_dlygate4sd3_1$1_0.X VDD.t16 sg13_lv_pmos ad=0.2254p pd=1.53u as=0.4256p ps=3u w=1.12u l=0.13u
X1838 sar_ctrl_async_phys_0.cmp_n sar_ctrl_async_phys_0.cmp_p a_30632_22281# VSS.t368 sg13_lv_nmos ad=0.39p pd=2.39u as=0.7p ps=4.7u w=2u l=0.13u
X1839 VSS.t1007 VDD.t309 VSS.t1006 VSS.t1005 sg13_lv_nmos ad=0.1428p pd=1.52u as=0 ps=0 w=0.42u l=1u
X1840 VDD.t175 sar_ctrl_async_phys_0.sg13g2_a21oi_1$1_6.B1 a_35672_47296# VDD.t42 sg13_lv_pmos ad=0.2114p pd=1.54u as=0.2856p ps=2.36u w=0.84u l=0.13u
X1841 oa_sar8_acore18_opt_0.sw_tg_opt_1.bot.t3 oa_sar8_acore18_opt_0.sw_bitcell_opt_b6_1.bot.t80 cap_cmim l=2.14u w=2.14u
X1842 VSS.t243 sar_ctrl_async_phys_0.sg13g2_o21ai_1$1_1.B1.t6 a_30484_39698# VSS.t242 sg13_lv_nmos ad=0.1626p pd=1.415u as=60.89999f ps=0.71u w=0.42u l=0.13u
X1843 VDD.t86 a_31716_38912# a_31674_38948# VDD.t29 sg13_lv_pmos ad=0.2618p pd=1.63u as=0.1176p ps=1.33u w=1.12u l=0.13u
X1844 sar_ctrl_async_phys_0.sg13g2_a22oi_1$1_0.A1 a_34904_38224# VDD.t478 VDD.t29 sg13_lv_pmos ad=0.42p pd=2.99u as=0.2114p ps=1.54u w=1.12u l=0.13u
X1845 a_33193_45119# a_32251_45007# a_32991_45357# VDD.t5 sg13_lv_pmos ad=93.45f pd=0.865u as=0.2048p ps=1.63u w=0.42u l=0.13u
X1846 oa_sar8_acore18_opt_0.sw_tg_opt_0.bot.t3 oa_sar8_acore18_opt_0.sw_bitcell_opt_b7_0.bot.t68 cap_cmim l=2.14u w=2.14u
X1847 sar_ctrl_async_phys_0.sg13g2_nor4_1$1_0.Y sar_ctrl_async_phys_0.sg13g2_dfrbpq_1$1_0.CLK.t21 VSS.t29 VSS.t559 sg13_lv_nmos ad=0.1406p pd=1.12u as=0.1406p ps=1.12u w=0.74u l=0.13u
X1848 oa_sar8_acore18_opt_0.sw_tg_opt_0.bot.t3 oa_sar8_acore18_opt_0.sw_bitcell_opt_b7_0.bot.t89 cap_cmim l=2.14u w=2.14u
X1849 sar_ctrl_async_phys_0.sg13g2_nand2b_1$1_6.A_N a_34618_46044# VDD.t390 VDD.t10 sg13_lv_pmos ad=0.3808p pd=2.92u as=0.2128p ps=1.5u w=1.12u l=0.13u
X1850 oa_sar8_acore18_opt_0.sw_bitcell_opt_b3_1.bot.t17 sar_ctrl_async_phys_0.dac_code_n[3] VDD.t992 VDD.t990 sg13_lv_pmos ad=0.819p pd=4.59u as=1.47p ps=9.1u w=4.2u l=0.13u
X1851 oa_sar8_acore18_opt_0.sw_tg_opt_1.bot.t3 oa_sar8_acore18_opt_0.sw_bitcell_opt_b5_1.bot.t2 cap_cmim l=2.14u w=2.14u
X1852 VSS.t44 VDD.t202 VSS.t270 VSS.t1004 sg13_lv_nmos ad=79.8f pd=0.8u as=0 ps=0 w=0.42u l=1u
X1853 VSS.t1057 VDD.t90 VSS.t1057 VSS.t179 sg13_lv_nmos ad=0.1428p pd=1.52u as=0 ps=0 w=0.42u l=1u
X1854 sar_ctrl_async_phys_0.dac_code[6] a_35672_38948# VSS.t79 VSS.t1151 sg13_lv_nmos ad=0.2886p pd=2.26u as=0.14875p ps=1.16u w=0.74u l=0.13u
X1855 sar_ctrl_async_phys_0.dac_code_n[2] a_35288_47296# VSS.t42 VSS.t41 sg13_lv_nmos ad=0.2886p pd=2.26u as=0.14875p ps=1.16u w=0.74u l=0.13u
X1856 VDD.t478 sar_ctrl_async_phys_0.sg13g2_nor2b_1$1_0.A a_34904_38224# VDD.t29 sg13_lv_pmos ad=0.2114p pd=1.54u as=0.2856p ps=2.36u w=0.84u l=0.13u
X1857 VDD.t121 VSS.t1057 VDD.t121 VDD.t76 sg13_lv_pmos ad=0.34p pd=2.68u as=0 ps=0 w=1u l=1u
X1858 VSS.t260 sar_ctrl_async_phys_0.sg13g2_a22oi_1$1_0.Y sar_ctrl_async_phys_0.sg13g2_inv_1$1_2.Y VSS.t176 sg13_lv_nmos ad=0.2516p pd=2.16u as=0.2516p ps=2.16u w=0.74u l=0.13u
X1859 a_29620_43488# a_29594_43452# VSS.t120 VSS.t1264 sg13_lv_nmos ad=0.2516p pd=2.16u as=0.1626p ps=1.415u w=0.74u l=0.13u
X1860 w_16692_n9960# a_20412_n9612# cap_cmim l=9.94u w=39.8u
X1861 a_32192_36166# sar_ctrl_async_phys_0.sg13g2_buf_1$1_2.X.t2 VDD.t19 VDD.t19 sg13_lv_pmos ad=79.8f pd=0.8u as=1.66112p ps=10.725u w=0.42u l=0.13u
X1862 VSS.t470 a_35391_30703# a_36058_30924# VSS.t469 sg13_lv_nmos ad=0.1406p pd=1.12u as=0.2516p ps=2.16u w=0.74u l=0.13u
X1863 VDD.t13 VSS.t775 VDD.t13 VDD.t5 sg13_lv_pmos ad=0.34p pd=2.68u as=0 ps=0 w=1u l=1u
X1864 oa_sar8_acore18_opt_0.sw_bitcell_opt_term_0.bot.t0 VDD.t1083 oa_sar8_acore18_opt_0.sw_bitcell_opt_term_0.VSS VSS.t1128 sg13_lv_nmos ad=0.2925p pd=1.89u as=0.525p ps=3.7u w=1.5u l=0.13u
X1865 a_35401_44549# a_34459_44356# a_35199_44311# VDD.t5 sg13_lv_pmos ad=93.45f pd=0.865u as=0.2048p ps=1.63u w=0.42u l=0.13u
X1866 VSS.t118 VDD.t132 VSS.t118 VSS.t743 sg13_lv_nmos ad=79.8f pd=0.8u as=0 ps=0 w=0.42u l=1u
X1867 a_35697_40808# sar_ctrl_async_phys_0.sg13g2_a21oi_1$1_0.A1 sar_ctrl_async_phys_0.sg13g2_a22oi_1$1_3.A2 VSS.t72 sg13_lv_nmos ad=0.1406p pd=1.12u as=0.1406p ps=1.12u w=0.74u l=0.13u
X1868 VDD.t270 VSS.t1019 VDD.t270 VDD.t147 sg13_lv_pmos ad=0.19p pd=1.38u as=0 ps=0 w=1u l=1u
X1869 sar_ctrl_async_phys_0.sg13g2_a22oi_1$1_3.B1 sar_ctrl_async_phys_0.sg13g2_and2_1$1_0.A a_31370_34782# VSS.t0 sg13_lv_nmos ad=0.2516p pd=2.16u as=0.1406p ps=1.12u w=0.74u l=0.13u
X1870 oa_sar8_acore18_opt_0.sw_tg_opt_1.bot.t4 oa_sar8_acore18_opt_0.sw_bitcell_opt_b7_1.bot.t2 cap_cmim l=2.14u w=2.14u
X1871 oa_sar8_acore18_opt_0.sw_bitcell_opt_term_0.vin oa_sar8_acore18_opt_0.sw_bitcell_opt_term_0.trkb.t17 oa_sar8_acore18_opt_0.sw_bitcell_opt_b4_0.bot.t1 VDD.t881 sg13_lv_pmos ad=0.7p pd=4.7u as=0.39p ps=2.39u w=2u l=0.13u
X1872 VSS.t979 VDD.t233 VSS.t979 VSS.t0 sg13_lv_nmos ad=79.8f pd=0.8u as=0 ps=0 w=0.42u l=1u
X1873 sar_ctrl_async_phys_0.dac_code[3] a_36056_42760# VSS.t331 VSS.t416 sg13_lv_nmos ad=0.2886p pd=2.26u as=0.14875p ps=1.16u w=0.74u l=0.13u
X1874 a_31638_32138# sar_ctrl_async_phys_0.sg13g2_inv_1$1_3.Y VDD.t345 VDD.t76 sg13_lv_pmos ad=79.8f pd=0.8u as=0.1428p ps=1.52u w=0.42u l=0.13u
X1875 a_32288_31630# a_32031_31749# a_32450_31826# VSS.t83 sg13_lv_nmos ad=0.1428p pd=1.52u as=37.8f ps=0.6u w=0.42u l=0.13u
X1876 VDD.t20 VSS.t1 VDD.t20 VDD.t19 sg13_lv_pmos ad=0.19p pd=1.38u as=0 ps=0 w=1u l=1u
X1877 sar_ctrl_async_phys_0.sg13g2_a21oi_1$1_4.A2 a_31546_43484# VDD.t218 VDD.t22 sg13_lv_pmos ad=0.3808p pd=2.92u as=0.2128p ps=1.5u w=1.12u l=0.13u
X1878 VDD.t372 sar_ctrl_async_phys_0.sg13g2_dfrbpq_1$1_0.RESET_B a_34106_34380# VDD.t147 sg13_lv_pmos ad=0.1563p pd=1.22u as=0.147p ps=1.54u w=0.42u l=0.13u
X1879 oa_sar8_acore18_opt_0.bstrap_opt_w2_c1200_1.out oa_sar8_acore18_opt_0.bstrap_opt_w2_c1200_1.gb vinp VSS.t165 sg13_lv_nmos ad=0.195p pd=1.39u as=0.35p ps=2.7u w=1u l=0.13u
X1880 sar_ctrl_async_phys_0.sg13g2_nor2b_1$1_0.A a_34520_38224# VSS.t401 VSS.t177 sg13_lv_nmos ad=0.2886p pd=2.26u as=0.14875p ps=1.16u w=0.74u l=0.13u
X1881 oa_sar8_acore18_opt_0.sw_tg_opt_0.bot.t3 oa_sar8_acore18_opt_0.sw_bitcell_opt_b5_0.bot.t35 cap_cmim l=2.14u w=2.14u
X1882 oa_sar8_acore18_opt_0.sw_tg_opt_1.bot.t3 oa_sar8_acore18_opt_0.sw_bitcell_opt_b7_1.bot.t137 cap_cmim l=2.14u w=2.14u
X1883 a_34420_34837# a_34651_34423# a_34106_34380# VSS.t1186 sg13_lv_nmos ad=0.2373p pd=1.97u as=79.8f ps=0.8u w=0.42u l=0.13u
X1884 VDD.t513 sar_ctrl_async_phys_0.sg13g2_buf_1$1_0.A a_34136_33688# VDD.t147 sg13_lv_pmos ad=0.2114p pd=1.54u as=0.2856p ps=2.36u w=0.84u l=0.13u
X1885 VSS.t199 a_27134_39887# sar_ctrl_async_phys_0.sg13g2_dlygate4sd3_1$1_6.X VSS.t103 sg13_lv_nmos ad=0.1426p pd=1.16u as=0.2516p ps=2.16u w=0.74u l=0.13u
X1886 a_29526_33650# sar_ctrl_async_phys_0.sg13g2_inv_1$1_6.Y VDD.t233 VDD.t147 sg13_lv_pmos ad=79.8f pd=0.8u as=0.1428p ps=1.52u w=0.42u l=0.13u
X1887 a_33846_34850# sar_ctrl_async_phys_0.sg13g2_buf_1$1_17.A VDD.t728 VDD.t147 sg13_lv_pmos ad=79.8f pd=0.8u as=0.1428p ps=1.52u w=0.42u l=0.13u
X1888 VSS.t819 VDD.t22 VSS.t818 VSS.t224 sg13_lv_nmos ad=0.1428p pd=1.52u as=0 ps=0 w=0.42u l=1u
X1889 oa_sar8_acore18_opt_0.sw_tg_opt_0.bot.t3 oa_sar8_acore18_opt_0.sw_bitcell_opt_b6_0.bot.t1 cap_cmim l=2.14u w=2.14u
X1890 oa_sar8_acore18_opt_0.sw_tg_opt_1.bot.t3 oa_sar8_acore18_opt_0.sw_bitcell_opt_b7_1.bot.t74 cap_cmim l=2.14u w=2.14u
X1891 sar_ctrl_async_phys_0.sg13g2_a21oi_1$1_2.B1 a_31450_40460# VDD.t326 VDD.t317 sg13_lv_pmos ad=0.3808p pd=2.92u as=0.2128p ps=1.5u w=1.12u l=0.13u
X1892 VSS.t739 VDD.t64 VSS.t118 VSS.t765 sg13_lv_nmos ad=79.8f pd=0.8u as=0 ps=0 w=0.42u l=1u
X1893 a_26174_42911# a_26289_42912# VDD.t22 VDD.t22 sg13_lv_pmos ad=0.34p pd=2.68u as=0.2254p ps=1.53u w=1u l=0.5u
X1894 done a_35288_33688# VSS.t635 VSS.t91 sg13_lv_nmos ad=0.2886p pd=2.26u as=0.14875p ps=1.16u w=0.74u l=0.13u
X1895 VDD.t159 VSS.t95 VDD.t159 VDD.t19 sg13_lv_pmos ad=0.34p pd=2.68u as=0 ps=0 w=1u l=1u
X1896 VDD.t159 VSS.t940 VDD.t159 VDD.t19 sg13_lv_pmos ad=0.34p pd=2.68u as=0 ps=0 w=1u l=1u
X1897 a_34442_45366# sar_ctrl_async_phys_0.sg13g2_nand2b_1$1_4.A_N VSS.t7 VSS.t1224 sg13_lv_nmos ad=0.1406p pd=1.12u as=0.2516p ps=2.16u w=0.74u l=0.13u
X1898 VDD.t317 a_31935_39775# a_32192_39918# VDD.t317 sg13_lv_pmos ad=1.6658p pd=10.66u as=79.8f ps=0.8u w=0.42u l=0.13u
X1899 a_29786_33873# a_30229_33629# a_29526_33650# VSS.t173 sg13_lv_nmos ad=79.8f pd=0.8u as=0.1296p ps=1.52u w=0.42u l=0.13u
X1900 VSS.t780 VDD.t51 VSS.t780 VSS.t781 sg13_lv_nmos ad=0.1428p pd=1.52u as=0 ps=0 w=0.42u l=1u
X1901 VDD.t17 VSS.t348 VDD.t17 VDD.t16 sg13_lv_pmos ad=0.34p pd=2.68u as=0 ps=0 w=1u l=1u
X1902 a_28862_36863# a_28977_36864# VSS.t62 VSS.t1173 sg13_lv_nmos ad=0.1428p pd=1.52u as=0.1426p ps=1.16u w=0.42u l=0.5u
X1903 VDD.t6 VSS.t832 VDD.t6 VDD.t5 sg13_lv_pmos ad=0.19p pd=1.38u as=0 ps=0 w=1u l=1u
X1904 sar_ctrl_async_phys_0.sg13g2_nand3_1$1_0.C track VSS.t1204 VSS.t103 sg13_lv_nmos ad=0.1406p pd=1.12u as=0.2516p ps=2.16u w=0.74u l=0.13u
X1905 oa_sar8_acore18_opt_0.sw_tg_opt_1.bot.t2 oa_sar8_acore18_opt_0.sw_bitcell_opt_b7_1.bot.t158 cap_cmim l=2.14u w=2.14u
X1906 a_35595_40460# sar_ctrl_async_phys_0.sg13g2_a21oi_1$1_3.A2 VDD.t317 VDD.t317 sg13_lv_pmos ad=0.3808p pd=2.92u as=0.2128p ps=1.5u w=1.12u l=0.13u
X1907 oa_sar8_acore18_opt_0.sw_tg_opt_1.bot.t3 oa_sar8_acore18_opt_0.sw_bitcell_opt_b5_1.bot.t22 cap_cmim l=2.14u w=2.14u
X1908 VSS.t820 VDD.t13 VSS.t819 VSS.t224 sg13_lv_nmos ad=0.1428p pd=1.52u as=0 ps=0 w=0.42u l=1u
X1909 a_29660_37436# sar_ctrl_async_phys_0.sg13g2_nor2_1$1_8.B sar_ctrl_async_phys_0.sg13g2_inv_1$1_7.A VDD.t16 sg13_lv_pmos ad=0.1176p pd=1.33u as=0.3808p ps=2.92u w=1.12u l=0.13u
X1910 VDD.t3 a_35391_30703# a_35648_30846# VDD.t3 sg13_lv_pmos ad=1.96315p pd=12.675u as=79.8f ps=0.8u w=0.42u l=0.13u
X1911 VSS.t169 a_35072_39918# a_34721_39775# VSS.t723 sg13_lv_nmos ad=79.8f pd=0.8u as=0.1428p ps=1.52u w=0.42u l=0.13u
X1912 oa_sar8_acore18_opt_0.sw_tg_opt_1.bot.t3 oa_sar8_acore18_opt_0.sw_bitcell_opt_b7_1.bot.t95 cap_cmim l=2.14u w=2.14u
X1913 result[2] a_33080_31388# VSS.t178 VSS.t2 sg13_lv_nmos ad=0.2886p pd=2.26u as=0.14875p ps=1.16u w=0.74u l=0.13u
X1914 VSS.t1096 VDD.t59 VSS.t1095 VSS.t1094 sg13_lv_nmos ad=0.1428p pd=1.52u as=0 ps=0 w=0.42u l=1u
X1915 a_30746_31356# a_31189_31399# a_31129_31435# VDD.t3 sg13_lv_pmos ad=79.8f pd=0.8u as=63f ps=0.72u w=0.42u l=0.13u
X1916 sar_ctrl_async_phys_0.sg13g2_buf_1$1_5.A a_36058_34412# VSS.t13 VSS.t21 sg13_lv_nmos ad=0.2516p pd=2.16u as=0.1406p ps=1.12u w=0.74u l=0.13u
X1917 a_30830_35166# sar_ctrl_async_phys_0.sg13g2_a21oi_1$1_2.Y a_30733_35166# VSS.t0 sg13_lv_nmos ad=0.1628p pd=1.18u as=0.13135p ps=1.095u w=0.74u l=0.13u
X1918 VSS.t40 VDD.t11 VSS.t40 VSS.t752 sg13_lv_nmos ad=0.1428p pd=1.52u as=0 ps=0 w=0.42u l=1u
X1919 a_35456_44454# a_35199_44311# a_35618_44234# VSS.t60 sg13_lv_nmos ad=0.1428p pd=1.52u as=37.8f ps=0.6u w=0.42u l=0.13u
X1920 a_35072_39918# a_34815_39775# a_35234_39698# VSS.t297 sg13_lv_nmos ad=0.1428p pd=1.52u as=37.8f ps=0.6u w=0.42u l=0.13u
X1921 sar_ctrl_async_phys_0.sg13g2_a21oi_1$1_4.A2 a_31546_43484# VSS.t137 VSS.t1174 sg13_lv_nmos ad=0.2516p pd=2.16u as=0.1406p ps=1.12u w=0.74u l=0.13u
X1922 oa_sar8_acore18_opt_0.sw_bitcell_opt_b7_1.bot.t0 sar_ctrl_async_phys_0.dac_code_n[7].t1 oa_sar8_acore18_opt_0.sw_bitcell_opt_b7_1.VSS VSS.t164 sg13_lv_nmos ad=0.663p pd=3.79u as=1.19p ps=7.5u w=3.4u l=0.13u
X1923 oa_sar8_acore18_opt_0.sw_bitcell_opt_term_0.vin oa_sar8_acore18_opt_0.sw_bitcell_opt_term_0.trkb.t14 oa_sar8_acore18_opt_0.sw_bitcell_opt_b1_0.bot.t4 VDD.t952 sg13_lv_pmos ad=0.7p pd=4.7u as=0.39p ps=2.39u w=2u l=0.13u
X1924 VDD.t229 a_31071_33727# a_31738_33948# VDD.t147 sg13_lv_pmos ad=0.2128p pd=1.5u as=0.3864p ps=2.93u w=1.12u l=0.13u
X1925 oa_sar8_acore18_opt_0.sw_bitcell_opt_term_0.vin oa_sar8_acore18_opt_0.sw_bitcell_opt_term_0.trkb.t16 oa_sar8_acore18_opt_0.sw_bitcell_opt_b3_0.bot.t1 VDD.t610 sg13_lv_pmos ad=0.7p pd=4.7u as=0.39p ps=2.39u w=2u l=0.13u
X1926 sar_ctrl_async_phys_0.sg13g2_inv_1$1_5.A sar_ctrl_async_phys_0.sg13g2_buf_1$1_0.A a_30671_33292# VSS.t466 sg13_lv_nmos ad=0.2664p pd=1.46u as=0.13875p ps=1.115u w=0.74u l=0.13u
X1927 a_32980_45759# a_33211_45868# a_32666_45969# VSS.t1140 sg13_lv_nmos ad=0.2373p pd=1.97u as=79.8f ps=0.8u w=0.42u l=0.13u
X1928 oa_sar8_acore18_opt_0.sw_tg_opt_1.bot.t3 oa_sar8_acore18_opt_0.sw_bitcell_opt_b5_1.bot.t22 cap_cmim l=2.14u w=2.14u
X1929 a_28680_40460# sar_ctrl_async_phys_0.sg13g2_nor4_1$1_0.C a_28578_40460# VDD.t317 sg13_lv_pmos ad=0.2128p pd=1.5u as=0.2128p ps=1.5u w=1.12u l=0.13u
X1930 VDD.t90 VSS.t1088 VDD.t90 VDD.t3 sg13_lv_pmos ad=0.19p pd=1.38u as=0 ps=0 w=1u l=1u
X1931 oa_sar8_acore18_opt_0.sw_bitcell_opt_b1_0.bot.t4 sar_ctrl_async_phys_0.dac_code[1] oa_sar8_acore18_opt_0.sw_bitcell_opt_term_0.VSS VSS.t1236 sg13_lv_nmos ad=0.3315p pd=2.09u as=0.595p ps=4.1u w=1.7u l=0.13u
X1932 VDD.t233 sar_ctrl_async_phys_0.sg13g2_buf_1$1_6.X a_29786_33873# VDD.t147 sg13_lv_pmos ad=0.1563p pd=1.22u as=0.147p ps=1.54u w=0.42u l=0.13u
X1933 sar_ctrl_async_phys_0.sg13g2_nand2_1$1_3.Y sar_ctrl_async_phys_0.sg13g2_nand2_1$1_3.A VDD.t330 VDD.t22 sg13_lv_pmos ad=0.2128p pd=1.5u as=0.3808p ps=2.92u w=1.12u l=0.13u
X1934 sar_ctrl_async_phys_0.sg13g2_buf_1$1_19.A a_33754_37436# VDD.t320 VDD.t16 sg13_lv_pmos ad=0.3808p pd=2.92u as=0.2128p ps=1.5u w=1.12u l=0.13u
X1935 oa_sar8_acore18_opt_0.sw_tg_opt_0.bot.t3 oa_sar8_acore18_opt_0.sw_bitcell_opt_b4_0.bot.t32 cap_cmim l=2.14u w=2.14u
X1936 VSS.t178 sar_ctrl_async_phys_0.sg13g2_buf_1$1_8.A a_33464_31388# VSS.t2 sg13_lv_nmos ad=0.14875p pd=1.16u as=0.187p ps=1.78u w=0.55u l=0.13u
X1937 sar_ctrl_async_phys_0.sg13g2_buf_1$1_6.X a_35384_32176# VSS.t309 VSS.t1187 sg13_lv_nmos ad=0.2886p pd=2.26u as=0.14875p ps=1.16u w=0.74u l=0.13u
X1938 a_34132_34416# a_34651_34423# a_35391_34773# VSS.t21 sg13_lv_nmos ad=0.3473p pd=2.71u as=0.12665p ps=1.145u w=0.74u l=0.13u
X1939 oa_sar8_acore18_opt_0.sw_tg_opt_1.bot.t3 oa_sar8_acore18_opt_0.sw_bitcell_opt_b7_1.bot.t74 cap_cmim l=2.14u w=2.14u
X1940 a_30830_35166# sar_ctrl_async_phys_0.sg13g2_buf_1$1_1.A a_30733_35460# VDD.t19 sg13_lv_pmos ad=0.2225p pd=1.445u as=0.3325p ps=1.665u w=1u l=0.13u
X1941 VDD.t51 VSS.t730 VDD.t51 VDD.t10 sg13_lv_pmos ad=0.34p pd=2.68u as=0 ps=0 w=1u l=1u
X1942 sar_ctrl_async_phys_0.sg13g2_a21oi_1$1_2.B1 a_31450_40460# VSS.t31 VSS.t30 sg13_lv_nmos ad=0.2516p pd=2.16u as=0.1406p ps=1.12u w=0.74u l=0.13u
X1943 oa_sar8_acore18_opt_0.sw_tg_opt_0.bot.t3 oa_sar8_acore18_opt_0.sw_bitcell_opt_b2_0.bot.t2 cap_cmim l=2.14u w=2.14u
X1944 VSS.t313 VDD.t25 VSS.t313 VSS.t856 sg13_lv_nmos ad=0.1428p pd=1.52u as=0 ps=0 w=0.42u l=1u
X1945 oa_sar8_acore18_opt_0.sw_tg_opt_0.bot.t2 oa_sar8_acore18_opt_0.sw_bitcell_opt_b7_0.bot.t149 cap_cmim l=2.14u w=2.14u
X1946 oa_sar8_acore18_opt_0.sw_tg_opt_0.bot.t3 oa_sar8_acore18_opt_0.sw_bitcell_opt_b7_0.bot.t78 cap_cmim l=2.14u w=2.14u
X1947 VSS.t1059 VDD.t121 VSS.t1060 VSS.t179 sg13_lv_nmos ad=79.8f pd=0.8u as=0 ps=0 w=0.42u l=1u
X1948 a_29620_43488# a_30139_43495# a_30879_43845# VSS.t525 sg13_lv_nmos ad=0.3473p pd=2.71u as=0.12665p ps=1.145u w=0.74u l=0.13u
X1949 sar_ctrl_async_phys_0.dac_code[1] a_34520_42760# VSS.t99 VSS.t402 sg13_lv_nmos ad=0.2886p pd=2.26u as=0.14875p ps=1.16u w=0.74u l=0.13u
X1950 VSS.t15 a_33087_37797# a_33754_37436# VSS.t14 sg13_lv_nmos ad=0.1406p pd=1.12u as=0.2516p ps=2.16u w=0.74u l=0.13u
X1951 a_26184_21025# sar_ctrl_async_phys_0.cmp_fire VDD.t440 VDD.t439 sg13_lv_pmos ad=0.7p pd=4.7u as=0.7p ps=4.7u w=2u l=0.13u
X1952 oa_sar8_acore18_opt_0.sw_bitcell_opt_b7_1.VSS sar_ctrl_async_phys_0.dac_code_n[3] oa_sar8_acore18_opt_0.sw_bitcell_opt_b3_1.bot.t0 VSS.t1218 sg13_lv_nmos ad=0.735p pd=4.9u as=0.4095p ps=2.49u w=2.1u l=0.13u
X1953 VDD.t59 VSS.t1064 VDD.t59 VDD.t3 sg13_lv_pmos ad=0.19p pd=1.38u as=0 ps=0 w=1u l=1u
X1954 VSS.t131 VDD.t184 VSS.t131 VSS.t798 sg13_lv_nmos ad=0.1428p pd=1.52u as=0 ps=0 w=0.42u l=1u
X1955 a_26570_42690# sar_ctrl_async_phys_0.sg13g2_dlygate4sd3_1$1_5.A VDD.t33 VDD.t22 sg13_lv_pmos ad=0.1428p pd=1.52u as=0.1523p ps=1.38u w=0.42u l=0.13u
X1956 oa_sar8_acore18_opt_0.sw_bitcell_opt_term_0.trkb.t0 oa_sar8_acore18_opt_0.sw_bitcell_opt_term_0.trkb.t2 VSS.t393 VDD.t880 sg13_lv_pmos ad=0.39p pd=2.39u as=0.7p ps=4.7u w=2u l=0.13u
X1957 VSS.t307 a_33632_40702# a_33281_40821# VSS.t306 sg13_lv_nmos ad=79.8f pd=0.8u as=0.1428p ps=1.52u w=0.42u l=0.13u
X1958 oa_sar8_acore18_opt_0.sw_tg_opt_1.bot.t2 oa_sar8_acore18_opt_0.sw_bitcell_opt_b7_1.bot.t163 cap_cmim l=2.14u w=2.14u
X1959 VDD.t19 sar_ctrl_async_phys_0.sg13g2_buf_1$1_17.A a_34424_35200# VDD.t19 sg13_lv_pmos ad=0.2114p pd=1.54u as=0.2856p ps=2.36u w=0.84u l=0.13u
X1960 VSS.t730 VDD.t43 VSS.t730 VSS.t731 sg13_lv_nmos ad=79.8f pd=0.8u as=0 ps=0 w=0.42u l=1u
X1961 VSS.t539 sar_ctrl_async_phys_0.sg13g2_o21ai_1$1_1.B1.t10 a_29332_40898# VSS.t538 sg13_lv_nmos ad=0.1626p pd=1.415u as=60.89999f ps=0.71u w=0.42u l=0.13u
X1962 a_31252_46933# a_30964_46512# a_31190_46933# VSS.t1192 sg13_lv_nmos ad=0.1428p pd=1.52u as=37.8f ps=0.6u w=0.42u l=0.13u
X1963 sar_ctrl_async_phys_0.sg13g2_nand2_1$1_5.Y sar_ctrl_async_phys_0.sg13g2_nand2b_1$1_1.B a_35402_42726# VSS.t1169 sg13_lv_nmos ad=0.2516p pd=2.16u as=0.1406p ps=1.12u w=0.74u l=0.13u
X1964 sar_ctrl_async_phys_0.bit_active[6] a_34904_38948# VDD.t431 VDD.t29 sg13_lv_pmos ad=0.42p pd=2.99u as=0.2114p ps=1.54u w=1.12u l=0.13u
X1965 VDD.t146 sar_ctrl_async_phys_0.sg13g2_dlygate4sd3_1$1_0.X a_28368_36877# VDD.t16 sg13_lv_pmos ad=0.2856p pd=2.36u as=0.1596p ps=1.22u w=0.84u l=0.13u
X1966 VSS.t309 sar_ctrl_async_phys_0.sg13g2_a22oi_1$1_1.A2 a_34590_32120# VSS.t58 sg13_lv_nmos ad=0.2516p pd=2.16u as=96.2f ps=1u w=0.74u l=0.13u
X1967 sar_ctrl_async_phys_0.sg13g2_buf_1$1_1.A a_33658_35460# VDD.t258 VDD.t19 sg13_lv_pmos ad=0.3808p pd=2.92u as=0.2128p ps=1.5u w=1.12u l=0.13u
X1968 VDD.t68 VSS.t111 VDD.t157 VDD.t0 sg13_lv_pmos ad=0.19p pd=1.38u as=0 ps=0 w=1u l=1u
X1969 VSS.t650 VDD.t30 VSS.t900 VSS.t103 sg13_lv_nmos ad=79.8f pd=0.8u as=0 ps=0 w=0.42u l=1u
X1970 a_29701_36874# sar_ctrl_async_phys_0.sg13g2_nor2_1$1_7.A VDD.t17 VDD.t16 sg13_lv_pmos ad=0.2856p pd=2.36u as=0.2198p ps=1.53u w=0.84u l=0.13u
X1971 VDD.t79 VSS.t1118 VDD.t79 VDD.t3 sg13_lv_pmos ad=0.19p pd=1.38u as=0 ps=0 w=1u l=1u
X1972 VSS.t1027 VDD.t148 VSS.t1026 VSS.t1025 sg13_lv_nmos ad=0.1428p pd=1.52u as=0 ps=0 w=0.42u l=1u
X1973 a_34453_35935# sar_ctrl_async_phys_0.sg13g2_dfrbpq_1$1_0.CLK.t10 VDD.t19 VDD.t19 sg13_lv_pmos ad=0.4088p pd=2.97u as=1.66112p ps=10.725u w=1.12u l=0.13u
X1974 a_32918_45759# sar_ctrl_async_phys_0.sg13g2_o21ai_1$1_1.B1.t15 VSS.t131 VSS.t366 sg13_lv_nmos ad=37.8f pd=0.6u as=0.1701p ps=1.65u w=0.42u l=0.13u
X1975 oa_sar8_acore18_opt_0.sw_tg_opt_1.bot.t3 oa_sar8_acore18_opt_0.sw_bitcell_opt_b7_1.bot.t58 cap_cmim l=2.14u w=2.14u
X1976 VDD.t4 sar_ctrl_async_phys_0.sg13g2_a22oi_1$1_1.B2 a_33080_31388# VDD.t3 sg13_lv_pmos ad=0.2114p pd=1.54u as=0.2856p ps=2.36u w=0.84u l=0.13u
X1977 VDD.t18 VSS.t954 VDD.t18 VDD.t16 sg13_lv_pmos ad=0.34p pd=2.68u as=0 ps=0 w=1u l=1u
X1978 VSS.t20 a_34549_34423# a_34651_34423# VSS.t19 sg13_lv_nmos ad=6.27915p pd=40.31u as=0.2516p ps=2.16u w=0.74u l=0.13u
X1979 sar_ctrl_async_phys_0.sg13g2_nand2b_1$1_2.A_N a_35578_41508# VSS.t87 VSS.t1279 sg13_lv_nmos ad=0.2516p pd=2.16u as=0.1406p ps=1.12u w=0.74u l=0.13u
X1980 VSS.t1060 VDD.t90 VSS.t1060 VSS.t179 sg13_lv_nmos ad=0.1428p pd=1.52u as=0 ps=0 w=0.42u l=1u
X1981 oa_sar8_acore18_opt_0.sw_bitcell_opt_b6_0.bot.t0 sar_ctrl_async_phys_0.dac_code[6] oa_sar8_acore18_opt_0.sw_bitcell_opt_term_0.VSS VSS.t1179 sg13_lv_nmos ad=0.585p pd=3.39u as=1.05p ps=6.7u w=3u l=0.13u
X1982 VDD.t381 sar_ctrl_async_phys_0.cmp_n sar_ctrl_async_phys_0.cmp_p VDD.t380 sg13_lv_pmos ad=1.05p pd=6.7u as=0.585p ps=3.39u w=3u l=0.13u
X1983 sar_ctrl_async_phys_0.sg13g2_nor2_1$1_3.Y sar_ctrl_async_phys_0.sg13g2_and2_1$1_3.A VSS.t65 VSS.t67 sg13_lv_nmos ad=0.1406p pd=1.12u as=0.2516p ps=2.16u w=0.74u l=0.13u
X1984 oa_sar8_acore18_opt_0.sw_tg_opt_1.bot.t3 oa_sar8_acore18_opt_0.sw_bitcell_opt_b6_1.bot.t22 cap_cmim l=2.14u w=2.14u
X1985 oa_sar8_acore18_opt_0.sw_tg_opt_0.bot.t3 oa_sar8_acore18_opt_0.sw_bitcell_opt_b6_0.bot.t41 cap_cmim l=2.14u w=2.14u
X1986 a_30632_22281# sar_ctrl_async_phys_0.cmp_p sar_ctrl_async_phys_0.cmp_n VSS.t368 sg13_lv_nmos ad=0.7p pd=4.7u as=0.39p ps=2.39u w=2u l=0.13u
X1987 oa_sar8_acore18_opt_0.sw_bitcell_opt_term_0.VSS sar_ctrl_async_phys_0.dac_code[7] oa_sar8_acore18_opt_0.sw_bitcell_opt_b7_0.bot.t1 VSS.t49 sg13_lv_nmos ad=1.19p pd=7.5u as=0.663p ps=3.79u w=3.4u l=0.13u
X1988 a_34590_32120# sar_ctrl_async_phys_0.sg13g2_a22oi_1$1_0.A1 sar_ctrl_async_phys_0.sg13g2_a22oi_1$1_1.Y VSS.t58 sg13_lv_nmos ad=96.2f pd=1u as=0.2664p ps=1.46u w=0.74u l=0.13u
X1989 VDD.t97 VSS.t1061 VDD.t121 VDD.t76 sg13_lv_pmos ad=0.34p pd=2.68u as=0 ps=0 w=1u l=1u
X1990 oa_sar8_acore18_opt_0.sw_tg_opt_1.bot.t3 oa_sar8_acore18_opt_0.sw_bitcell_opt_b6_1.bot.t55 cap_cmim l=2.14u w=2.14u
X1991 VDD.t159 VSS.t938 VDD.t159 VDD.t19 sg13_lv_pmos ad=0.19p pd=1.38u as=0 ps=0 w=1u l=1u
X1992 VSS.t7 a_34208_45966# a_33857_45823# VSS.t6 sg13_lv_nmos ad=79.8f pd=0.8u as=0.1428p ps=1.52u w=0.42u l=0.13u
X1993 VDD.t219 sar_ctrl_async_phys_0.sg13g2_a21oi_1$1_6.A2 a_33085_43832# VDD.t22 sg13_lv_pmos ad=0.1918p pd=1.5u as=0.1596p ps=1.22u w=0.84u l=0.13u
X1994 a_29258_36642# sar_ctrl_async_phys_0.sg13g2_dlygate4sd3_1$1_0.A VSS.t62 VSS.t213 sg13_lv_nmos ad=0.1428p pd=1.52u as=79.8f ps=0.8u w=0.42u l=0.13u
X1995 VDD.t15 VSS.t777 VDD.t13 VDD.t5 sg13_lv_pmos ad=0.34p pd=2.68u as=0 ps=0 w=1u l=1u
X1996 VDD.t328 sar_ctrl_async_phys_0.sg13g2_dlygate4sd3_1$1_9.X a_26184_39702# VDD.t317 sg13_lv_pmos ad=0.1523p pd=1.38u as=0.1428p ps=1.52u w=0.42u l=0.13u
X1997 VDD.t43 VSS.t730 VDD.t44 VDD.t42 sg13_lv_pmos ad=0.34p pd=2.68u as=0 ps=0 w=1u l=1u
X1998 VDD.t22 a_31136_43726# a_31081_43607# VDD.t22 sg13_lv_pmos ad=2.48357p pd=16.205u as=93.45f ps=0.865u w=0.42u l=0.13u
X1999 a_30484_39698# sar_ctrl_async_phys_0.sg13g2_nor2_1$1_18.A a_30390_39698# VSS.t1154 sg13_lv_nmos ad=60.89999f pd=0.71u as=0.1428p ps=1.52u w=0.42u l=0.13u
X2000 a_26728_37416# sar_ctrl_async_phys_0.sg13g2_and2_1$1_3.A VDD.t169 VDD.t16 sg13_lv_pmos ad=0.2128p pd=1.5u as=0.3808p ps=2.92u w=1.12u l=0.15u
X2001 a_31644_36638# sar_ctrl_async_phys_0.sg13g2_buf_1$1_13.A VDD.t18 VDD.t16 sg13_lv_pmos ad=0.2856p pd=2.36u as=0.2114p ps=1.54u w=0.84u l=0.13u
X2002 oa_sar8_acore18_opt_0.sw_tg_opt_0.bot.t3 oa_sar8_acore18_opt_0.sw_bitcell_opt_b7_0.bot.t120 cap_cmim l=2.14u w=2.14u
X2003 sar_ctrl_async_phys_0.sg13g2_nand2_1$1_5.B a_32986_44532# VDD.t692 VDD.t5 sg13_lv_pmos ad=0.3808p pd=2.92u as=0.2128p ps=1.5u w=1.12u l=0.13u
X2004 oa_sar8_acore18_opt_0.sw_tg_opt_0.bot.t3 oa_sar8_acore18_opt_0.sw_bitcell_opt_b3_0.bot.t12 cap_cmim l=2.14u w=2.14u
X2005 result[1] a_33464_30664# VDD.t4 VDD.t3 sg13_lv_pmos ad=0.42p pd=2.99u as=0.2114p ps=1.54u w=1.12u l=0.13u
X2006 VSS.t152 sar_ctrl_async_phys_0.sg13g2_buf_1$1_46.A a_36056_46508# VSS.t125 sg13_lv_nmos ad=0.14875p pd=1.16u as=0.187p ps=1.78u w=0.55u l=0.13u
X2007 a_25896_39706# sar_ctrl_async_phys_0.sg13g2_and2_1$1_3.X a_25794_39706# VSS.t103 sg13_lv_nmos ad=0.1406p pd=1.12u as=0.1406p ps=1.12u w=0.74u l=0.13u
X2008 VSS.t340 sar_ctrl_async_phys_0.sg13g2_and2_1$1_0.A a_29862_36682# VSS.t339 sg13_lv_nmos ad=0.18575p pd=1.26u as=0.1406p ps=1.12u w=0.74u l=0.13u
X2009 oa_sar8_acore18_opt_0.sw_tg_opt_1.bot.t3 oa_sar8_acore18_opt_0.sw_bitcell_opt_b4_1.bot.t16 cap_cmim l=2.14u w=2.14u
X2010 VSS.t817 VDD.t13 VSS.t818 VSS.t224 sg13_lv_nmos ad=79.8f pd=0.8u as=0 ps=0 w=0.42u l=1u
X2011 a_26270_39215# a_26385_39214# VSS.t208 VSS.t103 sg13_lv_nmos ad=0.1428p pd=1.52u as=0.1426p ps=1.16u w=0.42u l=0.5u
X2012 sar_ctrl_async_phys_0.sg13g2_inv_1$1_6.A sar_ctrl_async_phys_0.sg13g2_buf_1$1_7.A a_31247_33292# VSS.t57 sg13_lv_nmos ad=0.2664p pd=1.46u as=0.13875p ps=1.115u w=0.74u l=0.13u
X2013 sar_ctrl_async_phys_0.sg13g2_nor2_1$1_11.Y sar_ctrl_async_phys_0.sg13g2_nor2_1$1_5.A VSS.t457 VSS.t572 sg13_lv_nmos ad=0.1406p pd=1.12u as=0.2516p ps=2.16u w=0.74u l=0.13u
X2014 VSS.t126 VDD.t132 VSS.t126 VSS.t41 sg13_lv_nmos ad=79.8f pd=0.8u as=0 ps=0 w=0.42u l=1u
X2015 VSS.t311 sar_ctrl_async_phys_0.sg13g2_a22oi_1$1_0.B2 a_33464_30664# VSS.t705 sg13_lv_nmos ad=0.14875p pd=1.16u as=0.187p ps=1.78u w=0.55u l=0.13u
X2016 VDD.t120 VSS.t65 VDD.t120 VDD.t29 sg13_lv_pmos ad=0.34p pd=2.68u as=0 ps=0 w=1u l=1u
X2017 oa_sar8_acore18_opt_0.sw_tg_opt_1.bot.t3 oa_sar8_acore18_opt_0.sw_bitcell_opt_b4_1.bot.t30 cap_cmim l=2.14u w=2.14u
X2018 sar_ctrl_async_phys_0.sg13g2_nand2b_1$1_0.Y a_28651_39740# a_28853_39702# VSS.t103 sg13_lv_nmos ad=0.333p pd=2.38u as=0.1406p ps=1.12u w=0.74u l=0.13u
X2019 oa_sar8_acore18_opt_0.sw_bitcell_opt_b4_0.bot.t1 oa_sar8_acore18_opt_0.sw_bitcell_opt_term_0.trkb.t17 oa_sar8_acore18_opt_0.sw_bitcell_opt_term_0.vin VDD.t881 sg13_lv_pmos ad=0.39p pd=2.39u as=0.7p ps=4.7u w=2u l=0.13u
X2020 VDD.t0 a_35168_41430# a_35113_41525# VDD.t0 sg13_lv_pmos ad=3.62845p pd=23.965u as=93.45f ps=0.865u w=0.42u l=0.13u
X2021 oa_sar8_acore18_opt_0.sw_bitcell_opt_b4_1.bot.t0 sar_ctrl_async_phys_0.dac_code_n[4] oa_sar8_acore18_opt_0.sw_bitcell_opt_b7_1.VSS VSS.t491 sg13_lv_nmos ad=0.468p pd=2.79u as=0.84p ps=5.5u w=2.4u l=0.13u
X2022 oa_sar8_acore18_opt_0.sw_tg_opt_0.bot.t3 oa_sar8_acore18_opt_0.sw_bitcell_opt_b5_0.bot.t25 cap_cmim l=2.14u w=2.14u
X2023 oa_sar8_acore18_opt_0.sw_tg_opt_1.bot.t3 oa_sar8_acore18_opt_0.sw_bitcell_opt_b7_1.bot.t111 cap_cmim l=2.14u w=2.14u
X2024 sar_ctrl_async_phys_0.sg13g2_dlygate4sd3_1$1_8.X a_26566_41996# VDD.t157 VDD.t0 sg13_lv_pmos ad=0.4256p pd=3u as=0.2254p ps=1.53u w=1.12u l=0.13u
X2025 VDD.t132 VSS.t118 VDD.t132 VDD.t42 sg13_lv_pmos ad=0.34p pd=2.68u as=0 ps=0 w=1u l=1u
X2026 oa_sar8_acore18_opt_0.sw_tg_opt_0.bot.t3 oa_sar8_acore18_opt_0.sw_bitcell_opt_b6_0.bot.t74 cap_cmim l=2.14u w=2.14u
X2027 oa_sar8_acore18_opt_0.sw_tg_opt_1.bot.t3 oa_sar8_acore18_opt_0.sw_bitcell_opt_b7_1.bot.t48 cap_cmim l=2.14u w=2.14u
X2028 a_29562_39996# sar_ctrl_async_phys_0.sg13g2_nor2_1$1_5.A VDD.t361 VDD.t317 sg13_lv_pmos ad=0.1176p pd=1.33u as=0.4032p ps=2.96u w=1.12u l=0.13u
X2029 sar_ctrl_async_phys_0.sg13g2_dlygate4sd3_1$1_5.A track VSS.t51 VSS.t1205 sg13_lv_nmos ad=0.2516p pd=2.16u as=0.2516p ps=2.16u w=0.74u l=0.13u
X2030 a_26954_40424# sar_ctrl_async_phys_0.sg13g2_dlygate4sd3_1$1_9.A VDD.t340 VDD.t317 sg13_lv_pmos ad=0.1428p pd=1.52u as=0.1523p ps=1.38u w=0.42u l=0.13u
X2031 VSS.t829 VDD.t25 VSS.t829 VSS.t224 sg13_lv_nmos ad=0.1428p pd=1.52u as=0 ps=0 w=0.42u l=1u
X2032 VSS.t111 a_26454_41972# a_26566_41996# VSS.t577 sg13_lv_nmos ad=0.1426p pd=1.16u as=0.1428p ps=1.52u w=0.42u l=0.5u
X2033 VDD.t6 VSS.t829 VDD.t9 VDD.t5 sg13_lv_pmos ad=0.34p pd=2.68u as=0 ps=0 w=1u l=1u
X2034 VDD.t361 a_28651_39740# sar_ctrl_async_phys_0.sg13g2_nand2b_1$1_0.Y VDD.t317 sg13_lv_pmos ad=0.3808p pd=2.92u as=0.2128p ps=1.5u w=1.12u l=0.13u
X2035 VDD.t289 VSS.t975 VDD.t289 VDD.t19 sg13_lv_pmos ad=0.34p pd=2.68u as=0 ps=0 w=1u l=1u
X2036 VSS.t102 VDD.t82 VSS.t102 VSS.t919 sg13_lv_nmos ad=79.8f pd=0.8u as=0 ps=0 w=0.42u l=1u
X2037 a_30772_31392# a_30746_31356# VSS.t17 VSS.t195 sg13_lv_nmos ad=0.2516p pd=2.16u as=0.1626p ps=1.415u w=0.74u l=0.13u
X2038 VDD.t19 a_31935_36285# a_32192_36166# VDD.t19 sg13_lv_pmos ad=1.79957p pd=11.62u as=79.8f ps=0.8u w=0.42u l=0.13u
X2039 a_32576_44454# sar_ctrl_async_phys_0.sg13g2_buf_1$1_41.X VDD.t5 VDD.t5 sg13_lv_pmos ad=79.8f pd=0.8u as=1.79957p ps=11.62u w=0.42u l=0.13u
X2040 oa_sar8_acore18_opt_0.sw_tg_opt_1.bot.t3 oa_sar8_acore18_opt_0.sw_bitcell_opt_b7_1.bot.t107 cap_cmim l=2.14u w=2.14u
X2041 VDD.t270 VSS.t970 VDD.t270 VDD.t147 sg13_lv_pmos ad=0.19p pd=1.38u as=0 ps=0 w=1u l=1u
X2042 VSS.t1101 VDD.t59 VSS.t1103 VSS.t1102 sg13_lv_nmos ad=79.8f pd=0.8u as=0 ps=0 w=0.42u l=1u
X2043 a_32450_31826# sar_ctrl_async_phys_0.sg13g2_buf_1$1_6.X VSS.t449 VSS.t83 sg13_lv_nmos ad=37.8f pd=0.6u as=79.8f ps=0.8u w=0.42u l=0.13u
X2044 a_34261_36653# sar_ctrl_async_phys_0.sg13g2_dfrbpq_1$1_0.CLK.t13 VSS.t293 VSS.t292 sg13_lv_nmos ad=0.2516p pd=2.16u as=4.1082p ps=26.51u w=0.74u l=0.13u
X2045 oa_sar8_acore18_opt_0.sw_tg_opt_0.bot.t3 oa_sar8_acore18_opt_0.sw_bitcell_opt_b7_0.bot.t94 cap_cmim l=2.14u w=2.14u
X2046 oa_sar8_acore18_opt_0.sw_tg_opt_1.bot.t3 oa_sar8_acore18_opt_0.sw_bitcell_opt_b3_1.bot.t1 cap_cmim l=2.14u w=2.14u
X2047 oa_sar8_acore18_opt_0.sw_tg_opt_1.bot.t3 oa_sar8_acore18_opt_0.sw_bitcell_opt_b6_1.bot.t62 cap_cmim l=2.14u w=2.14u
X2048 result[5] a_34136_33688# VDD.t513 VDD.t147 sg13_lv_pmos ad=0.42p pd=2.99u as=0.2114p ps=1.54u w=1.12u l=0.13u
X2049 a_32319_44311# a_31477_44213# a_32225_44311# VSS.t27 sg13_lv_nmos ad=0.12665p pd=1.145u as=0.1428p ps=1.52u w=0.42u l=0.13u
X2050 VDD.t18 a_31644_36638# sar_ctrl_async_phys_0.sg13g2_and2_1$1_0.A VDD.t16 sg13_lv_pmos ad=0.2114p pd=1.54u as=0.42p ps=2.99u w=1.12u l=0.13u
X2051 a_35166_32120# sar_ctrl_async_phys_0.sg13g2_a22oi_1$1_0.A1 sar_ctrl_async_phys_0.sg13g2_a22oi_1$1_0.Y VSS.t59 sg13_lv_nmos ad=96.2f pd=1u as=0.2664p ps=1.46u w=0.74u l=0.13u
X2052 oa_sar8_acore18_opt_0.sw_tg_opt_1.bot.t4 oa_sar8_acore18_opt_0.sw_bitcell_opt_b7_1.bot.t5 cap_cmim l=2.14u w=2.14u
X2053 VDD.t90 VSS.t1093 VDD.t90 VDD.t3 sg13_lv_pmos ad=0.19p pd=1.38u as=0 ps=0 w=1u l=1u
X2054 VSS.t730 VDD.t51 VSS.t730 VSS.t760 sg13_lv_nmos ad=0.1428p pd=1.52u as=0 ps=0 w=0.42u l=1u
X2055 oa_sar8_acore18_opt_0.sw_tg_opt_0.bot.t3 oa_sar8_acore18_opt_0.sw_bitcell_opt_b4_0.bot.t10 cap_cmim l=2.14u w=2.14u
X2056 sar_ctrl_async_phys_0.sg13g2_dfrbpq_1$1_9.D sar_ctrl_async_phys_0.sg13g2_a22oi_1$1_2.A2 a_31194_44996# VDD.t5 sg13_lv_pmos ad=0.3808p pd=2.92u as=0.1176p ps=1.33u w=1.12u l=0.13u
X2057 a_30752_39190# sar_ctrl_async_phys_0.sg13g2_o21ai_1$1_1.B1.t1 VDD.t29 VDD.t29 sg13_lv_pmos ad=79.8f pd=0.8u as=3.62845p ps=23.965u w=0.42u l=0.13u
X2058 a_34615_31475# a_34767_31359# VSS.t82 VSS.t1147 sg13_lv_nmos ad=0.2516p pd=2.16u as=4.0265p ps=25.31u w=0.74u l=0.13u
X2059 oa_sar8_acore18_opt_0.sw_bitcell_opt_b5_1.bot.t0 sar_ctrl_async_phys_0.dac_code_n[5] oa_sar8_acore18_opt_0.sw_bitcell_opt_b7_1.VSS VSS.t97 sg13_lv_nmos ad=0.5265p pd=3.09u as=0.945p ps=6.1u w=2.7u l=0.13u
X2060 VSS.t260 sar_ctrl_async_phys_0.sg13g2_buf_1$1_0.A a_34136_33688# VSS.t465 sg13_lv_nmos ad=0.14875p pd=1.16u as=0.187p ps=1.78u w=0.55u l=0.13u
X2061 sar_ctrl_async_phys_0.sg13g2_dlygate4sd3_1$1_0.A a_28870_35948# VDD.t20 VDD.t19 sg13_lv_pmos ad=0.4256p pd=3u as=0.2254p ps=1.53u w=1.12u l=0.13u
X2062 a_33652_41528# a_33626_41433# VDD.t114 VDD.t0 sg13_lv_pmos ad=0.34p pd=2.68u as=0.36237p ps=2.605u w=1u l=0.13u
X2063 sar_ctrl_async_phys_0.sg13g2_inv_1$1_0.A sar_ctrl_async_phys_0.sg13g2_buf_1$1_8.A a_33359_33292# VSS.t57 sg13_lv_nmos ad=0.2664p pd=1.46u as=0.13875p ps=1.115u w=0.74u l=0.13u
X2064 VDD.t233 VSS.t1 VDD.t233 VDD.t147 sg13_lv_pmos ad=0.19p pd=1.38u as=0 ps=0 w=1u l=1u
X2065 a_34324_36349# a_34036_35928# a_34262_36349# VSS.t630 sg13_lv_nmos ad=0.1428p pd=1.52u as=37.8f ps=0.6u w=0.42u l=0.13u
X2066 a_32149_45007# sar_ctrl_async_phys_0.sg13g2_dfrbpq_1$1_0.CLK.t28 VSS.t283 VSS.t446 sg13_lv_nmos ad=0.2516p pd=2.16u as=5.02618p ps=31.995u w=0.74u l=0.13u
X2067 a_33782_39711# sar_ctrl_async_phys_0.sg13g2_o21ai_1$1_1.B1.t4 VSS.t246 VSS.t245 sg13_lv_nmos ad=37.8f pd=0.6u as=0.1701p ps=1.65u w=0.42u l=0.13u
X2068 a_29210_38916# a_29653_38959# a_29593_38995# VDD.t29 sg13_lv_pmos ad=79.8f pd=0.8u as=63f ps=0.72u w=0.42u l=0.13u
X2069 oa_sar8_acore18_opt_0.sw_tg_opt_1.bot.t2 oa_sar8_acore18_opt_0.sw_bitcell_opt_b7_1.bot.t149 cap_cmim l=2.14u w=2.14u
X2070 oa_sar8_acore18_opt_0.sw_bitcell_opt_b1_0.bot.t4 oa_sar8_acore18_opt_0.sw_bitcell_opt_term_0.trkb.t14 oa_sar8_acore18_opt_0.sw_bitcell_opt_term_0.vin VDD.t952 sg13_lv_pmos ad=0.39p pd=2.39u as=0.7p ps=4.7u w=2u l=0.13u
X2071 a_32020_35175# a_31732_35480# a_31958_35175# VSS.t618 sg13_lv_nmos ad=0.1428p pd=1.52u as=37.8f ps=0.6u w=0.42u l=0.13u
X2072 a_31252_46933# a_31483_46519# a_30938_46476# VSS.t464 sg13_lv_nmos ad=0.2373p pd=1.97u as=79.8f ps=0.8u w=0.42u l=0.13u
X2073 VSS.t126 sar_ctrl_async_phys_0.sg13g2_a21oi_1$1_1.B1 a_34520_46508# VSS.t125 sg13_lv_nmos ad=0.14875p pd=1.16u as=0.187p ps=1.78u w=0.55u l=0.13u
X2074 sar_ctrl_async_phys_0.sg13g2_nor2_1$1_10.Y sar_ctrl_async_phys_0.sg13g2_nor2_1$1_10.B a_30714_43020# VDD.t22 sg13_lv_pmos ad=0.3808p pd=2.92u as=0.1176p ps=1.33u w=1.12u l=0.13u
X2075 oa_sar8_acore18_opt_0.sw_bitcell_opt_b3_0.bot.t1 oa_sar8_acore18_opt_0.sw_bitcell_opt_term_0.trkb.t16 oa_sar8_acore18_opt_0.sw_bitcell_opt_term_0.vin VDD.t610 sg13_lv_pmos ad=0.39p pd=2.39u as=0.7p ps=4.7u w=2u l=0.13u
X2076 oa_sar8_acore18_opt_0.sw_bitcell_opt_term_0.vin oa_sar8_acore18_opt_0.sw_bitcell_opt_term_0.trkb.t19 oa_sar8_acore18_opt_0.sw_bitcell_opt_b6_0.bot.t0 VDD.t670 sg13_lv_pmos ad=0.7p pd=4.7u as=0.39p ps=2.39u w=2u l=0.13u
X2077 sar_ctrl_async_phys_0.dac_code_n[0] a_34904_47296# VSS.t42 VSS.t41 sg13_lv_nmos ad=0.2886p pd=2.26u as=0.14875p ps=1.16u w=0.74u l=0.13u
X2078 a_30678_46946# sar_ctrl_async_phys_0.sg13g2_nor2b_1$1_4.Y VDD.t64 VDD.t10 sg13_lv_pmos ad=79.8f pd=0.8u as=0.1428p ps=1.52u w=0.42u l=0.13u
X2079 sar_ctrl_async_phys_0.sg13g2_nor2_1$1_2.Y sar_ctrl_async_phys_0.sg13g2_nor2b_1$1_1.Y VSS.t15 VSS.t177 sg13_lv_nmos ad=0.1406p pd=1.12u as=0.2516p ps=2.16u w=0.74u l=0.13u
X2080 a_30100_33663# a_30331_33772# a_29786_33873# VSS.t173 sg13_lv_nmos ad=0.2373p pd=1.97u as=79.8f ps=0.8u w=0.42u l=0.13u
X2081 a_25596_47222# sar_ctrl_async_phys_0.sg13g2_buf_1$1_29.X VSS.t40 VSS.t691 sg13_lv_nmos ad=0.187p pd=1.78u as=0.14875p ps=1.16u w=0.55u l=0.13u
X2082 VDD.t120 a_26270_39215# sar_ctrl_async_phys_0.sg13g2_dlygate4sd3_1$1_7.A VDD.t29 sg13_lv_pmos ad=0.2254p pd=1.53u as=0.4256p ps=3u w=1.12u l=0.13u
X2083 VSS.t341 a_26666_38912# a_26385_39214# VSS.t103 sg13_lv_nmos ad=79.8f pd=0.8u as=0.1428p ps=1.52u w=0.42u l=0.5u
X2084 oa_sar8_acore18_opt_0.sw_tg_opt_1.bot.t3 oa_sar8_acore18_opt_0.sw_bitcell_opt_b5_1.bot.t15 cap_cmim l=2.14u w=2.14u
X2085 a_33936_31675# a_34055_31352# VSS.t178 VSS.t2 sg13_lv_nmos ad=0.2516p pd=2.16u as=0.1406p ps=1.12u w=0.74u l=0.13u
X2086 VSS.t355 sar_ctrl_async_phys_0.sg13g2_dlygate4sd3_1$1_6.X sar_ctrl_async_phys_0.sg13g2_nand3_1$1_0.C VSS.t103 sg13_lv_nmos ad=0.2516p pd=2.16u as=0.1406p ps=1.12u w=0.74u l=0.13u
X2087 VSS.t35 a_25878_40460# a_25990_40484# VSS.t651 sg13_lv_nmos ad=0.1426p pd=1.16u as=0.1428p ps=1.52u w=0.42u l=0.5u
X2088 VDD.t145 VSS.t146 VDD.t145 VDD.t16 sg13_lv_pmos ad=0.34p pd=2.68u as=0 ps=0 w=1u l=1u
X2089 a_34036_35928# a_34010_35892# VDD.t258 VDD.t19 sg13_lv_pmos ad=0.34p pd=2.68u as=0.36237p ps=2.605u w=1u l=0.13u
X2090 VDD.t8 sar_ctrl_async_phys_0.sg13g2_buf_1$1_41.X a_31446_45434# VDD.t5 sg13_lv_pmos ad=0.36237p pd=2.605u as=79.8f ps=0.8u w=0.42u l=0.13u
X2091 sar_ctrl_async_phys_0.sg13g2_nor2_1$1_2.Y sar_ctrl_async_phys_0.sg13g2_a22oi_1$1_0.A2 a_33882_38484# VDD.t29 sg13_lv_pmos ad=0.3808p pd=2.92u as=0.1176p ps=1.33u w=1.12u l=0.13u
X2092 a_28874_37806# sar_ctrl_async_phys_0.sg13g2_nand2_1$1_1.B VSS.t102 VSS.t265 sg13_lv_nmos ad=0.1406p pd=1.12u as=0.2516p ps=2.16u w=0.74u l=0.13u
X2093 oa_sar8_acore18_opt_0.sw_tg_opt_0.bot.t3 oa_sar8_acore18_opt_0.sw_bitcell_opt_b7_0.bot.t128 cap_cmim l=2.14u w=2.14u
X2094 VDD.t319 a_35280_35365# sar_ctrl_async_phys_0.sg13g2_nor2b_1$1_1.B_N VDD.t19 sg13_lv_pmos ad=0.1918p pd=1.5u as=0.3808p ps=2.92u w=1.12u l=0.13u
X2095 sar_ctrl_async_phys_0.sg13g2_buf_1$1_35.A sar_ctrl_async_phys_0.sg13g2_nand2b_1$1_2.A_N VDD.t562 VDD.t0 sg13_lv_pmos ad=0.2128p pd=1.5u as=0.3808p ps=2.92u w=1.12u l=0.13u
X2096 oa_sar8_acore18_opt_0.sw_tg_opt_1.bot.t3 oa_sar8_acore18_opt_0.sw_bitcell_opt_b7_1.bot.t142 cap_cmim l=2.14u w=2.14u
X2097 VSS.t33 a_35280_35365# sar_ctrl_async_phys_0.sg13g2_nor2b_1$1_1.B_N VSS.t12 sg13_lv_nmos ad=0.1331p pd=1.12u as=0.2516p ps=2.16u w=0.74u l=0.13u
X2098 sar_ctrl_async_phys_0.sg13g2_buf_1$1_13.A a_32602_35924# VSS.t75 VSS.t74 sg13_lv_nmos ad=0.2516p pd=2.16u as=0.1406p ps=1.12u w=0.74u l=0.13u
X2099 a_30486_31826# a_31291_31399# a_30746_31356# VDD.t3 sg13_lv_pmos ad=0.1428p pd=1.52u as=79.8f ps=0.8u w=0.42u l=0.13u
X2100 oa_sar8_acore18_opt_0.sw_tg_opt_1.bot.t3 oa_sar8_acore18_opt_0.sw_bitcell_opt_b5_1.bot.t30 cap_cmim l=2.14u w=2.14u
X2101 a_32687_33292# sar_ctrl_async_phys_0.sg13g2_a22oi_1$1_0.B1 VSS.t260 VSS.t57 sg13_lv_nmos ad=0.13875p pd=1.115u as=0.2553p ps=2.17u w=0.74u l=0.13u
X2102 a_31034_44457# a_31477_44213# a_30774_44234# VSS.t24 sg13_lv_nmos ad=79.8f pd=0.8u as=0.1296p ps=1.52u w=0.42u l=0.13u
X2103 sar_ctrl_async_phys_0.sg13g2_dlygate4sd3_1$1_5.A track VDD.t340 VDD.t317 sg13_lv_pmos ad=0.3808p pd=2.92u as=0.3808p ps=2.92u w=1.12u l=0.13u
X2104 a_34261_36653# sar_ctrl_async_phys_0.sg13g2_dfrbpq_1$1_0.CLK.t13 VDD.t16 VDD.t16 sg13_lv_pmos ad=0.4088p pd=2.97u as=2.2076p ps=14.4u w=1.12u l=0.13u
X2105 VDD.t64 VSS.t172 VDD.t64 VDD.t10 sg13_lv_pmos ad=0.19p pd=1.38u as=0 ps=0 w=1u l=1u
X2106 oa_sar8_acore18_opt_0.sw_tg_opt_0.bot.t3 oa_sar8_acore18_opt_0.sw_bitcell_opt_b7_0.bot.t94 cap_cmim l=2.14u w=2.14u
X2107 VDD.t372 sar_ctrl_async_phys_0.sg13g2_buf_1$1_5.A a_35288_33688# VDD.t147 sg13_lv_pmos ad=0.2114p pd=1.54u as=0.2856p ps=2.36u w=0.84u l=0.13u
X2108 VDD.t202 sar_ctrl_async_phys_0.sg13g2_a22oi_1$1_0.Y sar_ctrl_async_phys_0.sg13g2_inv_1$1_2.Y VDD.t147 sg13_lv_pmos ad=0.3808p pd=2.92u as=0.3808p ps=2.92u w=1.12u l=0.13u
X2109 VDD.t329 a_34636_31749# a_35659_31435# VDD.t3 sg13_lv_pmos ad=0.1563p pd=1.22u as=63f ps=0.72u w=0.42u l=0.13u
X2110 sar_ctrl_async_phys_0.sg13g2_buf_1$1_0.A a_31258_32436# VSS.t17 VSS.t1210 sg13_lv_nmos ad=0.2516p pd=2.16u as=0.1406p ps=1.12u w=0.74u l=0.13u
X2111 VSS.t120 sar_ctrl_async_phys_0.sg13g2_buf_1$1_41.X a_29428_43922# VSS.t119 sg13_lv_nmos ad=0.1626p pd=1.415u as=60.89999f ps=0.71u w=0.42u l=0.13u
X2112 sar_ctrl_async_phys_0.sg13g2_a22oi_1$1_0.A2 sar_ctrl_async_phys_0.sg13g2_a21oi_1$1_1.B1 VSS.t210 VSS.t14 sg13_lv_nmos ad=0.1406p pd=1.12u as=0.2516p ps=2.16u w=0.74u l=0.13u
X2113 a_33626_41433# a_34069_41189# a_33366_41210# VSS.t185 sg13_lv_nmos ad=79.8f pd=0.8u as=0.1296p ps=1.52u w=0.42u l=0.13u
X2114 VSS.t701 oa_sar8_acore18_opt_0.sw_bitcell_opt_term_0.trkb.t6 a_35028_n9612# VSS.t700 sg13_lv_nmos ad=0.345p pd=2.69u as=0.19p ps=1.38u w=1u l=0.15u
X2115 a_34106_30849# a_34549_30605# a_34489_31017# VDD.t3 sg13_lv_pmos ad=79.8f pd=0.8u as=63f ps=0.72u w=0.42u l=0.13u
X2116 result[7] a_34904_33688# VSS.t654 VSS.t712 sg13_lv_nmos ad=0.2886p pd=2.26u as=0.14875p ps=1.16u w=0.74u l=0.13u
X2117 a_35725_45266# sar_ctrl_async_phys_0.sg13g2_nand2b_1$1_4.A_N VSS.t109 VSS.t1225 sg13_lv_nmos ad=0.187p pd=1.78u as=0.14505p ps=1.15u w=0.55u l=0.13u
X2118 oa_sar8_acore18_opt_0.sw_tg_opt_1.bot.t3 oa_sar8_acore18_opt_0.sw_bitcell_opt_b7_1.bot.t100 cap_cmim l=2.14u w=2.14u
X2119 VSS.t95 sar_ctrl_async_phys_0.cmp_n a_25496_34412# VSS.t0 sg13_lv_nmos ad=0.14875p pd=1.16u as=0.187p ps=1.78u w=0.55u l=0.13u
X2120 a_35103_36751# a_34261_36653# a_33844_36992# VDD.t16 sg13_lv_pmos ad=0.2048p pd=1.63u as=0.34p ps=2.68u w=1u l=0.13u
X2121 VDD.t22 a_35360_43726# a_35305_43607# VDD.t22 sg13_lv_pmos ad=2.48357p pd=16.205u as=93.45f ps=0.865u w=0.42u l=0.13u
X2122 oa_sar8_acore18_opt_0.sw_tg_opt_1.bot.t3 oa_sar8_acore18_opt_0.sw_bitcell_opt_b7_1.bot.t79 cap_cmim l=2.14u w=2.14u
X2123 VDD.t23 VSS.t825 VDD.t23 VDD.t22 sg13_lv_pmos ad=0.19p pd=1.38u as=0 ps=0 w=1u l=1u
X2124 a_31298_43922# sar_ctrl_async_phys_0.sg13g2_buf_1$1_41.X VSS.t137 VSS.t142 sg13_lv_nmos ad=37.8f pd=0.6u as=79.8f ps=0.8u w=0.42u l=0.13u
X2125 a_32054_37861# sar_ctrl_async_phys_0.sg13g2_buf_1$1_2.X.t6 VSS.t344 VSS.t1240 sg13_lv_nmos ad=37.8f pd=0.6u as=0.1701p ps=1.65u w=0.42u l=0.13u
X2126 oa_sar8_acore18_opt_0.sw_tg_opt_0.bot.t3 oa_sar8_acore18_opt_0.sw_bitcell_opt_b7_0.bot.t110 cap_cmim l=2.14u w=2.14u
X2127 sar_ctrl_async_phys_0.sg13g2_nor2_1$1_4.Y sar_ctrl_async_phys_0.sg13g2_and2_1$1_3.A VSS.t65 VSS.t66 sg13_lv_nmos ad=0.1406p pd=1.12u as=0.2516p ps=2.16u w=0.74u l=0.13u
X2128 VDD.t11 a_26364_45710# sar_ctrl_async_phys_0.sg13g2_buf_1$1_29.X VDD.t10 sg13_lv_pmos ad=0.2114p pd=1.54u as=0.42p ps=2.99u w=1.12u l=0.13u
X2129 oa_sar8_acore18_opt_0.sw_tg_opt_1.bot.t3 oa_sar8_acore18_opt_0.sw_bitcell_opt_b5_1.bot.t2 cap_cmim l=2.14u w=2.14u
X2130 a_29236_38952# a_29755_38959# a_30495_39309# VSS.t1270 sg13_lv_nmos ad=0.3473p pd=2.71u as=0.12665p ps=1.145u w=0.74u l=0.13u
X2131 a_29276_37436# sar_ctrl_async_phys_0.sg13g2_nor2_1$1_6.Y sar_ctrl_async_phys_0.sg13g2_nor2_1$1_6.B VDD.t16 sg13_lv_pmos ad=0.1176p pd=1.33u as=0.3808p ps=2.92u w=1.12u l=0.13u
X2132 a_35664_37695# sar_ctrl_async_phys_0.sg13g2_buf_1$1_3.A a_35801_37784# VSS.t14 sg13_lv_nmos ad=0.2176p pd=1.96u as=0.1216p ps=1.02u w=0.64u l=0.13u
X2133 VDD.t177 VSS.t126 VDD.t176 VDD.t10 sg13_lv_pmos ad=0.34p pd=2.68u as=0 ps=0 w=1u l=1u
X2134 VDD.t157 a_26454_41972# a_26566_41996# VDD.t0 sg13_lv_pmos ad=0.2254p pd=1.53u as=0.34p ps=2.68u w=1u l=0.5u
X2135 a_35952_39901# sar_ctrl_async_phys_0.sg13g2_a21oi_1$1_3.A2 VDD.t317 VDD.t317 sg13_lv_pmos ad=0.1596p pd=1.22u as=0.1918p ps=1.5u w=0.84u l=0.13u
X2136 VDD.t233 VSS.t1 VDD.t233 VDD.t147 sg13_lv_pmos ad=0.34p pd=2.68u as=0 ps=0 w=1u l=1u
X2137 a_33460_41210# sar_ctrl_async_phys_0.sg13g2_nor2_1$1_15.Y a_33366_41210# VSS.t1162 sg13_lv_nmos ad=60.89999f pd=0.71u as=0.1428p ps=1.52u w=0.42u l=0.13u
X2138 sar_ctrl_async_phys_0.dac_code_n[4] a_35672_47296# VDD.t175 VDD.t42 sg13_lv_pmos ad=0.42p pd=2.99u as=0.2114p ps=1.54u w=1.12u l=0.13u
X2139 sar_ctrl_async_phys_0.sg13g2_nor2_1$1_0.Y sar_ctrl_async_phys_0.sg13g2_a22oi_1$1_4.A2 a_32442_38484# VDD.t29 sg13_lv_pmos ad=0.3808p pd=2.92u as=0.1176p ps=1.33u w=1.12u l=0.13u
X2140 sar_ctrl_async_phys_0.sg13g2_a22oi_1$1_2.Y sar_ctrl_async_phys_0.sg13g2_a22oi_1$1_2.B2 a_31823_33292# VSS.t57 sg13_lv_nmos ad=0.2664p pd=1.46u as=0.13875p ps=1.115u w=0.74u l=0.13u
X2141 a_33183_32215# a_32341_32117# a_31924_32456# VDD.t76 sg13_lv_pmos ad=0.2048p pd=1.63u as=0.34p ps=2.68u w=1u l=0.13u
X2142 VSS.t46 VDD.t219 VSS.t46 VSS.t860 sg13_lv_nmos ad=0.1428p pd=1.52u as=0 ps=0 w=0.42u l=1u
X2143 VSS.t208 sar_ctrl_async_phys_0.sg13g2_dlygate4sd3_1$1_9.X a_26184_39702# VSS.t103 sg13_lv_nmos ad=79.8f pd=0.8u as=0.1428p ps=1.52u w=0.42u l=0.13u
X2144 oa_sar8_acore18_opt_0.sw_tg_opt_0.bot.t3 oa_sar8_acore18_opt_0.sw_bitcell_opt_b7_0.bot.t47 cap_cmim l=2.14u w=2.14u
X2145 a_32687_32876# sar_ctrl_async_phys_0.sg13g2_buf_1$1_10.A sar_ctrl_async_phys_0.sg13g2_a22oi_1$1_4.Y VDD.t76 sg13_lv_pmos ad=0.2744p pd=1.61u as=0.2128p ps=1.5u w=1.12u l=0.13u
X2146 VSS.t65 sar_ctrl_async_phys_0.sg13g2_nor2_1$1_3.B sar_ctrl_async_phys_0.sg13g2_nor2_1$1_3.Y VSS.t1212 sg13_lv_nmos ad=0.2516p pd=2.16u as=0.1406p ps=1.12u w=0.74u l=0.13u
X2147 VDD.t6 VSS.t120 VDD.t6 VDD.t5 sg13_lv_pmos ad=0.34p pd=2.68u as=0 ps=0 w=1u l=1u
X2148 VSS.t42 sar_ctrl_async_phys_0.sg13g2_a21oi_1$1_6.B1 a_35672_47296# VSS.t41 sg13_lv_nmos ad=0.14875p pd=1.16u as=0.187p ps=1.78u w=0.55u l=0.13u
X2149 oa_sar8_acore18_opt_0.sw_tg_opt_0.bot.t3 oa_sar8_acore18_opt_0.sw_bitcell_opt_b6_0.bot.t64 cap_cmim l=2.14u w=2.14u
X2150 VSS.t270 VDD.t19 VSS.t270 VSS.t984 sg13_lv_nmos ad=0.1428p pd=1.52u as=0 ps=0 w=0.42u l=1u
X2151 VSS.t102 sar_ctrl_async_phys_0.sg13g2_nor2_1$1_5.A sar_ctrl_async_phys_0.sg13g2_nand2_1$1_1.B VSS.t573 sg13_lv_nmos ad=0.2516p pd=2.16u as=0.1406p ps=1.12u w=0.74u l=0.13u
X2152 oa_sar8_acore18_opt_0.sw_tg_opt_1.bot.t3 oa_sar8_acore18_opt_0.sw_bitcell_opt_b6_1.bot.t22 cap_cmim l=2.14u w=2.14u
X2153 VSS.t883 VDD.t157 VSS.t29 VSS.t884 sg13_lv_nmos ad=79.8f pd=0.8u as=0 ps=0 w=0.42u l=1u
X2154 VSS.t65 sar_ctrl_async_phys_0.sg13g2_and2_1$1_3.A a_26630_37814# VSS.t64 sg13_lv_nmos ad=0.1406p pd=1.12u as=0.2516p ps=2.16u w=0.74u l=0.15u
X2155 VDD.t16 a_35360_36894# a_35305_36989# VDD.t16 sg13_lv_pmos ad=2.48357p pd=16.205u as=93.45f ps=0.865u w=0.42u l=0.13u
X2156 VDD.t229 sar_ctrl_async_phys_0.sg13g2_and2_1$1_0.A sar_ctrl_async_phys_0.sg13g2_a22oi_1$1_3.B1 VDD.t147 sg13_lv_pmos ad=0.3808p pd=2.92u as=0.2128p ps=1.5u w=1.12u l=0.13u
X2157 a_33410_35162# sar_ctrl_async_phys_0.sg13g2_buf_1$1_6.X.t1 VSS.t44 VSS.t43 sg13_lv_nmos ad=37.8f pd=0.6u as=79.8f ps=0.8u w=0.42u l=0.13u
X2158 VDD.t176 sar_ctrl_async_phys_0.sg13g2_o21ai_1$1_1.B1.t15 a_32666_45969# VDD.t10 sg13_lv_pmos ad=0.1563p pd=1.22u as=0.147p ps=1.54u w=0.42u l=0.13u
X2159 oa_sar8_acore18_opt_0.sw_tg_opt_0.bot.t3 oa_sar8_acore18_opt_0.sw_bitcell_opt_b6_0.bot.t54 cap_cmim l=2.14u w=2.14u
X2160 a_28505_36720# sar_ctrl_async_phys_0.sg13g2_nand2_1$1_1.B VSS.t146 VSS.t266 sg13_lv_nmos ad=0.1216p pd=1.02u as=0.1331p ps=1.12u w=0.64u l=0.13u
X2161 oa_sar8_acore18_opt_0.sw_tg_opt_1.bot.t3 oa_sar8_acore18_opt_0.sw_bitcell_opt_b7_1.bot.t69 cap_cmim l=2.14u w=2.14u
X2162 a_35810_33338# sar_ctrl_async_phys_0.sg13g2_buf_1$1_6.X VSS.t92 VSS.t607 sg13_lv_nmos ad=37.8f pd=0.6u as=79.8f ps=0.8u w=0.42u l=0.13u
X2163 VDD.t4 VSS.t1122 VDD.t4 VDD.t3 sg13_lv_pmos ad=0.19p pd=1.38u as=0 ps=0 w=1u l=1u
X2164 VSS.t216 sar_ctrl_async_phys_0.sg13g2_nand2_1$1_3.B a_35018_42726# VSS.t215 sg13_lv_nmos ad=0.2516p pd=2.16u as=0.1406p ps=1.12u w=0.74u l=0.13u
X2165 VDD.t145 sar_ctrl_async_phys_0.sg13g2_and2_1$1_0.A sar_ctrl_async_phys_0.sg13g2_nor2_1$1_3.B VDD.t16 sg13_lv_pmos ad=0.3808p pd=2.92u as=0.2128p ps=1.5u w=1.12u l=0.15u
X2166 VDD.t100 VSS.t46 VDD.t2 VDD.t0 sg13_lv_pmos ad=0.19p pd=1.38u as=0 ps=0 w=1u l=1u
X2167 VDD.t562 a_35772_41936# sar_ctrl_async_phys_0.sg13g2_nand2b_1$1_1.B VDD.t0 sg13_lv_pmos ad=0.2114p pd=1.54u as=0.42p ps=2.99u w=1.12u l=0.13u
X2168 VSS.t111 a_26570_42690# a_26289_42912# VSS.t489 sg13_lv_nmos ad=79.8f pd=0.8u as=0.1428p ps=1.52u w=0.42u l=0.5u
X2169 oa_sar8_acore18_opt_0.sw_tg_opt_1.bot.t3 oa_sar8_acore18_opt_0.sw_bitcell_opt_b7_1.bot.t22 cap_cmim l=2.14u w=2.14u
X2170 a_33654_44234# sar_ctrl_async_phys_0.sg13g2_nor2_1$1_1.Y VDD.t407 VDD.t5 sg13_lv_pmos ad=79.8f pd=0.8u as=0.1428p ps=1.52u w=0.42u l=0.13u
X2171 a_31830_40898# sar_ctrl_async_phys_0.sg13g2_dfrbpq_1$1_11.D VDD.t326 VDD.t317 sg13_lv_pmos ad=79.8f pd=0.8u as=0.1428p ps=1.52u w=0.42u l=0.13u
X2172 VDD.t76 a_33440_32358# a_33385_32453# VDD.t76 sg13_lv_pmos ad=1.96315p pd=12.675u as=93.45f ps=0.865u w=0.42u l=0.13u
X2173 sar_ctrl_async_phys_0.sg13g2_a21oi_1$1_0.B1 a_35245_45266# VDD.t349 VDD.t5 sg13_lv_pmos ad=0.2128p pd=1.5u as=0.3808p ps=2.92u w=1.12u l=0.13u
X2174 a_35028_n9612# oa_sar8_acore18_opt_0.sw_bitcell_opt_term_0.trkb.t6 VSS.t701 VSS.t700 sg13_lv_nmos ad=0.19p pd=1.38u as=0.345p ps=2.69u w=1u l=0.15u
X2175 VSS.t1022 VDD.t97 VSS.t1024 VSS.t1023 sg13_lv_nmos ad=79.8f pd=0.8u as=0 ps=0 w=0.42u l=1u
X2176 a_31935_36285# a_31093_35935# a_31841_36285# VSS.t74 sg13_lv_nmos ad=0.12665p pd=1.145u as=0.1428p ps=1.52u w=0.42u l=0.13u
X2177 VDD.t2 VSS.t892 VDD.t2 VDD.t0 sg13_lv_pmos ad=0.19p pd=1.38u as=0 ps=0 w=1u l=1u
X2178 a_30964_46512# a_30938_46476# VDD.t64 VDD.t10 sg13_lv_pmos ad=0.34p pd=2.68u as=0.36237p ps=2.605u w=1u l=0.13u
X2179 oa_sar8_acore18_opt_0.sw_tg_opt_1.bot.t3 oa_sar8_acore18_opt_0.sw_bitcell_opt_b6_1.bot.t42 cap_cmim l=2.14u w=2.14u
X2180 a_29306_32361# a_29749_32117# a_29046_32138# VSS.t1253 sg13_lv_nmos ad=79.8f pd=0.8u as=0.1296p ps=1.52u w=0.42u l=0.13u
X2181 VDD.t349 sar_ctrl_async_phys_0.sg13g2_nand2b_1$1_1.B sar_ctrl_async_phys_0.sg13g2_a21oi_1$1_1.B1 VDD.t5 sg13_lv_pmos ad=0.2198p pd=1.53u as=0.2128p ps=1.5u w=1.12u l=0.13u
X2182 oa_sar8_acore18_opt_0.sw_bitcell_opt_b5_1.bot.t0 oa_sar8_acore18_opt_0.bstrap_opt_w2_c1200_1.gb oa_sar8_acore18_opt_0.bstrap_opt_w2_c1200_1.out VSS.t161 sg13_lv_nmos ad=0.195p pd=1.39u as=0.35p ps=2.7u w=1u l=0.13u
X2183 VDD.t79 VSS.t1065 VDD.t59 VDD.t3 sg13_lv_pmos ad=0.34p pd=2.68u as=0 ps=0 w=1u l=1u
X2184 a_34132_36687# a_33844_36992# a_34070_36687# VSS.t694 sg13_lv_nmos ad=0.1428p pd=1.52u as=37.8f ps=0.6u w=0.42u l=0.13u
X2185 oa_sar8_acore18_opt_0.sw_tg_opt_0.bot.t3 oa_sar8_acore18_opt_0.sw_bitcell_opt_b2_0.bot.t8 cap_cmim l=2.14u w=2.14u
X2186 oa_sar8_acore18_opt_0.sw_tg_opt_1.bot.t3 oa_sar8_acore18_opt_0.sw_bitcell_opt_b7_1.bot.t116 cap_cmim l=2.14u w=2.14u
X2187 a_29620_43488# a_29594_43452# VDD.t25 VDD.t22 sg13_lv_pmos ad=0.34p pd=2.68u as=0.36237p ps=2.605u w=1u l=0.13u
X2188 sar_ctrl_async_phys_0.sg13g2_buf_1$1_26.X a_25496_31388# VSS.t180 VSS.t179 sg13_lv_nmos ad=0.2886p pd=2.26u as=0.14875p ps=1.16u w=0.74u l=0.13u
X2189 VSS.t260 sar_ctrl_async_phys_0.sg13g2_a22oi_1$1_4.A2 a_32958_33292# VSS.t57 sg13_lv_nmos ad=0.2516p pd=2.16u as=96.2f ps=1u w=0.74u l=0.13u
X2190 oa_sar8_acore18_opt_0.sw_tg_opt_1.bot.t3 oa_sar8_acore18_opt_0.sw_bitcell_opt_b7_1.bot.t53 cap_cmim l=2.14u w=2.14u
X2191 VSS.t277 a_35103_36751# a_35770_36972# VSS.t276 sg13_lv_nmos ad=0.1406p pd=1.12u as=0.2516p ps=2.16u w=0.74u l=0.13u
X2192 VDD.t376 sar_ctrl_async_phys_0.sg13g2_buf_1$1_3.A sar_ctrl_async_phys_0.sg13g2_buf_1$1_21.A VDD.t29 sg13_lv_pmos ad=0.3808p pd=2.92u as=0.2128p ps=1.5u w=1.12u l=0.13u
X2193 oa_sar8_acore18_opt_0.sw_bitcell_opt_term_0.VSS sar_ctrl_async_phys_0.hold_req VSS.t514 VSS.t516 sg13_lv_nmos ad=0.39p pd=2.39u as=0.7p ps=4.7u w=2u l=0.13u
X2194 VDD.t416 a_36156_45710# sar_ctrl_async_phys_0.sg13g2_nand2_1$1_3.A VDD.t10 sg13_lv_pmos ad=0.2114p pd=1.54u as=0.42p ps=2.99u w=1.12u l=0.13u
X2195 a_26454_41972# a_26184_42013# VSS.t111 VSS.t110 sg13_lv_nmos ad=0.1428p pd=1.52u as=79.8f ps=0.8u w=0.42u l=0.5u
X2196 oa_sar8_acore18_opt_0.sw_bitcell_opt_b6_0.bot.t0 oa_sar8_acore18_opt_0.sw_bitcell_opt_term_0.trkb.t19 oa_sar8_acore18_opt_0.sw_bitcell_opt_term_0.vin VDD.t670 sg13_lv_pmos ad=0.39p pd=2.39u as=0.7p ps=4.7u w=2u l=0.13u
X2197 oa_sar8_acore18_opt_0.bstrap_opt_w2_c1200_1.out oa_sar8_acore18_opt_0.sw_bitcell_opt_term_0.trkb.t26 oa_sar8_acore18_opt_0.sw_bitcell_opt_b2_1.bot.t0 VDD.t608 sg13_lv_pmos ad=0.7p pd=4.7u as=0.39p ps=2.39u w=2u l=0.13u
X2198 VSS.t116 a_35557_31435# a_34636_31749# VSS.t1275 sg13_lv_nmos ad=0.1626p pd=1.415u as=0.2516p ps=2.16u w=0.74u l=0.13u
X2199 sar_ctrl_async_phys_0.sg13g2_inv_1$1_5.A sar_ctrl_async_phys_0.sg13g2_a22oi_1$1_0.B1 a_30671_32876# VDD.t76 sg13_lv_pmos ad=0.2128p pd=1.5u as=0.2716p ps=1.605u w=1.12u l=0.13u
X2200 VDD.t4 sar_ctrl_async_phys_0.sg13g2_a22oi_1$1_2.Y sar_ctrl_async_phys_0.sg13g2_inv_1$1_11.Y VDD.t3 sg13_lv_pmos ad=0.3808p pd=2.92u as=0.3808p ps=2.92u w=1.12u l=0.13u
X2201 sar_ctrl_async_phys_0.sg13g2_dlygate4sd3_1$1_3.A a_28774_41278# VSS.t575 VSS.t626 sg13_lv_nmos ad=0.2516p pd=2.16u as=0.1426p ps=1.16u w=0.74u l=0.13u
X2202 oa_sar8_acore18_opt_0.sw_tg_opt_1.bot.t3 oa_sar8_acore18_opt_0.sw_bitcell_opt_b3_1.bot.t9 cap_cmim l=2.14u w=2.14u
X2203 a_31081_43607# a_30139_43495# a_30879_43845# VDD.t22 sg13_lv_pmos ad=93.45f pd=0.865u as=0.2048p ps=1.63u w=0.42u l=0.13u
X2204 VSS.t33 sar_ctrl_async_phys_0.sg13g2_nor2b_1$1_1.B_N a_34808_35200# VSS.t430 sg13_lv_nmos ad=0.14875p pd=1.16u as=0.187p ps=1.78u w=0.55u l=0.13u
X2205 VSS.t886 VDD.t1 VSS.t537 VSS.t887 sg13_lv_nmos ad=79.8f pd=0.8u as=0 ps=0 w=0.42u l=1u
X2206 oa_sar8_acore18_opt_0.sw_tg_opt_1.bot.t3 oa_sar8_acore18_opt_0.sw_bitcell_opt_b6_1.bot.t70 cap_cmim l=2.14u w=2.14u
X2207 oa_sar8_acore18_opt_0.sw_tg_opt_0.bot.t3 oa_sar8_acore18_opt_0.sw_bitcell_opt_b7_0.bot.t73 cap_cmim l=2.14u w=2.14u
X2208 oa_sar8_acore18_opt_0.sw_tg_opt_1.bot.t3 oa_sar8_acore18_opt_0.sw_bitcell_opt_b2_1.bot.t2 cap_cmim l=2.14u w=2.14u
X2209 oa_sar8_acore18_opt_0.sw_tg_opt_0.bot.t2 oa_sar8_acore18_opt_0.sw_bitcell_opt_b7_0.bot.t162 cap_cmim l=2.14u w=2.14u
X2210 result[4] a_33752_33688# VSS.t260 VSS.t176 sg13_lv_nmos ad=0.2886p pd=2.26u as=0.14875p ps=1.16u w=0.74u l=0.13u
X2211 VSS.t210 sar_ctrl_async_phys_0.sg13g2_a21oi_1$1_0.A2 a_34833_37784# VSS.t14 sg13_lv_nmos ad=0.2516p pd=2.16u as=0.1406p ps=1.12u w=0.74u l=0.13u
X2212 VDD.t43 VSS.t40 VDD.t43 VDD.t42 sg13_lv_pmos ad=0.34p pd=2.68u as=0 ps=0 w=1u l=1u
X2213 a_35135_40830# a_35053_40730# sar_ctrl_async_phys_0.sg13g2_nand2b_1$1_3.Y VSS.t304 sg13_lv_nmos ad=0.1406p pd=1.12u as=0.333p ps=2.38u w=0.74u l=0.13u
X2214 VDD.t388 a_30495_39309# a_30752_39190# VDD.t29 sg13_lv_pmos ad=3.62845p pd=23.965u as=79.8f ps=0.8u w=0.42u l=0.13u
X2215 a_34262_36349# sar_ctrl_async_phys_0.sg13g2_dfrbpq_1$1_3.RESET_B VSS.t219 VSS.t1300 sg13_lv_nmos ad=37.8f pd=0.6u as=0.1701p ps=1.65u w=0.42u l=0.13u
X2216 oa_sar8_acore18_opt_0.sw_bitcell_opt_term_0.bot.t0 oa_sar8_acore18_opt_0.sw_bitcell_opt_term_0.gb.t4 oa_sar8_acore18_opt_0.sw_bitcell_opt_term_0.vin VSS.t590 sg13_lv_nmos ad=0.195p pd=1.39u as=0.35p ps=2.7u w=1u l=0.13u
X2217 a_31924_32456# a_31898_32361# VDD.t345 VDD.t76 sg13_lv_pmos ad=0.34p pd=2.68u as=0.36237p ps=2.605u w=1u l=0.13u
X2218 a_31958_35175# sar_ctrl_async_phys_0.sg13g2_buf_1$1_6.X.t2 VSS.t1 VSS.t604 sg13_lv_nmos ad=37.8f pd=0.6u as=0.1701p ps=1.65u w=0.42u l=0.13u
X2219 oa_sar8_acore18_opt_0.sw_tg_opt_0.bot.t3 oa_sar8_acore18_opt_0.sw_bitcell_opt_b6_0.bot.t49 cap_cmim l=2.14u w=2.14u
X2220 sar_ctrl_async_phys_0.sg13g2_a21oi_1$1_6.A2 a_32890_46508# VSS.t126 VSS.t125 sg13_lv_nmos ad=0.2516p pd=2.16u as=0.1406p ps=1.12u w=0.74u l=0.13u
X2221 VSS.t82 sar_ctrl_async_phys_0.sg13g2_dfrbpq_1$1_0.CLK.t2 a_34767_31359# VSS.t291 sg13_lv_nmos ad=3.35542p pd=21.09u as=0.2516p ps=2.16u w=0.74u l=0.13u
X2222 VSS.t109 sar_ctrl_async_phys_0.sg13g2_nand2b_1$1_1.B a_35327_45366# VSS.t1166 sg13_lv_nmos ad=0.14505p pd=1.15u as=0.1406p ps=1.12u w=0.74u l=0.13u
X2223 sar_ctrl_async_phys_0.sg13g2_and2_1$1_0.B a_31162_38948# VSS.t107 VSS.t374 sg13_lv_nmos ad=0.2516p pd=2.16u as=0.1406p ps=1.12u w=0.74u l=0.13u
X2224 oa_sar8_acore18_opt_0.sw_tg_opt_1.bot.t3 oa_sar8_acore18_opt_0.sw_bitcell_opt_b0_1.bot.t2 cap_cmim l=2.14u w=2.14u
X2225 sar_ctrl_async_phys_0.sg13g2_nand2_1$1_3.B a_35866_44532# VSS.t38 VSS.t60 sg13_lv_nmos ad=0.2516p pd=2.16u as=0.1406p ps=1.12u w=0.74u l=0.13u
X2226 VSS.t126 VDD.t177 VSS.t126 VSS.t125 sg13_lv_nmos ad=0.1428p pd=1.52u as=0 ps=0 w=0.42u l=1u
X2227 VDD.t5 a_32149_45007# a_32251_45007# VDD.t5 sg13_lv_pmos ad=1.96315p pd=12.675u as=0.3864p ps=2.93u w=1.12u l=0.13u
X2228 oa_sar8_acore18_opt_0.sw_tg_opt_1.bot.t3 oa_sar8_acore18_opt_0.sw_bitcell_opt_b7_1.bot.t53 cap_cmim l=2.14u w=2.14u
X2229 a_35522_43922# sar_ctrl_async_phys_0.sg13g2_buf_1$1_41.X VSS.t122 VSS.t121 sg13_lv_nmos ad=37.8f pd=0.6u as=79.8f ps=0.8u w=0.42u l=0.13u
X2230 a_26454_41972# a_26184_42013# VDD.t156 VDD.t0 sg13_lv_pmos ad=0.34p pd=2.68u as=0.1523p ps=1.38u w=1u l=0.5u
X2231 sar_ctrl_async_phys_0.sg13g2_buf_1$1_2.A a_32696_30664# VSS.t696 VSS.t695 sg13_lv_nmos ad=0.2886p pd=2.26u as=0.14875p ps=1.16u w=0.74u l=0.13u
X2232 a_31189_31399# sar_ctrl_async_phys_0.sg13g2_dfrbpq_1$1_0.CLK.t3 VSS.t82 VSS.t345 sg13_lv_nmos ad=0.2516p pd=2.16u as=3.35542p ps=21.09u w=0.74u l=0.13u
X2233 VSS.t831 VDD.t6 VSS.t832 VSS.t224 sg13_lv_nmos ad=79.8f pd=0.8u as=0 ps=0 w=0.42u l=1u
X2234 oa_sar8_acore18_opt_0.sw_tg_opt_0.bot.t3 oa_sar8_acore18_opt_0.sw_bitcell_opt_b5_0.bot.t5 cap_cmim l=2.14u w=2.14u
X2235 VDD.t81 sar_ctrl_async_phys_0.cmp_p a_25496_31388# VDD.t3 sg13_lv_pmos ad=0.2114p pd=1.54u as=0.2856p ps=2.36u w=0.84u l=0.13u
X2236 VSS.t111 VDD.t33 VSS.t111 VSS.t848 sg13_lv_nmos ad=0.1428p pd=1.52u as=0 ps=0 w=0.42u l=1u
X2237 VDD.t2 VSS.t889 VDD.t2 VDD.t0 sg13_lv_pmos ad=0.34p pd=2.68u as=0 ps=0 w=1u l=1u
X2238 sar_ctrl_async_phys_0.sg13g2_nand2_1$1_1.Y sar_ctrl_async_phys_0.sg13g2_buf_1$1_2.X.t7 a_28874_37806# VSS.t1304 sg13_lv_nmos ad=0.2516p pd=2.16u as=0.1406p ps=1.12u w=0.74u l=0.13u
X2239 oa_sar8_acore18_opt_0.sw_tg_opt_0.bot.t3 oa_sar8_acore18_opt_0.sw_bitcell_opt_b7_0.bot.t57 cap_cmim l=2.14u w=2.14u
X2240 VDD.t562 sar_ctrl_async_phys_0.sg13g2_nand2b_1$1_1.B sar_ctrl_async_phys_0.sg13g2_buf_1$1_35.A VDD.t0 sg13_lv_pmos ad=0.3808p pd=2.92u as=0.2128p ps=1.5u w=1.12u l=0.13u
X2241 done a_35288_33688# VDD.t372 VDD.t147 sg13_lv_pmos ad=0.42p pd=2.99u as=0.2114p ps=1.54u w=1.12u l=0.13u
X2242 VDD.t320 a_34308_37400# a_34266_37436# VDD.t16 sg13_lv_pmos ad=0.2618p pd=1.63u as=0.1176p ps=1.33u w=1.12u l=0.13u
X2243 VSS.t390 sar_ctrl_async_phys_0.sample oa_sar8_acore18_opt_0.sw_bitcell_opt_term_0.trkb.t0 VSS.t389 sg13_lv_nmos ad=0.35p pd=2.7u as=0.195p ps=1.39u w=1u l=0.13u
X2244 VSS.t822 VDD.t33 VSS.t821 VSS.t224 sg13_lv_nmos ad=0.1428p pd=1.52u as=0 ps=0 w=0.42u l=1u
X2245 a_31286_44247# sar_ctrl_async_phys_0.sg13g2_buf_1$1_41.X VSS.t137 VSS.t138 sg13_lv_nmos ad=37.8f pd=0.6u as=0.1701p ps=1.65u w=0.42u l=0.13u
X2246 VSS.t341 a_26454_39702# a_26566_39766# VSS.t103 sg13_lv_nmos ad=0.1426p pd=1.16u as=0.1428p ps=1.52u w=0.42u l=0.5u
X2247 a_30027_39996# sar_ctrl_async_phys_0.sg13g2_a21oi_1$1_2.B1 sar_ctrl_async_phys_0.sg13g2_a21oi_1$1_2.Y VDD.t317 sg13_lv_pmos ad=0.2128p pd=1.5u as=0.3808p ps=2.92u w=1.12u l=0.13u
X2248 VDD.t13 VSS.t822 VDD.t13 VDD.t5 sg13_lv_pmos ad=0.34p pd=2.68u as=0 ps=0 w=1u l=1u
X2249 VSS.t511 sar_ctrl_async_phys_0.hold_req oa_sar8_acore18_opt_0.sw_bitcell_opt_b7_1.VSS VSS.t510 sg13_lv_nmos ad=0.7p pd=4.7u as=0.39p ps=2.39u w=2u l=0.13u
X2250 oa_sar8_acore18_opt_0.sw_tg_opt_0.bot.t2 oa_sar8_acore18_opt_0.sw_bitcell_opt_b7_0.bot.t167 cap_cmim l=2.14u w=2.14u
X2251 oa_sar8_acore18_opt_0.sw_bitcell_opt_term_0.VSS sar_ctrl_async_phys_0.hold_req VSS.t514 VSS.t513 sg13_lv_nmos ad=0.39p pd=2.39u as=0.7p ps=4.7u w=2u l=0.13u
X2252 VSS.t635 sar_ctrl_async_phys_0.sg13g2_buf_1$1_5.A a_35288_33688# VSS.t91 sg13_lv_nmos ad=0.14875p pd=1.16u as=0.187p ps=1.78u w=0.55u l=0.13u
X2253 oa_sar8_acore18_opt_0.sw_tg_opt_0.bot.t3 oa_sar8_acore18_opt_0.sw_bitcell_opt_b7_0.bot.t141 cap_cmim l=2.14u w=2.14u
X2254 a_33276_42686# sar_ctrl_async_phys_0.sg13g2_buf_1$1_13.A VDD.t219 VDD.t22 sg13_lv_pmos ad=0.2856p pd=2.36u as=0.2114p ps=1.54u w=0.84u l=0.13u
X2255 oa_sar8_acore18_opt_0.sw_tg_opt_1.bot.t3 oa_sar8_acore18_opt_0.sw_bitcell_opt_b4_1.bot.t10 cap_cmim l=2.14u w=2.14u
X2256 VSS.t1086 VDD.t90 VSS.t1088 VSS.t1087 sg13_lv_nmos ad=79.8f pd=0.8u as=0 ps=0 w=0.42u l=1u
X2257 VSS.t79 sar_ctrl_async_phys_0.sg13g2_nand2_1$1_5.Y a_36056_38948# VSS.t381 sg13_lv_nmos ad=0.14875p pd=1.16u as=0.187p ps=1.78u w=0.55u l=0.13u
X2258 sar_ctrl_async_phys_0.sg13g2_nor2_1$1_8.A sar_ctrl_async_phys_0.sg13g2_buf_1$1_2.X.t4 VDD.t17 VDD.t16 sg13_lv_pmos ad=0.2128p pd=1.5u as=0.2128p ps=1.5u w=1.12u l=0.13u
X2259 VSS.t1 sar_ctrl_async_phys_0.sg13g2_buf_1$1_17.A a_30507_35204# VSS.t0 sg13_lv_nmos ad=0.18945p pd=1.27u as=0.187p ps=1.78u w=0.55u l=0.13u
X2260 a_33940_41223# a_34171_41332# a_33626_41433# VSS.t1231 sg13_lv_nmos ad=0.2373p pd=1.97u as=79.8f ps=0.8u w=0.42u l=0.13u
X2261 oa_sar8_acore18_opt_0.sw_tg_opt_1.bot.t4 oa_sar8_acore18_opt_0.sw_bitcell_opt_b7_1.bot.t15 cap_cmim l=2.14u w=2.14u
X2262 VDD.t20 sar_ctrl_async_phys_0.sg13g2_buf_1$1_6.X.t2 a_31706_35385# VDD.t19 sg13_lv_pmos ad=0.1563p pd=1.22u as=0.147p ps=1.54u w=0.42u l=0.13u
X2263 a_33846_30626# a_34651_30748# a_34106_30849# VDD.t3 sg13_lv_pmos ad=0.1428p pd=1.52u as=79.8f ps=0.8u w=0.42u l=0.13u
X2264 a_34895_32460# sar_ctrl_async_phys_0.sg13g2_a22oi_1$1_0.A1 VDD.t343 VDD.t76 sg13_lv_pmos ad=0.2716p pd=1.605u as=0.3808p ps=2.92u w=1.12u l=0.13u
X2265 oa_sar8_acore18_opt_0.sw_tg_opt_1.bot.t3 oa_sar8_acore18_opt_0.sw_bitcell_opt_b6_1.bot.t2 cap_cmim l=2.14u w=2.14u
X2266 VSS.t621 sar_ctrl_async_phys_0.sg13g2_inv_1$1_5.A sar_ctrl_async_phys_0.sg13g2_inv_1$1_5.Y VSS.t608 sg13_lv_nmos ad=0.2516p pd=2.16u as=0.2516p ps=2.16u w=0.74u l=0.13u
X2267 sar_ctrl_async_phys_0.sg13g2_inv_1$1_6.A sar_ctrl_async_phys_0.sg13g2_a22oi_1$1_0.B1 a_31247_32876# VDD.t76 sg13_lv_pmos ad=0.2128p pd=1.5u as=0.2716p ps=1.605u w=1.12u l=0.13u
X2268 a_32090_40428# a_32533_40471# a_32473_40507# VDD.t317 sg13_lv_pmos ad=79.8f pd=0.8u as=63f ps=0.72u w=0.42u l=0.13u
X2269 oa_sar8_acore18_opt_0.sw_tg_opt_0.bot.t3 oa_sar8_acore18_opt_0.sw_bitcell_opt_b5_0.bot.t22 cap_cmim l=2.14u w=2.14u
X2270 VDD.t330 sar_ctrl_async_phys_0.sg13g2_nand2b_1$1_1.B sar_ctrl_async_phys_0.sg13g2_nand2_1$1_5.Y VDD.t22 sg13_lv_pmos ad=0.3808p pd=2.92u as=0.2128p ps=1.5u w=1.12u l=0.13u
X2271 oa_sar8_acore18_opt_0.sw_tg_opt_1.bot.t3 oa_sar8_acore18_opt_0.sw_bitcell_opt_b5_1.bot.t35 cap_cmim l=2.14u w=2.14u
X2272 VDD.t156 VSS.t111 VDD.t154 VDD.t0 sg13_lv_pmos ad=0.19p pd=1.38u as=0 ps=0 w=1u l=1u
X2273 VDD.t114 sar_ctrl_async_phys_0.sg13g2_a21oi_1$1_0.A1 a_31947_41508# VDD.t0 sg13_lv_pmos ad=0.2128p pd=1.5u as=0.2128p ps=1.5u w=1.12u l=0.13u
X2274 a_29908_43909# a_30139_43495# a_29594_43452# VSS.t524 sg13_lv_nmos ad=0.2373p pd=1.97u as=79.8f ps=0.8u w=0.42u l=0.13u
X2275 a_33973_39677# sar_ctrl_async_phys_0.sg13g2_dfrbpq_1$1_0.CLK.t17 VDD.t317 VDD.t317 sg13_lv_pmos ad=0.4088p pd=2.97u as=1.55472p ps=9.945u w=1.12u l=0.13u
X2276 sar_ctrl_async_phys_0.sg13g2_buf_1$1_46.A sar_ctrl_async_phys_0.sg13g2_nand2b_1$1_6.A_N VDD.t416 VDD.t10 sg13_lv_pmos ad=0.2128p pd=1.5u as=0.3808p ps=2.92u w=1.12u l=0.13u
X2277 VSS.t794 VDD.t64 VSS.t172 VSS.t795 sg13_lv_nmos ad=79.8f pd=0.8u as=0 ps=0 w=0.42u l=1u
X2278 VSS.t65 sar_ctrl_async_phys_0.sg13g2_buf_1$1_26.X sar_ctrl_async_phys_0.sg13g2_nor2_1$1_4.Y VSS.t1221 sg13_lv_nmos ad=0.2516p pd=2.16u as=0.1406p ps=1.12u w=0.74u l=0.13u
X2279 oa_sar8_acore18_opt_0.sw_tg_opt_0.bot.t3 oa_sar8_acore18_opt_0.sw_bitcell_opt_b7_0.bot.t68 cap_cmim l=2.14u w=2.14u
X2280 a_33558_36674# a_34363_36796# a_33818_36897# VDD.t16 sg13_lv_pmos ad=0.1428p pd=1.52u as=79.8f ps=0.8u w=0.42u l=0.13u
X2281 VDD.t1 sar_ctrl_async_phys_0.sg13g2_dlygate4sd3_1$1_3.A a_28968_42013# VDD.t0 sg13_lv_pmos ad=0.1523p pd=1.38u as=0.1428p ps=1.52u w=0.42u l=0.13u
X2282 VDD.t114 VSS.t46 VDD.t114 VDD.t0 sg13_lv_pmos ad=0.19p pd=1.38u as=0 ps=0 w=1u l=1u
X2283 oa_sar8_acore18_opt_0.sw_tg_opt_1.bot.t3 oa_sar8_acore18_opt_0.sw_bitcell_opt_b7_1.bot.t132 cap_cmim l=2.14u w=2.14u
X2284 a_30964_39711# a_31195_39820# a_30650_39921# VSS.t201 sg13_lv_nmos ad=0.2373p pd=1.97u as=79.8f ps=0.8u w=0.42u l=0.13u
X2285 oa_sar8_acore18_opt_0.sw_tg_opt_0.bot.t3 oa_sar8_acore18_opt_0.sw_bitcell_opt_b7_0.bot.t99 cap_cmim l=2.14u w=2.14u
X2286 a_32281_32529# a_31924_32456# VDD.t342 VDD.t76 sg13_lv_pmos ad=63f pd=0.72u as=0.1563p ps=1.22u w=0.42u l=0.13u
X2287 VDD.t317 a_35072_39918# a_35017_40013# VDD.t317 sg13_lv_pmos ad=1.6658p pd=10.66u as=93.45f ps=0.865u w=0.42u l=0.13u
X2288 VDD.t322 a_35648_34654# a_35593_34535# VDD.t147 sg13_lv_pmos ad=2.2076p pd=14.4u as=93.45f ps=0.865u w=0.42u l=0.13u
X2289 VDD.t86 VSS.t344 VDD.t86 VDD.t29 sg13_lv_pmos ad=0.34p pd=2.68u as=0 ps=0 w=1u l=1u
X2290 oa_sar8_acore18_opt_0.sw_tg_opt_1.bot.t3 oa_sar8_acore18_opt_0.sw_bitcell_opt_b5_1.bot.t10 cap_cmim l=2.14u w=2.14u
X2291 VSS.t1116 VDD.t79 VSS.t1118 VSS.t1117 sg13_lv_nmos ad=79.8f pd=0.8u as=0 ps=0 w=0.42u l=1u
X2292 VSS.t898 VDD.t114 VSS.t31 VSS.t893 sg13_lv_nmos ad=0.1428p pd=1.52u as=0 ps=0 w=0.42u l=1u
X2293 a_34106_32868# a_34549_32911# a_33846_33338# VSS.t1133 sg13_lv_nmos ad=79.8f pd=0.8u as=0.1296p ps=1.52u w=0.42u l=0.13u
X2294 a_29812_40885# a_30043_40471# a_29498_40428# VSS.t273 sg13_lv_nmos ad=0.2373p pd=1.97u as=79.8f ps=0.8u w=0.42u l=0.13u
X2295 a_33109_45725# sar_ctrl_async_phys_0.sg13g2_dfrbpq_1$1_0.CLK.t29 VSS.t283 VSS.t282 sg13_lv_nmos ad=0.2516p pd=2.16u as=5.02618p ps=31.995u w=0.74u l=0.13u
X2296 a_30591_32215# a_29749_32117# a_29332_32456# VDD.t76 sg13_lv_pmos ad=0.2048p pd=1.63u as=0.34p ps=2.68u w=1u l=0.13u
X2297 VDD.t163 VSS.t99 VDD.t114 VDD.t0 sg13_lv_pmos ad=0.19p pd=1.38u as=0 ps=0 w=1u l=1u
X2298 VDD.t23 VSS.t851 VDD.t23 VDD.t22 sg13_lv_pmos ad=0.19p pd=1.38u as=0 ps=0 w=1u l=1u
X2299 VSS.t99 VDD.t114 VSS.t46 VSS.t877 sg13_lv_nmos ad=0.1428p pd=1.52u as=0 ps=0 w=0.42u l=1u
X2300 VDD.t8 sar_ctrl_async_phys_0.sg13g2_buf_1$1_41.X a_31034_44457# VDD.t5 sg13_lv_pmos ad=0.1563p pd=1.22u as=0.147p ps=1.54u w=0.42u l=0.13u
X2301 sar_ctrl_async_phys_0.dac_code[0] a_36056_46508# VDD.t416 VDD.t10 sg13_lv_pmos ad=0.42p pd=2.99u as=0.2114p ps=1.54u w=1.12u l=0.13u
X2302 sar_ctrl_async_phys_0.sg13g2_nor2b_1$1_4.Y sar_ctrl_async_phys_0.sg13g2_nor2b_1$1_0.A VSS.t137 VSS.t229 sg13_lv_nmos ad=0.1406p pd=1.12u as=0.2516p ps=2.16u w=0.74u l=0.13u
X2303 VSS.t126 a_34236_46472# sar_ctrl_async_phys_0.sg13g2_buf_1$1_41.X VSS.t125 sg13_lv_nmos ad=0.14875p pd=1.16u as=0.2886p ps=2.26u w=0.74u l=0.13u
X2304 VDD.t156 VSS.t240 VDD.t156 VDD.t0 sg13_lv_pmos ad=0.34p pd=2.68u as=0 ps=0 w=1u l=1u
X2305 VSS.t348 VDD.t17 VSS.t348 VSS.t931 sg13_lv_nmos ad=0.1428p pd=1.52u as=0 ps=0 w=0.42u l=1u
X2306 oa_sar8_acore18_opt_0.sw_tg_opt_1.bot.t2 oa_sar8_acore18_opt_0.sw_bitcell_opt_b7_1.bot.t149 cap_cmim l=2.14u w=2.14u
X2307 sar_ctrl_async_phys_0.sg13g2_a21oi_1$1_5.A2 a_32602_39996# VDD.t326 VDD.t317 sg13_lv_pmos ad=0.3808p pd=2.92u as=0.2128p ps=1.5u w=1.12u l=0.13u
X2308 oa_sar8_acore18_opt_0.sw_bitcell_opt_b7_1.VSS sar_ctrl_async_phys_0.dac_code_n[6] oa_sar8_acore18_opt_0.sw_bitcell_opt_b6_1.bot.t0 VSS.t571 sg13_lv_nmos ad=1.05p pd=6.7u as=0.585p ps=3.39u w=3u l=0.13u
X2309 w_39600_n9960# oa_sar8_acore18_opt_0.sw_bitcell_opt_term_0.trkb.t4 oa_sar8_acore18_opt_0.sw_bitcell_opt_term_0.gb.t1 w_39600_n9960# sg13_lv_pmos ad=0.7p pd=4.7u as=0.7p ps=4.7u w=2u l=0.13u
X2310 VSS.t975 VDD.t289 VSS.t975 VSS.t0 sg13_lv_nmos ad=79.8f pd=0.8u as=0 ps=0 w=0.42u l=1u
X2311 a_31542_37874# sar_ctrl_async_phys_0.sg13g2_nor2b_1$1_0.Y VDD.t18 VDD.t16 sg13_lv_pmos ad=79.8f pd=0.8u as=0.1428p ps=1.52u w=0.42u l=0.13u
X2312 a_31644_36638# sar_ctrl_async_phys_0.sg13g2_buf_1$1_13.A VSS.t222 VSS.t221 sg13_lv_nmos ad=0.187p pd=1.78u as=0.14875p ps=1.16u w=0.55u l=0.13u
X2313 oa_sar8_acore18_opt_0.sw_tg_opt_0.bot.t3 oa_sar8_acore18_opt_0.sw_bitcell_opt_b4_0.bot.t22 cap_cmim l=2.14u w=2.14u
X2314 oa_sar8_acore18_opt_0.sw_tg_opt_1.bot.t3 oa_sar8_acore18_opt_0.sw_bitcell_opt_b7_1.bot.t90 cap_cmim l=2.14u w=2.14u
X2315 a_34036_35928# a_34010_35892# VSS.t219 VSS.t218 sg13_lv_nmos ad=0.2516p pd=2.16u as=0.1626p ps=1.415u w=0.74u l=0.13u
X2316 VDD.t317 a_30783_40821# a_31040_40702# VDD.t317 sg13_lv_pmos ad=1.6658p pd=10.66u as=79.8f ps=0.8u w=0.42u l=0.13u
X2317 oa_sar8_acore18_opt_0.sw_tg_opt_1.bot.t4 oa_sar8_acore18_opt_0.sw_bitcell_opt_b7_1.bot.t5 cap_cmim l=2.14u w=2.14u
X2318 VDD.t343 sar_ctrl_async_phys_0.sg13g2_buf_1$1_6.X a_34106_32868# VDD.t76 sg13_lv_pmos ad=0.1563p pd=1.22u as=0.147p ps=1.54u w=0.42u l=0.13u
X2319 VDD.t20 VSS.t340 VDD.t20 VDD.t19 sg13_lv_pmos ad=0.19p pd=1.38u as=0 ps=0 w=1u l=1u
X2320 VDD.t328 a_25878_40460# a_25990_40484# VDD.t317 sg13_lv_pmos ad=0.2254p pd=1.53u as=0.34p ps=2.68u w=1u l=0.5u
X2321 oa_sar8_acore18_opt_0.sw_tg_opt_0.bot.t3 oa_sar8_acore18_opt_0.sw_bitcell_opt_b4_0.bot.t4 cap_cmim l=2.14u w=2.14u
X2322 VSS.t730 VDD.t44 VSS.t730 VSS.t733 sg13_lv_nmos ad=79.8f pd=0.8u as=0 ps=0 w=0.42u l=1u
X2323 a_32692_46064# a_32666_45969# VSS.t131 VSS.t643 sg13_lv_nmos ad=0.2516p pd=2.16u as=0.1626p ps=1.415u w=0.74u l=0.13u
X2324 VSS.t508 sar_ctrl_async_phys_0.hold_req oa_sar8_acore18_opt_0.sw_bitcell_opt_b7_1.VSS VSS.t507 sg13_lv_nmos ad=0.7p pd=4.7u as=0.39p ps=2.39u w=2u l=0.13u
X2325 VSS.t1054 VDD.t80 VSS.t1056 VSS.t179 sg13_lv_nmos ad=79.8f pd=0.8u as=0 ps=0 w=0.42u l=1u
X2326 sar_ctrl_async_phys_0.sg13g2_nand2b_1$1_2.A_N a_35578_41508# VDD.t562 VDD.t0 sg13_lv_pmos ad=0.3808p pd=2.92u as=0.2128p ps=1.5u w=1.12u l=0.13u
X2327 sar_ctrl_async_phys_0.sg13g2_dlygate4sd3_1$1_8.X a_26566_41996# VSS.t111 VSS.t1161 sg13_lv_nmos ad=0.2516p pd=2.16u as=0.1426p ps=1.16u w=0.74u l=0.13u
X2328 VDD.t71 VSS.t851 VDD.t69 VDD.t0 sg13_lv_pmos ad=0.19p pd=1.38u as=0 ps=0 w=1u l=1u
X2329 a_34009_41601# a_33652_41528# VDD.t501 VDD.t0 sg13_lv_pmos ad=63f pd=0.72u as=0.1563p ps=1.22u w=0.42u l=0.13u
X2330 a_26666_38912# sar_ctrl_async_phys_0.sg13g2_dlygate4sd3_1$1_11.X VDD.t120 VDD.t29 sg13_lv_pmos ad=0.1428p pd=1.52u as=0.1523p ps=1.38u w=0.42u l=0.13u
X2331 a_32480_46750# sar_ctrl_async_phys_0.sg13g2_buf_1$1_41.X VDD.t10 VDD.t10 sg13_lv_pmos ad=79.8f pd=0.8u as=2.2076p ps=14.4u w=0.42u l=0.13u
X2332 VSS.t111 VDD.t157 VSS.t111 VSS.t864 sg13_lv_nmos ad=0.1428p pd=1.52u as=0 ps=0 w=0.42u l=1u
X2333 a_28368_36877# sar_ctrl_async_phys_0.sg13g2_dlygate4sd3_1$1_0.X a_28505_36720# VSS.t197 sg13_lv_nmos ad=0.2176p pd=1.96u as=0.1216p ps=1.02u w=0.64u l=0.13u
X2334 oa_sar8_acore18_opt_0.sw_bitcell_opt_b0_0.bot.t2 sar_ctrl_async_phys_0.dac_code[0] oa_sar8_acore18_opt_0.sw_bitcell_opt_term_0.VSS VSS.t1196 sg13_lv_nmos ad=0.2925p pd=1.89u as=0.525p ps=3.7u w=1.5u l=0.13u
X2335 VDD.t121 VSS.t1057 VDD.t121 VDD.t76 sg13_lv_pmos ad=0.19p pd=1.38u as=0 ps=0 w=1u l=1u
X2336 VSS.t109 sar_ctrl_async_phys_0.sg13g2_nand2b_1$1_1.B a_35327_45750# VSS.t1166 sg13_lv_nmos ad=0.14505p pd=1.15u as=0.1406p ps=1.12u w=0.74u l=0.13u
X2337 oa_sar8_acore18_opt_0.sw_tg_opt_0.bot.t3 oa_sar8_acore18_opt_0.sw_bitcell_opt_b7_0.bot.t136 cap_cmim l=2.14u w=2.14u
X2338 VSS.t1012 VDD.t121 VSS.t1011 VSS.t1010 sg13_lv_nmos ad=0.1428p pd=1.52u as=0 ps=0 w=0.42u l=1u
X2339 VDD.t13 VSS.t775 VDD.t13 VDD.t5 sg13_lv_pmos ad=0.19p pd=1.38u as=0 ps=0 w=1u l=1u
X2340 sar_ctrl_async_phys_0.sg13g2_nor2_1$1_3.B sar_ctrl_async_phys_0.sg13g2_and2_1$1_0.A a_26630_37814# VSS.t338 sg13_lv_nmos ad=0.2516p pd=2.16u as=0.1406p ps=1.12u w=0.74u l=0.15u
X2341 oa_sar8_acore18_opt_0.sw_tg_opt_1.bot.t3 oa_sar8_acore18_opt_0.sw_bitcell_opt_b7_1.bot.t86 cap_cmim l=2.14u w=2.14u
X2342 sar_ctrl_async_phys_0.bit_active[7] a_35672_38224# VSS.t210 VSS.t177 sg13_lv_nmos ad=0.2886p pd=2.26u as=0.14875p ps=1.16u w=0.74u l=0.13u
X2343 VSS.t114 sar_ctrl_async_phys_0.sg13g2_buf_1$1_21.A a_36056_38224# VSS.t177 sg13_lv_nmos ad=0.14875p pd=1.16u as=0.187p ps=1.78u w=0.55u l=0.13u
X2344 a_33654_44234# a_34459_44356# a_33914_44457# VDD.t5 sg13_lv_pmos ad=0.1428p pd=1.52u as=79.8f ps=0.8u w=0.42u l=0.13u
X2345 VDD.t309 VSS.t1006 VDD.t309 VDD.t147 sg13_lv_pmos ad=0.34p pd=2.68u as=0 ps=0 w=1u l=1u
X2346 sar_ctrl_async_phys_0.sg13g2_inv_1$1_0.A sar_ctrl_async_phys_0.sg13g2_a22oi_1$1_3.B1 a_33359_32876# VDD.t76 sg13_lv_pmos ad=0.2128p pd=1.5u as=0.2716p ps=1.605u w=1.12u l=0.13u
X2347 VDD.t76 a_30848_32358# a_30793_32453# VDD.t76 sg13_lv_pmos ad=1.96315p pd=12.675u as=93.45f ps=0.865u w=0.42u l=0.13u
X2348 a_35305_43607# a_34363_43495# a_35103_43845# VDD.t22 sg13_lv_pmos ad=93.45f pd=0.865u as=0.2048p ps=1.63u w=0.42u l=0.13u
X2349 oa_sar8_acore18_opt_0.sw_tg_opt_0.bot.t3 oa_sar8_acore18_opt_0.sw_bitcell_opt_b6_0.bot.t69 cap_cmim l=2.14u w=2.14u
X2350 VSS.t975 VDD.t148 VSS.t975 VSS.t0 sg13_lv_nmos ad=0.1428p pd=1.52u as=0 ps=0 w=0.42u l=1u
X2351 VSS.t65 VDD.t120 VSS.t65 VSS.t912 sg13_lv_nmos ad=0.1428p pd=1.52u as=0 ps=0 w=0.42u l=1u
X2352 a_32116_37861# a_32347_37447# a_31802_37404# VSS.t710 sg13_lv_nmos ad=0.2373p pd=1.97u as=79.8f ps=0.8u w=0.42u l=0.13u
X2353 oa_sar8_acore18_opt_0.sw_tg_opt_1.bot.t3 oa_sar8_acore18_opt_0.sw_bitcell_opt_b5_1.bot.t10 cap_cmim l=2.14u w=2.14u
X2354 a_34526_31511# a_34268_31826# VDD.t3 VDD.t3 sg13_lv_pmos ad=93.45f pd=0.865u as=1.96315p ps=12.675u w=0.42u l=0.13u
X2355 oa_sar8_acore18_opt_0.sw_bitcell_opt_b2_1.bot.t0 oa_sar8_acore18_opt_0.sw_bitcell_opt_term_0.trkb.t26 oa_sar8_acore18_opt_0.bstrap_opt_w2_c1200_1.out VDD.t608 sg13_lv_pmos ad=0.39p pd=2.39u as=0.7p ps=4.7u w=2u l=0.13u
X2356 oa_sar8_acore18_opt_0.sw_tg_opt_0.bot.t2 oa_sar8_acore18_opt_0.sw_bitcell_opt_b7_0.bot.t157 cap_cmim l=2.14u w=2.14u
X2357 VSS.t823 VDD.t13 VSS.t822 VSS.t224 sg13_lv_nmos ad=0.1428p pd=1.52u as=0 ps=0 w=0.42u l=1u
X2358 a_33114_41508# sar_ctrl_async_phys_0.sg13g2_nor2b_1$1_3.Y VDD.t114 VDD.t0 sg13_lv_pmos ad=0.1176p pd=1.33u as=0.4032p ps=2.96u w=1.12u l=0.13u
X2359 VSS.t102 sar_ctrl_async_phys_0.sg13g2_nor2_1$1_6.B sar_ctrl_async_phys_0.sg13g2_nor2_1$1_6.Y VSS.t693 sg13_lv_nmos ad=0.2516p pd=2.16u as=0.1406p ps=1.12u w=0.74u l=0.13u
X2360 oa_sar8_acore18_opt_0.sw_tg_opt_1.bot.t3 oa_sar8_acore18_opt_0.sw_bitcell_opt_b7_1.bot.t26 cap_cmim l=2.14u w=2.14u
X2361 VSS.t118 VDD.t132 VSS.t126 VSS.t41 sg13_lv_nmos ad=79.8f pd=0.8u as=0 ps=0 w=0.42u l=1u
X2362 VDD.t8 sar_ctrl_async_phys_0.sg13g2_buf_1$1_41.X a_31706_44964# VDD.t5 sg13_lv_pmos ad=0.1563p pd=1.22u as=0.147p ps=1.54u w=0.42u l=0.13u
X2363 oa_sar8_acore18_opt_0.sw_tg_opt_0.bot.t3 oa_sar8_acore18_opt_0.sw_bitcell_opt_b5_0.bot.t15 cap_cmim l=2.14u w=2.14u
X2364 a_35557_31435# a_34615_31475# a_35463_31435# VDD.t3 sg13_lv_pmos ad=79.8f pd=0.8u as=0.1428p ps=1.52u w=0.42u l=0.13u
X2365 VDD.t23 VSS.t826 VDD.t23 VDD.t22 sg13_lv_pmos ad=0.34p pd=2.68u as=0 ps=0 w=1u l=1u
X2366 a_29620_32151# a_29851_32260# a_29306_32361# VSS.t1145 sg13_lv_nmos ad=0.2373p pd=1.97u as=79.8f ps=0.8u w=0.42u l=0.13u
X2367 oa_sar8_acore18_opt_0.sw_tg_opt_1.bot.t3 oa_sar8_acore18_opt_0.sw_bitcell_opt_b6_1.bot.t50 cap_cmim l=2.14u w=2.14u
X2368 VDD.t258 VSS.t237 VDD.t258 VDD.t19 sg13_lv_pmos ad=0.34p pd=2.68u as=0 ps=0 w=1u l=1u
X2369 VSS.t506 a_35772_41936# sar_ctrl_async_phys_0.sg13g2_nand2b_1$1_1.B VSS.t550 sg13_lv_nmos ad=0.14875p pd=1.16u as=0.2886p ps=2.26u w=0.74u l=0.13u
X2370 sar_ctrl_async_phys_0.sg13g2_and2_1$1_1.B a_35770_36972# VSS.t277 VSS.t276 sg13_lv_nmos ad=0.2516p pd=2.16u as=0.1406p ps=1.12u w=0.74u l=0.13u
X2371 VSS.t831 VDD.t6 VSS.t829 VSS.t224 sg13_lv_nmos ad=0.1428p pd=1.52u as=0 ps=0 w=0.42u l=1u
X2372 VDD.t8 VSS.t792 VDD.t8 VDD.t5 sg13_lv_pmos ad=0.19p pd=1.38u as=0 ps=0 w=1u l=1u
X2373 a_32692_46064# a_33211_45868# a_33951_45823# VSS.t1143 sg13_lv_nmos ad=0.3473p pd=2.71u as=0.12665p ps=1.145u w=0.74u l=0.13u
X2374 a_33818_43452# a_34261_43495# a_34201_43531# VDD.t22 sg13_lv_pmos ad=79.8f pd=0.8u as=63f ps=0.72u w=0.42u l=0.13u
X2375 VDD.t4 sar_ctrl_async_phys_0.sg13g2_a22oi_1$1_0.B2 a_33464_30664# VDD.t3 sg13_lv_pmos ad=0.2114p pd=1.54u as=0.2856p ps=2.36u w=0.84u l=0.13u
X2376 VSS.t824 VDD.t23 VSS.t824 VSS.t224 sg13_lv_nmos ad=0.1428p pd=1.52u as=0 ps=0 w=0.42u l=1u
X2377 oa_sar8_acore18_opt_0.sw_tg_opt_1.bot.t3 oa_sar8_acore18_opt_0.sw_bitcell_opt_b6_1.bot.t35 cap_cmim l=2.14u w=2.14u
X2378 a_30671_32876# sar_ctrl_async_phys_0.sg13g2_buf_1$1_0.A sar_ctrl_async_phys_0.sg13g2_inv_1$1_5.A VDD.t76 sg13_lv_pmos ad=0.2744p pd=1.61u as=0.2128p ps=1.5u w=1.12u l=0.13u
X2379 a_35327_42342# a_35245_42242# sar_ctrl_async_phys_0.sg13g2_a21oi_1$1_3.B1 VSS.t474 sg13_lv_nmos ad=0.1406p pd=1.12u as=0.333p ps=2.38u w=0.74u l=0.13u
X2380 VSS.t240 sar_ctrl_async_phys_0.sg13g2_dlygate4sd3_1$1_7.A a_25608_40501# VSS.t239 sg13_lv_nmos ad=79.8f pd=0.8u as=0.1428p ps=1.52u w=0.42u l=0.13u
X2381 VSS.t126 a_32223_46869# a_32890_46508# VSS.t125 sg13_lv_nmos ad=0.1406p pd=1.12u as=0.2516p ps=2.16u w=0.74u l=0.13u
X2382 VDD.t15 VSS.t825 VDD.t13 VDD.t5 sg13_lv_pmos ad=0.34p pd=2.68u as=0 ps=0 w=1u l=1u
X2383 sar_ctrl_async_phys_0.dac_code_n[1].t0 a_34520_46508# VDD.t390 VDD.t10 sg13_lv_pmos ad=0.42p pd=2.99u as=0.2114p ps=1.54u w=1.12u l=0.13u
X2384 VSS.t313 VDD.t25 VSS.t313 VSS.t858 sg13_lv_nmos ad=0.1428p pd=1.52u as=0 ps=0 w=0.42u l=1u
X2385 sar_ctrl_async_phys_0.sg13g2_nand2b_1$1_0.A_N sar_ctrl_async_phys_0.sg13g2_nor2_1$1_13.A VSS.t29 VSS.t28 sg13_lv_nmos ad=0.1406p pd=1.12u as=0.2516p ps=2.16u w=0.74u l=0.13u
X2386 oa_sar8_acore18_opt_0.sw_tg_opt_1.bot.t3 oa_sar8_acore18_opt_0.sw_bitcell_opt_b6_1.bot.t50 cap_cmim l=2.14u w=2.14u
X2387 oa_sar8_acore18_opt_0.sw_tg_opt_0.bot.t3 oa_sar8_acore18_opt_0.sw_bitcell_opt_b7_0.bot.t107 cap_cmim l=2.14u w=2.14u
X2388 VDD.t394 sar_ctrl_async_phys_0.sg13g2_a22oi_1$1_0.A2 a_34895_32460# VDD.t76 sg13_lv_pmos ad=0.3808p pd=2.92u as=0.2744p ps=1.61u w=1.12u l=0.13u
X2389 a_35305_36989# a_34363_36796# a_35103_36751# VDD.t16 sg13_lv_pmos ad=93.45f pd=0.865u as=0.2048p ps=1.63u w=0.42u l=0.13u
X2390 VDD.t132 VSS.t126 VDD.t132 VDD.t42 sg13_lv_pmos ad=0.34p pd=2.68u as=0 ps=0 w=1u l=1u
X2391 oa_sar8_acore18_opt_0.sw_tg_opt_1.bot.t3 oa_sar8_acore18_opt_0.sw_bitcell_opt_b7_1.bot.t121 cap_cmim l=2.14u w=2.14u
X2392 VSS.t287 a_29941_40471# a_30043_40471# VSS.t1251 sg13_lv_nmos ad=5.25845p pd=33.575u as=0.2516p ps=2.16u w=0.74u l=0.13u
X2393 sar_ctrl_async_phys_0.sg13g2_nor2b_1$1_3.Y sar_ctrl_async_phys_0.sg13g2_nor2b_1$1_0.A VSS.t113 VSS.t153 sg13_lv_nmos ad=0.1406p pd=1.12u as=0.2516p ps=2.16u w=0.74u l=0.13u
X2394 oa_sar8_acore18_opt_0.sw_tg_opt_1.bot.t3 oa_sar8_acore18_opt_0.sw_bitcell_opt_b4_1.bot.t20 cap_cmim l=2.14u w=2.14u
X2395 oa_sar8_acore18_opt_0.sw_tg_opt_1.bot.t3 oa_sar8_acore18_opt_0.sw_bitcell_opt_b7_1.bot.t74 cap_cmim l=2.14u w=2.14u
X2396 VSS.t1091 VDD.t90 VSS.t1093 VSS.t1092 sg13_lv_nmos ad=79.8f pd=0.8u as=0 ps=0 w=0.42u l=1u
X2397 VDD.t82 VSS.t344 VDD.t85 VDD.t29 sg13_lv_pmos ad=0.34p pd=2.68u as=0 ps=0 w=1u l=1u
X2398 VDD.t322 a_34549_34423# a_34651_34423# VDD.t147 sg13_lv_pmos ad=2.2076p pd=14.4u as=0.3864p ps=2.93u w=1.12u l=0.13u
X2399 sar_ctrl_async_phys_0.sg13g2_nand2b_1$1_5.A_N a_33658_44996# VSS.t7 VSS.t632 sg13_lv_nmos ad=0.2516p pd=2.16u as=0.1406p ps=1.12u w=0.74u l=0.13u
X2400 VSS.t87 sar_ctrl_async_phys_0.sg13g2_buf_1$1_3.A a_35135_40830# VSS.t86 sg13_lv_nmos ad=0.14505p pd=1.15u as=0.1406p ps=1.12u w=0.74u l=0.13u
X2401 VDD.t169 VSS.t940 VDD.t169 VDD.t16 sg13_lv_pmos ad=0.34p pd=2.68u as=0 ps=0 w=1u l=1u
X2402 oa_sar8_acore18_opt_0.sw_tg_opt_0.bot.t3 oa_sar8_acore18_opt_0.sw_bitcell_opt_b2_0.bot.t4 cap_cmim l=2.14u w=2.14u
X2403 oa_sar8_acore18_opt_0.sw_tg_opt_0.bot.t3 oa_sar8_acore18_opt_0.sw_bitcell_opt_b7_0.bot.t78 cap_cmim l=2.14u w=2.14u
X2404 oa_sar8_acore18_opt_0.sw_tg_opt_0.bot.t3 oa_sar8_acore18_opt_0.sw_bitcell_opt_b6_0.bot.t69 cap_cmim l=2.14u w=2.14u
X2405 oa_sar8_acore18_opt_0.bstrap_opt_w2_c1200_1.out oa_sar8_acore18_opt_0.bstrap_opt_w2_c1200_1.gb oa_sar8_acore18_opt_0.sw_bitcell_opt_b1_1.bot.t0 VSS.t157 sg13_lv_nmos ad=0.35p pd=2.7u as=0.195p ps=1.39u w=1u l=0.13u
X2406 VSS.t260 VDD.t238 VSS.t260 VSS.t176 sg13_lv_nmos ad=0.1428p pd=1.52u as=0 ps=0 w=0.42u l=1u
X2407 oa_sar8_acore18_opt_0.sw_bitcell_opt_term_0.trkb.t0 sar_ctrl_async_phys_0.sample VSS.t393 VSS.t392 sg13_lv_nmos ad=0.195p pd=1.39u as=0.35p ps=2.7u w=1u l=0.13u
X2408 VDD.t150 sar_ctrl_async_phys_0.sg13g2_buf_1$1_6.X a_29306_32361# VDD.t76 sg13_lv_pmos ad=0.1563p pd=1.22u as=0.147p ps=1.54u w=0.42u l=0.13u
X2409 sar_ctrl_async_phys_0.dac_code[2] a_35672_42760# VSS.t506 VSS.t581 sg13_lv_nmos ad=0.2886p pd=2.26u as=0.14875p ps=1.16u w=0.74u l=0.13u
X2410 VDD.t390 sar_ctrl_async_phys_0.sg13g2_a21oi_1$1_3.B1 a_34904_46508# VDD.t10 sg13_lv_pmos ad=0.2114p pd=1.54u as=0.2856p ps=2.36u w=0.84u l=0.13u
X2411 a_27134_39887# a_27249_39888# VSS.t199 VSS.t103 sg13_lv_nmos ad=0.1428p pd=1.52u as=0.1426p ps=1.16u w=0.42u l=0.5u
X2412 a_33385_32453# a_32443_32260# a_33183_32215# VDD.t76 sg13_lv_pmos ad=93.45f pd=0.865u as=0.2048p ps=1.63u w=0.42u l=0.13u
X2413 a_31328_33870# sar_ctrl_async_phys_0.sg13g2_buf_1$1_6.X VDD.t147 VDD.t147 sg13_lv_pmos ad=79.8f pd=0.8u as=2.2076p ps=14.4u w=0.42u l=0.13u
X2414 a_34208_45966# sar_ctrl_async_phys_0.sg13g2_o21ai_1$1_1.B1.t14 VDD.t10 VDD.t10 sg13_lv_pmos ad=79.8f pd=0.8u as=2.2076p ps=14.4u w=0.42u l=0.13u
X2415 sar_ctrl_async_phys_0.sg13g2_a21oi_1$1_6.B1 a_34765_45266# VDD.t349 VDD.t5 sg13_lv_pmos ad=0.2128p pd=1.5u as=0.3808p ps=2.92u w=1.12u l=0.13u
X2416 a_28008_23477# sar_ctrl_async_phys_0.cmp_fire VSS.t183 VSS.t182 sg13_lv_nmos ad=0.285p pd=1.88u as=0.5175p ps=3.69u w=1.5u l=0.3u
X2417 sar_ctrl_async_phys_0.sg13g2_nor2_1$1_12.Y sar_ctrl_async_phys_0.sg13g2_dlygate4sd3_1$1_5.A VSS.t111 VSS.t1284 sg13_lv_nmos ad=0.1406p pd=1.12u as=0.2516p ps=2.16u w=0.74u l=0.13u
X2418 VSS.t243 a_30752_39190# a_30401_39309# VSS.t656 sg13_lv_nmos ad=79.8f pd=0.8u as=0.1428p ps=1.52u w=0.42u l=0.13u
X2419 VSS.t401 sar_ctrl_async_phys_0.sg13g2_buf_1$1_19.A a_34520_38224# VSS.t177 sg13_lv_nmos ad=0.14875p pd=1.16u as=0.187p ps=1.78u w=0.55u l=0.13u
X2420 VSS.t1007 VDD.t121 VSS.t1009 VSS.t1008 sg13_lv_nmos ad=79.8f pd=0.8u as=0 ps=0 w=0.42u l=1u
X2421 VSS.t277 a_35295_36285# a_35962_35924# VSS.t369 sg13_lv_nmos ad=0.1406p pd=1.12u as=0.2516p ps=2.16u w=0.74u l=0.13u
X2422 a_34010_35892# a_34453_35935# a_33750_36362# VSS.t586 sg13_lv_nmos ad=79.8f pd=0.8u as=0.1296p ps=1.52u w=0.42u l=0.13u
X2423 oa_sar8_acore18_opt_0.sw_tg_opt_1.bot.t3 oa_sar8_acore18_opt_0.sw_bitcell_opt_b6_1.bot.t75 cap_cmim l=2.14u w=2.14u
X2424 a_31732_32138# sar_ctrl_async_phys_0.sg13g2_inv_1$1_3.Y a_31638_32138# VSS.t614 sg13_lv_nmos ad=60.89999f pd=0.71u as=0.1428p ps=1.52u w=0.42u l=0.13u
X2425 VDD.t728 sar_ctrl_async_phys_0.sg13g2_a22oi_1$1_2.B2 a_33752_33688# VDD.t147 sg13_lv_pmos ad=0.2114p pd=1.54u as=0.2856p ps=2.36u w=0.84u l=0.13u
X2426 oa_sar8_acore18_opt_0.sw_tg_opt_1.bot.t3 oa_sar8_acore18_opt_0.sw_bitcell_opt_b7_1.bot.t58 cap_cmim l=2.14u w=2.14u
X2427 VSS.t1053 VDD.t121 VSS.t180 VSS.t179 sg13_lv_nmos ad=0.1428p pd=1.52u as=0 ps=0 w=0.42u l=1u
X2428 VDD.t345 a_30591_32215# a_31258_32436# VDD.t76 sg13_lv_pmos ad=0.2128p pd=1.5u as=0.3864p ps=2.93u w=1.12u l=0.13u
X2429 a_34106_34380# a_34549_34423# a_34489_34459# VDD.t147 sg13_lv_pmos ad=79.8f pd=0.8u as=63f ps=0.72u w=0.42u l=0.13u
X2430 VDD.t699 sar_ctrl_async_phys_0.dac_code_n[4] oa_sar8_acore18_opt_0.sw_bitcell_opt_b4_1.bot.t1 VDD.t698 sg13_lv_pmos ad=1.68p pd=10.3u as=0.936p ps=5.19u w=4.8u l=0.13u
X2431 a_29524_40464# a_29498_40428# VSS.t539 VSS.t1144 sg13_lv_nmos ad=0.2516p pd=2.16u as=0.1626p ps=1.415u w=0.74u l=0.13u
X2432 a_30390_39698# sar_ctrl_async_phys_0.sg13g2_nor2_1$1_18.A VDD.t361 VDD.t317 sg13_lv_pmos ad=79.8f pd=0.8u as=0.1428p ps=1.52u w=0.42u l=0.13u
X2433 oa_sar8_acore18_opt_0.sw_tg_opt_0.bot.t3 oa_sar8_acore18_opt_0.sw_bitcell_opt_b7_0.bot.t89 cap_cmim l=2.14u w=2.14u
X2434 VDD.t90 VSS.t1057 VDD.t90 VDD.t3 sg13_lv_pmos ad=0.34p pd=2.68u as=0 ps=0 w=1u l=1u
X2435 sar_ctrl_async_phys_0.sg13g2_buf_1$1_10.A a_33850_32436# VDD.t561 VDD.t76 sg13_lv_pmos ad=0.3808p pd=2.92u as=0.2128p ps=1.5u w=1.12u l=0.13u
X2436 sar_ctrl_async_phys_0.sg13g2_a21oi_1$1_2.Y sar_ctrl_async_phys_0.sg13g2_a21oi_1$1_2.B1 VSS.t243 VSS.t499 sg13_lv_nmos ad=0.1406p pd=1.12u as=0.2516p ps=2.16u w=0.74u l=0.13u
X2437 VSS.t82 a_31189_31399# a_31291_31399# VSS.t81 sg13_lv_nmos ad=4.0265p pd=25.31u as=0.2516p ps=2.16u w=0.74u l=0.13u
X2438 a_32442_38484# sar_ctrl_async_phys_0.sg13g2_nor2b_1$1_0.Y VDD.t948 VDD.t29 sg13_lv_pmos ad=0.1176p pd=1.33u as=0.4032p ps=2.96u w=1.12u l=0.13u
X2439 oa_sar8_acore18_opt_0.sw_tg_opt_1.bot.t3 oa_sar8_acore18_opt_0.sw_bitcell_opt_b6_1.bot.t22 cap_cmim l=2.14u w=2.14u
X2440 a_35648_30846# a_35391_30703# a_35810_30626# VSS.t468 sg13_lv_nmos ad=0.1428p pd=1.52u as=37.8f ps=0.6u w=0.42u l=0.13u
X2441 a_35810_34850# sar_ctrl_async_phys_0.sg13g2_dfrbpq_1$1_0.RESET_B VSS.t13 VSS.t21 sg13_lv_nmos ad=37.8f pd=0.6u as=79.8f ps=0.8u w=0.42u l=0.13u
X2442 sar_ctrl_async_phys_0.sg13g2_a21oi_1$1_0.A2 a_35962_35924# VDD.t319 VDD.t19 sg13_lv_pmos ad=0.3808p pd=2.92u as=0.2128p ps=1.5u w=1.12u l=0.13u
X2443 VDD.t507 VSS.t902 VDD.t104 VDD.t29 sg13_lv_pmos ad=0.19p pd=1.38u as=0 ps=0 w=1u l=1u
X2444 VSS.t40 VDD.t43 VSS.t40 VSS.t725 sg13_lv_nmos ad=0.1428p pd=1.52u as=0 ps=0 w=0.42u l=1u
X2445 oa_sar8_acore18_opt_0.sw_bitcell_opt_term_0.vin oa_sar8_acore18_opt_0.sw_bitcell_opt_term_0.gb.t6 oa_sar8_acore18_opt_0.sw_bitcell_opt_b1_0.bot.t4 VSS.t1201 sg13_lv_nmos ad=0.35p pd=2.7u as=0.195p ps=1.39u w=1u l=0.13u
X2446 VSS.t681 sar_ctrl_async_phys_0.sg13g2_buf_1$1_17.A a_34424_35200# VSS.t680 sg13_lv_nmos ad=0.14875p pd=1.16u as=0.187p ps=1.78u w=0.55u l=0.13u
X2447 a_34549_34423# sar_ctrl_async_phys_0.sg13g2_dfrbpq_1$1_0.CLK.t8 VSS.t20 VSS.t707 sg13_lv_nmos ad=0.2516p pd=2.16u as=4.70937p ps=30.235u w=0.74u l=0.13u
X2448 a_35295_36285# a_34453_35935# a_35201_36285# VSS.t369 sg13_lv_nmos ad=0.12665p pd=1.145u as=0.1428p ps=1.52u w=0.42u l=0.13u
X2449 a_31828_37440# a_31802_37404# VDD.t18 VDD.t16 sg13_lv_pmos ad=0.34p pd=2.68u as=0.36237p ps=2.605u w=1u l=0.13u
X2450 a_35552_36166# sar_ctrl_async_phys_0.sg13g2_dfrbpq_1$1_3.RESET_B VDD.t19 VDD.t19 sg13_lv_pmos ad=79.8f pd=0.8u as=1.66112p ps=10.725u w=0.42u l=0.13u
X2451 a_35360_36894# a_35103_36751# a_35522_36674# VSS.t275 sg13_lv_nmos ad=0.1428p pd=1.52u as=37.8f ps=0.6u w=0.42u l=0.13u
X2452 a_28506_37436# sar_ctrl_async_phys_0.sg13g2_nand2_1$1_1.Y VDD.t146 VDD.t16 sg13_lv_pmos ad=0.1176p pd=1.33u as=0.4032p ps=2.96u w=1.12u l=0.13u
X2453 oa_sar8_acore18_opt_0.sw_bitcell_opt_b1_1.bot.t0 sar_ctrl_async_phys_0.dac_code_n[1].t1 oa_sar8_acore18_opt_0.sw_bitcell_opt_b7_1.VSS VSS.t52 sg13_lv_nmos ad=0.3315p pd=2.09u as=0.595p ps=4.1u w=1.7u l=0.13u
X2454 a_30037_43495# sar_ctrl_async_phys_0.sg13g2_dfrbpq_1$1_0.CLK.t25 VSS.t443 VSS.t442 sg13_lv_nmos ad=0.2516p pd=2.16u as=3.64875p ps=22.56u w=0.74u l=0.13u
X2455 oa_sar8_acore18_opt_0.sw_tg_opt_1.bot.t2 oa_sar8_acore18_opt_0.sw_bitcell_opt_b7_1.bot.t158 cap_cmim l=2.14u w=2.14u
X2456 VSS.t44 VDD.t238 VSS.t44 VSS.t1001 sg13_lv_nmos ad=0.1428p pd=1.52u as=0 ps=0 w=0.42u l=1u
X2457 a_30390_36362# sar_ctrl_async_phys_0.sg13g2_a22oi_1$1_0.B1 VDD.t20 VDD.t19 sg13_lv_pmos ad=79.8f pd=0.8u as=0.1428p ps=1.52u w=0.42u l=0.13u
X2458 oa_sar8_acore18_opt_0.sw_tg_opt_0.bot.t4 oa_sar8_acore18_opt_0.sw_bitcell_opt_b7_0.bot.t5 cap_cmim l=2.14u w=2.14u
X2459 oa_sar8_acore18_opt_0.sw_bitcell_opt_b0_1.bot.t0 oa_sar8_acore18_opt_0.bstrap_opt_w2_c1200_1.gb oa_sar8_acore18_opt_0.bstrap_opt_w2_c1200_1.out VSS.t156 sg13_lv_nmos ad=0.195p pd=1.39u as=0.35p ps=2.7u w=1u l=0.13u
X2460 VDD.t728 sar_ctrl_async_phys_0.sg13g2_dfrbpq_1$1_0.RESET_B a_33846_34850# VDD.t147 sg13_lv_pmos ad=0.36237p pd=2.605u as=79.8f ps=0.8u w=0.42u l=0.13u
X2461 VSS.t851 VDD.t69 VSS.t851 VSS.t867 sg13_lv_nmos ad=79.8f pd=0.8u as=0 ps=0 w=0.42u l=1u
X2462 sar_ctrl_async_phys_0.sg13g2_dfrbpq_1$1_0.CLK.t0 a_29350_41996# VDD.t1 VDD.t0 sg13_lv_pmos ad=0.4256p pd=3u as=0.2254p ps=1.53u w=1.12u l=0.13u
X2463 vinn oa_sar8_acore18_opt_0.sw_bitcell_opt_term_0.gb.t3 oa_sar8_acore18_opt_0.sw_bitcell_opt_term_0.vin VSS.t561 sg13_lv_nmos ad=0.35p pd=2.7u as=0.195p ps=1.39u w=1u l=0.13u
X2464 sar_ctrl_async_phys_0.sg13g2_buf_1$1_7.A a_31738_33948# VSS.t194 VSS.t176 sg13_lv_nmos ad=0.2516p pd=2.16u as=0.1406p ps=1.12u w=0.74u l=0.13u
X2465 a_33913_40089# a_33556_40016# VDD.t392 VDD.t317 sg13_lv_pmos ad=63f pd=0.72u as=0.1563p ps=1.22u w=0.42u l=0.13u
X2466 VDD.t121 VSS.t1060 VDD.t121 VDD.t76 sg13_lv_pmos ad=0.19p pd=1.38u as=0 ps=0 w=1u l=1u
X2467 a_32404_40885# a_32635_40471# a_32090_40428# VSS.t1188 sg13_lv_nmos ad=0.2373p pd=1.97u as=79.8f ps=0.8u w=0.42u l=0.13u
X2468 VDD.t13 VSS.t777 VDD.t13 VDD.t5 sg13_lv_pmos ad=0.19p pd=1.38u as=0 ps=0 w=1u l=1u
X2469 oa_sar8_acore18_opt_0.sw_tg_opt_1.bot.t3 oa_sar8_acore18_opt_0.sw_bitcell_opt_b6_1.bot.t2 cap_cmim l=2.14u w=2.14u
X2470 VSS.t109 a_33951_45823# a_34618_46044# VSS.t565 sg13_lv_nmos ad=0.1406p pd=1.12u as=0.2516p ps=2.16u w=0.74u l=0.13u
X2471 VSS.t578 sar_ctrl_async_phys_0.sg13g2_buf_1$1_6.X a_34362_31826# VSS.t2 sg13_lv_nmos ad=79.8f pd=0.8u as=37.8f ps=0.6u w=0.42u l=0.13u
X2472 result[7] a_34904_33688# VDD.t372 VDD.t147 sg13_lv_pmos ad=0.42p pd=2.99u as=0.2114p ps=1.54u w=1.12u l=0.13u
X2473 a_30733_35166# sar_ctrl_async_phys_0.sg13g2_buf_1$1_17.A VSS.t1 VSS.t0 sg13_lv_nmos ad=0.13135p pd=1.095u as=0.18945p ps=1.27u w=0.74u l=0.13u
X2474 VSS.t109 sar_ctrl_async_phys_0.sg13g2_nand2b_1$1_1.B a_34847_45366# VSS.t1165 sg13_lv_nmos ad=0.14505p pd=1.15u as=0.1406p ps=1.12u w=0.74u l=0.13u
X2475 VDD.t317 a_33973_39677# a_34075_39820# VDD.t317 sg13_lv_pmos ad=1.6658p pd=10.66u as=0.3864p ps=2.93u w=1.12u l=0.13u
X2476 oa_sar8_acore18_opt_0.sw_tg_opt_0.bot.t3 oa_sar8_acore18_opt_0.sw_bitcell_opt_b5_0.bot.t35 cap_cmim l=2.14u w=2.14u
X2477 oa_sar8_acore18_opt_0.sw_tg_opt_1.bot.t3 oa_sar8_acore18_opt_0.sw_bitcell_opt_b7_1.bot.t137 cap_cmim l=2.14u w=2.14u
X2478 oa_sar8_acore18_opt_0.sw_tg_opt_0.bot.t3 oa_sar8_acore18_opt_0.sw_bitcell_opt_b7_0.bot.t73 cap_cmim l=2.14u w=2.14u
X2479 oa_sar8_acore18_opt_0.sw_tg_opt_1.bot.t3 oa_sar8_acore18_opt_0.sw_bitcell_opt_b7_1.bot.t48 cap_cmim l=2.14u w=2.14u
X2480 sar_ctrl_async_phys_0.sg13g2_dlygate4sd3_1$1_9.A a_26662_41278# VSS.t51 VSS.t673 sg13_lv_nmos ad=0.2516p pd=2.16u as=0.1426p ps=1.16u w=0.74u l=0.13u
X2481 a_34420_33325# a_34651_32911# a_34106_32868# VSS.t606 sg13_lv_nmos ad=0.2373p pd=1.97u as=79.8f ps=0.8u w=0.42u l=0.13u
X2482 VSS.t941 VDD.t159 VSS.t943 VSS.t942 sg13_lv_nmos ad=79.8f pd=0.8u as=0 ps=0 w=0.42u l=1u
X2483 VSS.t313 sar_ctrl_async_phys_0.sg13g2_dlygate4sd3_1$1_3.A a_28968_42013# VSS.t557 sg13_lv_nmos ad=79.8f pd=0.8u as=0.1428p ps=1.52u w=0.42u l=0.13u
X2484 a_33846_33338# sar_ctrl_async_phys_0.sg13g2_inv_1$1_1.Y VDD.t561 VDD.t76 sg13_lv_pmos ad=79.8f pd=0.8u as=0.1428p ps=1.52u w=0.42u l=0.13u
X2485 VDD.t270 VSS.t970 VDD.t270 VDD.t147 sg13_lv_pmos ad=0.19p pd=1.38u as=0 ps=0 w=1u l=1u
X2486 VSS.t970 VDD.t159 VSS.t970 VSS.t0 sg13_lv_nmos ad=0.1428p pd=1.52u as=0 ps=0 w=0.42u l=1u
X2487 oa_sar8_acore18_opt_0.sw_bitcell_opt_b5_0.bot.t1 sar_ctrl_async_phys_0.dac_code[5] oa_sar8_acore18_opt_0.sw_bitcell_opt_term_0.VSS VSS.t214 sg13_lv_nmos ad=0.5265p pd=3.09u as=0.945p ps=6.1u w=2.7u l=0.13u
X2488 VDD.t148 VSS.t1026 VDD.t148 VDD.t147 sg13_lv_pmos ad=0.34p pd=2.68u as=0 ps=0 w=1u l=1u
X2489 VDD.t169 VSS.t938 VDD.t169 VDD.t16 sg13_lv_pmos ad=0.19p pd=1.38u as=0 ps=0 w=1u l=1u
X2490 VSS.t137 a_32580_43448# sar_ctrl_async_phys_0.sg13g2_nor2b_1$1_4.Y VSS.t268 sg13_lv_nmos ad=0.17255p pd=1.25u as=0.1406p ps=1.12u w=0.74u l=0.13u
X2491 VSS.t65 VDD.t169 VSS.t65 VSS.t910 sg13_lv_nmos ad=0.1428p pd=1.52u as=0 ps=0 w=0.42u l=1u
X2492 a_34596_40424# sar_ctrl_async_phys_0.sg13g2_buf_1$1_15.A VDD.t375 VDD.t317 sg13_lv_pmos ad=0.2856p pd=2.36u as=0.2618p ps=1.63u w=0.84u l=0.13u
X2493 VSS.t283 a_33109_45725# a_33211_45868# VSS.t1141 sg13_lv_nmos ad=6.70155p pd=42.66u as=0.2516p ps=2.16u w=0.74u l=0.13u
X2494 VSS.t834 VDD.t6 VSS.t120 VSS.t833 sg13_lv_nmos ad=0.1428p pd=1.52u as=0 ps=0 w=0.42u l=1u
X2495 oa_sar8_acore18_opt_0.sw_bitcell_opt_term_0.vin oa_sar8_acore18_opt_0.sw_bitcell_opt_term_0.trkb.t15 oa_sar8_acore18_opt_0.sw_bitcell_opt_b2_0.bot.t1 VDD.t777 sg13_lv_pmos ad=0.7p pd=4.7u as=0.39p ps=2.39u w=2u l=0.13u
X2496 VDD.t233 VSS.t979 VDD.t148 VDD.t147 sg13_lv_pmos ad=0.19p pd=1.38u as=0 ps=0 w=1u l=1u
X2497 a_32537_41256# sar_ctrl_async_phys_0.sg13g2_buf_1$1_3.A VSS.t85 VSS.t84 sg13_lv_nmos ad=0.1216p pd=1.02u as=0.1331p ps=1.12u w=0.64u l=0.13u
X2498 oa_sar8_acore18_opt_0.sw_tg_opt_1.bot.t2 oa_sar8_acore18_opt_0.sw_bitcell_opt_b7_1.bot.t163 cap_cmim l=2.14u w=2.14u
X2499 oa_sar8_acore18_opt_0.sw_tg_opt_1.bot.t3 oa_sar8_acore18_opt_0.sw_bitcell_opt_b7_1.bot.t137 cap_cmim l=2.14u w=2.14u
X2500 a_33248_45238# sar_ctrl_async_phys_0.sg13g2_buf_1$1_41.X VDD.t5 VDD.t5 sg13_lv_pmos ad=79.8f pd=0.8u as=1.79957p ps=11.62u w=0.42u l=0.13u
X2501 oa_sar8_acore18_opt_0.sw_tg_opt_1.bot.t3 oa_sar8_acore18_opt_0.sw_bitcell_opt_b5_1.bot.t22 cap_cmim l=2.14u w=2.14u
X2502 oa_sar8_acore18_opt_0.sw_tg_opt_1.bot.t3 oa_sar8_acore18_opt_0.sw_bitcell_opt_b3_1.bot.t3 cap_cmim l=2.14u w=2.14u
X2503 oa_sar8_acore18_opt_0.sw_tg_opt_1.bot.t3 oa_sar8_acore18_opt_0.sw_bitcell_opt_b7_1.bot.t95 cap_cmim l=2.14u w=2.14u
X2504 a_33109_45725# sar_ctrl_async_phys_0.sg13g2_dfrbpq_1$1_0.CLK.t29 VDD.t10 VDD.t10 sg13_lv_pmos ad=0.4088p pd=2.97u as=1.98685p ps=12.96u w=1.12u l=0.13u
X2505 VDD.t330 sar_ctrl_async_phys_0.sg13g2_nand2_1$1_3.B sar_ctrl_async_phys_0.sg13g2_nand2_1$1_3.Y VDD.t22 sg13_lv_pmos ad=0.3808p pd=2.92u as=0.2128p ps=1.5u w=1.12u l=0.13u
X2506 VDD.t30 VSS.t102 VDD.t30 VDD.t29 sg13_lv_pmos ad=0.19p pd=1.38u as=0 ps=0 w=1u l=1u
X2507 oa_sar8_acore18_opt_0.sw_tg_opt_1.bot.t4 oa_sar8_acore18_opt_0.sw_bitcell_opt_b7_1.bot.t10 cap_cmim l=2.14u w=2.14u
X2508 a_31706_35385# a_32149_35141# a_32089_35553# VDD.t19 sg13_lv_pmos ad=79.8f pd=0.8u as=63f ps=0.72u w=0.42u l=0.13u
X2509 oa_sar8_acore18_opt_0.sw_tg_opt_0.bot.t3 oa_sar8_acore18_opt_0.sw_bitcell_opt_b4_0.bot.t12 cap_cmim l=2.14u w=2.14u
X2510 sar_ctrl_async_phys_0.sg13g2_a22oi_1$1_1.B2 a_36058_32900# VSS.t92 VSS.t607 sg13_lv_nmos ad=0.2516p pd=2.16u as=0.1406p ps=1.12u w=0.74u l=0.13u
X2511 VSS.t48 sar_ctrl_async_phys_0.sg13g2_nor2_1$1_10.B a_30942_33292# VSS.t57 sg13_lv_nmos ad=0.2516p pd=2.16u as=96.2f ps=1u w=0.74u l=0.13u
X2512 VDD.t49 VSS.t780 VDD.t11 VDD.t10 sg13_lv_pmos ad=0.19p pd=1.38u as=0 ps=0 w=1u l=1u
X2513 VDD.t79 VSS.t1113 VDD.t79 VDD.t3 sg13_lv_pmos ad=0.19p pd=1.38u as=0 ps=0 w=1u l=1u
X2514 a_29428_43922# sar_ctrl_async_phys_0.sg13g2_nor2_1$1_10.A a_29334_43922# VSS.t224 sg13_lv_nmos ad=60.89999f pd=0.71u as=0.1428p ps=1.52u w=0.42u l=0.13u
X2515 sar_ctrl_async_phys_0.sg13g2_a22oi_1$1_0.B1 a_31832_34412# VSS.t1 VSS.t1157 sg13_lv_nmos ad=0.2886p pd=2.26u as=0.14875p ps=1.16u w=0.74u l=0.13u
X2516 VDD.t132 VSS.t126 VDD.t175 VDD.t42 sg13_lv_pmos ad=0.19p pd=1.38u as=0 ps=0 w=1u l=1u
X2517 a_35245_45936# sar_ctrl_async_phys_0.sg13g2_nand2b_1$1_6.A_N VSS.t109 VSS.t217 sg13_lv_nmos ad=0.187p pd=1.78u as=0.14505p ps=1.15u w=0.55u l=0.13u
X2518 VSS.t1120 VDD.t4 VSS.t1122 VSS.t1121 sg13_lv_nmos ad=79.8f pd=0.8u as=0 ps=0 w=0.42u l=1u
X2519 a_32116_40464# a_32090_40428# VSS.t85 VSS.t253 sg13_lv_nmos ad=0.2516p pd=2.16u as=0.1626p ps=1.415u w=0.74u l=0.13u
X2520 a_32116_40464# a_32635_40471# a_33375_40821# VSS.t1189 sg13_lv_nmos ad=0.3473p pd=2.71u as=0.12665p ps=1.145u w=0.74u l=0.13u
X2521 VDD.t229 sar_ctrl_async_phys_0.sg13g2_a22oi_1$1_0.B1 sar_ctrl_async_phys_0.sg13g2_buf_1$1_17.A VDD.t147 sg13_lv_pmos ad=0.3808p pd=2.92u as=0.3808p ps=2.92u w=1.12u l=0.13u
X2522 VSS.t169 VDD.t1087 VSS.t169 VSS.t909 sg13_lv_nmos ad=0.1428p pd=1.52u as=0 ps=0 w=0.42u l=1u
X2523 a_35456_44454# sar_ctrl_async_phys_0.sg13g2_buf_1$1_41.X VDD.t5 VDD.t5 sg13_lv_pmos ad=79.8f pd=0.8u as=1.79957p ps=11.62u w=0.42u l=0.13u
X2524 oa_sar8_acore18_opt_0.bstrap_opt_w2_c1200_1.out oa_sar8_acore18_opt_0.bstrap_opt_w2_c1200_1.gb oa_sar8_acore18_opt_0.sw_bitcell_opt_b3_1.bot.t0 VSS.t159 sg13_lv_nmos ad=0.35p pd=2.7u as=0.195p ps=1.39u w=1u l=0.13u
X2525 VDD.t329 sar_ctrl_async_phys_0.sg13g2_inv_1$1_0.Y a_35463_31435# VDD.t3 sg13_lv_pmos ad=0.1428p pd=1.52u as=79.8f ps=0.8u w=0.42u l=0.13u
X2526 VSS.t111 a_26174_42911# sar_ctrl_async_phys_0.sg13g2_dlygate4sd3_1$1_5.X VSS.t144 sg13_lv_nmos ad=0.1426p pd=1.16u as=0.2516p ps=2.16u w=0.74u l=0.13u
X2527 a_31898_32361# a_32341_32117# a_31638_32138# VSS.t100 sg13_lv_nmos ad=79.8f pd=0.8u as=0.1296p ps=1.52u w=0.42u l=0.13u
X2528 VDD.t255 VSS.t15 VDD.t254 VDD.t29 sg13_lv_pmos ad=0.34p pd=2.68u as=0 ps=0 w=1u l=1u
X2529 oa_sar8_acore18_opt_0.sw_tg_opt_0.bot.t3 oa_sar8_acore18_opt_0.sw_bitcell_opt_b7_0.bot.t52 cap_cmim l=2.14u w=2.14u
X2530 VDD.t81 VSS.t1080 VDD.t81 VDD.t3 sg13_lv_pmos ad=0.34p pd=2.68u as=0 ps=0 w=1u l=1u
X2531 a_34132_32904# a_34651_32911# a_35391_33261# VSS.t607 sg13_lv_nmos ad=0.3473p pd=2.71u as=0.12665p ps=1.145u w=0.74u l=0.13u
X2532 VSS.t42 sar_ctrl_async_phys_0.sg13g2_nand2b_1$1_3.Y a_35672_46508# VSS.t125 sg13_lv_nmos ad=0.14875p pd=1.16u as=0.187p ps=1.78u w=0.55u l=0.13u
X2533 oa_sar8_acore18_opt_0.sw_tg_opt_1.bot.t3 oa_sar8_acore18_opt_0.sw_bitcell_opt_b5_1.bot.t15 cap_cmim l=2.14u w=2.14u
X2534 sar_ctrl_async_phys_0.sg13g2_nor2b_1$1_0.Y sar_ctrl_async_phys_0.sg13g2_nor2b_1$1_0.A VSS.t235 VSS.t234 sg13_lv_nmos ad=0.1406p pd=1.12u as=0.2516p ps=2.16u w=0.74u l=0.13u
X2535 a_35593_34535# a_34651_34423# a_35391_34773# VDD.t147 sg13_lv_pmos ad=93.45f pd=0.865u as=0.2048p ps=1.63u w=0.42u l=0.13u
X2536 VDD.t184 VSS.t131 VDD.t184 VDD.t10 sg13_lv_pmos ad=0.19p pd=1.38u as=0 ps=0 w=1u l=1u
X2537 oa_sar8_acore18_opt_0.sw_tg_opt_0.bot.t3 oa_sar8_acore18_opt_0.sw_bitcell_opt_b5_0.bot.t30 cap_cmim l=2.14u w=2.14u
X2538 a_32958_33292# sar_ctrl_async_phys_0.sg13g2_a22oi_1$1_0.A1 sar_ctrl_async_phys_0.sg13g2_a22oi_1$1_4.Y VSS.t57 sg13_lv_nmos ad=96.2f pd=1u as=0.2664p ps=1.46u w=0.74u l=0.13u
X2539 VDD.t4 VSS.t696 VDD.t4 VDD.t3 sg13_lv_pmos ad=0.19p pd=1.38u as=0 ps=0 w=1u l=1u
X2540 sar_ctrl_async_phys_0.sg13g2_nor2_1$1_5.A sar_ctrl_async_phys_0.sg13g2_and2_1$1_0.A VDD.t30 VDD.t29 sg13_lv_pmos ad=0.3808p pd=2.92u as=0.3808p ps=2.92u w=1.12u l=0.13u
X2541 VSS.t102 sar_ctrl_async_phys_0.sg13g2_nor2_1$1_7.A sar_ctrl_async_phys_0.sg13g2_nor2_1$1_6.B VSS.t545 sg13_lv_nmos ad=0.2516p pd=2.16u as=0.1406p ps=1.12u w=0.74u l=0.13u
X2542 a_33248_45238# a_32991_45357# a_33410_45434# VSS.t1131 sg13_lv_nmos ad=0.1428p pd=1.52u as=37.8f ps=0.6u w=0.42u l=0.13u
X2543 VSS.t279 a_32533_40471# a_32635_40471# VSS.t421 sg13_lv_nmos ad=5.25845p pd=33.575u as=0.2516p ps=2.16u w=0.74u l=0.13u
X2544 VSS.t102 VDD.t145 VSS.t65 VSS.t914 sg13_lv_nmos ad=0.1428p pd=1.52u as=0 ps=0 w=0.42u l=1u
X2545 a_31071_33727# a_30229_33629# a_30977_33727# VSS.t176 sg13_lv_nmos ad=0.12665p pd=1.145u as=0.1428p ps=1.52u w=0.42u l=0.13u
X2546 VDD.t359 sar_ctrl_async_phys_0.sg13g2_buf_1$1_41.X a_33818_43452# VDD.t22 sg13_lv_pmos ad=0.1563p pd=1.22u as=0.147p ps=1.54u w=0.42u l=0.13u
X2547 VDD.t90 VSS.t1060 VDD.t90 VDD.t3 sg13_lv_pmos ad=0.34p pd=2.68u as=0 ps=0 w=1u l=1u
X2548 a_26558_40727# a_26673_40726# VSS.t51 VSS.t262 sg13_lv_nmos ad=0.1428p pd=1.52u as=0.1426p ps=1.16u w=0.42u l=0.5u
X2549 oa_sar8_acore18_opt_0.sw_tg_opt_1.bot.t4 oa_sar8_acore18_opt_0.sw_bitcell_opt_b7_1.bot.t10 cap_cmim l=2.14u w=2.14u
X2550 sar_ctrl_async_phys_0.sg13g2_inv_1$1_10.Y sar_ctrl_async_phys_0.sg13g2_dfrbpq_1$1_0.CLK.t23 VSS.t29 VSS.t284 sg13_lv_nmos ad=0.2516p pd=2.16u as=0.2516p ps=2.16u w=0.74u l=0.13u
X2551 a_28130_40838# sar_ctrl_async_phys_0.sg13g2_inv_1$1_10.Y VSS.t29 VSS.t1194 sg13_lv_nmos ad=0.2516p pd=2.16u as=0.1406p ps=1.12u w=0.74u l=0.15u
X2552 a_33750_36362# a_34555_35935# a_34010_35892# VDD.t19 sg13_lv_pmos ad=0.1428p pd=1.52u as=79.8f ps=0.8u w=0.42u l=0.13u
X2553 VDD.t175 sar_ctrl_async_phys_0.sg13g2_nor2_1$1_4.Y a_34136_47296# VDD.t42 sg13_lv_pmos ad=0.2114p pd=1.54u as=0.2856p ps=2.36u w=0.84u l=0.13u
X2554 oa_sar8_acore18_opt_0.sw_tg_opt_0.bot.t3 oa_sar8_acore18_opt_0.sw_bitcell_opt_b6_0.bot.t24 cap_cmim l=2.14u w=2.14u
X2555 VSS.t1064 VDD.t77 VSS.t1063 VSS.t179 sg13_lv_nmos ad=0.1428p pd=1.52u as=0 ps=0 w=0.42u l=1u
X2556 oa_sar8_acore18_opt_0.sw_tg_opt_0.bot.t4 oa_sar8_acore18_opt_0.sw_bitcell_opt_b7_0.bot.t15 cap_cmim l=2.14u w=2.14u
X2557 VSS.t970 VDD.t159 VSS.t970 VSS.t0 sg13_lv_nmos ad=79.8f pd=0.8u as=0 ps=0 w=0.42u l=1u
X2558 VSS.t54 a_34549_32911# a_34651_32911# VSS.t1134 sg13_lv_nmos ad=5.99755p pd=39.725u as=0.2516p ps=2.16u w=0.74u l=0.13u
X2559 a_30390_39698# a_31195_39820# a_30650_39921# VDD.t317 sg13_lv_pmos ad=0.1428p pd=1.52u as=79.8f ps=0.8u w=0.42u l=0.13u
X2560 VDD.t79 VSS.t23 VDD.t79 VDD.t3 sg13_lv_pmos ad=0.34p pd=2.68u as=0 ps=0 w=1u l=1u
X2561 sar_ctrl_async_phys_0.sg13g2_nor2_1$1_3.B sar_ctrl_async_phys_0.sg13g2_buf_1$1_26.X a_26728_37416# VDD.t16 sg13_lv_pmos ad=0.2128p pd=1.5u as=0.2128p ps=1.5u w=1.12u l=0.15u
X2562 oa_sar8_acore18_opt_0.sw_tg_opt_1.bot.t3 oa_sar8_acore18_opt_0.sw_bitcell_opt_b6_1.bot.t55 cap_cmim l=2.14u w=2.14u
X2563 a_32149_35141# sar_ctrl_async_phys_0.sg13g2_dfrbpq_1$1_0.CLK.t9 VSS.t206 VSS.t558 sg13_lv_nmos ad=0.2516p pd=2.16u as=4.70937p ps=30.235u w=0.74u l=0.13u
X2564 sar_ctrl_async_phys_0.sg13g2_a21oi_1$1_3.A2 a_35482_39996# VSS.t79 VSS.t78 sg13_lv_nmos ad=0.2516p pd=2.16u as=0.1406p ps=1.12u w=0.74u l=0.13u
X2565 VSS.t730 VDD.t44 VSS.t730 VSS.t734 sg13_lv_nmos ad=0.1428p pd=1.52u as=0 ps=0 w=0.42u l=1u
X2566 oa_sar8_acore18_opt_0.sw_bitcell_opt_b4_1.bot.t1 sar_ctrl_async_phys_0.dac_code_n[4] VDD.t700 VDD.t698 sg13_lv_pmos ad=0.936p pd=5.19u as=1.68p ps=10.3u w=4.8u l=0.13u
X2567 a_35245_45936# sar_ctrl_async_phys_0.sg13g2_nand2b_1$1_6.A_N VDD.t416 VDD.t10 sg13_lv_pmos ad=0.2856p pd=2.36u as=0.2198p ps=1.53u w=0.84u l=0.13u
X2568 oa_sar8_acore18_opt_0.sw_tg_opt_1.bot.t3 oa_sar8_acore18_opt_0.sw_bitcell_opt_b7_1.bot.t79 cap_cmim l=2.14u w=2.14u
X2569 oa_sar8_acore18_opt_0.sw_tg_opt_0.bot.t3 oa_sar8_acore18_opt_0.sw_bitcell_opt_b7_0.bot.t120 cap_cmim l=2.14u w=2.14u
X2570 VSS.t48 sar_ctrl_async_phys_0.sg13g2_a21oi_1$1_5.Y a_31518_33292# VSS.t57 sg13_lv_nmos ad=0.2516p pd=2.16u as=96.2f ps=1u w=0.74u l=0.13u
X2571 VDD.t22 a_25596_43448# sar_ctrl_async_phys_0.sample VDD.t22 sg13_lv_pmos ad=0.2114p pd=1.54u as=0.42p ps=2.99u w=1.12u l=0.13u
X2572 sar_ctrl_async_phys_0.sg13g2_a21oi_1$1_5.Y sar_ctrl_async_phys_0.sg13g2_nand2b_1$1_3.Y VSS.t85 VSS.t893 sg13_lv_nmos ad=0.1406p pd=1.12u as=0.2516p ps=2.16u w=0.74u l=0.13u
X2573 oa_sar8_acore18_opt_0.sw_tg_opt_0.bot.t3 oa_sar8_acore18_opt_0.sw_bitcell_opt_b3_0.bot.t8 cap_cmim l=2.14u w=2.14u
X2574 VDD.t562 sar_ctrl_async_phys_0.sg13g2_buf_1$1_36.A a_36056_41972# VDD.t0 sg13_lv_pmos ad=0.2114p pd=1.54u as=0.2856p ps=2.36u w=0.84u l=0.13u
X2575 oa_sar8_acore18_opt_0.sw_tg_opt_1.bot.t3 oa_sar8_acore18_opt_0.sw_bitcell_opt_b5_1.bot.t2 cap_cmim l=2.14u w=2.14u
X2576 a_34261_43495# sar_ctrl_async_phys_0.sg13g2_dfrbpq_1$1_0.CLK.t24 VSS.t26 VSS.t556 sg13_lv_nmos ad=0.2516p pd=2.16u as=3.64875p ps=22.56u w=0.74u l=0.13u
X2577 a_32027_43832# sar_ctrl_async_phys_0.sg13g2_a21oi_1$1_4.A2 a_31933_43832# VSS.t359 sg13_lv_nmos ad=0.1216p pd=1.02u as=0.2176p ps=1.96u w=0.64u l=0.13u
X2578 a_21332_n9711# VDD.t1082 oa_sar8_acore18_opt_0.bstrap_opt_w2_c1200_1.gb VSS.t1129 sg13_lv_nmos ad=0.345p pd=2.69u as=0.19p ps=1.38u w=1u l=0.15u
X2579 VDD.t561 a_33183_32215# a_33850_32436# VDD.t76 sg13_lv_pmos ad=0.2128p pd=1.5u as=0.3864p ps=2.93u w=1.12u l=0.13u
X2580 a_30793_32453# a_29851_32260# a_30591_32215# VDD.t76 sg13_lv_pmos ad=93.45f pd=0.865u as=0.2048p ps=1.63u w=0.42u l=0.13u
X2581 a_35211_37436# sar_ctrl_async_phys_0.sg13g2_a21oi_1$1_1.B1 sar_ctrl_async_phys_0.sg13g2_a22oi_1$1_0.A2 VDD.t16 sg13_lv_pmos ad=0.2128p pd=1.5u as=0.3808p ps=2.92u w=1.12u l=0.13u
X2582 result[4] a_33752_33688# VDD.t728 VDD.t147 sg13_lv_pmos ad=0.42p pd=2.99u as=0.2114p ps=1.54u w=1.12u l=0.13u
X2583 oa_sar8_acore18_opt_0.sw_tg_opt_1.bot.t3 oa_sar8_acore18_opt_0.sw_bitcell_opt_b7_1.bot.t36 cap_cmim l=2.14u w=2.14u
X2584 a_31706_44964# a_32149_45007# a_32089_45043# VDD.t5 sg13_lv_pmos ad=79.8f pd=0.8u as=63f ps=0.72u w=0.42u l=0.13u
X2585 VDD.t17 sar_ctrl_async_phys_0.sg13g2_nor2_1$1_8.A a_29660_37436# VDD.t16 sg13_lv_pmos ad=0.4032p pd=2.96u as=0.1176p ps=1.33u w=1.12u l=0.13u
X2586 VSS.t780 VDD.t15 VSS.t780 VSS.t807 sg13_lv_nmos ad=79.8f pd=0.8u as=0 ps=0 w=0.42u l=1u
X2587 a_25596_43448# sar_ctrl_async_phys_0.sg13g2_nor2_1$1_12.Y VDD.t22 VDD.t22 sg13_lv_pmos ad=0.2856p pd=2.36u as=0.2114p ps=1.54u w=0.84u l=0.13u
X2588 VDD.t202 VSS.t270 VDD.t202 VDD.t147 sg13_lv_pmos ad=0.19p pd=1.38u as=0 ps=0 w=1u l=1u
X2589 oa_sar8_acore18_opt_0.sw_tg_opt_0.bot.t3 oa_sar8_acore18_opt_0.sw_bitcell_opt_b4_0.bot.t18 cap_cmim l=2.14u w=2.14u
X2590 oa_sar8_acore18_opt_0.sw_tg_opt_1.bot.t3 oa_sar8_acore18_opt_0.sw_bitcell_opt_b4_1.bot.t28 cap_cmim l=2.14u w=2.14u
X2591 a_31518_33292# sar_ctrl_async_phys_0.sg13g2_a22oi_1$1_0.A1 sar_ctrl_async_phys_0.sg13g2_inv_1$1_6.A VSS.t57 sg13_lv_nmos ad=96.2f pd=1u as=0.2664p ps=1.46u w=0.74u l=0.13u
X2592 VDD.t159 VSS.t945 VDD.t159 VDD.t19 sg13_lv_pmos ad=0.34p pd=2.68u as=0 ps=0 w=1u l=1u
X2593 VDD.t359 sar_ctrl_async_phys_0.sg13g2_buf_1$1_41.X a_33558_43922# VDD.t22 sg13_lv_pmos ad=0.36237p pd=2.605u as=79.8f ps=0.8u w=0.42u l=0.13u
X2594 VSS.t260 sar_ctrl_async_phys_0.sg13g2_a22oi_1$1_2.B2 a_33752_33688# VSS.t176 sg13_lv_nmos ad=0.14875p pd=1.16u as=0.187p ps=1.78u w=0.55u l=0.13u
X2595 VSS.t946 VDD.t159 VSS.t948 VSS.t947 sg13_lv_nmos ad=79.8f pd=0.8u as=0 ps=0 w=0.42u l=1u
X2596 VSS.t137 a_32576_44454# a_32225_44311# VSS.t423 sg13_lv_nmos ad=79.8f pd=0.8u as=0.1428p ps=1.52u w=0.42u l=0.13u
X2597 a_31477_44213# sar_ctrl_async_phys_0.sg13g2_dfrbpq_1$1_0.CLK.t27 VSS.t26 VSS.t445 sg13_lv_nmos ad=0.2516p pd=2.16u as=3.64875p ps=22.56u w=0.74u l=0.13u
X2598 VDD.t22 VSS.t818 VDD.t22 VDD.t22 sg13_lv_pmos ad=0.34p pd=2.68u as=0 ps=0 w=1u l=1u
X2599 a_33846_34850# a_34651_34423# a_34106_34380# VDD.t147 sg13_lv_pmos ad=0.1428p pd=1.52u as=79.8f ps=0.8u w=0.42u l=0.13u
X2600 VSS.t126 VDD.t132 VSS.t126 VSS.t41 sg13_lv_nmos ad=0.1428p pd=1.52u as=0 ps=0 w=0.42u l=1u
X2601 VDD.t25 VSS.t313 VDD.t25 VDD.t22 sg13_lv_pmos ad=0.34p pd=2.68u as=0 ps=0 w=1u l=1u
X2602 VDD.t361 sar_ctrl_async_phys_0.sg13g2_o21ai_1$1_1.B1.t6 a_30390_39698# VDD.t317 sg13_lv_pmos ad=0.36237p pd=2.605u as=79.8f ps=0.8u w=0.42u l=0.13u
X2603 oa_sar8_acore18_opt_0.sw_tg_opt_0.bot.t3 oa_sar8_acore18_opt_0.sw_bitcell_opt_b7_0.bot.t47 cap_cmim l=2.14u w=2.14u
X2604 a_34297_44625# a_33940_44552# VDD.t408 VDD.t5 sg13_lv_pmos ad=63f pd=0.72u as=0.1563p ps=1.22u w=0.42u l=0.13u
X2605 oa_sar8_acore18_opt_0.sw_tg_opt_1.bot.t3 oa_sar8_acore18_opt_0.sw_bitcell_opt_b7_1.bot.t111 cap_cmim l=2.14u w=2.14u
X2606 VDD.t362 sar_ctrl_async_phys_0.sg13g2_buf_1$1_3.A a_35664_37695# VDD.t16 sg13_lv_pmos ad=0.2856p pd=2.36u as=0.1596p ps=1.22u w=0.84u l=0.13u
X2607 oa_sar8_acore18_opt_0.sw_tg_opt_0.bot.t3 oa_sar8_acore18_opt_0.sw_bitcell_opt_b6_0.bot.t74 cap_cmim l=2.14u w=2.14u
X2608 VSS.t248 VDD.t1089 VSS.t903 VSS.t549 sg13_lv_nmos ad=0.1428p pd=1.52u as=0 ps=0 w=0.42u l=1u
X2609 a_33276_42686# sar_ctrl_async_phys_0.sg13g2_buf_1$1_13.A VSS.t99 VSS.t220 sg13_lv_nmos ad=0.187p pd=1.78u as=0.14875p ps=1.16u w=0.55u l=0.13u
X2610 VSS.t954 VDD.t18 VSS.t954 VSS.t953 sg13_lv_nmos ad=0.1428p pd=1.52u as=0 ps=0 w=0.42u l=1u
X2611 oa_sar8_acore18_opt_0.sw_tg_opt_1.bot.t3 oa_sar8_acore18_opt_0.sw_bitcell_opt_b6_1.bot.t30 cap_cmim l=2.14u w=2.14u
X2612 VDD.t19 a_35295_36285# a_35552_36166# VDD.t19 sg13_lv_pmos ad=1.79957p pd=11.62u as=79.8f ps=0.8u w=0.42u l=0.13u
X2613 oa_sar8_acore18_opt_0.sw_bitcell_opt_b5_0.bot.t1 oa_sar8_acore18_opt_0.sw_bitcell_opt_term_0.gb.t10 oa_sar8_acore18_opt_0.sw_bitcell_opt_term_0.vin VSS.t1314 sg13_lv_nmos ad=0.195p pd=1.39u as=0.35p ps=2.7u w=1u l=0.13u
X2614 VDD.t233 VSS.t979 VDD.t233 VDD.t147 sg13_lv_pmos ad=0.19p pd=1.38u as=0 ps=0 w=1u l=1u
X2615 VDD.t8 VSS.t836 VDD.t6 VDD.t5 sg13_lv_pmos ad=0.34p pd=2.68u as=0 ps=0 w=1u l=1u
X2616 VDD.t77 VSS.t1024 VDD.t97 VDD.t76 sg13_lv_pmos ad=0.19p pd=1.38u as=0 ps=0 w=1u l=1u
X2617 a_32687_32876# sar_ctrl_async_phys_0.sg13g2_a22oi_1$1_0.A1 VDD.t342 VDD.t76 sg13_lv_pmos ad=0.2716p pd=1.605u as=0.3808p ps=2.92u w=1.12u l=0.13u
X2618 oa_sar8_acore18_opt_0.sw_tg_opt_0.bot.t3 oa_sar8_acore18_opt_0.sw_bitcell_opt_b6_0.bot.t41 cap_cmim l=2.14u w=2.14u
X2619 a_34847_42342# a_34765_42242# sar_ctrl_async_phys_0.sg13g2_nand2b_1$1_1.Y VSS.t435 sg13_lv_nmos ad=0.1406p pd=1.12u as=0.333p ps=2.38u w=0.74u l=0.13u
X2620 oa_sar8_acore18_opt_0.sw_tg_opt_1.bot.t3 oa_sar8_acore18_opt_0.sw_bitcell_opt_b7_1.bot.t69 cap_cmim l=2.14u w=2.14u
X2621 a_28130_40838# sar_ctrl_async_phys_0.sg13g2_o21ai_1$1_1.B1.t11 sar_ctrl_async_phys_0.sg13g2_nor2_1$1_13.A VSS.t529 sg13_lv_nmos ad=0.1406p pd=1.12u as=0.2516p ps=2.16u w=0.74u l=0.15u
X2622 VDD.t20 sar_ctrl_async_phys_0.sg13g2_buf_1$1_2.X.t3 a_30390_36362# VDD.t19 sg13_lv_pmos ad=0.36237p pd=2.605u as=79.8f ps=0.8u w=0.42u l=0.13u
X2623 a_34765_45266# sar_ctrl_async_phys_0.sg13g2_nand2b_1$1_5.A_N VDD.t349 VDD.t5 sg13_lv_pmos ad=0.2856p pd=2.36u as=0.2198p ps=1.53u w=0.84u l=0.13u
X2624 VSS.t225 a_25596_43448# sar_ctrl_async_phys_0.sample VSS.t224 sg13_lv_nmos ad=0.14875p pd=1.16u as=0.2886p ps=2.26u w=0.74u l=0.13u
X2625 VDD.t956 sar_ctrl_async_phys_0.dac_code[6] oa_sar8_acore18_opt_0.sw_bitcell_opt_b6_0.bot.t81 VDD.t955 sg13_lv_pmos ad=2.1p pd=12.7u as=1.17p ps=6.39u w=6u l=0.13u
X2626 a_34362_31826# a_34055_31352# a_34268_31826# VSS.t2 sg13_lv_nmos ad=37.8f pd=0.6u as=0.1428p ps=1.52u w=0.42u l=0.13u
X2627 oa_sar8_acore18_opt_0.sw_tg_opt_1.bot.t3 oa_sar8_acore18_opt_0.sw_bitcell_opt_b6_1.bot.t62 cap_cmim l=2.14u w=2.14u
X2628 oa_sar8_acore18_opt_0.sw_tg_opt_1.bot.t3 oa_sar8_acore18_opt_0.sw_bitcell_opt_b7_1.bot.t26 cap_cmim l=2.14u w=2.14u
X2629 VDD.t372 sar_ctrl_async_phys_0.sg13g2_buf_1$1_1.A a_34904_33688# VDD.t147 sg13_lv_pmos ad=0.2114p pd=1.54u as=0.2856p ps=2.36u w=0.84u l=0.13u
X2630 oa_sar8_acore18_opt_0.sw_tg_opt_0.bot.t3 oa_sar8_acore18_opt_0.sw_bitcell_opt_b5_0.bot.t10 cap_cmim l=2.14u w=2.14u
X2631 oa_sar8_acore18_opt_0.sw_bitcell_opt_b2_0.bot.t1 oa_sar8_acore18_opt_0.sw_bitcell_opt_term_0.trkb.t15 oa_sar8_acore18_opt_0.sw_bitcell_opt_term_0.vin VDD.t777 sg13_lv_pmos ad=0.39p pd=2.39u as=0.7p ps=4.7u w=2u l=0.13u
X2632 a_34236_46472# sar_ctrl_async_phys_0.sg13g2_buf_1$1_2.A VDD.t177 VDD.t10 sg13_lv_pmos ad=0.2856p pd=2.36u as=0.2114p ps=1.54u w=0.84u l=0.13u
X2633 a_30169_34041# a_29812_33968# VDD.t233 VDD.t147 sg13_lv_pmos ad=63f pd=0.72u as=0.1563p ps=1.22u w=0.42u l=0.13u
X2634 a_25596_43448# sar_ctrl_async_phys_0.sg13g2_nor2_1$1_12.Y VSS.t225 VSS.t224 sg13_lv_nmos ad=0.187p pd=1.78u as=0.14875p ps=1.16u w=0.55u l=0.13u
X2635 VSS.t260 sar_ctrl_async_phys_0.sg13g2_a22oi_1$1_3.A2 a_33630_33292# VSS.t57 sg13_lv_nmos ad=0.2516p pd=2.16u as=96.2f ps=1u w=0.74u l=0.13u
X2636 a_32991_35239# a_32149_35141# a_31732_35480# VDD.t19 sg13_lv_pmos ad=0.2048p pd=1.63u as=0.34p ps=2.68u w=1u l=0.13u
X2637 a_34895_32120# sar_ctrl_async_phys_0.sg13g2_a22oi_1$1_0.B1 VSS.t309 VSS.t58 sg13_lv_nmos ad=0.13875p pd=1.115u as=0.2553p ps=2.17u w=0.74u l=0.13u
X2638 oa_sar8_acore18_opt_0.sw_tg_opt_0.bot.t3 oa_sar8_acore18_opt_0.sw_bitcell_opt_b7_0.bot.t115 cap_cmim l=2.14u w=2.14u
X2639 a_31477_44213# sar_ctrl_async_phys_0.sg13g2_dfrbpq_1$1_0.CLK.t27 VDD.t5 VDD.t5 sg13_lv_pmos ad=0.4088p pd=2.97u as=1.79957p ps=11.62u w=1.12u l=0.13u
X2640 oa_sar8_acore18_opt_0.sw_tg_opt_1.bot.t3 oa_sar8_acore18_opt_0.sw_bitcell_opt_b6_1.bot.t62 cap_cmim l=2.14u w=2.14u
X2641 oa_sar8_acore18_opt_0.sw_tg_opt_1.bot.t3 oa_sar8_acore18_opt_0.sw_bitcell_opt_b7_1.bot.t65 cap_cmim l=2.14u w=2.14u
X2642 oa_sar8_acore18_opt_0.sw_bitcell_opt_b4_0.bot.t1 oa_sar8_acore18_opt_0.sw_bitcell_opt_term_0.gb.t9 oa_sar8_acore18_opt_0.sw_bitcell_opt_term_0.vin VSS.t406 sg13_lv_nmos ad=0.195p pd=1.39u as=0.35p ps=2.7u w=1u l=0.13u
X2643 a_30733_35460# sar_ctrl_async_phys_0.sg13g2_buf_1$1_17.A VDD.t20 VDD.t19 sg13_lv_pmos ad=0.3325p pd=1.665u as=0.253p ps=1.53u w=1u l=0.13u
X2644 oa_sar8_acore18_opt_0.bstrap_opt_w2_c1200_1.gb VDD.t1082 a_21332_n9711# VSS.t1129 sg13_lv_nmos ad=0.19p pd=1.38u as=0.345p ps=2.69u w=1u l=0.15u
X2645 oa_sar8_acore18_opt_0.sw_tg_opt_1.bot.t3 oa_sar8_acore18_opt_0.sw_bitcell_opt_b6_1.bot.t30 cap_cmim l=2.14u w=2.14u
X2646 sar_ctrl_async_phys_0.sg13g2_nor2_1$1_3.Y sar_ctrl_async_phys_0.sg13g2_nor2_1$1_3.B a_27354_37436# VDD.t16 sg13_lv_pmos ad=0.3808p pd=2.92u as=0.1176p ps=1.33u w=1.12u l=0.13u
X2647 sar_ctrl_async_phys_0.sg13g2_buf_1$1_20.A a_31933_43832# VDD.t219 VDD.t22 sg13_lv_pmos ad=0.3808p pd=2.92u as=0.1918p ps=1.5u w=1.12u l=0.13u
X2648 VDD.t361 sar_ctrl_async_phys_0.sg13g2_o21ai_1$1_1.B1.t10 a_29238_40898# VDD.t317 sg13_lv_pmos ad=0.36237p pd=2.605u as=79.8f ps=0.8u w=0.42u l=0.13u
X2649 VDD.t59 VSS.t1100 VDD.t59 VDD.t3 sg13_lv_pmos ad=0.34p pd=2.68u as=0 ps=0 w=1u l=1u
X2650 oa_sar8_acore18_opt_0.sw_tg_opt_0.bot.t3 oa_sar8_acore18_opt_0.sw_bitcell_opt_b6_0.bot.t34 cap_cmim l=2.14u w=2.14u
X2651 VDD.t68 VSS.t29 VDD.t157 VDD.t0 sg13_lv_pmos ad=0.19p pd=1.38u as=0 ps=0 w=1u l=1u
X2652 oa_sar8_acore18_opt_0.sw_bitcell_opt_b7_1.bot.t0 oa_sar8_acore18_opt_0.bstrap_opt_w2_c1200_1.gb oa_sar8_acore18_opt_0.bstrap_opt_w2_c1200_1.out VSS.t164 sg13_lv_nmos ad=0.195p pd=1.39u as=0.35p ps=2.7u w=1u l=0.13u
X2653 a_33818_36897# a_34261_36653# a_33558_36674# VSS.t1311 sg13_lv_nmos ad=79.8f pd=0.8u as=0.1296p ps=1.52u w=0.42u l=0.13u
X2654 VDD.t325 a_27530_39666# a_27249_39888# VDD.t317 sg13_lv_pmos ad=0.1523p pd=1.38u as=0.34p ps=2.68u w=1u l=0.5u
X2655 oa_sar8_acore18_opt_0.sw_tg_opt_1.bot.t3 oa_sar8_acore18_opt_0.sw_bitcell_opt_b7_1.bot.t142 cap_cmim l=2.14u w=2.14u
X2656 VSS.t344 VDD.t18 VSS.t344 VSS.t932 sg13_lv_nmos ad=0.1428p pd=1.52u as=0 ps=0 w=0.42u l=1u
X2657 oa_sar8_acore18_opt_0.sw_tg_opt_1.bot.t3 oa_sar8_acore18_opt_0.sw_bitcell_opt_b5_1.bot.t30 cap_cmim l=2.14u w=2.14u
X2658 sar_ctrl_async_phys_0.sg13g2_a22oi_1$1_2.Y sar_ctrl_async_phys_0.sg13g2_a22oi_1$1_0.B1 a_31823_32876# VDD.t76 sg13_lv_pmos ad=0.2128p pd=1.5u as=0.2716p ps=1.605u w=1.12u l=0.13u
X2659 a_35417_35208# sar_ctrl_async_phys_0.sg13g2_a21oi_1$1_0.A2 VSS.t33 VSS.t12 sg13_lv_nmos ad=0.1216p pd=1.02u as=0.1331p ps=1.12u w=0.64u l=0.13u
X2660 a_31446_35162# a_32251_35284# a_31706_35385# VDD.t19 sg13_lv_pmos ad=0.1428p pd=1.52u as=79.8f ps=0.8u w=0.42u l=0.13u
X2661 oa_sar8_acore18_opt_0.sw_tg_opt_0.bot.t3 oa_sar8_acore18_opt_0.sw_bitcell_opt_b7_0.bot.t78 cap_cmim l=2.14u w=2.14u
X2662 VSS.t1032 VDD.t247 VSS.t1034 VSS.t1033 sg13_lv_nmos ad=79.8f pd=0.8u as=0 ps=0 w=0.42u l=1u
X2663 oa_sar8_acore18_opt_0.sw_tg_opt_1.bot.t3 oa_sar8_acore18_opt_0.sw_bitcell_opt_b2_1.bot.t4 cap_cmim l=2.14u w=2.14u
X2664 VDD.t10 a_33109_45725# a_33211_45868# VDD.t10 sg13_lv_pmos ad=2.2076p pd=14.4u as=0.3864p ps=2.93u w=1.12u l=0.13u
X2665 VDD.t905 VDD.t903 oa_sar8_acore18_opt_0.sw_bitcell_opt_term_1.bot.t3 VDD.t904 sg13_lv_pmos ad=1.05p pd=6.7u as=0.585p ps=3.39u w=3u l=0.13u
X2666 a_30580_31826# sar_ctrl_async_phys_0.sg13g2_inv_1$1_11.Y a_30486_31826# VSS.t608 sg13_lv_nmos ad=60.89999f pd=0.71u as=0.1428p ps=1.52u w=0.42u l=0.13u
X2667 VDD.t147 a_30229_33629# a_30331_33772# VDD.t147 sg13_lv_pmos ad=2.2076p pd=14.4u as=0.3864p ps=2.93u w=1.12u l=0.13u
X2668 VDD.t19 a_33248_35382# a_33193_35477# VDD.t19 sg13_lv_pmos ad=1.79957p pd=11.62u as=93.45f ps=0.865u w=0.42u l=0.13u
X2669 a_29524_40464# a_30043_40471# a_30783_40821# VSS.t30 sg13_lv_nmos ad=0.3473p pd=2.71u as=0.12665p ps=1.145u w=0.74u l=0.13u
X2670 a_31202_40898# sar_ctrl_async_phys_0.sg13g2_o21ai_1$1_1.B1.t9 VSS.t462 VSS.t30 sg13_lv_nmos ad=37.8f pd=0.6u as=79.8f ps=0.8u w=0.42u l=0.13u
X2671 VSS.t519 a_29653_38959# a_29755_38959# VSS.t668 sg13_lv_nmos ad=5.61045p pd=35.775u as=0.2516p ps=2.16u w=0.74u l=0.13u
X2672 VSS.t351 VDD.t1090 VSS.t902 VSS.t549 sg13_lv_nmos ad=79.8f pd=0.8u as=0 ps=0 w=0.42u l=1u
X2673 VSS.t737 VDD.t44 VSS.t737 VSS.t736 sg13_lv_nmos ad=0.1428p pd=1.52u as=0 ps=0 w=0.42u l=1u
X2674 oa_sar8_acore18_opt_0.sw_tg_opt_1.bot.t3 oa_sar8_acore18_opt_0.sw_bitcell_opt_b6_1.bot.t15 cap_cmim l=2.14u w=2.14u
X2675 a_33846_30626# sar_ctrl_async_phys_0.sg13g2_inv_1$1_2.Y VDD.t603 VDD.t3 sg13_lv_pmos ad=79.8f pd=0.8u as=0.1428p ps=1.52u w=0.42u l=0.13u
X2676 VDD.t64 VSS.t789 VDD.t64 VDD.t10 sg13_lv_pmos ad=0.34p pd=2.68u as=0 ps=0 w=1u l=1u
X2677 oa_sar8_acore18_opt_0.sw_tg_opt_1.bot.t3 oa_sar8_acore18_opt_0.sw_bitcell_opt_b5_1.bot.t30 cap_cmim l=2.14u w=2.14u
X2678 VSS.t126 a_32480_46750# a_32129_46869# VSS.t125 sg13_lv_nmos ad=79.8f pd=0.8u as=0.1428p ps=1.52u w=0.42u l=0.13u
X2679 sar_ctrl_async_phys_0.sg13g2_nor2_1$1_11.Y sar_ctrl_async_phys_0.sg13g2_a21oi_1$1_2.Y a_29562_39996# VDD.t317 sg13_lv_pmos ad=0.3808p pd=2.92u as=0.1176p ps=1.33u w=1.12u l=0.13u
X2680 VSS.t15 a_33344_37678# a_32993_37797# VSS.t14 sg13_lv_nmos ad=79.8f pd=0.8u as=0.1428p ps=1.52u w=0.42u l=0.13u
X2681 oa_sar8_acore18_opt_0.sw_tg_opt_0.bot.t3 oa_sar8_acore18_opt_0.sw_bitcell_opt_b7_0.bot.t86 cap_cmim l=2.14u w=2.14u
X2682 oa_sar8_acore18_opt_0.sw_tg_opt_1.bot.t3 oa_sar8_acore18_opt_0.sw_bitcell_opt_b7_1.bot.t100 cap_cmim l=2.14u w=2.14u
X2683 oa_sar8_acore18_opt_0.sw_tg_opt_1.bot.t3 oa_sar8_acore18_opt_0.sw_bitcell_opt_b7_1.bot.t53 cap_cmim l=2.14u w=2.14u
X2684 oa_sar8_acore18_opt_0.sw_bitcell_opt_b0_0.bot.t2 oa_sar8_acore18_opt_0.sw_bitcell_opt_term_0.gb.t5 oa_sar8_acore18_opt_0.sw_bitcell_opt_term_0.vin VSS.t591 sg13_lv_nmos ad=0.195p pd=1.39u as=0.35p ps=2.7u w=1u l=0.13u
X2685 a_31732_45000# a_31706_44964# VSS.t135 VSS.t256 sg13_lv_nmos ad=0.2516p pd=2.16u as=0.1626p ps=1.415u w=0.74u l=0.13u
X2686 VSS.t307 sar_ctrl_async_phys_0.sg13g2_o21ai_1$1_1.B1.t13 a_33460_41210# VSS.t552 sg13_lv_nmos ad=0.1626p pd=1.415u as=60.89999f ps=0.71u w=0.42u l=0.13u
X2687 a_34731_37436# sar_ctrl_async_phys_0.sg13g2_a21oi_1$1_0.A2 VDD.t320 VDD.t16 sg13_lv_pmos ad=0.3808p pd=2.92u as=0.2128p ps=1.5u w=1.12u l=0.13u
X2688 VSS.t75 a_32580_36642# sar_ctrl_async_phys_0.sg13g2_nor2b_1$1_0.Y VSS.t234 sg13_lv_nmos ad=0.17255p pd=1.25u as=0.1406p ps=1.12u w=0.74u l=0.13u
X2689 a_33558_36674# sar_ctrl_async_phys_0.sg13g2_nor2b_1$1_1.Y VDD.t649 VDD.t16 sg13_lv_pmos ad=79.8f pd=0.8u as=0.1428p ps=1.52u w=0.42u l=0.13u
X2690 oa_sar8_acore18_opt_0.sw_tg_opt_0.bot.t3 oa_sar8_acore18_opt_0.sw_bitcell_opt_b5_0.bot.t5 cap_cmim l=2.14u w=2.14u
X2691 VSS.t777 VDD.t11 VSS.t780 VSS.t779 sg13_lv_nmos ad=79.8f pd=0.8u as=0 ps=0 w=0.42u l=1u
X2692 oa_sar8_acore18_opt_0.sw_tg_opt_0.bot.t3 oa_sar8_acore18_opt_0.sw_bitcell_opt_b7_0.bot.t57 cap_cmim l=2.14u w=2.14u
X2693 oa_sar8_acore18_opt_0.sw_bitcell_opt_b3_0.bot.t1 oa_sar8_acore18_opt_0.sw_bitcell_opt_term_0.gb.t8 oa_sar8_acore18_opt_0.sw_bitcell_opt_term_0.vin VSS.t1316 sg13_lv_nmos ad=0.195p pd=1.39u as=0.35p ps=2.7u w=1u l=0.13u
X2694 a_35245_45266# sar_ctrl_async_phys_0.sg13g2_nand2_1$1_3.B VDD.t349 VDD.t5 sg13_lv_pmos ad=0.2856p pd=2.36u as=0.2198p ps=1.53u w=0.84u l=0.13u
X2695 VDD.t435 sar_ctrl_async_phys_0.sg13g2_buf_1$1_21.A a_36056_38224# VDD.t29 sg13_lv_pmos ad=0.2114p pd=1.54u as=0.2856p ps=2.36u w=0.84u l=0.13u
X2696 a_32185_37483# a_31828_37440# VDD.t18 VDD.t16 sg13_lv_pmos ad=63f pd=0.72u as=0.1563p ps=1.22u w=0.42u l=0.13u
X2697 VSS.t183 sar_ctrl_async_phys_0.cmp_fire a_28008_23477# VSS.t182 sg13_lv_nmos ad=0.5175p pd=3.69u as=0.285p ps=1.88u w=1.5u l=0.3u
X2698 sar_ctrl_async_phys_0.dac_code_n[3] a_34904_46508# VSS.t42 VSS.t125 sg13_lv_nmos ad=0.2886p pd=2.26u as=0.14875p ps=1.16u w=0.74u l=0.13u
X2699 VSS.t146 VDD.t145 VSS.t146 VSS.t949 sg13_lv_nmos ad=0.1428p pd=1.52u as=0 ps=0 w=0.42u l=1u
X2700 a_29332_32456# a_29306_32361# VSS.t23 VSS.t22 sg13_lv_nmos ad=0.2516p pd=2.16u as=0.1626p ps=1.415u w=0.74u l=0.13u
X2701 oa_sar8_acore18_opt_0.sw_tg_opt_0.bot.t3 oa_sar8_acore18_opt_0.sw_bitcell_opt_b7_0.bot.t128 cap_cmim l=2.14u w=2.14u
X2702 VSS.t114 sar_ctrl_async_phys_0.sg13g2_buf_1$1_20.A a_36056_37436# VSS.t14 sg13_lv_nmos ad=0.14875p pd=1.16u as=0.187p ps=1.78u w=0.55u l=0.13u
X2703 VDD.t342 sar_ctrl_async_phys_0.sg13g2_a22oi_1$1_4.A2 a_32687_32876# VDD.t76 sg13_lv_pmos ad=0.3808p pd=2.92u as=0.2744p ps=1.61u w=1.12u l=0.13u
X2704 VSS.t270 a_32991_35239# a_33658_35460# VSS.t1234 sg13_lv_nmos ad=0.1406p pd=1.12u as=0.2516p ps=2.16u w=0.74u l=0.13u
X2705 a_29236_38952# a_29210_38916# VSS.t272 VSS.t271 sg13_lv_nmos ad=0.2516p pd=2.16u as=0.1626p ps=1.415u w=0.74u l=0.13u
X2706 a_33748_44234# sar_ctrl_async_phys_0.sg13g2_nor2_1$1_1.Y a_33654_44234# VSS.t1219 sg13_lv_nmos ad=60.89999f pd=0.71u as=0.1428p ps=1.52u w=0.42u l=0.13u
X2707 oa_sar8_acore18_opt_0.sw_tg_opt_1.bot.t3 oa_sar8_acore18_opt_0.sw_bitcell_opt_b4_1.bot.t12 cap_cmim l=2.14u w=2.14u
X2708 a_33951_45823# a_33109_45725# a_33857_45823# VSS.t1142 sg13_lv_nmos ad=0.12665p pd=1.145u as=0.1428p ps=1.52u w=0.42u l=0.13u
X2709 VSS.t825 VDD.t15 VSS.t825 VSS.t224 sg13_lv_nmos ad=0.1428p pd=1.52u as=0 ps=0 w=0.42u l=1u
X2710 VDD.t2 VSS.t537 VDD.t1 VDD.t0 sg13_lv_pmos ad=0.19p pd=1.38u as=0 ps=0 w=1u l=1u
X2711 VSS.t575 sar_ctrl_async_phys_0.sg13g2_nor2_1$1_5.A sar_ctrl_async_phys_0.sg13g2_nor4_1$1_0.Y VSS.t574 sg13_lv_nmos ad=0.2516p pd=2.16u as=0.1406p ps=1.12u w=0.74u l=0.13u
X2712 VDD.t18 VSS.t340 VDD.t17 VDD.t16 sg13_lv_pmos ad=0.34p pd=2.68u as=0 ps=0 w=1u l=1u
X2713 oa_sar8_acore18_opt_0.sw_tg_opt_1.bot.t4 oa_sar8_acore18_opt_0.sw_bitcell_opt_b7_1.bot.t15 cap_cmim l=2.14u w=2.14u
X2714 sar_ctrl_async_phys_0.sg13g2_buf_1$1_32.A sar_ctrl_async_phys_0.sg13g2_nand2b_1$1_4.A_N VDD.t408 VDD.t5 sg13_lv_pmos ad=0.2128p pd=1.5u as=0.3808p ps=2.92u w=1.12u l=0.13u
X2715 a_26630_37814# sar_ctrl_async_phys_0.sg13g2_buf_1$1_26.X VSS.t65 VSS.t1220 sg13_lv_nmos ad=0.1406p pd=1.12u as=0.1406p ps=1.12u w=0.74u l=0.15u
X2716 oa_sar8_acore18_opt_0.sw_tg_opt_0.bot.t3 oa_sar8_acore18_opt_0.sw_bitcell_opt_b6_0.bot.t64 cap_cmim l=2.14u w=2.14u
X2717 VSS.t135 VDD.t184 VSS.t131 VSS.t797 sg13_lv_nmos ad=79.8f pd=0.8u as=0 ps=0 w=0.42u l=1u
X2718 oa_sar8_acore18_opt_0.sw_tg_opt_1.bot.t3 oa_sar8_acore18_opt_0.sw_bitcell_opt_b6_1.bot.t2 cap_cmim l=2.14u w=2.14u
X2719 VSS.t1 VDD.t233 VSS.t1 VSS.t0 sg13_lv_nmos ad=79.8f pd=0.8u as=0 ps=0 w=0.42u l=1u
X2720 VSS.t819 VDD.t22 VSS.t820 VSS.t224 sg13_lv_nmos ad=79.8f pd=0.8u as=0 ps=0 w=0.42u l=1u
X2721 a_35053_40730# sar_ctrl_async_phys_0.sg13g2_nand2_1$1_2.B VDD.t375 VDD.t317 sg13_lv_pmos ad=0.2856p pd=2.36u as=0.2198p ps=1.53u w=0.84u l=0.13u
X2722 a_33252_36642# sar_ctrl_async_phys_0.sg13g2_nor2b_1$1_1.B_N VSS.t431 VSS.t234 sg13_lv_nmos ad=0.187p pd=1.78u as=0.17255p ps=1.25u w=0.55u l=0.13u
X2723 VSS.t941 VDD.t169 VSS.t940 VSS.t939 sg13_lv_nmos ad=0.1428p pd=1.52u as=0 ps=0 w=0.42u l=1u
X2724 oa_sar8_acore18_opt_0.sw_bitcell_opt_term_0.VSS sar_ctrl_async_phys_0.dac_code[4] oa_sar8_acore18_opt_0.sw_bitcell_opt_b4_0.bot.t1 VSS.t254 sg13_lv_nmos ad=0.84p pd=5.5u as=0.468p ps=2.79u w=2.4u l=0.13u
X2725 VDD.t49 VSS.t730 VDD.t49 VDD.t10 sg13_lv_pmos ad=0.19p pd=1.38u as=0 ps=0 w=1u l=1u
X2726 a_25914_38948# track VDD.t191 VDD.t29 sg13_lv_pmos ad=0.1176p pd=1.33u as=0.4032p ps=2.96u w=1.12u l=0.13u
X2727 a_30938_46476# a_31381_46519# a_31321_46555# VDD.t10 sg13_lv_pmos ad=79.8f pd=0.8u as=63f ps=0.72u w=0.42u l=0.13u
X2728 VDD.t13 VSS.t821 VDD.t13 VDD.t5 sg13_lv_pmos ad=0.19p pd=1.38u as=0 ps=0 w=1u l=1u
X2729 oa_sar8_acore18_opt_0.sw_bitcell_opt_b7_0.bot.t1 oa_sar8_acore18_opt_0.sw_bitcell_opt_term_0.gb.t12 oa_sar8_acore18_opt_0.sw_bitcell_opt_term_0.vin VSS.t1315 sg13_lv_nmos ad=0.195p pd=1.39u as=0.35p ps=2.7u w=1u l=0.13u
X2730 VSS.t333 VDD.t13 VSS.t802 VSS.t801 sg13_lv_nmos ad=0.1428p pd=1.52u as=0 ps=0 w=0.42u l=1u
X2731 VSS.t851 VDD.t24 VSS.t855 VSS.t854 sg13_lv_nmos ad=79.8f pd=0.8u as=0 ps=0 w=0.42u l=1u
X2732 oa_sar8_acore18_opt_0.sw_tg_opt_0.bot.t3 oa_sar8_acore18_opt_0.sw_bitcell_opt_b7_0.bot.t68 cap_cmim l=2.14u w=2.14u
X2733 VSS.t309 sar_ctrl_async_phys_0.sg13g2_a22oi_1$1_0.A2 a_35166_32120# VSS.t376 sg13_lv_nmos ad=0.2516p pd=2.16u as=96.2f ps=1u w=0.74u l=0.13u
X2734 a_36074_41214# sar_ctrl_async_phys_0.sg13g2_nand2b_1$1_2.A_N VSS.t87 VSS.t88 sg13_lv_nmos ad=0.1406p pd=1.12u as=0.2516p ps=2.16u w=0.74u l=0.13u
X2735 sar_ctrl_async_phys_0.sg13g2_a22oi_1$1_0.B2 a_36058_30924# VSS.t470 VSS.t563 sg13_lv_nmos ad=0.2516p pd=2.16u as=0.1406p ps=1.12u w=0.74u l=0.13u
X2736 VSS.t128 a_32319_44311# a_32986_44532# VSS.t479 sg13_lv_nmos ad=0.1406p pd=1.12u as=0.2516p ps=2.16u w=0.74u l=0.13u
X2737 oa_sar8_acore18_opt_0.sw_bitcell_opt_b0_1.bot.t0 sar_ctrl_async_phys_0.dac_code_n[0] oa_sar8_acore18_opt_0.sw_bitcell_opt_b7_1.VSS VSS.t356 sg13_lv_nmos ad=0.2925p pd=1.89u as=0.525p ps=3.7u w=1.5u l=0.13u
X2738 a_31446_45434# a_32251_45007# a_31706_44964# VDD.t5 sg13_lv_pmos ad=0.1428p pd=1.52u as=79.8f ps=0.8u w=0.42u l=0.13u
X2739 VDD.t20 sar_ctrl_async_phys_0.sg13g2_buf_1$1_2.X.t3 a_30650_35892# VDD.t19 sg13_lv_pmos ad=0.1563p pd=1.22u as=0.147p ps=1.54u w=0.42u l=0.13u
X2740 VSS.t87 sar_ctrl_async_phys_0.sg13g2_a21oi_1$1_3.A2 a_35697_40808# VSS.t1272 sg13_lv_nmos ad=0.2516p pd=2.16u as=0.1406p ps=1.12u w=0.74u l=0.13u
X2741 oa_sar8_acore18_opt_0.sw_tg_opt_1.bot.t3 oa_sar8_acore18_opt_0.sw_bitcell_opt_b4_1.bot.t2 cap_cmim l=2.14u w=2.14u
X2742 oa_sar8_acore18_opt_0.sw_tg_opt_0.bot.t3 oa_sar8_acore18_opt_0.sw_bitcell_opt_b7_0.bot.t25 cap_cmim l=2.14u w=2.14u
X2743 VDD.t3 a_32288_31630# a_32233_31511# VDD.t3 sg13_lv_pmos ad=1.96315p pd=12.675u as=93.45f ps=0.865u w=0.42u l=0.13u
X2744 VDD.t233 VSS.t1 VDD.t233 VDD.t147 sg13_lv_pmos ad=0.19p pd=1.38u as=0 ps=0 w=1u l=1u
X2745 VDD.t330 sar_ctrl_async_phys_0.sg13g2_buf_1$1_35.A a_36056_42760# VDD.t22 sg13_lv_pmos ad=0.2114p pd=1.54u as=0.2856p ps=2.36u w=0.84u l=0.13u
X2746 VDD.t345 sar_ctrl_async_phys_0.sg13g2_buf_1$1_6.X a_31638_32138# VDD.t76 sg13_lv_pmos ad=0.36237p pd=2.605u as=79.8f ps=0.8u w=0.42u l=0.13u
X2747 VDD.t289 sar_ctrl_async_phys_0.sg13g2_dlygate4sd3_1$1_1.A a_28488_35965# VDD.t19 sg13_lv_pmos ad=0.1523p pd=1.38u as=0.1428p ps=1.52u w=0.42u l=0.13u
X2748 VDD.t175 sar_ctrl_async_phys_0.sg13g2_a21oi_1$1_0.B1 a_35288_47296# VDD.t42 sg13_lv_pmos ad=0.2114p pd=1.54u as=0.2856p ps=2.36u w=0.84u l=0.13u
X2749 oa_sar8_acore18_opt_0.sw_bitcell_opt_b6_0.bot.t81 sar_ctrl_async_phys_0.dac_code[6] VDD.t957 VDD.t955 sg13_lv_pmos ad=1.17p pd=6.39u as=2.1p ps=12.7u w=6u l=0.13u
X2750 VSS.t331 sar_ctrl_async_phys_0.sg13g2_buf_1$1_36.A a_36056_41972# VSS.t330 sg13_lv_nmos ad=0.14875p pd=1.16u as=0.187p ps=1.78u w=0.55u l=0.13u
X2751 VDD.t22 a_30037_43495# a_30139_43495# VDD.t22 sg13_lv_pmos ad=2.48357p pd=16.205u as=0.3864p ps=2.93u w=1.12u l=0.13u
X2752 VDD.t121 VSS.t1011 VDD.t121 VDD.t76 sg13_lv_pmos ad=0.34p pd=2.68u as=0 ps=0 w=1u l=1u
X2753 VSS.t1022 VDD.t270 VSS.t1024 VSS.t1023 sg13_lv_nmos ad=79.8f pd=0.8u as=0 ps=0 w=0.42u l=1u
X2754 sar_ctrl_async_phys_0.sg13g2_dfrbpq_1$1_0.CLK a_29350_41996# VSS.t313 VSS.t477 sg13_lv_nmos ad=0.2516p pd=2.16u as=0.1426p ps=1.16u w=0.74u l=0.13u
X2755 a_25878_40460# a_25608_40501# VDD.t328 VDD.t317 sg13_lv_pmos ad=0.34p pd=2.68u as=0.1523p ps=1.38u w=1u l=0.5u
X2756 a_26364_45710# sar_ctrl_async_phys_0.sg13g2_and2_1$1_0.A VDD.t11 VDD.t10 sg13_lv_pmos ad=0.2856p pd=2.36u as=0.2114p ps=1.54u w=0.84u l=0.13u
X2757 VDD.t328 a_26558_40727# sar_ctrl_async_phys_0.sg13g2_dlygate4sd3_1$1_9.X VDD.t317 sg13_lv_pmos ad=0.2254p pd=1.53u as=0.4256p ps=3u w=1.12u l=0.13u
X2758 oa_sar8_acore18_opt_0.sw_tg_opt_1.bot.t3 oa_sar8_acore18_opt_0.sw_bitcell_opt_b6_1.bot.t42 cap_cmim l=2.14u w=2.14u
X2759 VSS.t1057 VDD.t90 VSS.t1059 VSS.t179 sg13_lv_nmos ad=79.8f pd=0.8u as=0 ps=0 w=0.42u l=1u
X2760 VSS.t792 VDD.t8 VSS.t789 VSS.t814 sg13_lv_nmos ad=0.1428p pd=1.52u as=0 ps=0 w=0.42u l=1u
X2761 oa_sar8_acore18_opt_0.sw_tg_opt_0.bot.t3 oa_sar8_acore18_opt_0.sw_bitcell_opt_b2_0.bot.t6 cap_cmim l=2.14u w=2.14u
X2762 VDD.t233 sar_ctrl_async_phys_0.sg13g2_buf_1$1_6.X a_29526_33650# VDD.t147 sg13_lv_pmos ad=0.36237p pd=2.605u as=79.8f ps=0.8u w=0.42u l=0.13u
X2763 oa_sar8_acore18_opt_0.sw_tg_opt_1.bot.t3 oa_sar8_acore18_opt_0.sw_bitcell_opt_b7_1.bot.t116 cap_cmim l=2.14u w=2.14u
X2764 a_32980_45759# a_32692_46064# a_32918_45759# VSS.t366 sg13_lv_nmos ad=0.1428p pd=1.52u as=37.8f ps=0.6u w=0.42u l=0.13u
X2765 oa_sar8_acore18_opt_0.sw_tg_opt_0.bot.t3 oa_sar8_acore18_opt_0.sw_bitcell_opt_b7_0.bot.t52 cap_cmim l=2.14u w=2.14u
X2766 oa_sar8_acore18_opt_0.sw_tg_opt_1.bot.t4 oa_sar8_acore18_opt_0.sw_bitcell_opt_b7_1.bot.t5 cap_cmim l=2.14u w=2.14u
X2767 VSS.t178 a_33440_32358# a_33089_32215# VSS.t58 sg13_lv_nmos ad=79.8f pd=0.8u as=0.1428p ps=1.52u w=0.42u l=0.13u
X2768 VSS.t1017 VDD.t121 VSS.t1016 VSS.t1015 sg13_lv_nmos ad=0.1428p pd=1.52u as=0 ps=0 w=0.42u l=1u
X2769 oa_sar8_acore18_opt_0.sw_tg_opt_0.bot.t3 oa_sar8_acore18_opt_0.sw_bitcell_opt_b4_0.bot.t6 cap_cmim l=2.14u w=2.14u
X2770 sar_ctrl_async_phys_0.sg13g2_buf_1$1_32.A sar_ctrl_async_phys_0.sg13g2_nand2_1$1_3.A a_34442_45366# VSS.t148 sg13_lv_nmos ad=0.2516p pd=2.16u as=0.1406p ps=1.12u w=0.74u l=0.13u
X2771 VSS.t46 VDD.t114 VSS.t46 VSS.t876 sg13_lv_nmos ad=79.8f pd=0.8u as=0 ps=0 w=0.42u l=1u
X2772 a_30998_31813# sar_ctrl_async_phys_0.sg13g2_buf_1$1_6.X VSS.t17 VSS.t451 sg13_lv_nmos ad=37.8f pd=0.6u as=0.1701p ps=1.65u w=0.42u l=0.13u
X2773 VSS.t1075 VDD.t79 VSS.t1076 VSS.t179 sg13_lv_nmos ad=79.8f pd=0.8u as=0 ps=0 w=0.42u l=1u
X2774 VDD.t757 sar_ctrl_async_phys_0.dac_code_n[6] oa_sar8_acore18_opt_0.sw_bitcell_opt_b6_1.bot.t1 VDD.t756 sg13_lv_pmos ad=2.1p pd=12.7u as=1.17p ps=6.39u w=6u l=0.13u
X2775 a_33179_43832# sar_ctrl_async_phys_0.sg13g2_buf_1$1_37.A a_33085_43832# VSS.t504 sg13_lv_nmos ad=0.1216p pd=1.02u as=0.2176p ps=1.96u w=0.64u l=0.13u
X2776 VDD.t833 sar_ctrl_async_phys_0.sg13g2_buf_1$1_19.A a_34520_38224# VDD.t29 sg13_lv_pmos ad=0.2114p pd=1.54u as=0.2856p ps=2.36u w=0.84u l=0.13u
X2777 VDD.t219 VSS.t46 VDD.t218 VDD.t22 sg13_lv_pmos ad=0.34p pd=2.68u as=0 ps=0 w=1u l=1u
X2778 a_34070_43909# sar_ctrl_async_phys_0.sg13g2_buf_1$1_41.X VSS.t128 VSS.t143 sg13_lv_nmos ad=37.8f pd=0.6u as=0.1701p ps=1.65u w=0.42u l=0.13u
X2779 sar_ctrl_async_phys_0.sg13g2_inv_1$1_10.Y sar_ctrl_async_phys_0.sg13g2_dfrbpq_1$1_0.CLK.t23 VDD.t69 VDD.t0 sg13_lv_pmos ad=0.3808p pd=2.92u as=0.3808p ps=2.92u w=1.12u l=0.13u
X2780 a_32031_31749# a_31189_31399# a_31937_31749# VSS.t83 sg13_lv_nmos ad=0.12665p pd=1.145u as=0.1428p ps=1.52u w=0.42u l=0.13u
X2781 VSS.t1032 VDD.t247 VSS.t1031 VSS.t1030 sg13_lv_nmos ad=0.1428p pd=1.52u as=0 ps=0 w=0.42u l=1u
X2782 a_26558_40727# a_26673_40726# VDD.t328 VDD.t317 sg13_lv_pmos ad=0.34p pd=2.68u as=0.2254p ps=1.53u w=1u l=0.5u
X2783 VDD.t4 a_32031_31749# a_32698_31388# VDD.t3 sg13_lv_pmos ad=0.2128p pd=1.5u as=0.3864p ps=2.93u w=1.12u l=0.13u
X2784 oa_sar8_acore18_opt_0.sw_tg_opt_1.bot.t3 oa_sar8_acore18_opt_0.sw_bitcell_opt_b7_1.bot.t116 cap_cmim l=2.14u w=2.14u
X2785 sar_ctrl_async_phys_0.sg13g2_nand3_1$1_0.Y sar_ctrl_async_phys_0.sg13g2_nand3_1$1_0.C VDD.t328 VDD.t317 sg13_lv_pmos ad=0.2128p pd=1.5u as=0.3808p ps=2.92u w=1.12u l=0.13u
X2786 oa_sar8_acore18_opt_0.sw_tg_opt_1.bot.t3 oa_sar8_acore18_opt_0.sw_bitcell_opt_b2_1.bot.t8 cap_cmim l=2.14u w=2.14u
X2787 a_35234_39698# sar_ctrl_async_phys_0.sg13g2_o21ai_1$1_1.B1.t3 VSS.t169 VSS.t241 sg13_lv_nmos ad=37.8f pd=0.6u as=79.8f ps=0.8u w=0.42u l=0.13u
X2788 VSS.t654 sar_ctrl_async_phys_0.sg13g2_buf_1$1_1.A a_34904_33688# VSS.t653 sg13_lv_nmos ad=0.14875p pd=1.16u as=0.187p ps=1.78u w=0.55u l=0.13u
X2789 oa_sar8_acore18_opt_0.sw_tg_opt_1.bot.t3 oa_sar8_acore18_opt_0.sw_bitcell_opt_b5_1.bot.t10 cap_cmim l=2.14u w=2.14u
X2790 oa_sar8_acore18_opt_0.sw_tg_opt_1.bot.t3 oa_sar8_acore18_opt_0.sw_bitcell_opt_b6_1.bot.t70 cap_cmim l=2.14u w=2.14u
X2791 VSS.t40 VDD.t43 VSS.t40 VSS.t727 sg13_lv_nmos ad=0.1428p pd=1.52u as=0 ps=0 w=0.42u l=1u
X2792 a_34765_42242# sar_ctrl_async_phys_0.sg13g2_a21oi_1$1_2.B1 VDD.t562 VDD.t0 sg13_lv_pmos ad=0.2856p pd=2.36u as=0.2198p ps=1.53u w=0.84u l=0.13u
X2793 a_34132_32904# a_34106_32868# VSS.t260 VSS.t417 sg13_lv_nmos ad=0.2516p pd=2.16u as=0.1626p ps=1.415u w=0.74u l=0.13u
X2794 oa_sar8_acore18_opt_0.sw_tg_opt_1.bot.t3 oa_sar8_acore18_opt_0.sw_bitcell_opt_b7_1.bot.t31 cap_cmim l=2.14u w=2.14u
X2795 VSS.t79 sar_ctrl_async_phys_0.sg13g2_nand2_1$1_2.Y a_35672_38948# VSS.t463 sg13_lv_nmos ad=0.14875p pd=1.16u as=0.187p ps=1.78u w=0.55u l=0.13u
X2796 oa_sar8_acore18_opt_0.sw_tg_opt_0.bot.t3 oa_sar8_acore18_opt_0.sw_bitcell_opt_b5_0.bot.t15 cap_cmim l=2.14u w=2.14u
X2797 sar_ctrl_async_phys_0.sg13g2_buf_1$1_7.A a_31738_33948# VDD.t229 VDD.t147 sg13_lv_pmos ad=0.3808p pd=2.92u as=0.2128p ps=1.5u w=1.12u l=0.13u
X2798 a_34420_34837# a_34132_34416# a_34358_34837# VSS.t358 sg13_lv_nmos ad=0.1428p pd=1.52u as=37.8f ps=0.6u w=0.42u l=0.13u
X2799 a_35786_45750# sar_ctrl_async_phys_0.sg13g2_nand2b_1$1_6.A_N VSS.t109 VSS.t687 sg13_lv_nmos ad=0.1406p pd=1.12u as=0.2516p ps=2.16u w=0.74u l=0.13u
X2800 VSS.t979 VDD.t20 VSS.t979 VSS.t0 sg13_lv_nmos ad=79.8f pd=0.8u as=0 ps=0 w=0.42u l=1u
X2801 a_32991_45357# a_32149_45007# a_32897_45357# VSS.t638 sg13_lv_nmos ad=0.12665p pd=1.145u as=0.1428p ps=1.52u w=0.42u l=0.13u
X2802 oa_sar8_acore18_opt_0.sw_tg_opt_0.bot.t3 oa_sar8_acore18_opt_0.sw_bitcell_opt_b6_0.bot.t44 cap_cmim l=2.14u w=2.14u
X2803 a_28782_40460# sar_ctrl_async_phys_0.sg13g2_dfrbpq_1$1_0.CLK.t21 a_28680_40460# VDD.t317 sg13_lv_pmos ad=0.2128p pd=1.5u as=0.2128p ps=1.5u w=1.12u l=0.13u
X2804 a_29210_38916# a_29653_38959# a_28950_39386# VSS.t667 sg13_lv_nmos ad=79.8f pd=0.8u as=0.1296p ps=1.52u w=0.42u l=0.13u
X2805 sar_ctrl_async_phys_0.sg13g2_dlygate4sd3_1$1_11.X a_26566_39766# VDD.t328 VDD.t317 sg13_lv_pmos ad=0.4256p pd=3u as=0.2254p ps=1.53u w=1.12u l=0.13u
X2806 VSS.t936 VDD.t169 VSS.t938 VSS.t937 sg13_lv_nmos ad=79.8f pd=0.8u as=0 ps=0 w=0.42u l=1u
X2807 oa_sar8_acore18_opt_0.sw_bitcell_opt_term_1.bot.t3 VDD.t903 VDD.t907 VDD.t904 sg13_lv_pmos ad=0.585p pd=3.39u as=1.05p ps=6.7u w=3u l=0.13u
X2808 a_32400_41413# sar_ctrl_async_phys_0.sg13g2_buf_1$1_3.A VDD.t114 VDD.t0 sg13_lv_pmos ad=0.1596p pd=1.22u as=0.1918p ps=1.5u w=0.84u l=0.13u
X2809 VSS.t771 VDD.t13 VSS.t773 VSS.t772 sg13_lv_nmos ad=79.8f pd=0.8u as=0 ps=0 w=0.42u l=1u
X2810 VSS.t975 VDD.t270 VSS.t975 VSS.t0 sg13_lv_nmos ad=79.8f pd=0.8u as=0 ps=0 w=0.42u l=1u
X2811 VSS.t372 sar_ctrl_async_phys_0.sg13g2_a22oi_1$1_2.Y sar_ctrl_async_phys_0.sg13g2_inv_1$1_11.Y VSS.t371 sg13_lv_nmos ad=0.2516p pd=2.16u as=0.2516p ps=2.16u w=0.74u l=0.13u
X2812 VDD.t82 VSS.t348 VDD.t82 VDD.t29 sg13_lv_pmos ad=0.34p pd=2.68u as=0 ps=0 w=1u l=1u
X2813 VDD.t289 VSS.t975 VDD.t289 VDD.t19 sg13_lv_pmos ad=0.19p pd=1.38u as=0 ps=0 w=1u l=1u
X2814 VSS.t311 sar_ctrl_async_phys_0.sg13g2_buf_1$1_6.X a_33940_30626# VSS.t600 sg13_lv_nmos ad=0.1626p pd=1.415u as=60.89999f ps=0.71u w=0.42u l=0.13u
X2815 oa_sar8_acore18_opt_0.sw_tg_opt_0.bot.t4 oa_sar8_acore18_opt_0.sw_bitcell_opt_b7_0.bot.t10 cap_cmim l=2.14u w=2.14u
X2816 VSS.t118 VDD.t132 VSS.t118 VSS.t742 sg13_lv_nmos ad=0.1428p pd=1.52u as=0 ps=0 w=0.42u l=1u
X2817 VDD.t330 sar_ctrl_async_phys_0.sg13g2_buf_1$1_32.A a_34520_42760# VDD.t22 sg13_lv_pmos ad=0.2114p pd=1.54u as=0.2856p ps=2.36u w=0.84u l=0.13u
X2818 oa_sar8_acore18_opt_0.sw_tg_opt_1.bot.t3 oa_sar8_acore18_opt_0.sw_bitcell_opt_b6_1.bot.t35 cap_cmim l=2.14u w=2.14u
X2819 sar_ctrl_async_phys_0.sg13g2_buf_1$1_19.A a_33754_37436# VSS.t15 VSS.t14 sg13_lv_nmos ad=0.2516p pd=2.16u as=0.1406p ps=1.12u w=0.74u l=0.13u
X2820 a_34055_31352# a_34615_31475# a_34526_31511# VDD.t3 sg13_lv_pmos ad=0.2048p pd=1.63u as=93.45f ps=0.865u w=0.42u l=0.13u
X2821 VDD.t44 VSS.t730 VDD.t44 VDD.t42 sg13_lv_pmos ad=0.19p pd=1.38u as=0 ps=0 w=1u l=1u
X2822 a_30632_22281# oa_sar8_acore18_opt_0.sw_tg_opt_0.bot.t5 a_28008_23477# VSS.t495 sg13_lv_nmos ad=0.19p pd=1.38u as=0.345p ps=2.69u w=1u l=0.15u
X2823 VDD.t76 a_34549_32911# a_34651_32911# VDD.t76 sg13_lv_pmos ad=1.96315p pd=12.675u as=0.3864p ps=2.93u w=1.12u l=0.13u
X2824 a_33794_40898# sar_ctrl_async_phys_0.sg13g2_o21ai_1$1_1.B1.t7 VSS.t307 VSS.t459 sg13_lv_nmos ad=37.8f pd=0.6u as=79.8f ps=0.8u w=0.42u l=0.13u
X2825 VSS.t102 VDD.t30 VSS.t102 VSS.t917 sg13_lv_nmos ad=79.8f pd=0.8u as=0 ps=0 w=0.42u l=1u
X2826 sar_ctrl_async_phys_0.bit_active[4] a_36056_35200# VSS.t13 VSS.t12 sg13_lv_nmos ad=0.2886p pd=2.26u as=0.14875p ps=1.16u w=0.74u l=0.13u
X2827 oa_sar8_acore18_opt_0.sw_tg_opt_0.bot.t3 oa_sar8_acore18_opt_0.sw_bitcell_opt_b4_0.bot.t30 cap_cmim l=2.14u w=2.14u
X2828 oa_sar8_acore18_opt_0.sw_tg_opt_1.bot.t3 oa_sar8_acore18_opt_0.sw_bitcell_opt_b7_1.bot.t74 cap_cmim l=2.14u w=2.14u
X2829 sar_ctrl_async_phys_0.dac_code_n[6] a_35672_46508# VDD.t416 VDD.t10 sg13_lv_pmos ad=0.42p pd=2.99u as=0.2114p ps=1.54u w=1.12u l=0.13u
X2830 VSS.t828 VDD.t9 VSS.t829 VSS.t224 sg13_lv_nmos ad=79.8f pd=0.8u as=0 ps=0 w=0.42u l=1u
X2831 VDD.t270 VSS.t975 VDD.t270 VDD.t147 sg13_lv_pmos ad=0.19p pd=1.38u as=0 ps=0 w=1u l=1u
X2832 VSS.t1111 VDD.t79 VSS.t1113 VSS.t1112 sg13_lv_nmos ad=79.8f pd=0.8u as=0 ps=0 w=0.42u l=1u
X2833 VSS.t730 VDD.t49 VSS.t730 VSS.t759 sg13_lv_nmos ad=79.8f pd=0.8u as=0 ps=0 w=0.42u l=1u
X2834 oa_sar8_acore18_opt_0.sw_tg_opt_0.bot.t3 oa_sar8_acore18_opt_0.sw_bitcell_opt_b3_0.bot.t2 cap_cmim l=2.14u w=2.14u
X2835 VDD.t121 VSS.t1009 VDD.t121 VDD.t76 sg13_lv_pmos ad=0.19p pd=1.38u as=0 ps=0 w=1u l=1u
X2836 oa_sar8_acore18_opt_0.sw_tg_opt_0.bot.t3 oa_sar8_acore18_opt_0.sw_bitcell_opt_b7_0.bot.t83 cap_cmim l=2.14u w=2.14u
X2837 a_36156_45710# sar_ctrl_async_phys_0.sg13g2_buf_1$1_37.A VDD.t416 VDD.t10 sg13_lv_pmos ad=0.2856p pd=2.36u as=0.2114p ps=1.54u w=0.84u l=0.13u
X2838 oa_sar8_acore18_opt_0.sw_tg_opt_1.bot.t2 oa_sar8_acore18_opt_0.sw_bitcell_opt_b7_1.bot.t149 cap_cmim l=2.14u w=2.14u
X2839 sar_ctrl_async_phys_0.cmp_fault a_34136_47296# VDD.t175 VDD.t42 sg13_lv_pmos ad=0.42p pd=2.99u as=0.2114p ps=1.54u w=1.12u l=0.13u
X2840 a_31034_44457# a_31477_44213# a_31417_44625# VDD.t5 sg13_lv_pmos ad=79.8f pd=0.8u as=63f ps=0.72u w=0.42u l=0.13u
X2841 VDD.t120 VSS.t65 VDD.t120 VDD.t29 sg13_lv_pmos ad=0.19p pd=1.38u as=0 ps=0 w=1u l=1u
X2842 oa_sar8_acore18_opt_0.sw_tg_opt_1.bot.t3 oa_sar8_acore18_opt_0.sw_bitcell_opt_b7_1.bot.t31 cap_cmim l=2.14u w=2.14u
X2843 a_34549_34423# sar_ctrl_async_phys_0.sg13g2_dfrbpq_1$1_0.CLK.t8 VDD.t322 VDD.t147 sg13_lv_pmos ad=0.4088p pd=2.97u as=1.98685p ps=12.96u w=1.12u l=0.13u
X2844 VDD.t13 VSS.t824 VDD.t13 VDD.t5 sg13_lv_pmos ad=0.19p pd=1.38u as=0 ps=0 w=1u l=1u
X2845 oa_sar8_acore18_opt_0.sw_tg_opt_0.bot.t3 oa_sar8_acore18_opt_0.sw_bitcell_opt_b6_0.bot.t4 cap_cmim l=2.14u w=2.14u
X2846 VDD.t146 a_28368_36877# sar_ctrl_async_phys_0.sg13g2_nor2_1$1_7.A VDD.t16 sg13_lv_pmos ad=0.1918p pd=1.5u as=0.3808p ps=2.92u w=1.12u l=0.13u
X2847 VDD.t146 a_29258_36642# a_28977_36864# VDD.t16 sg13_lv_pmos ad=0.1523p pd=1.38u as=0.34p ps=2.68u w=1u l=0.5u
X2848 VSS.t313 VDD.t25 VSS.t313 VSS.t857 sg13_lv_nmos ad=79.8f pd=0.8u as=0 ps=0 w=0.42u l=1u
X2849 a_33506_37874# sar_ctrl_async_phys_0.sg13g2_buf_1$1_2.X.t5 VSS.t15 VSS.t14 sg13_lv_nmos ad=37.8f pd=0.6u as=79.8f ps=0.8u w=0.42u l=0.13u
X2850 oa_sar8_acore18_opt_0.sw_tg_opt_0.bot.t3 oa_sar8_acore18_opt_0.sw_bitcell_opt_b7_0.bot.t35 cap_cmim l=2.14u w=2.14u
X2851 sar_ctrl_async_phys_0.bit_active[0] a_34424_35200# VSS.t681 VSS.t1280 sg13_lv_nmos ad=0.2886p pd=2.26u as=0.14875p ps=1.16u w=0.74u l=0.13u
X2852 VDD.t132 VSS.t126 VDD.t132 VDD.t42 sg13_lv_pmos ad=0.19p pd=1.38u as=0 ps=0 w=1u l=1u
X2853 VSS.t178 sar_ctrl_async_phys_0.sg13g2_a22oi_1$1_1.B2 a_33080_31388# VSS.t2 sg13_lv_nmos ad=0.14875p pd=1.16u as=0.187p ps=1.78u w=0.55u l=0.13u
X2854 VSS.t194 VDD.t229 VSS.t260 VSS.t176 sg13_lv_nmos ad=79.8f pd=0.8u as=0 ps=0 w=0.42u l=1u
X2855 a_34370_45746# sar_ctrl_async_phys_0.sg13g2_o21ai_1$1_1.B1.t14 VSS.t7 VSS.t530 sg13_lv_nmos ad=37.8f pd=0.6u as=79.8f ps=0.8u w=0.42u l=0.13u
X2856 sar_ctrl_async_phys_0.sg13g2_buf_1$1_15.A a_33085_43832# VDD.t219 VDD.t22 sg13_lv_pmos ad=0.3808p pd=2.92u as=0.1918p ps=1.5u w=1.12u l=0.13u
X2857 oa_sar8_acore18_opt_0.sw_tg_opt_1.bot.t3 oa_sar8_acore18_opt_0.sw_bitcell_opt_b5_1.bot.t35 cap_cmim l=2.14u w=2.14u
X2858 VSS.t1081 VDD.t81 VSS.t1080 VSS.t1079 sg13_lv_nmos ad=0.1428p pd=1.52u as=0 ps=0 w=0.42u l=1u
X2859 VSS.t126 sar_ctrl_async_phys_0.sg13g2_nor2_1$1_4.Y a_34136_47296# VSS.t41 sg13_lv_nmos ad=0.14875p pd=1.16u as=0.187p ps=1.78u w=0.55u l=0.13u
X2860 a_34106_32868# a_34549_32911# a_34489_32947# VDD.t76 sg13_lv_pmos ad=79.8f pd=0.8u as=63f ps=0.72u w=0.42u l=0.13u
X2861 sar_ctrl_async_phys_0.sg13g2_nor2_1$1_8.B sar_ctrl_async_phys_0.sg13g2_nor2_1$1_3.Y VSS.t146 VSS.t1158 sg13_lv_nmos ad=0.1406p pd=1.12u as=0.2516p ps=2.16u w=0.74u l=0.13u
X2862 a_31136_43726# sar_ctrl_async_phys_0.sg13g2_buf_1$1_41.X VDD.t22 VDD.t22 sg13_lv_pmos ad=79.8f pd=0.8u as=2.2076p ps=14.4u w=0.42u l=0.13u
X2863 a_33844_39711# a_33556_40016# a_33782_39711# VSS.t151 sg13_lv_nmos ad=0.1428p pd=1.52u as=37.8f ps=0.6u w=0.42u l=0.13u
X2864 oa_sar8_acore18_opt_0.sw_tg_opt_1.bot.t3 oa_sar8_acore18_opt_0.sw_bitcell_opt_b7_1.bot.t58 cap_cmim l=2.14u w=2.14u
X2865 a_35814_31813# a_34636_31749# a_35418_31668# VSS.t1199 sg13_lv_nmos ad=37.8f pd=0.6u as=0.1428p ps=1.52u w=0.42u l=0.13u
X2866 VDD.t114 VSS.t462 VDD.t100 VDD.t0 sg13_lv_pmos ad=0.19p pd=1.38u as=0 ps=0 w=1u l=1u
X2867 VSS.t210 sar_ctrl_async_phys_0.sg13g2_and2_1$1_0.X a_35672_38224# VSS.t177 sg13_lv_nmos ad=0.14875p pd=1.16u as=0.187p ps=1.78u w=0.55u l=0.13u
X2868 oa_sar8_acore18_opt_0.sw_tg_opt_1.bot.t3 oa_sar8_acore18_opt_0.sw_bitcell_opt_b7_1.bot.t128 cap_cmim l=2.14u w=2.14u
X2869 VDD.t20 sar_ctrl_async_phys_0.sg13g2_buf_1$1_17.A a_30507_35204# VDD.t19 sg13_lv_pmos ad=0.253p pd=1.53u as=0.2856p ps=2.36u w=0.84u l=0.13u
X2870 oa_sar8_acore18_opt_0.sw_tg_opt_0.bot.t3 oa_sar8_acore18_opt_0.sw_bitcell_opt_b7_0.bot.t99 cap_cmim l=2.14u w=2.14u
X2871 oa_sar8_acore18_opt_0.bstrap_opt_w2_c1200_1.out oa_sar8_acore18_opt_0.bstrap_opt_w2_c1200_1.gb oa_sar8_acore18_opt_0.sw_bitcell_opt_term_1.bot.t0 VSS.t155 sg13_lv_nmos ad=0.35p pd=2.7u as=0.195p ps=1.39u w=1u l=0.13u
X2872 sar_ctrl_async_phys_0.sg13g2_nand3_1$1_0.Y sar_ctrl_async_phys_0.sg13g2_dlygate4sd3_1$1_9.X a_25896_39706# VSS.t103 sg13_lv_nmos ad=0.2516p pd=2.16u as=0.1406p ps=1.12u w=0.74u l=0.13u
X2873 oa_sar8_acore18_opt_0.sw_tg_opt_0.bot.t3 oa_sar8_acore18_opt_0.sw_bitcell_opt_b5_0.bot.t10 cap_cmim l=2.14u w=2.14u
X2874 VDD.t349 a_35199_44311# a_35866_44532# VDD.t5 sg13_lv_pmos ad=0.2128p pd=1.5u as=0.3864p ps=2.93u w=1.12u l=0.13u
X2875 oa_sar8_acore18_opt_0.sw_tg_opt_1.bot.t3 oa_sar8_acore18_opt_0.sw_bitcell_opt_b6_1.bot.t22 cap_cmim l=2.14u w=2.14u
X2876 VSS.t243 sar_ctrl_async_phys_0.sg13g2_a21oi_1$1_2.Y sar_ctrl_async_phys_0.sg13g2_nor2_1$1_11.Y VSS.t715 sg13_lv_nmos ad=0.2516p pd=2.16u as=0.1406p ps=1.12u w=0.74u l=0.13u
X2877 VDD.t317 a_34815_39775# a_35482_39996# VDD.t317 sg13_lv_pmos ad=0.2128p pd=1.5u as=0.3864p ps=2.93u w=1.12u l=0.13u
X2878 VDD.t553 a_32580_36642# a_32538_36972# VDD.t16 sg13_lv_pmos ad=0.2618p pd=1.63u as=0.1176p ps=1.33u w=1.12u l=0.13u
X2879 VDD.t76 a_35648_33142# a_35593_33023# VDD.t76 sg13_lv_pmos ad=1.96315p pd=12.675u as=93.45f ps=0.865u w=0.42u l=0.13u
X2880 a_26954_40424# sar_ctrl_async_phys_0.sg13g2_dlygate4sd3_1$1_9.A VSS.t51 VSS.t543 sg13_lv_nmos ad=0.1428p pd=1.52u as=79.8f ps=0.8u w=0.42u l=0.13u
X2881 VSS.t789 VDD.t64 VSS.t789 VSS.t790 sg13_lv_nmos ad=0.1428p pd=1.52u as=0 ps=0 w=0.42u l=1u
X2882 sar_ctrl_async_phys_0.bit_active[2] a_34808_35200# VDD.t19 VDD.t19 sg13_lv_pmos ad=0.42p pd=2.99u as=0.2114p ps=1.54u w=1.12u l=0.13u
X2883 VDD.t11 VSS.t770 VDD.t11 VDD.t10 sg13_lv_pmos ad=0.34p pd=2.68u as=0 ps=0 w=1u l=1u
X2884 VDD.t11 VSS.t40 VDD.t11 VDD.t10 sg13_lv_pmos ad=0.34p pd=2.68u as=0 ps=0 w=1u l=1u
X2885 a_35245_42242# sar_ctrl_async_phys_0.sg13g2_nand2b_1$1_2.A_N VDD.t562 VDD.t0 sg13_lv_pmos ad=0.2856p pd=2.36u as=0.2198p ps=1.53u w=0.84u l=0.13u
X2886 oa_sar8_acore18_opt_0.bstrap_opt_w2_c1200_1.out oa_sar8_acore18_opt_0.sw_bitcell_opt_term_0.trkb.t29 oa_sar8_acore18_opt_0.sw_bitcell_opt_term_1.bot.t0 VDD.t671 sg13_lv_pmos ad=0.7p pd=4.7u as=0.39p ps=2.39u w=2u l=0.13u
X2887 VDD.t319 sar_ctrl_async_phys_0.sg13g2_buf_1$1_15.A a_36056_35200# VDD.t19 sg13_lv_pmos ad=0.2114p pd=1.54u as=0.2856p ps=2.36u w=0.84u l=0.13u
X2888 VDD.t22 a_34261_43495# a_34363_43495# VDD.t22 sg13_lv_pmos ad=2.48357p pd=16.205u as=0.3864p ps=2.93u w=1.12u l=0.13u
X2889 a_35168_41430# sar_ctrl_async_phys_0.sg13g2_o21ai_1$1_1.B1.t12 VDD.t0 VDD.t0 sg13_lv_pmos ad=79.8f pd=0.8u as=3.62845p ps=23.965u w=0.42u l=0.13u
X2890 oa_sar8_acore18_opt_0.sw_tg_opt_1.bot.t2 oa_sar8_acore18_opt_0.sw_bitcell_opt_b7_1.bot.t153 cap_cmim l=2.14u w=2.14u
X2891 a_35028_n9612# VDD.t1081 oa_sar8_acore18_opt_0.sw_bitcell_opt_term_0.gb.t0 VSS.t1130 sg13_lv_nmos ad=0.345p pd=2.69u as=0.19p ps=1.38u w=1u l=0.15u
X2892 a_30632_22281# sar_ctrl_async_phys_0.cmp_fire VDD.t444 VDD.t443 sg13_lv_pmos ad=0.7p pd=4.7u as=0.7p ps=4.7u w=2u l=0.13u
X2893 sar_ctrl_async_phys_0.sg13g2_nor2b_1$1_1.Y sar_ctrl_async_phys_0.sg13g2_nor2b_1$1_0.A VSS.t237 VSS.t234 sg13_lv_nmos ad=0.1406p pd=1.12u as=0.2516p ps=2.16u w=0.74u l=0.13u
X2894 a_34765_45266# sar_ctrl_async_phys_0.sg13g2_nand2b_1$1_5.A_N VSS.t109 VSS.t568 sg13_lv_nmos ad=0.187p pd=1.78u as=0.14505p ps=1.15u w=0.55u l=0.13u
X2895 VDD.t392 sar_ctrl_async_phys_0.sg13g2_o21ai_1$1_1.B1.t4 a_33530_39921# VDD.t317 sg13_lv_pmos ad=0.1563p pd=1.22u as=0.147p ps=1.54u w=0.42u l=0.13u
X2896 oa_sar8_acore18_opt_0.sw_tg_opt_0.bot.t4 oa_sar8_acore18_opt_0.sw_bitcell_opt_b7_0.bot.t5 cap_cmim l=2.14u w=2.14u
X2897 VDD.t90 VSS.t1056 VDD.t80 VDD.t3 sg13_lv_pmos ad=0.19p pd=1.38u as=0 ps=0 w=1u l=1u
X2898 VDD.t33 VSS.t111 VDD.t33 VDD.t22 sg13_lv_pmos ad=0.34p pd=2.68u as=0 ps=0 w=1u l=1u
X2899 VDD.t114 VSS.t46 VDD.t114 VDD.t0 sg13_lv_pmos ad=0.34p pd=2.68u as=0 ps=0 w=1u l=1u
X2900 oa_sar8_acore18_opt_0.sw_tg_opt_1.bot.t3 oa_sar8_acore18_opt_0.sw_bitcell_opt_b7_1.bot.t90 cap_cmim l=2.14u w=2.14u
X2901 VSS.t455 VDD.t79 VSS.t455 VSS.t1078 sg13_lv_nmos ad=79.8f pd=0.8u as=0 ps=0 w=0.42u l=1u
X2902 a_33193_35477# a_32251_35284# a_32991_35239# VDD.t19 sg13_lv_pmos ad=93.45f pd=0.865u as=0.2048p ps=1.63u w=0.42u l=0.13u
X2903 VDD.t64 sar_ctrl_async_phys_0.sg13g2_buf_1$1_41.X a_30938_46476# VDD.t10 sg13_lv_pmos ad=0.1563p pd=1.22u as=0.147p ps=1.54u w=0.42u l=0.13u
X2904 oa_sar8_acore18_opt_0.sw_tg_opt_1.bot.t3 oa_sar8_acore18_opt_0.sw_bitcell_opt_b6_1.bot.t10 cap_cmim l=2.14u w=2.14u
X2905 VSS.t48 VDD.t150 VSS.t1050 VSS.t173 sg13_lv_nmos ad=0.1428p pd=1.52u as=0 ps=0 w=0.42u l=1u
X2906 a_28008_23477# oa_sar8_acore18_opt_0.sw_tg_opt_0.bot.t5 a_30632_22281# VSS.t495 sg13_lv_nmos ad=0.345p pd=2.69u as=0.19p ps=1.38u w=1u l=0.15u
X2907 VDD.t6 VSS.t789 VDD.t6 VDD.t5 sg13_lv_pmos ad=0.19p pd=1.38u as=0 ps=0 w=1u l=1u
X2908 sar_ctrl_async_phys_0.sg13g2_nor2_1$1_10.B sar_ctrl_async_phys_0.sg13g2_a21oi_1$1_4.B1 VSS.t46 VSS.t1183 sg13_lv_nmos ad=0.1406p pd=1.12u as=0.2516p ps=2.16u w=0.74u l=0.13u
X2909 VDD.t150 sar_ctrl_async_phys_0.sg13g2_inv_1$1_6.A sar_ctrl_async_phys_0.sg13g2_inv_1$1_6.Y VDD.t76 sg13_lv_pmos ad=0.3808p pd=2.92u as=0.3808p ps=2.92u w=1.12u l=0.13u
X2910 sar_ctrl_async_phys_0.sg13g2_buf_1$1_35.A sar_ctrl_async_phys_0.sg13g2_nand2b_1$1_1.B a_36074_41214# VSS.t720 sg13_lv_nmos ad=0.2516p pd=2.16u as=0.1406p ps=1.12u w=0.74u l=0.13u
X2911 sar_ctrl_async_phys_0.sg13g2_dfrbpq_1$1_11.D sar_ctrl_async_phys_0.sg13g2_a21oi_1$1_5.Y VSS.t107 VSS.t549 sg13_lv_nmos ad=0.1406p pd=1.12u as=0.2516p ps=2.16u w=0.74u l=0.13u
X2912 oa_sar8_acore18_opt_0.sw_tg_opt_0.bot.t3 oa_sar8_acore18_opt_0.sw_bitcell_opt_b7_0.bot.t131 cap_cmim l=2.14u w=2.14u
X2913 VSS.t970 VDD.t159 VSS.t970 VSS.t0 sg13_lv_nmos ad=0.1428p pd=1.52u as=0 ps=0 w=0.42u l=1u
X2914 VDD.t5 a_32319_44311# a_32576_44454# VDD.t5 sg13_lv_pmos ad=1.96315p pd=12.675u as=79.8f ps=0.8u w=0.42u l=0.13u
X2915 oa_sar8_acore18_opt_0.sw_tg_opt_0.bot.t3 oa_sar8_acore18_opt_0.sw_bitcell_opt_b5_0.bot.t22 cap_cmim l=2.14u w=2.14u
X2916 result[0] a_33080_30664# VDD.t4 VDD.t3 sg13_lv_pmos ad=0.42p pd=2.99u as=0.2114p ps=1.54u w=1.12u l=0.13u
X2917 VSS.t1012 VDD.t270 VSS.t1011 VSS.t1010 sg13_lv_nmos ad=0.1428p pd=1.52u as=0 ps=0 w=0.42u l=1u
X2918 sar_ctrl_async_phys_0.sg13g2_nor4_1$1_0.Y sar_ctrl_async_phys_0.sg13g2_nand2b_1$1_0.Y VSS.t29 VSS.t409 sg13_lv_nmos ad=0.1406p pd=1.12u as=0.23757p ps=2.16u w=0.74u l=0.13u
X2919 oa_sar8_acore18_opt_0.sw_tg_opt_0.bot.t3 oa_sar8_acore18_opt_0.sw_bitcell_opt_b7_0.bot.t73 cap_cmim l=2.14u w=2.14u
X2920 oa_sar8_acore18_opt_0.sw_bitcell_opt_b7_1.VSS VDD.t1084 oa_sar8_acore18_opt_0.sw_bitcell_opt_term_1.bot.t0 VSS.t1127 sg13_lv_nmos ad=0.525p pd=3.7u as=0.2925p ps=1.89u w=1.5u l=0.13u
X2921 VSS.t730 VDD.t43 VSS.t40 VSS.t729 sg13_lv_nmos ad=0.1428p pd=1.52u as=0 ps=0 w=0.42u l=1u
X2922 oa_sar8_acore18_opt_0.sw_tg_opt_1.bot.t3 oa_sar8_acore18_opt_0.sw_bitcell_opt_b7_1.bot.t48 cap_cmim l=2.14u w=2.14u
X2923 a_31136_43726# a_30879_43845# a_31298_43922# VSS.t1152 sg13_lv_nmos ad=0.1428p pd=1.52u as=37.8f ps=0.6u w=0.42u l=0.13u
X2924 a_29524_40464# a_29498_40428# VDD.t361 VDD.t317 sg13_lv_pmos ad=0.34p pd=2.68u as=0.36237p ps=2.605u w=1u l=0.13u
X2925 VDD.t541 sar_ctrl_async_phys_0.dac_code[3] oa_sar8_acore18_opt_0.sw_bitcell_opt_b3_0.bot.t0 VDD.t540 sg13_lv_pmos ad=1.47p pd=9.1u as=0.819p ps=4.59u w=4.2u l=0.13u
X2926 VDD.t157 VSS.t111 VDD.t157 VDD.t0 sg13_lv_pmos ad=0.34p pd=2.68u as=0 ps=0 w=1u l=1u
X2927 oa_sar8_acore18_opt_0.sw_bitcell_opt_b6_1.bot.t1 sar_ctrl_async_phys_0.dac_code_n[6] VDD.t758 VDD.t756 sg13_lv_pmos ad=1.17p pd=6.39u as=2.1p ps=12.7u w=6u l=0.13u
X2928 VDD.t79 VSS.t1115 VDD.t79 VDD.t3 sg13_lv_pmos ad=0.34p pd=2.68u as=0 ps=0 w=1u l=1u
X2929 a_33632_40702# a_33375_40821# a_33794_40898# VSS.t1259 sg13_lv_nmos ad=0.1428p pd=1.52u as=37.8f ps=0.6u w=0.42u l=0.13u
X2930 VDD.t121 VSS.t180 VDD.t121 VDD.t76 sg13_lv_pmos ad=0.34p pd=2.68u as=0 ps=0 w=1u l=1u
X2931 VDD.t427 oa_sar8_acore18_opt_0.bstrap_opt_w2_c1200_1.gb w_16692_n9960# w_16692_n9960# sg13_lv_pmos ad=0.7p pd=4.7u as=0.7p ps=4.7u w=2u l=0.13u
X2932 VSS.t979 VDD.t20 VSS.t979 VSS.t0 sg13_lv_nmos ad=0.1428p pd=1.52u as=0 ps=0 w=0.42u l=1u
X2933 VSS.t311 sar_ctrl_async_phys_0.sg13g2_buf_1$1_10.A a_33080_30664# VSS.t310 sg13_lv_nmos ad=0.14875p pd=1.16u as=0.187p ps=1.78u w=0.55u l=0.13u
X2934 VDD.t13 VSS.t770 VDD.t13 VDD.t5 sg13_lv_pmos ad=0.34p pd=2.68u as=0 ps=0 w=1u l=1u
X2935 oa_sar8_acore18_opt_0.sw_tg_opt_0.bot.t3 oa_sar8_acore18_opt_0.sw_bitcell_opt_b6_0.bot.t29 cap_cmim l=2.14u w=2.14u
R0 VDD.n537 VDD.n536 42.1996
R1 VDD.n519 VDD.n518 25.0383
R2 VDD.n467 VDD.t900 22.1806
R3 VDD.n574 VDD.t903 22.1806
R4 VDD.n511 VDD.t1082 22.1289
R5 VDD.n501 VDD.t1081 22.1286
R6 VDD.n467 VDD.t1083 21.1066
R7 VDD.n574 VDD.t1084 21.1066
R8 VDD.n468 VDD.n467 20.8627
R9 VDD.n511 VDD.t427 19.8644
R10 VDD.n501 VDD.t776 19.8644
R11 VDD.n349 VDD.t833 17.2581
R12 VDD.n343 VDD.t475 17.2247
R13 VDD.n339 VDD.t478 17.2247
R14 VDD.n339 VDD.t431 17.2247
R15 VDD.n347 VDD.t558 17.2247
R16 VDD.n347 VDD.t678 17.2247
R17 VDD.n375 VDD.t435 17.2247
R18 VDD.n375 VDD.t611 17.2247
R19 VDD.n192 VDD.n351 17.0005
R20 VDD.n192 VDD.n335 17.0005
R21 VDD.n192 VDD.n344 17.0005
R22 VDD.n192 VDD.n342 17.0005
R23 VDD.n150 VDD.n354 17.0005
R24 VDD.n150 VDD.n369 17.0005
R25 VDD.n150 VDD.n355 17.0005
R26 VDD.n150 VDD.n367 17.0005
R27 VDD.n150 VDD.n359 17.0005
R28 VDD.n535 VDD.t442 15.5072
R29 VDD.n533 VDD.t440 15.5072
R30 VDD.n526 VDD.t444 15.5072
R31 VDD.n524 VDD.t446 15.5072
R32 VDD.n348 VDD.t1087 15.2621
R33 VDD.n352 VDD.t1085 15.2617
R34 VDD.n575 VDD.n574 14.3209
R35 VDD.n580 VDD.n579 13.349
R36 VDD.n531 VDD.n530 9.6902
R37 VDD.n529 VDD.n528 9.6902
R38 VDD.n465 VDD.n464 9.6462
R39 VDD.n471 VDD.n470 9.6462
R40 VDD.n475 VDD.n474 9.6462
R41 VDD.n479 VDD.n478 9.6462
R42 VDD.n483 VDD.n482 9.6462
R43 VDD.n487 VDD.n486 9.6462
R44 VDD.n491 VDD.n490 9.6462
R45 VDD.n495 VDD.n494 9.6462
R46 VDD.n499 VDD.n498 9.6462
R47 VDD.n514 VDD.n513 9.6462
R48 VDD.n540 VDD.n539 9.6462
R49 VDD.n544 VDD.n543 9.6462
R50 VDD.n548 VDD.n547 9.6462
R51 VDD.n552 VDD.n551 9.6462
R52 VDD.n556 VDD.n555 9.6462
R53 VDD.n560 VDD.n559 9.6462
R54 VDD.n564 VDD.n563 9.6462
R55 VDD.n568 VDD.n567 9.6462
R56 VDD.n577 VDD.n576 9.6462
R57 VDD.n194 VDD.t42 0.336659
R58 VDD.n192 VDD.n193 2.7645
R59 VDD.n179 VDD.t238 0.421685
R60 VDD.n181 VDD.t17 0.857546
R61 VDD.n180 VDD.t184 0.752064
R62 VDD.n115 VDD.t517 0.406151
R63 VDD.n115 VDD.n114 0.00364021
R64 VDD.n199 VDD.n200 0.00127991
R65 VDD.t901 VDD.n197 0.355524
R66 VDD.n176 VDD.t781 8.501
R67 VDD.t781 VDD.n203 0.426166
R68 VDD.n6 VDD.n5 0.002995
R69 VDD.n207 VDD.n210 0.00468862
R70 VDD.n172 VDD.n184 0.00260869
R71 VDD.t1008 VDD.n66 3.4011
R72 VDD.n216 VDD.n215 0.00166658
R73 VDD.t777 VDD.n213 0.405824
R74 VDD.n218 VDD.n131 0.0012785
R75 VDD.t456 VDD.n218 1.00136
R76 VDD.t456 VDD.n127 3.40102
R77 VDD.t456 VDD.n126 0.567851
R78 VDD.t610 VDD.n134 0.406196
R79 VDD.n134 VDD.n169 0.00371205
R80 VDD.n165 VDD.n224 0.00257133
R81 VDD.t540 VDD.n224 2.42951
R82 VDD.n223 VDD.n222 0.00199975
R83 VDD.n156 VDD.t881 8.501
R84 VDD.t881 VDD.n227 0.426166
R85 VDD.n63 VDD.n118 0.0028135
R86 VDD.t495 VDD.n63 0.321473
R87 VDD.t495 VDD.n119 3.40102
R88 VDD.n125 VDD.n124 0.00237824
R89 VDD.t882 VDD.n125 0.405427
R90 VDD.n139 VDD.n147 0.00266416
R91 VDD.t467 VDD.n139 0.321659
R92 VDD.n234 VDD.n233 0.00205508
R93 VDD.n237 VDD.n238 0.00234899
R94 VDD.t955 VDD.n237 0.895961
R95 VDD.n235 VDD.n236 0.00166658
R96 VDD.n185 VDD.n235 0.00305984
R97 VDD.n160 VDD.n159 0.00282961
R98 VDD.t519 VDD.n160 0.405508
R99 VDD.n145 VDD.t337 0.322014
R100 VDD.t337 VDD.n62 3.4011
R101 VDD.t337 VDD.n121 3.40102
R102 VDD.t779 VDD.n13 4.251
R103 VDD.n151 VDD.n108 0.00300379
R104 VDD.t685 VDD.n140 3.40102
R105 VDD.n249 VDD.n141 0.00257133
R106 VDD.t685 VDD.n249 2.42951
R107 VDD.t685 VDD.n151 0.294012
R108 VDD.t778 VDD.n90 0.405365
R109 VDD.n1 VDD.n0 0.00397515
R110 VDD.n256 VDD.n255 0.00199975
R111 VDD.n39 VDD.n36 0.00424343
R112 VDD.n257 VDD.n258 0.00170812
R113 VDD.t383 VDD.n35 1.30801
R114 VDD.t383 VDD.n36 0.348657
R115 VDD.n104 VDD.t780 2.83406
R116 VDD.n104 VDD.n103 0.00183319
R117 VDD.t780 VDD.n105 0.473658
R118 VDD.t698 VDD.n42 3.40102
R119 VDD.t698 VDD.n41 1.13434
R120 VDD.t953 VDD.n554 1.62283
R121 VDD.n111 VDD.n264 0.00369013
R122 VDD.n4 VDD.n394 8.47175
R123 VDD.t635 VDD.n4 0.330127
R124 VDD.t609 VDD.n87 0.405365
R125 VDD.n270 VDD.n269 0.00166658
R126 VDD.t716 VDD.n97 1.54592
R127 VDD.t951 VDD.n9 4.251
R128 VDD.t582 VDD.n91 0.425889
R129 VDD.n188 VDD.n92 0.00274982
R130 VDD.n82 VDD.n84 0.00135742
R131 VDD.t883 VDD.n84 0.406151
R132 VDD.t669 VDD.n77 0.405365
R133 VDD.t880 VDD.n74 0.405365
R134 VDD.n71 VDD.n70 0.00250003
R135 VDD.t618 VDD.n78 0.655133
R136 VDD.t380 VDD.n32 1.88931
R137 VDD.n32 VDD.n31 0.00294348
R138 VDD.t380 VDD.n33 0.437361
R139 VDD.t443 VDD.n18 0.448321
R140 VDD.t445 VDD.n23 0.448321
R141 VDD.n295 VDD.n192 5.64741
R142 VDD.n294 VDD.n150 3.33195
R143 VDD.t85 VDD.n293 0.356246
R144 VDD.n29 VDD.n192 4.22743
R145 VDD.n522 VDD.n21 8.47815
R146 VDD.n523 VDD.n26 8.47815
R147 VDD.n422 VDD.n236 8.47188
R148 VDD.n137 VDD.n138 1.51862
R149 VDD.n144 VDD.n53 0.0605902
R150 VDD.n421 VDD.n238 8.47145
R151 VDD.n163 VDD.n162 2.72262
R152 VDD.n423 VDD.n235 8.47145
R153 VDD.n248 VDD.n413 8.47145
R154 VDD.n253 VDD.n2 1.64691
R155 VDD.n40 VDD.n39 0.0545974
R156 VDD.n403 VDD.n258 8.47145
R157 VDD.t322 VDD.t513 8.47111
R158 VDD.n308 VDD.t16 8.47111
R159 VDD.n192 VDD.n333 8.47111
R160 VDD.n150 VDD.n374 8.47111
R161 VDD.n150 VDD.n363 8.47111
R162 VDD.n457 VDD.n200 8.47103
R163 VDD.n199 VDD.n458 8.47103
R164 VDD.n5 VDD.n7 1.72248
R165 VDD.n449 VDD.n170 8.47103
R166 VDD.n62 VDD.n61 3.30711
R167 VDD.n155 VDD.n154 2.29793
R168 VDD.n161 VDD.n418 0.476713
R169 VDD.n109 VDD.n142 1.77378
R170 VDD.n153 VDD.n152 2.72122
R171 VDD.n38 VDD.n37 1.97695
R172 VDD.n38 VDD.n404 0.643549
R173 VDD.n274 VDD.n48 0.146092
R174 VDD.n93 VDD.n274 1.5524
R175 VDD.n283 VDD.n31 4.17681
R176 VDD.n34 VDD.n283 0.53887
R177 VDD.n176 VDD.n177 0.736388
R178 VDD.n209 VDD.n208 1.10035
R179 VDD.n211 VDD.n171 0.143743
R180 VDD.n67 VDD.n66 3.30579
R181 VDD.n215 VDD.n217 8.4706
R182 VDD.n216 VDD.n446 8.4706
R183 VDD.n131 VDD.n132 0.10419
R184 VDD.n169 VDD.n221 4.17576
R185 VDD.n156 VDD.n157 0.736388
R186 VDD.n143 VDD.n118 0.0819569
R187 VDD.n65 VDD.n64 3.30606
R188 VDD.n164 VDD.n431 0.540571
R189 VDD.n229 VDD.n230 2.71906
R190 VDD.n240 VDD.n239 1.46342
R191 VDD.n158 VDD.n240 4.17576
R192 VDD.n13 VDD.n245 4.17576
R193 VDD.n252 VDD.n411 8.4706
R194 VDD.n259 VDD.n103 4.17576
R195 VDD.n107 VDD.n259 0.546425
R196 VDD.n52 VDD.n44 0.829322
R197 VDD.n265 VDD.n68 0.809568
R198 VDD.n8 VDD.n394 0.652059
R199 VDD.n268 VDD.n392 8.4706
R200 VDD.n269 VDD.n271 8.4706
R201 VDD.n99 VDD.n100 2.71963
R202 VDD.n9 VDD.n273 4.17576
R203 VDD.n278 VDD.n506 8.4706
R204 VDD.n281 VDD.n508 8.4706
R205 VDD.n79 VDD.n80 3.3054
R206 VDD.n444 VDD.n129 0.659141
R207 VDD.n167 VDD.n168 2.71785
R208 VDD.n96 VDD.n95 2.29412
R209 VDD.n262 VDD.n261 4.17503
R210 VDD.n321 VDD.t44 8.36235
R211 VDD.t592 VDD.n385 8.36235
R212 VDD.n323 VDD.t175 8.36235
R213 VDD.t51 VDD.n321 8.3005
R214 VDD.t9 VDD.n313 8.3005
R215 VDD.n327 VDD.t23 8.3005
R216 VDD.n329 VDD.t69 8.3005
R217 VDD.t721 VDD.n330 8.3005
R218 VDD.t30 VDD.n307 8.3005
R219 VDD.n379 VDD.t146 8.3005
R220 VDD.n380 VDD.t289 8.3005
R221 VDD.t148 VDD.n381 8.3005
R222 VDD.t77 VDD.n298 8.3005
R223 VDD.n386 VDD.t59 8.3005
R224 VDD.n385 VDD.t561 8.3005
R225 VDD.n383 VDD.t728 8.3005
R226 VDD.t201 VDD.n303 8.3005
R227 VDD.t320 VDD.n378 8.3005
R228 VDD.n377 VDD.n376 8.3005
R229 VDD.n331 VDD.t392 8.3005
R230 VDD.t501 VDD.n310 8.3005
R231 VDD.t359 VDD.n326 8.3005
R232 VDD.n325 VDD.t407 8.3005
R233 VDD.n323 VDD.t177 8.3005
R234 VDD.n364 VDD.t1086 7.62594
R235 VDD.n361 VDD.t1090 7.62594
R236 VDD.n371 VDD.t1089 7.62594
R237 VDD.n27 VDD.t1088 7.62594
R238 VDD.n537 VDD.n519 7.5905
R239 VDD.n513 VDD.t620 6.20712
R240 VDD.n513 VDD.t619 6.01855
R241 VDD.n353 VDD.t243 6.00239
R242 VDD.n362 VDD.t251 5.99523
R243 VDD.n341 VDD.t705 5.98729
R244 VDD.n345 VDD.t376 5.98729
R245 VDD.n332 VDD.t858 5.97146
R246 VDD.t926 VDD.t948 5.97146
R247 VDD.n337 VDD.t1058 5.97146
R248 VDD.n370 VDD.t253 5.96935
R249 VDD.n334 VDD.t259 5.96901
R250 VDD.n360 VDD.t103 5.96901
R251 VDD.n366 VDD.t507 5.96901
R252 VDD.n368 VDD.t262 5.96901
R253 VDD.n336 VDD.t230 5.96901
R254 VDD.n289 VDD.t76 0.631899
R255 VDD.n290 VDD.t147 0.760986
R256 VDD.n296 VDD.t317 0.435254
R257 VDD.n297 VDD.t5 0.6344
R258 VDD.n372 VDD.t254 5.96024
R259 VDD.n350 VDD.t260 5.9599
R260 VDD.n114 VDD.n461 0.00249999
R261 VDD.n207 VDD.n206 0.00131048
R262 VDD.n127 VDD.n443 0.00229996
R263 VDD.n224 VDD.n167 0.00242827
R264 VDD.t540 VDD.n223 2.42928
R265 VDD.t467 VDD.n234 1.8894
R266 VDD.t670 VDD.n493 1.62166
R267 VDD.t955 VDD.n185 1.54598
R268 VDD.n186 VDD.n62 0.00249999
R269 VDD.t337 VDD.n243 2.42928
R270 VDD.n14 VDD.n13 0.00169658
R271 VDD.n249 VDD.n152 0.00242827
R272 VDD.t518 VDD.n256 2.42928
R273 VDD.n35 VDD.n257 0.00327736
R274 VDD.n187 VDD.n51 0.00323534
R275 VDD.t698 VDD.n187 0.449214
R276 VDD.n111 VDD.t990 0.363368
R277 VDD.t990 VDD.n260 2.42928
R278 VDD.n68 VDD.n397 0.00465401
R279 VDD.n97 VDD.n270 0.00324149
R280 VDD.n10 VDD.n9 0.00169658
R281 VDD.n188 VDD.n49 0.00224968
R282 VDD.t582 VDD.n188 2.12585
R283 VDD.n189 VDD.n503 0.00249999
R284 VDD.t618 VDD.n71 1.06373
R285 VDD.t671 VDD.n578 1.62208
R286 VDD.t904 VDD.n287 0.568193
R287 VDD.n47 VDD.n571 0.00497053
R288 VDD.t904 VDD.n47 0.945011
R289 VDD.n361 VDD.t104 5.65005
R290 VDD.n364 VDD.t252 5.65005
R291 VDD.n371 VDD.t242 5.65005
R292 VDD.n27 VDD.t231 5.65005
R293 VDD.n348 VDD.t261 5.64493
R294 VDD.n352 VDD.t255 5.64493
R295 VDD.n150 VDD.n356 5.64096
R296 VDD.n450 VDD.n171 5.63624
R297 VDD.n54 VDD.n55 2.72259
R298 VDD.n2 VDD.n0 0.803883
R299 VDD.n233 VDD.n427 5.61509
R300 VDD.n60 VDD.n186 5.61509
R301 VDD.n418 VDD.n417 5.61509
R302 VDD.n121 VDD.n161 3.30711
R303 VDD.n404 VDD.n257 5.61509
R304 VDD.n192 VDD.n346 5.61485
R305 VDD.n192 VDD.n340 5.61485
R306 VDD.n205 VDD.n6 5.6168
R307 VDD.n142 VDD.n141 2.29804
R308 VDD.n93 VDD.n92 3.30672
R309 VDD.n49 VDD.n50 2.72061
R310 VDD.n59 VDD.n58 0.814793
R311 VDD.n34 VDD.n30 3.30672
R312 VDD.n571 VDD.n570 5.61471
R313 VDD.n46 VDD.n570 0.53723
R314 VDD.n45 VDD.n46 2.72061
R315 VDD.n431 VDD.n430 5.61434
R316 VDD.n51 VDD.n52 2.71976
R317 VDD.n114 VDD.n195 5.61396
R318 VDD.n204 VDD.n201 5.61396
R319 VDD.n208 VDD.n206 0.98575
R320 VDD.n448 VDD.n184 5.61396
R321 VDD.n214 VDD.n212 5.61396
R322 VDD.n444 VDD.n443 5.61396
R323 VDD.n440 VDD.n220 5.61396
R324 VDD.n228 VDD.n225 5.61396
R325 VDD.n232 VDD.n231 5.61396
R326 VDD.n16 VDD.n15 5.61396
R327 VDD.n251 VDD.n250 5.61396
R328 VDD.n255 VDD.n254 5.61396
R329 VDD.n106 VDD.n107 3.3054
R330 VDD.n267 VDD.n266 5.61396
R331 VDD.n390 VDD.n270 5.61396
R332 VDD.n12 VDD.n11 5.61396
R333 VDD.n189 VDD.n275 5.61396
R334 VDD.n277 VDD.n276 5.61396
R335 VDD.n280 VDD.n279 5.61396
R336 VDD.n71 VDD.n190 5.61396
R337 VDD.n222 VDD.n437 5.61359
R338 VDD.n8 VDD.n3 1.71978
R339 VDD.n166 VDD.n165 0.985019
R340 VDD.n436 VDD.n435 5.61321
R341 VDD.n264 VDD.n263 5.61321
R342 VDD.n518 VDD.n501 5.11917
R343 VDD.n567 VDD.t584 4.32323
R344 VDD.n576 VDD.t907 4.32323
R345 VDD.n464 VDD.t909 4.30984
R346 VDD.n470 VDD.t970 4.30984
R347 VDD.n530 VDD.t381 4.29172
R348 VDD.n528 VDD.t595 4.29172
R349 VDD.n426 VDD.n425 4.17741
R350 VDD.n247 VDD.n246 4.17741
R351 VDD.t29 VDD.n357 4.17719
R352 VDD.n193 VDD.n347 0.327533
R353 VDD.n198 VDD.n196 4.177
R354 VDD.n119 VDD.n164 2.71994
R355 VDD.n43 VDD.n44 1.97492
R356 VDD.n461 VDD.n460 4.17595
R357 VDD.n210 VDD.n209 2.71923
R358 VDD.n242 VDD.n241 4.17595
R359 VDD.n407 VDD.n406 4.17595
R360 VDD.n397 VDD.n396 4.17595
R361 VDD.n503 VDD.n502 4.17595
R362 VDD.n128 VDD.n129 1.97342
R363 VDD.n464 VDD.t902 4.12127
R364 VDD.n470 VDD.t969 4.12127
R365 VDD.n530 VDD.t382 4.12127
R366 VDD.n528 VDD.t597 4.12127
R367 VDD.n567 VDD.t583 4.12127
R368 VDD.n576 VDD.t905 4.12127
R369 VDD.n563 VDD.t718 3.922
R370 VDD.n474 VDD.t1010 3.90861
R371 VDD.n474 VDD.t1009 3.72004
R372 VDD.n563 VDD.t717 3.72004
R373 VDD.n512 VDD.n511 3.47008
R374 VDD.n559 VDD.t637 3.46484
R375 VDD.n478 VDD.t458 3.45146
R376 VDD.n555 VDD.t992 3.38128
R377 VDD.n482 VDD.t542 3.3679
R378 VDD.n531 VDD.n529 3.35367
R379 VDD.n192 VDD.n338 3.33205
R380 VDD.n478 VDD.t457 3.26288
R381 VDD.n559 VDD.t636 3.26288
R382 VDD.n482 VDD.t541 3.17933
R383 VDD.n555 VDD.t991 3.17933
R384 VDD.n551 VDD.t700 3.01965
R385 VDD.n486 VDD.t497 3.00627
R386 VDD.n547 VDD.t385 2.91844
R387 VDD.n490 VDD.t469 2.90513
R388 VDD.n486 VDD.t496 2.81769
R389 VDD.n551 VDD.t699 2.81769
R390 VDD.n543 VDD.t758 2.77627
R391 VDD.n494 VDD.t957 2.76289
R392 VDD.n490 VDD.t468 2.71648
R393 VDD.n547 VDD.t384 2.71648
R394 VDD.n517 VDD.n516 2.67717
R395 VDD.n498 VDD.t339 2.62121
R396 VDD.n539 VDD.t687 2.62121
R397 VDD.n516 VDD.n515 2.60383
R398 VDD.n494 VDD.t956 2.57431
R399 VDD.n543 VDD.t757 2.57431
R400 VDD.n519 VDD.n500 2.55158
R401 VDD.n498 VDD.t338 2.43265
R402 VDD.n539 VDD.t686 2.43265
R403 VDD.n540 VDD.n538 2.00892
R404 VDD.n499 VDD.n497 2.00892
R405 VDD.t0 VDD.t68 2.00798
R406 VDD.n306 VDD.t147 1.97853
R407 VDD.t3 VDD.n299 1.97641
R408 VDD.t317 VDD.n312 1.9761
R409 VDD.n544 VDD.n542 1.86225
R410 VDD.n495 VDD.n493 1.86225
R411 VDD.n580 VDD.n386 1.84532
R412 VDD.n419 VDD.n146 1.136
R413 VDD.n465 VDD.n463 1.83169
R414 VDD.n400 VDD.n110 1.09395
R415 VDD.n401 VDD.n57 1.12102
R416 VDD.n548 VDD.n546 1.75225
R417 VDD.n491 VDD.n489 1.75225
R418 VDD.n459 VDD.n123 1.08737
R419 VDD.n175 VDD.n205 1.41639
R420 VDD.n572 VDD.n288 1.80126
R421 VDD.n391 VDD.n133 1.08091
R422 VDD.n552 VDD.n550 1.64225
R423 VDD.n487 VDD.n485 1.64225
R424 VDD.n527 VDD.t594 1.62397
R425 VDD.n285 VDD.n284 1.56883
R426 VDD.n462 VDD.n178 1.63117
R427 VDD.n447 VDD.n174 1.03582
R428 VDD.n441 VDD.n219 1.63117
R429 VDD.n429 VDD.n149 1.00924
R430 VDD.n89 VDD.n411 1.4011
R431 VDD.n408 VDD.n113 1.03582
R432 VDD.n102 VDD.n259 1.44097
R433 VDD.n86 VDD.n392 1.4011
R434 VDD.n504 VDD.n83 1.63117
R435 VDD.n76 VDD.n506 1.4011
R436 VDD.n73 VDD.n508 1.4011
R437 VDD.n556 VDD.n554 1.53225
R438 VDD.n483 VDD.n481 1.53225
R439 VDD.t3 VDD.t331 1.51827
R440 VDD.t0 VDD.t163 1.51788
R441 VDD.n428 VDD.n148 1.12472
R442 VDD.n560 VDD.n558 1.45892
R443 VDD.n479 VDD.n477 1.45892
R444 VDD.n414 VDD.n109 1.15423
R445 VDD.t756 VDD.n1 0.259264
R446 VDD.n47 VDD.n45 0.0020271
R447 VDD.t361 VDD.t452 1.39943
R448 VDD.n179 VDD.t322 1.13625
R449 VDD.n564 VDD.n562 1.38558
R450 VDD.n475 VDD.n473 1.38558
R451 VDD.n445 VDD.n132 1.10073
R452 VDD.n395 VDD.n130 1.10073
R453 VDD.n409 VDD.n253 2.01407
R454 VDD.n60 VDD.n146 1.50447
R455 VDD.n178 VDD.n117 1.09242
R456 VDD.n455 VDD.n177 1.79599
R457 VDD.n452 VDD.n208 1.67464
R458 VDD.n219 VDD.n136 1.09242
R459 VDD.n433 VDD.n157 1.79599
R460 VDD.n230 VDD.n149 1.55847
R461 VDD.n89 VDD.n88 0.145558
R462 VDD.n102 VDD.n101 0.202336
R463 VDD.n57 VDD.n56 0.081594
R464 VDD.n398 VDD.n265 1.75687
R465 VDD.n86 VDD.n85 0.145558
R466 VDD.n83 VDD.n82 1.09242
R467 VDD.n76 VDD.n75 0.145558
R468 VDD.n73 VDD.n72 0.145558
R469 VDD.n438 VDD.n166 1.85945
R470 VDD.n415 VDD.n244 1.35361
R471 VDD.n388 VDD.n272 1.35361
R472 VDD.n538 VDD.n537 1.32508
R473 VDD.n568 VDD.n566 1.31225
R474 VDD.n471 VDD.n469 1.31225
R475 VDD.n578 VDD.n577 1.31225
R476 VDD.n566 VDD.n565 1.3095
R477 VDD.n562 VDD.n561 1.3095
R478 VDD.n558 VDD.n557 1.3095
R479 VDD.n554 VDD.n553 1.3095
R480 VDD.n550 VDD.n549 1.3095
R481 VDD.n546 VDD.n545 1.3095
R482 VDD.n542 VDD.n541 1.3095
R483 VDD.n497 VDD.n496 1.3095
R484 VDD.n493 VDD.n492 1.3095
R485 VDD.n489 VDD.n488 1.3095
R486 VDD.n485 VDD.n484 1.3095
R487 VDD.n481 VDD.n480 1.3095
R488 VDD.n477 VDD.n476 1.3095
R489 VDD.n473 VDD.n472 1.3095
R490 VDD.n197 VDD.n122 0.00341346
R491 VDD.t952 VDD.n182 1.30852
R492 VDD.t608 VDD.n69 0.405372
R493 VDD.n420 VDD.n239 1.02359
R494 VDD.n510 VDD.n282 1.02359
R495 VDD.n291 VDD.t19 0.245282
R496 VDD.t18 VDD.t553 1.26259
R497 VDD.n293 VDD.t388 1.0519
R498 VDD.n20 VDD.n19 1.13756
R499 VDD.n25 VDD.n24 1.13756
R500 VDD.n96 VDD.n110 1.71992
R501 VDD.n382 VDD.t147 1.20523
R502 VDD.t340 VDD.t325 1.15305
R503 VDD.t24 VDD.t25 1.1493
R504 VDD.t114 VDD.n328 1.14841
R505 VDD.t317 VDD.t375 1.14772
R506 VDD.n320 VDD.t175 1.13439
R507 VDD.t247 VDD.t150 1.1322
R508 VDD.n515 VDD.n514 1.12892
R509 VDD.n524 VDD.n24 1.11486
R510 VDD.n315 VDD.t359 1.11424
R511 VDD.t362 VDD.t320 1.11321
R512 VDD.t80 VDD.t90 1.10678
R513 VDD.t501 VDD.t562 1.10318
R514 VDD.n175 VDD.n5 0.158108
R515 VDD.n59 VDD.n520 1.49759
R516 VDD.n288 VDD.n286 0.814793
R517 VDD.t49 VDD.n318 1.09326
R518 VDD.t1 VDD.t2 1.09307
R519 VDD.n358 VDD.t120 1.09209
R520 VDD.t6 VDD.t8 1.0912
R521 VDD.n579 VDD.n578 1.08926
R522 VDD.n319 VDD.t175 1.08789
R523 VDD.n520 VDD.n285 1.08712
R524 VDD.n317 VDD.t64 1.07764
R525 VDD.t132 VDD.n320 1.07437
R526 VDD.t100 VDD.t2 1.07256
R527 VDD.n311 VDD.t326 1.07248
R528 VDD.n469 VDD.n468 1.06842
R529 VDD.t721 VDD.t361 1.06171
R530 VDD.n301 VDD.t4 1.04836
R531 VDD.t156 VDD.t157 1.04678
R532 VDD.t343 VDD.t394 1.04654
R533 VDD.t349 VDD.t408 1.04383
R534 VDD.t82 VDD.t85 1.04227
R535 VDD.n304 VDD.t233 1.03809
R536 VDD.n300 VDD.t79 1.03786
R537 VDD.t148 VDD.n305 1.03197
R538 VDD.t77 VDD.t247 1.03181
R539 VDD.n309 VDD.t145 1.03011
R540 VDD.n527 VDD.n526 1.02625
R541 VDD.n305 VDD.t270 1.02617
R542 VDD.n292 VDD.t20 0.757674
R543 VDD.n533 VDD.n532 1.02442
R544 VDD.n410 VDD.n409 1.02192
R545 VDD.t229 VDD.n304 1.02095
R546 VDD.t592 VDD.t603 1.01472
R547 VDD.t372 VDD.t419 1.01361
R548 VDD.t9 VDD.t6 1.00281
R549 VDD.t218 VDD.t219 1.00249
R550 VDD.t71 VDD.t1 1.0022
R551 VDD.n416 VDD.n415 0.994743
R552 VDD.n389 VDD.n388 0.994743
R553 VDD.t390 VDD.t177 0.98009
R554 VDD.t238 VDD.n290 0.880861
R555 VDD.t30 VDD.t82 0.969734
R556 VDD.t184 VDD.n317 0.967456
R557 VDD.n291 VDD.t201 0.299917
R558 VDD.t8 VDD.n324 0.96504
R559 VDD.t24 VDD.t23 0.963975
R560 VDD.n181 VDD.t146 1.00312
R561 VDD.n194 VDD.t43 0.818059
R562 VDD.t649 VDD.t320 0.938934
R563 VDD.n302 VDD.t592 0.936619
R564 VDD.n296 VDD.t326 0.748912
R565 VDD.n439 VDD.n438 0.93222
R566 VDD.n300 VDD.t4 0.925283
R567 VDD.t390 VDD.t416 0.92051
R568 VDD.t23 VDD.n314 0.918311
R569 VDD.n302 VDD.t329 0.910525
R570 VDD.t132 VDD.t130 0.895479
R571 VDD.t692 VDD.n324 0.889135
R572 VDD.n525 VDD.n524 0.879583
R573 VDD.n535 VDD.n534 0.87775
R574 VDD.n322 VDD.t51 0.87773
R575 VDD.n180 VDD.t176 0.0478594
R576 VDD.t176 VDD.t177 0.874826
R577 VDD.t17 VDD.t18 0.873798
R578 VDD.t64 VDD.n322 0.864223
R579 VDD.t81 VDD.t80 0.861151
R580 VDD.t154 VDD.t156 0.860828
R581 VDD.t219 VDD.n316 0.859489
R582 VDD.t319 VDD.t19 0.734623
R583 VDD.t218 VDD.t25 0.838803
R584 VDD.t44 VDD.t130 0.835952
R585 VDD.t359 VDD.n316 0.824491
R586 VDD.t441 VDD.n536 1.95552
R587 VDD.t439 VDD.n534 1.95552
R588 VDD.n573 VDD.n572 0.805837
R589 VDD.t289 VDD.n292 0.298478
R590 VDD.t5 VDD.n324 0.800596
R591 VDD.n289 VDD.t342 1.1694
R592 VDD.t22 VDD.n316 0.800188
R593 VDD.n289 VDD.t345 0.631018
R594 VDD.t11 VDD.n318 0.798662
R595 VDD.t97 VDD.t77 0.796882
R596 VDD.t15 VDD.t9 0.796882
R597 VDD.n292 VDD.t19 0.266932
R598 VDD.t407 VDD.n297 0.81222
R599 VDD.t392 VDD.t485 0.789379
R600 VDD.n525 VDD.n19 0.783944
R601 VDD.n463 VDD.n462 0.780359
R602 VDD.n456 VDD.n455 0.780359
R603 VDD.n453 VDD.n452 0.780359
R604 VDD.n442 VDD.n441 0.780359
R605 VDD.n434 VDD.n433 0.780359
R606 VDD.n399 VDD.n398 0.780359
R607 VDD.n505 VDD.n504 0.780359
R608 VDD.n203 VDD.n202 0.00206254
R609 VDD.t952 VDD.n207 0.587572
R610 VDD.n213 VDD.n173 0.00215473
R611 VDD.n227 VDD.n226 0.00206254
R612 VDD.n90 VDD.n88 0.00233733
R613 VDD.t518 VDD.n112 0.486759
R614 VDD.n69 VDD.n68 0.00218866
R615 VDD.n87 VDD.n85 0.00233733
R616 VDD.n77 VDD.n75 0.00233733
R617 VDD.n74 VDD.n72 0.00233733
R618 VDD.n384 VDD.t561 0.769466
R619 VDD.n518 VDD.n517 0.76775
R620 VDD.t649 VDD.t553 0.755064
R621 VDD.t191 VDD.n358 0.748675
R622 VDD.n309 VDD.t169 0.72604
R623 VDD.n297 VDD.t692 0.577129
R624 VDD.t330 VDD.n315 0.715996
R625 VDD.n290 VDD.t229 0.55784
R626 VDD.n311 VDD.t452 0.71071
R627 VDD.t779 VDD.n16 0.448123
R628 VDD.t951 VDD.n12 0.448123
R629 VDD.n78 VDD.n70 0.00167311
R630 VDD.n319 VDD.t424 0.70644
R631 VDD.t328 VDD.t340 0.703219
R632 VDD.t968 VDD.n6 0.355984
R633 VDD.n285 VDD.n33 0.00182061
R634 VDD.n287 VDD.n286 0.00122981
R635 VDD.n91 VDD.n48 0.00163441
R636 VDD.n322 VDD.t10 0.664133
R637 VDD.n384 VDD.t76 0.65898
R638 VDD.t716 VDD.n98 0.436968
R639 VDD.n384 VDD.t342 0.645189
R640 VDD.t233 VDD.n382 0.630995
R641 VDD.n382 VDD.t148 0.628821
R642 VDD.t540 VDD.n191 0.426153
R643 VDD.n111 VDD.n94 0.00230817
R644 VDD.n532 VDD.n521 0.593278
R645 VDD.n192 VDD.n150 0.00156048
R646 VDD.t1008 VDD.n172 0.378487
R647 VDD.n314 VDD.t22 0.584817
R648 VDD.n521 VDD.n520 0.572995
R649 VDD.t16 VDD.t18 0.572173
R650 VDD.t317 VDD.t340 0.568216
R651 VDD.n21 VDD.n18 0.00149102
R652 VDD.n26 VDD.n23 0.00149102
R653 VDD.n305 VDD.t147 0.553997
R654 VDD.t3 VDD.t80 0.552929
R655 VDD.t0 VDD.t156 0.552784
R656 VDD.t16 VDD.n181 0.467028
R657 VDD.t501 VDD.t163 0.55205
R658 VDD.t485 VDD.n296 0.068936
R659 VDD.t728 VDD.t202 0.539977
R660 VDD.t59 VDD.t331 0.531012
R661 VDD.n180 VDD.t10 0.456128
R662 VDD.t5 VDD.t15 0.52061
R663 VDD.t76 VDD.t97 0.52061
R664 VDD.n466 VDD.n459 0.519944
R665 VDD.n469 VDD.n456 0.519944
R666 VDD.n472 VDD.n454 0.519944
R667 VDD.n473 VDD.n453 0.519944
R668 VDD.n476 VDD.n451 0.519944
R669 VDD.n477 VDD.n447 0.519944
R670 VDD.n480 VDD.n445 0.519944
R671 VDD.n481 VDD.n442 0.519944
R672 VDD.n484 VDD.n439 0.519944
R673 VDD.n485 VDD.n434 0.519944
R674 VDD.n488 VDD.n432 0.519944
R675 VDD.n489 VDD.n429 0.519944
R676 VDD.n492 VDD.n428 0.519944
R677 VDD.n496 VDD.n424 0.519944
R678 VDD.n497 VDD.n420 0.519944
R679 VDD.n500 VDD.n419 0.519944
R680 VDD.n538 VDD.n416 0.519944
R681 VDD.n541 VDD.n414 0.519944
R682 VDD.n542 VDD.n412 0.519944
R683 VDD.n545 VDD.n410 0.519944
R684 VDD.n546 VDD.n408 0.519944
R685 VDD.n549 VDD.n405 0.519944
R686 VDD.n550 VDD.n402 0.519944
R687 VDD.n553 VDD.n401 0.519944
R688 VDD.n557 VDD.n400 0.519944
R689 VDD.n558 VDD.n399 0.519944
R690 VDD.n561 VDD.n395 0.519944
R691 VDD.n562 VDD.n393 0.519944
R692 VDD.n565 VDD.n391 0.519944
R693 VDD.n566 VDD.n389 0.519944
R694 VDD.n569 VDD.n387 0.519944
R695 VDD.n517 VDD.n505 0.519944
R696 VDD.n516 VDD.n507 0.519944
R697 VDD.n515 VDD.n509 0.519944
R698 VDD.n512 VDD.n510 0.519944
R699 VDD.n575 VDD.n573 0.519944
R700 VDD.t22 VDD.t24 0.519045
R701 VDD.t3 VDD.n300 0.517536
R702 VDD.t202 VDD.n179 0.0697654
R703 VDD.n34 VDD.n284 0.627887
R704 VDD.t721 VDD.n312 0.506762
R705 VDD.t59 VDD.n299 0.506211
R706 VDD.n462 VDD.n116 0.505076
R707 VDD.n455 VDD.n202 0.505076
R708 VDD.n452 VDD.n182 0.505076
R709 VDD.n174 VDD.n173 0.171724
R710 VDD.n441 VDD.n135 0.505076
R711 VDD.n433 VDD.n226 0.505076
R712 VDD.n149 VDD.n124 0.202336
R713 VDD.n412 VDD.n89 1.05907
R714 VDD.n113 VDD.n112 0.171724
R715 VDD.n402 VDD.n102 1.00924
R716 VDD.n398 VDD.n183 0.505076
R717 VDD.n393 VDD.n86 1.05907
R718 VDD.n504 VDD.n81 0.505076
R719 VDD.n507 VDD.n76 1.05907
R720 VDD.n509 VDD.n73 1.05907
R721 VDD.n1 VDD.n253 0.814012
R722 VDD.n145 VDD.n120 0.00134515
R723 VDD.t955 VDD.n53 0.473188
R724 VDD.n123 VDD.n122 0.114399
R725 VDD.n454 VDD.n175 1.0469
R726 VDD.n572 VDD.n45 0.464754
R727 VDD.n521 VDD.n284 0.453688
R728 VDD.t79 VDD.t331 0.452767
R729 VDD.t163 VDD.t114 0.451632
R730 VDD.n304 VDD.t147 0.438715
R731 VDD.n317 VDD.t10 0.43589
R732 VDD.t317 VDD.n311 0.431478
R733 VDD.t322 VDD.t419 0.430826
R734 VDD.t42 VDD.n319 0.429889
R735 VDD.n195 VDD.n460 0.426846
R736 VDD.n254 VDD.n406 0.426846
R737 VDD.n275 VDD.n502 0.426846
R738 VDD.t16 VDD.t649 0.426323
R739 VDD.t86 VDD.n293 0.699624
R740 VDD.t270 VDD.n306 0.424018
R741 VDD.t29 VDD.n358 0.422816
R742 VDD.n427 VDD.n425 0.417797
R743 VDD.t0 VDD.t1 0.412677
R744 VDD.t42 VDD.t130 0.389638
R745 VDD.t317 VDD.t361 0.38822
R746 VDD.n194 VDD.t44 0.967653
R747 VDD.t16 VDD.n309 0.385047
R748 VDD.t5 VDD.t349 0.383157
R749 VDD.n437 VDD.n435 0.370823
R750 VDD.t0 VDD.t562 0.368899
R751 VDD.t22 VDD.n315 0.368249
R752 VDD.t157 VDD.t68 0.367039
R753 VDD.n240 VDD.n241 0.486887
R754 VDD.n431 VDD.n65 0.48333
R755 VDD.n52 VDD.n57 1.69061
R756 VDD.n390 VDD.n100 0.541953
R757 VDD.t76 VDD.t394 0.362268
R758 VDD.n93 VDD.n50 0.655218
R759 VDD.n288 VDD.n570 0.99201
R760 VDD.n458 VDD.n196 0.360726
R761 VDD.n418 VDD.n155 0.590458
R762 VDD.n413 VDD.n246 0.359037
R763 VDD.n133 VDD.n98 0.122906
R764 VDD.t10 VDD.t390 0.357605
R765 VDD.n423 VDD.n55 0.467849
R766 VDD.t90 VDD.n299 0.347119
R767 VDD.t309 VDD.n306 0.33953
R768 VDD.n536 VDD.n535 0.33325
R769 VDD.n534 VDD.n533 0.33325
R770 VDD.n526 VDD.n525 0.331417
R771 VDD.t69 VDD.t68 0.32475
R772 VDD.t29 VDD.t82 0.323286
R773 VDD.t392 VDD.t375 0.318933
R774 VDD.n437 VDD.n168 0.550591
R775 VDD.n262 VDD.n263 0.431554
R776 VDD.n444 VDD.n132 1.49836
R777 VDD.n178 VDD.n195 0.873031
R778 VDD.n177 VDD.n201 1.05553
R779 VDD.n446 VDD.n212 0.305817
R780 VDD.n221 VDD.n220 0.426889
R781 VDD.n157 VDD.n225 1.05553
R782 VDD.n230 VDD.n231 0.544742
R783 VDD.n245 VDD.n15 0.426889
R784 VDD.n411 VDD.n250 0.305817
R785 VDD.n113 VDD.n254 1.42527
R786 VDD.n265 VDD.n396 1.07419
R787 VDD.n392 VDD.n266 0.305817
R788 VDD.n273 VDD.n11 0.426889
R789 VDD.n83 VDD.n275 0.873031
R790 VDD.n506 VDD.n276 0.305817
R791 VDD.n508 VDD.n279 0.305817
R792 VDD.n190 VDD.n80 0.486383
R793 VDD.n282 VDD.n190 1.40304
R794 VDD.n449 VDD.n67 0.423924
R795 VDD.n67 VDD.n448 0.484008
R796 VDD.n448 VDD.n211 1.44212
R797 VDD.n390 VDD.n271 0.304098
R798 VDD.n65 VDD.n143 1.63159
R799 VDD.n61 VDD.n60 0.476713
R800 VDD.n438 VDD.n191 0.299683
R801 VDD.n110 VDD.n94 0.111689
R802 VDD.n427 VDD.n138 0.749107
R803 VDD.n404 VDD.n403 0.299566
R804 VDD.n314 VDD.t33 0.297139
R805 VDD.t22 VDD.t218 0.296655
R806 VDD.t3 VDD.n302 0.289693
R807 VDD.n312 VDD.t325 0.286534
R808 VDD.t0 VDD.n328 0.282778
R809 VDD.t159 VDD.t19 0.282318
R810 VDD.t13 VDD.t15 0.281735
R811 VDD.t121 VDD.t97 0.281735
R812 VDD.t30 VDD.n357 0.279511
R813 VDD.n450 VDD.n449 0.271929
R814 VDD.n339 VDD.n338 0.249074
R815 VDD.n262 VDD.n96 0.668814
R816 VDD.n394 VDD.n130 1.43767
R817 VDD.n168 VDD.n166 1.10902
R818 VDD.n446 VDD.n217 0.245126
R819 VDD.n174 VDD.n217 1.36458
R820 VDD.n221 VDD.n219 0.933412
R821 VDD.n245 VDD.n244 0.427228
R822 VDD.n273 VDD.n272 0.427228
R823 VDD.n133 VDD.n271 1.40912
R824 VDD.n432 VDD.n143 1.12165
R825 VDD.n458 VDD.n457 0.241701
R826 VDD.n457 VDD.n123 1.42217
R827 VDD.n7 VDD.n205 0.702115
R828 VDD.n283 VDD.n59 1.05157
R829 VDD.n468 VDD.n466 0.241583
R830 VDD.n155 VDD.n61 0.707687
R831 VDD.n153 VDD.n142 0.764854
R832 VDD.n138 VDD.n148 1.89458
R833 VDD.n413 VDD.n153 0.474609
R834 VDD.n40 VDD.n403 1.48312
R835 VDD.n423 VDD.n422 0.237422
R836 VDD.n422 VDD.n163 0.469063
R837 VDD.n163 VDD.n421 0.46784
R838 VDD.n421 VDD.n144 1.4589
R839 VDD.n424 VDD.n144 1.1389
R840 VDD.n291 VDD.t258 0.286504
R841 VDD.n375 VDD.n193 0.149384
R842 VDD.n239 VDD.n159 0.186763
R843 VDD.n415 VDD.n16 0.219409
R844 VDD.n388 VDD.n12 0.219409
R845 VDD.n282 VDD.n70 0.186763
R846 VDD.n405 VDD.n40 1.14413
R847 VDD.n579 VDD.n569 0.216597
R848 VDD.t5 VDD.t6 0.215811
R849 VDD.n294 VDD.t86 0.127268
R850 VDD.t3 VDD.n301 0.211238
R851 VDD.n445 VDD.n129 0.437498
R852 VDD.n395 VDD.n8 0.491807
R853 VDD.n463 VDD.n460 0.20388
R854 VDD.n453 VDD.n209 0.321617
R855 VDD.n420 VDD.n241 0.20388
R856 VDD.n408 VDD.n406 0.20388
R857 VDD.n399 VDD.n396 0.20388
R858 VDD.n505 VDD.n502 0.20388
R859 VDD.n391 VDD.n100 0.320811
R860 VDD.n432 VDD.n164 0.319993
R861 VDD.n401 VDD.n44 0.432263
R862 VDD.n21 VDD.n20 0.173133
R863 VDD.n26 VDD.n25 0.173133
R864 VDD.n459 VDD.n196 0.201362
R865 VDD.n428 VDD.n425 0.198808
R866 VDD.n414 VDD.n246 0.198808
R867 VDD.n405 VDD.n38 0.425008
R868 VDD.n340 VDD.n339 0.195486
R869 VDD.t926 VDD.n294 0.276882
R870 VDD.t76 VDD.t247 0.237655
R871 VDD.n366 VDD.n356 0.190118
R872 VDD.n409 VDD.n0 0.185638
R873 VDD.n522 VDD.n17 0.183979
R874 VDD.n523 VDD.n22 0.183979
R875 VDD.t603 VDD.n301 0.183734
R876 VDD.n341 VDD.n340 0.173325
R877 VDD.n346 VDD.n345 0.173325
R878 VDD.n387 VDD.n274 1.05856
R879 VDD.n211 VDD.n451 1.1521
R880 VDD.n353 VDD.n352 0.16689
R881 VDD.n349 VDD.n348 0.166554
R882 VDD.n347 VDD.n346 0.165486
R883 VDD.n363 VDD.n360 0.162039
R884 VDD.t146 VDD.n308 0.160789
R885 VDD.t372 VDD.t513 0.158289
R886 VDD.n146 VDD.n120 0.0639454
R887 VDD.n439 VDD.n435 0.146866
R888 VDD.n400 VDD.n263 0.146866
R889 VDD.n456 VDD.n201 0.143453
R890 VDD.n447 VDD.n212 0.143453
R891 VDD.n442 VDD.n220 0.143453
R892 VDD.n434 VDD.n225 0.143453
R893 VDD.n429 VDD.n231 0.143453
R894 VDD.n416 VDD.n15 0.143453
R895 VDD.n412 VDD.n250 0.143453
R896 VDD.n402 VDD.n107 0.263065
R897 VDD.n393 VDD.n266 0.143453
R898 VDD.n389 VDD.n11 0.143453
R899 VDD.n507 VDD.n276 0.143453
R900 VDD.n509 VDD.n279 0.143453
R901 VDD.n510 VDD.n80 0.263065
R902 VDD.n130 VDD.n3 0.10419
R903 VDD.n454 VDD.n7 0.482163
R904 VDD.n387 VDD.n50 0.317248
R905 VDD.n573 VDD.n46 0.317248
R906 VDD.t728 VDD.t513 0.140789
R907 VDD.n419 VDD.n161 0.257037
R908 VDD.n424 VDD.n55 0.308911
R909 VDD.n410 VDD.n2 0.790947
R910 VDD.n19 VDD.n522 0.132266
R911 VDD.n24 VDD.n523 0.132266
R912 VDD.n362 VDD.n361 0.12922
R913 VDD.n28 VDD.n27 0.12922
R914 VDD.n349 VDD.n338 0.127578
R915 VDD.n357 VDD.t120 0.119991
R916 VDD.n365 VDD.n355 0.11925
R917 VDD VDD.n580 0.116367
R918 VDD.n351 VDD.n350 0.11425
R919 VDD.n372 VDD.n354 0.11425
R920 VDD.n335 VDD.n334 0.10925
R921 VDD.n370 VDD.n369 0.10925
R922 VDD.n308 VDD.t145 0.108289
R923 VDD.n29 VDD.n337 0.141252
R924 VDD.t345 VDD.t150 0.1055
R925 VDD.n365 VDD.n364 0.103337
R926 VDD.n373 VDD.n371 0.103337
R927 VDD.n369 VDD.n368 0.10175
R928 VDD.t51 VDD.t49 0.1005
R929 VDD.n148 VDD.n147 0.0759419
R930 VDD.n353 VDD.n295 0.0317231
R931 VDD.n351 VDD.n349 0.08675
R932 VDD.n354 VDD.n353 0.08675
R933 VDD.n569 VDD.n568 0.0820833
R934 VDD.n565 VDD.n564 0.0820833
R935 VDD.n561 VDD.n560 0.0820833
R936 VDD.n557 VDD.n556 0.0820833
R937 VDD.n553 VDD.n552 0.0820833
R938 VDD.n549 VDD.n548 0.0820833
R939 VDD.n545 VDD.n544 0.0820833
R940 VDD.n541 VDD.n540 0.0820833
R941 VDD.n500 VDD.n499 0.0820833
R942 VDD.n496 VDD.n495 0.0820833
R943 VDD.n492 VDD.n491 0.0820833
R944 VDD.n488 VDD.n487 0.0820833
R945 VDD.n484 VDD.n483 0.0820833
R946 VDD.n480 VDD.n479 0.0820833
R947 VDD.n476 VDD.n475 0.0820833
R948 VDD.n472 VDD.n471 0.0820833
R949 VDD.n466 VDD.n465 0.0820833
R950 VDD.n514 VDD.n512 0.0820833
R951 VDD.n532 VDD.n531 0.0820833
R952 VDD.n529 VDD.n527 0.0820833
R953 VDD.n577 VDD.n575 0.0820833
R954 VDD.t561 VDD.t343 0.0805
R955 VDD.n344 VDD.n343 0.0755
R956 VDD.n334 VDD.n333 0.072039
R957 VDD.n374 VDD.n370 0.072039
R958 VDD.n109 VDD.n108 0.047013
R959 VDD.n342 VDD.n341 0.068
R960 VDD.n345 VDD.n344 0.068
R961 VDD.n350 VDD.n333 0.067039
R962 VDD.n363 VDD.n362 0.065789
R963 VDD.n29 VDD.n28 0.0335761
R964 VDD.n386 VDD.n298 0.0623545
R965 VDD.n381 VDD.n298 0.0623545
R966 VDD.n381 VDD.n380 0.0623545
R967 VDD.n380 VDD.n379 0.0623545
R968 VDD.n379 VDD.n307 0.0623545
R969 VDD.n330 VDD.n307 0.0623545
R970 VDD.n330 VDD.n329 0.0623545
R971 VDD.n329 VDD.n327 0.0623545
R972 VDD.n327 VDD.n313 0.0623545
R973 VDD.n321 VDD.n313 0.0623545
R974 VDD.n385 VDD.n383 0.0623545
R975 VDD.n383 VDD.n303 0.0623545
R976 VDD.n378 VDD.n303 0.0623545
R977 VDD.n378 VDD.n377 0.0623545
R978 VDD.n377 VDD.n331 0.0623545
R979 VDD.n331 VDD.n310 0.0623545
R980 VDD.n326 VDD.n310 0.0623545
R981 VDD.n326 VDD.n325 0.0623545
R982 VDD.n325 VDD.n323 0.0623545
R983 VDD.n374 VDD.n373 0.062039
R984 VDD.t407 VDD.t408 0.058
R985 VDD.n451 VDD.n450 0.0555037
R986 VDD.n337 VDD.n336 0.05425
R987 VDD.n335 VDD.n332 0.048
R988 VDD.n359 VDD.t926 0.048
R989 VDD.n343 VDD.n342 0.0455
R990 VDD.n362 VDD.n356 0.0423097
R991 VDD.n328 VDD.t100 0.0360899
R992 VDD.n376 VDD.n332 0.033
R993 VDD.t69 VDD.t71 0.0205
R994 VDD.n360 VDD.n359 0.01925
R995 VDD.n368 VDD.n355 0.01925
R996 VDD.n336 VDD.n295 0.0811926
R997 VDD.n367 VDD.n366 0.01175
R998 VDD.n373 VDD.n372 0.0055
R999 VDD.n426 VDD.n147 0.0028712
R1000 VDD.n119 VDD.n118 0.00286341
R1001 VDD.n128 VDD.n126 0.0031825
R1002 VDD.n461 VDD.n116 0.00368524
R1003 VDD.n198 VDD.n197 0.00158374
R1004 VDD.n407 VDD.n112 0.00368524
R1005 VDD.n43 VDD.n41 0.00286611
R1006 VDD.n503 VDD.n81 0.00368524
R1007 VDD.n204 VDD.n203 0.00293569
R1008 VDD.n214 VDD.n213 0.00284308
R1009 VDD.n440 VDD.n135 0.00277922
R1010 VDD.n436 VDD.n191 0.00281227
R1011 VDD.n228 VDD.n227 0.00293569
R1012 VDD.n121 VDD.n120 0.00284348
R1013 VDD.n106 VDD.n105 0.00315191
R1014 VDD.n30 VDD.n33 0.00317858
R1015 VDD.n367 VDD.n365 0.00175
R1016 VDD.n223 VDD.n436 0.00349966
R1017 VDD.n234 VDD.n426 0.00427681
R1018 VDD.n417 VDD.n243 0.00349966
R1019 VDD.n256 VDD.n407 0.00349966
R1020 VDD.n37 VDD.n35 0.00484281
R1021 VDD.n261 VDD.n260 0.00349966
R1022 VDD.n99 VDD.n97 0.00408902
R1023 VDD.n571 VDD.n287 0.00423226
R1024 VDD.n25 VDD.n22 1.23417
R1025 VDD.n20 VDD.n17 1.23417
R1026 VDD.t16 VDD.t362 0.370162
R1027 VDD.n318 VDD.t10 0.308212
R1028 VDD.t42 VDD.n320 0.176305
R1029 VDD.n376 VDD.n28 0.04275
R1030 VDD.n198 VDD.n199 0.00782479
R1031 VDD.n37 VDD.n36 0.00675348
R1032 VDD.n214 VDD.n216 0.00483237
R1033 VDD.n237 VDD.n162 0.00468054
R1034 VDD.n202 VDD.n176 0.00399997
R1035 VDD.n171 VDD.n170 0.00399983
R1036 VDD.n280 VDD.n281 0.00399966
R1037 VDD.n277 VDD.n278 0.00399966
R1038 VDD.n267 VDD.n268 0.00399966
R1039 VDD.n251 VDD.n252 0.00399966
R1040 VDD.n247 VDD.n248 0.00399966
R1041 VDD.n228 VDD.n156 0.00399966
R1042 VDD.n204 VDD.n176 0.00399966
R1043 VDD.n229 VDD.n124 0.00384577
R1044 VDD.n264 VDD.n261 0.00349994
R1045 VDD.n281 VDD.n72 0.00345826
R1046 VDD.n278 VDD.n75 0.00345826
R1047 VDD.n268 VDD.n85 0.00345826
R1048 VDD.n252 VDD.n88 0.00345826
R1049 VDD.n185 VDD.n54 0.00327128
R1050 VDD.n242 VDD.n158 0.00299994
R1051 VDD.n232 VDD.n229 0.00299994
R1052 VDD.n159 VDD.n158 0.00284604
R1053 VDD.n64 VDD.n63 0.00581053
R1054 VDD.n443 VDD.n218 0.00358746
R1055 VDD.n206 VDD.n182 0.00349997
R1056 VDD.n117 VDD.n115 0.00135742
R1057 VDD.n136 VDD.n134 0.00128598
R1058 VDD.n440 VDD.n169 0.00349994
R1059 VDD.n184 VDD.n66 0.00349989
R1060 VDD.n397 VDD.n183 0.00349978
R1061 VDD.n210 VDD.n182 0.00349978
R1062 VDD.n191 VDD.n165 0.0031875
R1063 VDD.n242 VDD.n160 0.00431919
R1064 VDD.n226 VDD.n156 0.00399997
R1065 VDD.n16 VDD.n14 0.00240315
R1066 VDD.n243 VDD.n154 0.00349972
R1067 VDD.n247 VDD.n151 0.0041441
R1068 VDD.n139 VDD.n137 0.00595452
R1069 VDD.n233 VDD.n137 0.00516655
R1070 VDD.n186 VDD.n145 0.00430753
R1071 VDD.n232 VDD.n125 0.00476773
R1072 VDD.n99 VDD.n98 0.00471742
R1073 VDD.n121 VDD.n417 0.00449989
R1074 VDD.n119 VDD.n430 0.00449989
R1075 VDD.n140 VDD.n108 0.004146
R1076 VDD.n112 VDD.n255 0.00381417
R1077 VDD.n98 VDD.n269 0.00378196
R1078 VDD.n141 VDD.n140 0.00369993
R1079 VDD.n128 VDD.n127 0.00369993
R1080 VDD.n95 VDD.n94 0.00349999
R1081 VDD.n12 VDD.n10 0.00240315
R1082 VDD.n260 VDD.n95 0.00349972
R1083 VDD.t29 VDD.t388 0.00349308
R1084 VDD.n173 VDD.n215 0.00299997
R1085 VDD.n222 VDD.n167 0.00299997
R1086 VDD.n236 VDD.n162 0.00299997
R1087 VDD.n248 VDD.n152 0.00299997
R1088 VDD.n171 VDD.n172 0.00188743
R1089 VDD.t322 VDD.t147 0.00299858
R1090 VDD.n150 VDD.t388 0.00343786
R1091 VDD.n200 VDD.n122 0.00338752
R1092 VDD.n91 VDD.n92 0.0049239
R1093 VDD.n66 VDD.n170 0.00449994
R1094 VDD.n64 VDD.n430 0.00449994
R1095 VDD.n62 VDD.n154 0.00449994
R1096 VDD.n79 VDD.n71 0.00449937
R1097 VDD.n42 VDD.n51 0.00429995
R1098 VDD.n69 VDD.n183 0.00364849
R1099 VDD.n251 VDD.n90 0.00419799
R1100 VDD.n267 VDD.n87 0.00419799
R1101 VDD.n84 VDD.n189 0.00364021
R1102 VDD.n277 VDD.n77 0.00419799
R1103 VDD.n280 VDD.n74 0.00419799
R1104 VDD.n286 VDD.n45 0.00403703
R1105 VDD.n58 VDD.n32 0.00255488
R1106 VDD.n54 VDD.n53 0.00395829
R1107 VDD.n49 VDD.n48 0.00393996
R1108 VDD.n187 VDD.n56 0.00376355
R1109 VDD.n43 VDD.n42 0.00369993
R1110 VDD.n285 VDD.n58 0.00349995
R1111 VDD.n79 VDD.n78 0.00332663
R1112 VDD.n117 VDD.n116 0.00331383
R1113 VDD.n82 VDD.n81 0.00331383
R1114 VDD.n136 VDD.n135 0.00321994
R1115 VDD.n258 VDD.n39 0.00316655
R1116 VDD.n41 VDD.n56 0.0031332
R1117 VDD.n4 VDD.n3 0.00250817
R1118 VDD.n238 VDD.n53 0.00300839
R1119 VDD.n106 VDD.n103 0.00299997
R1120 VDD.n31 VDD.n30 0.00299997
R1121 VDD.n104 VDD.n101 0.00266629
R1122 VDD.n126 VDD.n131 0.00294999
R1123 VDD.n105 VDD.n101 0.0028473
R1124 VDD.n23 VDD.n22 8.48079
R1125 VDD.n18 VDD.n17 8.48079
R1126 VDD.n244 VDD.n14 5.61555
R1127 VDD.n272 VDD.n10 5.61555
R1128 VSS.t125 VSS.n1744 258112
R1129 VSS.t1291 VSS.t228 54734.6
R1130 VSS.n2249 VSS.n2248 53822.3
R1131 VSS.t1295 VSS.n1306 46775.5
R1132 VSS.n1354 VSS.t669 46775.5
R1133 VSS.t1255 VSS.n1568 46757.2
R1134 VSS.t1289 VSS.t1313 44304.3
R1135 VSS.n1015 VSS.n615 40030.7
R1136 VSS.n1720 VSS.t422 37453.8
R1137 VSS.n1279 VSS.n1275 22494.4
R1138 VSS.t179 VSS.n1540 21381.9
R1139 VSS.n2209 VSS.n1763 17263.5
R1140 VSS.n2418 VSS.n2355 17263.5
R1141 VSS.n2249 VSS.n615 14604.8
R1142 VSS.n1663 VSS.t641 14365.6
R1143 VSS.n2250 VSS.n2249 12083.7
R1144 VSS.n2249 VSS.n1018 12083.7
R1145 VSS.t182 VSS.n615 11896.1
R1146 VSS.t638 VSS.n1250 11816.4
R1147 VSS.n1458 VSS.n857 11755.7
R1148 VSS.n959 VSS.n615 10382.4
R1149 VSS.n2465 VSS.n615 8742.86
R1150 VSS.n2293 VSS.n2292 7500
R1151 VSS.n2214 VSS.n915 7500
R1152 VSS.n2232 VSS.n1755 7500
R1153 VSS.n2234 VSS.n1753 7500
R1154 VSS.n2236 VSS.n1751 7500
R1155 VSS.n2196 VSS.n1749 7500
R1156 VSS.n2099 VSS.n2074 7500
R1157 VSS.n2049 VSS.n1876 7500
R1158 VSS.n2047 VSS.n1920 7500
R1159 VSS.n1007 VSS.n1006 7500
R1160 VSS.n2467 VSS.n671 7500
R1161 VSS.n2467 VSS.n670 7500
R1162 VSS.n2468 VSS.n2467 7500
R1163 VSS.n2467 VSS.n669 7500
R1164 VSS.n2467 VSS.n668 7500
R1165 VSS.n2467 VSS.n667 7500
R1166 VSS.n2467 VSS.n666 7500
R1167 VSS.n2467 VSS.n665 7500
R1168 VSS.n1077 VSS.t228 7250
R1169 VSS.n1032 VSS.n1018 6613.64
R1170 VSS.n1458 VSS.n1457 6613.64
R1171 VSS.n2209 VSS.n2208 6555.52
R1172 VSS.n2231 VSS.n2230 5739.13
R1173 VSS.n2233 VSS.n1754 5739.13
R1174 VSS.n2235 VSS.n1752 5739.13
R1175 VSS.n2237 VSS.n1750 5739.13
R1176 VSS.n2207 VSS.n1765 5739.13
R1177 VSS.n2104 VSS.n2050 5739.13
R1178 VSS.n2048 VSS.n1919 5739.13
R1179 VSS.n2467 VSS.n677 5739.13
R1180 VSS.n2467 VSS.n676 5739.13
R1181 VSS.n2467 VSS.n675 5739.13
R1182 VSS.n2467 VSS.n674 5739.13
R1183 VSS.n2467 VSS.n673 5739.13
R1184 VSS.n2467 VSS.n664 5739.13
R1185 VSS.n2467 VSS.n672 5739.13
R1186 VSS.n2295 VSS.n2294 5739.13
R1187 VSS.n1580 VSS.t179 5478.26
R1188 VSS.n1638 VSS.t0 5478.26
R1189 VSS.n1638 VSS.n1334 5478.26
R1190 VSS.t103 VSS.n1334 5478.26
R1191 VSS.n1683 VSS.t103 5478.26
R1192 VSS.n1683 VSS.n1117 5478.26
R1193 VSS.t224 VSS.n1117 5478.26
R1194 VSS.n358 VSS.t224 5478.26
R1195 VSS.n1744 VSS.n358 5478.26
R1196 VSS.n1460 VSS.n1458 4546.88
R1197 VSS.n1580 VSS.n1438 4413.04
R1198 VSS.n1307 VSS.t1295 4262.19
R1199 VSS.t669 VSS.n1353 4262.19
R1200 VSS.n1569 VSS.t1255 4262.19
R1201 VSS.n1074 VSS.t1313 3625
R1202 VSS.n857 VSS.n615 3484.29
R1203 VSS.n2465 VSS.t162 3428.57
R1204 VSS.n1213 VSS.t1140 2714.25
R1205 VSS.t1189 VSS.n1719 2319.23
R1206 VSS.n1438 VSS.n857 2242.58
R1207 VSS.n961 VSS.n959 1534.88
R1208 VSS.n1012 VSS.n959 1352.46
R1209 VSS.n1006 VSS.n961 1304.35
R1210 VSS.n2467 VSS.n856 1191.19
R1211 VSS.t162 VSS.n858 1189.29
R1212 VSS.t0 VSS.n1438 1065.22
R1213 VSS.n1006 VSS.n868 1026.43
R1214 VSS.n2467 VSS.n857 980.226
R1215 VSS.n2466 VSS.n134 961.135
R1216 VSS.n2047 VSS.n2046 905.765
R1217 VSS.t366 VSS.n1212 876.155
R1218 VSS.n1251 VSS.t123 859.519
R1219 VSS.t1140 VSS.t366 804.067
R1220 VSS.t162 VSS.n106 725.606
R1221 VSS.n2467 VSS.n2466 613.384
R1222 VSS.n1009 VSS.n961 613.236
R1223 VSS.n1012 VSS.n1011 602.727
R1224 VSS.t162 VSS.n2464 577.934
R1225 VSS.n1009 VSS.n1008 522.712
R1226 VSS.n2462 VSS.n2461 499.043
R1227 VSS.n57 VSS.n1012 462.399
R1228 VSS.n1744 VSS.n1111 427.132
R1229 VSS.n1160 VSS.n1117 427.132
R1230 VSS.n1746 VSS.n1076 427.132
R1231 VSS.n1747 VSS.n1075 427.132
R1232 VSS.n1684 VSS.n1683 427.132
R1233 VSS.n1748 VSS.n438 427.132
R1234 VSS.n1401 VSS.n1334 427.132
R1235 VSS.n1640 VSS.n1639 427.132
R1236 VSS.n1639 VSS.n1437 427.132
R1237 VSS.n1642 VSS.n1641 427.132
R1238 VSS.n1641 VSS.n1436 427.132
R1239 VSS.n1644 VSS.n1643 427.132
R1240 VSS.n1645 VSS.n1644 427.132
R1241 VSS.n1582 VSS.n1581 427.132
R1242 VSS.n1581 VSS.n1445 427.132
R1243 VSS.n1584 VSS.n1583 427.132
R1244 VSS.n1583 VSS.n1444 427.132
R1245 VSS.n1586 VSS.n1585 427.132
R1246 VSS.n1585 VSS.n1443 427.132
R1247 VSS.n1588 VSS.n1587 427.132
R1248 VSS.n1587 VSS.n1442 427.132
R1249 VSS.n1590 VSS.n1589 427.132
R1250 VSS.n1589 VSS.n1441 427.132
R1251 VSS.n1606 VSS.n1605 427.132
R1252 VSS.n1389 VSS.t347 422.846
R1253 VSS.t1183 VSS.n1180 418.56
R1254 VSS.t657 VSS.n1727 418.56
R1255 VSS.n434 VSS.n1364 415.67
R1256 VSS.t499 VSS.n1348 414.952
R1257 VSS.n352 VSS.t687 414.274
R1258 VSS.n1193 VSS.t215 414.274
R1259 VSS.n1313 VSS.t88 414.274
R1260 VSS.t720 VSS.n1075 414.274
R1261 VSS.n1010 VSS.n1009 414.241
R1262 VSS.n1707 VSS.n1324 412.608
R1263 VSS.t484 VSS.n1631 411.526
R1264 VSS.n1745 VSS.n353 411.43
R1265 VSS.n359 VSS.n358 427.132
R1266 VSS.n1230 VSS.n1229 411.43
R1267 VSS.n1232 VSS.n1231 411.43
R1268 VSS.n1234 VSS.n1233 411.43
R1269 VSS.n1236 VSS.n1235 411.43
R1270 VSS.n1238 VSS.n1237 411.43
R1271 VSS.n1240 VSS.n1239 411.43
R1272 VSS.n1241 VSS.n1218 411.43
R1273 VSS.n1688 VSS.n1687 411.43
R1274 VSS.n1700 VSS.n1330 411.43
R1275 VSS.n493 VSS.n1638 427.132
R1276 VSS.n1649 VSS.n1431 411.43
R1277 VSS.n520 VSS.n1580 427.132
R1278 VSS.t1205 VSS.n1331 407.144
R1279 VSS.n1704 VSS.t559 407.144
R1280 VSS.n1242 VSS.n1217 400
R1281 VSS.n1659 VSS.n1658 400
R1282 VSS.t1143 VSS.n1209 398.572
R1283 VSS.t148 VSS.n1208 398.572
R1284 VSS.n1294 VSS.t5 398.572
R1285 VSS.t1232 VSS.n1724 398.572
R1286 VSS.t300 VSS.n1376 398.572
R1287 VSS.n1379 VSS.t497 398.572
R1288 VSS.n1417 VSS.t265 398.572
R1289 VSS.n1626 VSS.t521 398.572
R1290 VSS.n1172 VSS.t557 397.755
R1291 VSS.n1351 VSS.t73 395.416
R1292 VSS.n1182 VSS.t68 394.286
R1293 VSS.n1186 VSS.t69 394.286
R1294 VSS.t70 VSS.n1133 394.286
R1295 VSS.n1015 VSS.n1014 388.161
R1296 VSS.n1296 VSS.t579 386.587
R1297 VSS.n1286 VSS.t1195 385.714
R1298 VSS.n1381 VSS.t295 385.714
R1299 VSS.n1414 VSS.t1235 385.714
R1300 VSS.t405 VSS.n1422 385.714
R1301 VSS.t440 VSS.n1434 385.714
R1302 VSS.t360 VSS.n1139 384.274
R1303 VSS.t1272 VSS.n1313 384.274
R1304 VSS.n2015 VSS.n1997 381.443
R1305 VSS.t403 VSS.n1691 381.43
R1306 VSS.n1699 VSS.t543 381.43
R1307 VSS.t361 VSS.n1328 381.43
R1308 VSS.t421 VSS.n416 377.351
R1309 VSS.n515 VSS.t671 377.351
R1310 VSS.n1299 VSS.t25 376.724
R1311 VSS.t321 VSS.n1359 376.724
R1312 VSS.n1631 VSS.t205 376.724
R1313 VSS.t81 VSS.n1062 376.724
R1314 VSS.t629 VSS.n1321 375
R1315 VSS.n415 VSS.t639 374.002
R1316 VSS.n1597 VSS.t712 373.926
R1317 VSS.n1259 VSS.t432 372.858
R1318 VSS.n1228 VSS.t352 372.858
R1319 VSS.t380 VSS.n1132 372.858
R1320 VSS.n1190 VSS.t611 372.858
R1321 VSS.n1191 VSS.t402 372.858
R1322 VSS.n1734 VSS.t416 372.858
R1323 VSS.t1190 VSS.n1369 372.858
R1324 VSS.t1151 VSS.n1366 372.858
R1325 VSS.t422 VSS.t1189 369.231
R1326 VSS.n1188 VSS.t646 368.572
R1327 VSS.n1074 VSS.t275 365.279
R1328 VSS.n1703 VSS.t409 364.286
R1329 VSS.n1602 VSS.t267 362.5
R1330 VSS.n1273 VSS.t685 362.07
R1331 VSS.n1080 VSS.t192 361.033
R1332 VSS.n1269 VSS.t1294 361.033
R1333 VSS.t668 VSS.n1349 361.033
R1334 VSS.n1669 VSS.t472 361.033
R1335 VSS.n1611 VSS.t19 361.033
R1336 VSS.n1287 VSS.t438 360
R1337 VSS.t713 VSS.n1386 360
R1338 VSS.t171 VSS.n1247 355.714
R1339 VSS.t335 VSS.n1159 355.714
R1340 VSS.n1177 VSS.t677 355.714
R1341 VSS.n1701 VSS.t28 355.714
R1342 VSS.n1413 VSS.t66 355.714
R1343 VSS.n1416 VSS.t722 355.714
R1344 VSS.t573 VSS.n1393 355.714
R1345 VSS.t545 VSS.n1392 355.714
R1346 VSS.t1178 VSS.n1391 355.714
R1347 VSS.t1158 VSS.n1435 355.714
R1348 VSS.n2214 VSS.n2213 354.812
R1349 VSS.n1066 VSS.t211 352.437
R1350 VSS.n1253 VSS.t1142 351.43
R1351 VSS.n1255 VSS.t108 351.43
R1352 VSS.n1295 VSS.t27 351.43
R1353 VSS.t188 VSS.n1316 351.43
R1354 VSS.t11 VSS.n1370 351.43
R1355 VSS.t78 VSS.n1367 351.43
R1356 VSS.n1627 VSS.t207 351.43
R1357 VSS.n1621 VSS.t269 351.43
R1358 VSS.n1410 VSS.t337 350.613
R1359 VSS.n1250 VSS.t1141 348.139
R1360 VSS.n1292 VSS.t268 347.144
R1361 VSS.n1254 VSS.t6 347.144
R1362 VSS.t423 VSS.n1290 347.144
R1363 VSS.t45 VSS.n1142 347.144
R1364 VSS.t723 VSS.n1368 347.144
R1365 VSS.n427 VSS.t580 346.327
R1366 VSS.n1405 VSS.t1212 346.327
R1367 VSS.n1346 VSS.t572 345.834
R1368 VSS.t1175 VSS.n1670 345.834
R1369 VSS.t1318 VSS.n1246 345.704
R1370 VSS.n1275 VSS.n1274 343.75
R1371 VSS.t239 VSS.t382 342.858
R1372 VSS.n1289 VSS.t479 342.041
R1373 VSS.n1300 VSS.t1174 341.668
R1374 VSS.t374 VSS.n1358 341.668
R1375 VSS.t1210 VSS.n1055 341.668
R1376 VSS.n1077 VSS.t121 339.664
R1377 VSS.n1174 VSS.t477 338.572
R1378 VSS.t34 VSS.n1690 338.572
R1379 VSS.n1694 VSS.t1229 338.572
R1380 VSS.t673 VSS.n1696 338.572
R1381 VSS.n1326 VSS.t626 338.572
R1382 VSS.n1646 VSS.t1213 338.572
R1383 VSS.n1648 VSS.t328 338.572
R1384 VSS.t1228 VSS.n1432 338.572
R1385 VSS.t619 VSS.n1303 337.5
R1386 VSS.n1355 VSS.t656 337.5
R1387 VSS.t16 VSS.n1056 337.5
R1388 VSS.n1298 VSS.t359 335.245
R1389 VSS.n1256 VSS.t413 334.286
R1390 VSS.t76 VSS.n1205 334.286
R1391 VSS.n1258 VSS.t385 334.286
R1392 VSS.n1288 VSS.t504 334.286
R1393 VSS.t655 VSS.n1131 334.286
R1394 VSS.t435 VSS.n1127 334.286
R1395 VSS.t550 VSS.t581 334.286
R1396 VSS.n1726 VSS.t304 334.286
R1397 VSS.t1279 VSS.t72 334.286
R1398 VSS.t197 VSS.n1433 334.286
R1399 VSS.t643 VSS.n1215 330.084
R1400 VSS.n1598 VSS.t653 330.074
R1401 VSS.n1161 VSS.t1284 330
R1402 VSS.t1297 VSS.n1143 330
R1403 VSS.t1221 VSS.n1412 330
R1404 VSS.n1415 VSS.t338 330
R1405 VSS.t693 VSS.n1395 330
R1406 VSS.n1418 VSS.t101 330
R1407 VSS.n1419 VSS.t441 330
R1408 VSS.t1198 VSS.t266 330
R1409 VSS.t22 VSS.n1564 329.168
R1410 VSS.n1086 VSS.t329 329.168
R1411 VSS.n1244 VSS.t256 329.168
R1412 VSS.t1264 VSS.n1266 329.168
R1413 VSS.t301 VSS.n1304 329.168
R1414 VSS.t1144 VSS.n1325 329.168
R1415 VSS.n1320 VSS.t1135 329.168
R1416 VSS.t271 VSS.n1343 329.168
R1417 VSS.n1342 VSS.t724 329.168
R1418 VSS.t398 VSS.n1363 329.168
R1419 VSS.n1676 VSS.t343 329.168
R1420 VSS.n1651 VSS.t582 329.168
R1421 VSS.n1618 VSS.t566 329.168
R1422 VSS.n1637 VSS.t411 329.168
R1423 VSS.n1604 VSS.t417 329.168
R1424 VSS.n1059 VSS.t195 329.168
R1425 VSS.n1821 VSS.n1755 329.038
R1426 VSS.t1159 VSS.n1669 328.714
R1427 VSS.t691 VSS.n1109 328.56
R1428 VSS.t220 VSS.n1135 328.56
R1429 VSS.t652 VSS.n1196 328.56
R1430 VSS.n1733 VSS.t505 328.56
R1431 VSS.t330 VSS.n1733 328.56
R1432 VSS.t625 VSS.n1053 326.649
R1433 VSS.t565 VSS.n1208 325.714
R1434 VSS.n1728 VSS.t589 325.714
R1435 VSS.t529 VSS.t284 325.714
R1436 VSS.n1622 VSS.t1234 325.714
R1437 VSS.n1612 VSS.t430 324.695
R1438 VSS.t233 VSS.n1360 322.351
R1439 VSS.n1293 VSS.t229 321.43
R1440 VSS.n1178 VSS.t232 321.43
R1441 VSS.t688 VSS.t474 321.43
R1442 VSS.n1285 VSS.t675 320.613
R1443 VSS.t94 VSS.n1705 320.613
R1444 VSS.n1283 VSS.t198 320.271
R1445 VSS.t218 VSS.n1428 320.271
R1446 VSS.n1605 VSS.t251 319.99
R1447 VSS.t1206 VSS.n1070 319.86
R1448 VSS.n1636 VSS.t1266 319.836
R1449 VSS.n2251 VSS.n2250 319.385
R1450 VSS.t1304 VSS.t281 317.144
R1451 VSS.t503 VSS.n353 312.858
R1452 VSS.t332 VSS.n1225 312.858
R1453 VSS.n1189 VSS.t258 312.858
R1454 VSS.t98 VSS.n1129 312.858
R1455 VSS.t1276 VSS.n1332 312.858
R1456 VSS.n1377 VSS.t168 312.858
R1457 VSS.t90 VSS.t298 312.858
R1458 VSS.n1380 VSS.t463 312.858
R1459 VSS.t1219 VSS.t140 312.5
R1460 VSS.t71 VSS.t253 312.5
R1461 VSS.t1165 VSS.n1206 308.572
R1462 VSS.n1257 VSS.t1166 308.572
R1463 VSS.t1168 VSS.n1203 308.572
R1464 VSS.t326 VSS.t144 308.572
R1465 VSS.t1161 VSS.t1283 308.572
R1466 VSS.t502 VSS.n1130 308.572
R1467 VSS.t1170 VSS.n1125 308.572
R1468 VSS.t86 VSS.n1315 308.572
R1469 VSS.t632 VSS.n1210 305.159
R1470 VSS.t1139 VSS.n1263 305.159
R1471 VSS.n1712 VSS.t893 305.159
R1472 VSS.t1154 VSS.n1352 305.159
R1473 VSS.t549 VSS.n1362 305.159
R1474 VSS.n1667 VSS.t177 305.159
R1475 VSS.n1609 VSS.t12 305.159
R1476 VSS.n1628 VSS.t1002 305.159
R1477 VSS.n1595 VSS.t91 305.159
R1478 VSS.t466 VSS.n1592 305.159
R1479 VSS.t2 VSS.n1067 305.159
R1480 VSS.n1063 VSS.t614 305.159
R1481 VSS.n1423 VSS.t1176 304.286
R1482 VSS.t1243 VSS.n1656 304.286
R1483 VSS.n1620 VSS.t682 304.286
R1484 VSS.n1615 VSS.t680 304.168
R1485 VSS.n1603 VSS.t465 304.168
R1486 VSS.n1869 VSS.n1753 303.265
R1487 VSS.t149 VSS.t1171 295.714
R1488 VSS.t89 VSS.t644 295.714
R1489 VSS.n1070 VSS.t376 295.062
R1490 VSS.n1163 VSS.t634 291.43
R1491 VSS.t577 VSS.n1156 291.43
R1492 VSS.n1174 VSS.t378 291.43
R1493 VSS.n1690 VSS.t651 291.43
R1494 VSS.t262 VSS.n1694 291.43
R1495 VSS.n1696 VSS.t617 291.43
R1496 VSS.t624 VSS.n1326 291.43
R1497 VSS.n1646 VSS.t145 291.43
R1498 VSS.n1702 VSS.t647 287.144
R1499 VSS.n1593 VSS.t486 283.668
R1500 VSS.t339 VSS.n1655 278.572
R1501 VSS.n1655 VSS.t544 278.572
R1502 VSS.n2161 VSS.n1751 277.491
R1503 VSS.t556 VSS.n1271 275.863
R1504 VSS.n2355 VSS.n671 275.774
R1505 VSS.t527 VSS.n1078 275.072
R1506 VSS.t442 VSS.n1263 275.072
R1507 VSS.n1712 VSS.t286 275.072
R1508 VSS.n1718 VSS.t278 275.072
R1509 VSS.n1352 VSS.t518 275.072
R1510 VSS.t708 VSS.n1429 275.072
R1511 VSS.t707 VSS.n1609 275.072
R1512 VSS.t558 VSS.n1628 275.072
R1513 VSS.t53 VSS.n1595 275.072
R1514 VSS.t444 VSS.n1591 275.072
R1515 VSS.t291 VSS.n1051 275.072
R1516 VSS.n1067 VSS.t555 275.072
R1517 VSS.n346 VSS.t568 273.471
R1518 VSS.t217 VSS.n352 272.846
R1519 VSS.n345 VSS.t1225 272.846
R1520 VSS.n1164 VSS.t110 272.846
R1521 VSS.t489 VSS.n1164 272.846
R1522 VSS.t312 VSS.n1149 272.846
R1523 VSS.n1196 VSS.t1164 272.846
R1524 VSS.t388 VSS.n508 272.846
R1525 VSS.n506 VSS.t346 272.846
R1526 VSS.t61 VSS.n505 272.846
R1527 VSS.n41 VSS.n1000 271.969
R1528 VSS.t446 VSS.n1214 267.409
R1529 VSS.t530 VSS.t564 265.714
R1530 VSS.t136 VSS.t478 265.714
R1531 VSS.t297 VSS.t241 265.714
R1532 VSS.t43 VSS.t1233 265.714
R1533 VSS.t1271 VSS.t381 261.43
R1534 VSS.n2196 VSS.n2195 260.31
R1535 VSS.t454 VSS.t1258 258.334
R1536 VSS.n1567 VSS.t1253 258.334
R1537 VSS.t117 VSS.t1192 258.334
R1538 VSS.t676 VSS.t130 258.334
R1539 VSS.t141 VSS.t93 258.334
R1540 VSS.t1293 VSS.n1264 258.334
R1541 VSS.t24 VSS.n1301 258.334
R1542 VSS.t536 VSS.t1136 258.334
R1543 VSS.t1250 VSS.n1709 258.334
R1544 VSS.t357 VSS.t540 258.334
R1545 VSS.n1717 VSS.t420 258.334
R1546 VSS.t459 VSS.t1259 258.334
R1547 VSS.t1286 VSS.t553 258.334
R1548 VSS.t255 VSS.t456 258.334
R1549 VSS.n1347 VSS.t667 258.334
R1550 VSS.n1357 VSS.t320 258.334
R1551 VSS.t151 VSS.t245 258.334
R1552 VSS.n1373 VSS.t8 258.334
R1553 VSS.t1240 VSS.t288 258.334
R1554 VSS.t471 VSS.n1672 258.334
R1555 VSS.t1242 VSS.t1292 258.334
R1556 VSS.t1209 VSS.t358 258.334
R1557 VSS.t604 VSS.t618 258.334
R1558 VSS.t204 VSS.n1633 258.334
R1559 VSS.t1309 VSS.t1191 258.334
R1560 VSS.t1148 VSS.n1049 258.334
R1561 VSS.t1307 VSS.t1199 258.334
R1562 VSS.n1061 VSS.t80 258.334
R1563 VSS.t745 VSS.n1080 257.88
R1564 VSS.n1269 VSS.t837 257.88
R1565 VSS.n1593 VSS.t47 257.88
R1566 VSS.t83 VSS.n1053 257.88
R1567 VSS.t496 VSS.n1126 257.144
R1568 VSS.n1687 VSS.t567 257.144
R1569 VSS.n1693 VSS.t659 257.144
R1570 VSS.t50 VSS.n1697 257.144
R1571 VSS.n1088 VSS.t742 252.065
R1572 VSS.n1176 VSS.t871 252.065
R1573 VSS.n1406 VSS.t916 252.065
R1574 VSS.n1166 VSS.t848 252.041
R1575 VSS.t850 VSS.n1154 252.041
R1576 VSS.n1170 VSS.t853 252.041
R1577 VSS.t877 VSS.n1137 252.041
R1578 VSS.n1405 VSS.t914 252.041
R1579 VSS.n1408 VSS.t932 252.041
R1580 VSS.n1653 VSS.t950 252.041
R1581 VSS.n364 VSS.t804 251.417
R1582 VSS.n368 VSS.t806 251.417
R1583 VSS.n372 VSS.t808 251.417
R1584 VSS.n376 VSS.t810 251.417
R1585 VSS.n380 VSS.t812 251.417
R1586 VSS.n384 VSS.t814 251.417
R1587 VSS.n1246 VSS.t796 251.417
R1588 VSS.t862 VSS.n1160 251.417
R1589 VSS.n1147 VSS.t858 251.417
R1590 VSS.n1146 VSS.t869 251.417
R1591 VSS.n1139 VSS.t875 251.417
R1592 VSS.t910 VSS.n1401 251.417
R1593 VSS.t912 VSS.n1399 251.417
R1594 VSS.t918 VSS.n1407 251.417
R1595 VSS.t143 VSS.t342 251.351
R1596 VSS.t127 VSS.t1180 251.351
R1597 VSS.t1247 VSS.t694 251.351
R1598 VSS.t586 VSS.n1426 251.351
R1599 VSS.n1087 VSS.t124 250.952
R1600 VSS.n1245 VSS.t134 250.952
R1601 VSS.t1239 VSS.n1385 250.952
R1602 VSS.n1652 VSS.t1241 250.952
R1603 VSS.n1619 VSS.t1207 250.952
R1604 VSS.t1188 VSS.n416 249.643
R1605 VSS.n515 VSS.t622 249.643
R1606 VSS.t123 VSS.t1262 249.538
R1607 VSS.n348 VSS.t1261 249.523
R1608 VSS.n2230 VSS.n2229 249.142
R1609 VSS.n1835 VSS.n1754 249.142
R1610 VSS.n2115 VSS.n1752 249.142
R1611 VSS.n2178 VSS.n1750 249.142
R1612 VSS.n2207 VSS.n2206 249.142
R1613 VSS.n2104 VSS.n2103 249.142
R1614 VSS.n1919 VSS.n1918 249.142
R1615 VSS.t1145 VSS.n1561 249.002
R1616 VSS.t464 VSS.n1081 249.002
R1617 VSS.t524 VSS.n404 249.002
R1618 VSS.n1348 VSS.t1269 249.002
R1619 VSS.t1186 VSS.n1612 249.002
R1620 VSS.t1194 VSS.n1328 244.286
R1621 VSS.n1403 VSS.t911 243.496
R1622 VSS.n1176 VSS.t870 243.494
R1623 VSS.t878 VSS.n1136 243.494
R1624 VSS.n1406 VSS.t915 243.494
R1625 VSS.t861 VSS.n1137 243.47
R1626 VSS.n1172 VSS.t854 243.47
R1627 VSS.n1170 VSS.t867 243.47
R1628 VSS.t865 VSS.n1154 243.47
R1629 VSS.t863 VSS.n1158 243.47
R1630 VSS.n1410 VSS.t933 243.47
R1631 VSS.n1408 VSS.t921 243.47
R1632 VSS.t919 VSS.n1390 243.47
R1633 VSS.n2099 VSS.n2098 243.127
R1634 VSS.n365 VSS.t776 242.846
R1635 VSS.n369 VSS.t779 242.846
R1636 VSS.n373 VSS.t782 242.846
R1637 VSS.n377 VSS.t785 242.846
R1638 VSS.n381 VSS.t788 242.846
R1639 VSS.n385 VSS.t791 242.846
R1640 VSS.n1175 VSS.t859 242.846
R1641 VSS.t100 VSS.n1064 241.935
R1642 VSS.t743 VSS.n1084 236.502
R1643 VSS.n1078 VSS.t746 236.391
R1644 VSS.n1630 VSS.t1001 236.391
R1645 VSS.n1108 VSS.t725 235.714
R1646 VSS.n1105 VSS.t727 235.714
R1647 VSS.n1102 VSS.t729 235.714
R1648 VSS.n1099 VSS.t732 235.714
R1649 VSS.n1096 VSS.t734 235.714
R1650 VSS.n1093 VSS.t736 235.714
R1651 VSS.n1090 VSS.t740 235.714
R1652 VSS.n359 VSS.t769 251.417
R1653 VSS.n357 VSS.t801 252.041
R1654 VSS.n1230 VSS.t774 235.714
R1655 VSS.n1232 VSS.t778 235.714
R1656 VSS.n1234 VSS.t781 235.714
R1657 VSS.n1236 VSS.t784 235.714
R1658 VSS.n1238 VSS.t787 235.714
R1659 VSS.n1240 VSS.t790 235.714
R1660 VSS.n1218 VSS.t793 235.714
R1661 VSS.t864 VSS.n1155 235.714
R1662 VSS.n1169 VSS.t866 235.714
R1663 VSS.t856 VSS.n1150 235.714
R1664 VSS.t860 VSS.n1138 235.714
R1665 VSS.n1699 VSS.t882 235.714
R1666 VSS.t425 VSS.t429 235.714
R1667 VSS.n1421 VSS.t920 235.714
R1668 VSS.n493 VSS.t934 251.417
R1669 VSS.n1437 VSS.t939 235.714
R1670 VSS.n1436 VSS.t944 235.714
R1671 VSS.n520 VSS.t1005 251.417
R1672 VSS.n1445 VSS.t1010 235.714
R1673 VSS.n1444 VSS.t1015 235.714
R1674 VSS.n1443 VSS.t1020 235.714
R1675 VSS.n1442 VSS.t1025 235.714
R1676 VSS.n1441 VSS.t1030 235.714
R1677 VSS.n1374 VSS.t299 233.333
R1678 VSS.t710 VSS.n1671 233.333
R1679 VSS.t520 VSS.n1632 233.333
R1680 VSS.n1071 VSS.t3 233.333
R1681 VSS.t1275 VSS.t115 233.333
R1682 VSS.n1565 VSS.t1077 229.167
R1683 VSS.n1267 VSS.t833 229.167
R1684 VSS.t905 VSS.n1371 229.167
R1685 VSS.t753 VSS.n1108 227.143
R1686 VSS.t755 VSS.n1105 227.143
R1687 VSS.t757 VSS.n1102 227.143
R1688 VSS.t759 VSS.n1099 227.143
R1689 VSS.t761 VSS.n1096 227.143
R1690 VSS.t763 VSS.n1093 227.143
R1691 VSS.t765 VSS.n1090 227.143
R1692 VSS.n1227 VSS.t772 227.143
R1693 VSS.n1229 VSS.t803 227.143
R1694 VSS.n1231 VSS.t805 227.143
R1695 VSS.n1233 VSS.t807 227.143
R1696 VSS.n1235 VSS.t809 227.143
R1697 VSS.n1237 VSS.t811 227.143
R1698 VSS.n1239 VSS.t813 227.143
R1699 VSS.n1241 VSS.t815 227.143
R1700 VSS.n1248 VSS.t795 227.143
R1701 VSS.n1168 VSS.t849 227.143
R1702 VSS.t852 VSS.n1152 227.143
R1703 VSS.t857 VSS.n1148 227.143
R1704 VSS.n1178 VSS.t872 227.143
R1705 VSS.t874 VSS.n1141 227.143
R1706 VSS.n1184 VSS.t876 227.143
R1707 VSS.n1700 VSS.t884 227.143
R1708 VSS.t913 VSS.n1398 227.143
R1709 VSS.n1417 VSS.t917 227.143
R1710 VSS.n1640 VSS.t937 227.143
R1711 VSS.n1642 VSS.t942 227.143
R1712 VSS.n1643 VSS.t947 227.143
R1713 VSS.n1657 VSS.t964 227.143
R1714 VSS.t1004 VSS.n1622 227.143
R1715 VSS.n1582 VSS.t1008 227.143
R1716 VSS.n1584 VSS.t1013 227.143
R1717 VSS.n1586 VSS.t1018 227.143
R1718 VSS.n1588 VSS.t1023 227.143
R1719 VSS.n1590 VSS.t1028 227.143
R1720 VSS.n1606 VSS.t1033 227.143
R1721 VSS.t1290 VSS.n1277 227.028
R1722 VSS.t683 VSS.n1276 227.028
R1723 VSS.n1664 VSS.t1288 227.028
R1724 VSS.n2108 VSS.n1876 225.946
R1725 VSS.n1982 VSS.n1920 225.946
R1726 VSS.t445 VSS.t336 223.496
R1727 VSS.t1162 VSS.t427 223.496
R1728 VSS.t766 VSS.n1088 222.065
R1729 VSS.t965 VSS.n1653 222.042
R1730 VSS.t931 VSS.n1390 222.041
R1731 VSS.n1171 VSS.t868 221.417
R1732 VSS.n1409 VSS.t922 221.417
R1733 VSS.n1566 VSS.t1078 220.833
R1734 VSS.t797 VSS.n1242 220.833
R1735 VSS.n1268 VSS.t835 220.833
R1736 VSS.n1711 VSS.t887 220.833
R1737 VSS.n1375 VSS.t908 220.833
R1738 VSS.t951 VSS.n489 236.502
R1739 VSS.t18 VSS.t1280 220.833
R1740 VSS.t880 VSS.t1185 218.571
R1741 VSS.t923 VSS.n1674 215.669
R1742 VSS.t984 VSS.n1616 215.669
R1743 VSS.t562 VSS.t528 210.602
R1744 VSS.t56 VSS.n1591 210.602
R1745 VSS.n1069 VSS.t59 210.602
R1746 VSS.t1220 VSS.t63 210
R1747 VSS.t142 VSS.t488 208.333
R1748 VSS.t196 VSS.t494 208.333
R1749 VSS.t294 VSS.t453 208.333
R1750 VSS.n1274 VSS.t227 206.898
R1751 VSS.t221 VSS.t234 206.304
R1752 VSS.t868 VSS.n1151 205.714
R1753 VSS.t881 VSS.n1688 205.714
R1754 VSS.n1689 VSS.t881 205.714
R1755 VSS.n1421 VSS.t931 205.714
R1756 VSS.t922 VSS.n1387 205.714
R1757 VSS.n1645 VSS.t949 205.714
R1758 VSS.t213 VSS.t962 205.714
R1759 VSS.n1654 VSS.t965 205.714
R1760 VSS.n2294 VSS.n915 202.661
R1761 VSS.t1131 VSS.n1251 202.006
R1762 VSS.t59 VSS.n1050 202.006
R1763 VSS.t588 VSS.t719 201.429
R1764 VSS.n2419 VSS.n2418 201.338
R1765 VSS.n1708 VSS.t891 201.135
R1766 VSS.n1107 VSS.t726 200.613
R1767 VSS.n1106 VSS.t755 200.613
R1768 VSS.n1104 VSS.t728 200.613
R1769 VSS.n1103 VSS.t757 200.613
R1770 VSS.n1101 VSS.t731 200.613
R1771 VSS.n1100 VSS.t759 200.613
R1772 VSS.n1098 VSS.t733 200.613
R1773 VSS.n1097 VSS.t761 200.613
R1774 VSS.n1095 VSS.t735 200.613
R1775 VSS.n1094 VSS.t763 200.613
R1776 VSS.n1092 VSS.t738 200.613
R1777 VSS.n1091 VSS.t765 200.613
R1778 VSS.n1089 VSS.t741 200.613
R1779 VSS.n360 VSS.t772 200.613
R1780 VSS.t795 VSS.n388 200.613
R1781 VSS.t911 VSS.n1402 200.613
R1782 VSS.t915 VSS.n1397 200.613
R1783 VSS.t937 VSS.n490 200.613
R1784 VSS.t942 VSS.n497 200.613
R1785 VSS.n501 VSS.t947 200.613
R1786 VSS.t1008 VSS.n517 200.613
R1787 VSS.t1013 VSS.n524 200.613
R1788 VSS.t1018 VSS.n528 200.613
R1789 VSS.t1023 VSS.n532 200.613
R1790 VSS.t1028 VSS.n536 200.613
R1791 VSS.t1033 VSS.n539 200.613
R1792 VSS.t798 VSS.n1216 200
R1793 VSS.n1675 VSS.t923 200
R1794 VSS.t953 VSS.n1430 200
R1795 VSS.n1617 VSS.t984 200
R1796 VSS.n1109 VSS.t753 199.989
R1797 VSS.n365 VSS.t805 199.989
R1798 VSS.n369 VSS.t807 199.989
R1799 VSS.n373 VSS.t809 199.989
R1800 VSS.n377 VSS.t811 199.989
R1801 VSS.n381 VSS.t813 199.989
R1802 VSS.t815 VSS.n385 199.989
R1803 VSS.t849 VSS.n1167 199.989
R1804 VSS.n1153 VSS.t852 199.989
R1805 VSS.t854 VSS.n1171 199.989
R1806 VSS.n1149 VSS.t857 199.989
R1807 VSS.t870 VSS.n1175 199.989
R1808 VSS.t876 VSS.n1183 199.989
R1809 VSS.n1135 VSS.t880 199.989
R1810 VSS.t884 VSS.n423 199.989
R1811 VSS.t933 VSS.n1409 199.989
R1812 VSS.n1623 VSS.t1004 199.989
R1813 VSS.t58 VSS.t704 197.708
R1814 VSS.t39 VSS.t752 197.143
R1815 VSS.t879 VSS.t250 197.143
R1816 VSS.t606 VSS.t1150 195.833
R1817 VSS.t887 VSS.n418 194.835
R1818 VSS.n1007 VSS.n1005 193.637
R1819 VSS.t1222 VSS.t64 192.857
R1820 VSS.n1214 VSS.n1213 192.202
R1821 VSS.t740 VSS.n1089 192.042
R1822 VSS.t764 VSS.n1091 192.042
R1823 VSS.t736 VSS.n1092 192.042
R1824 VSS.t762 VSS.n1094 192.042
R1825 VSS.t734 VSS.n1095 192.042
R1826 VSS.t760 VSS.n1097 192.042
R1827 VSS.t732 VSS.n1098 192.042
R1828 VSS.t758 VSS.n1100 192.042
R1829 VSS.t729 VSS.n1101 192.042
R1830 VSS.t756 VSS.n1103 192.042
R1831 VSS.t727 VSS.n1104 192.042
R1832 VSS.t754 VSS.n1106 192.042
R1833 VSS.t725 VSS.n1107 192.042
R1834 VSS.t793 VSS.n388 192.042
R1835 VSS.t769 VSS.n360 192.042
R1836 VSS.t914 VSS.n1397 192.042
R1837 VSS.n1404 VSS.t912 192.042
R1838 VSS.n1402 VSS.t910 192.042
R1839 VSS.t962 VSS.n511 192.042
R1840 VSS.t944 VSS.n501 192.042
R1841 VSS.t939 VSS.n497 192.042
R1842 VSS.t934 VSS.n490 192.042
R1843 VSS.t1030 VSS.n539 192.042
R1844 VSS.t1025 VSS.n536 192.042
R1845 VSS.t1020 VSS.n532 192.042
R1846 VSS.t1015 VSS.n528 192.042
R1847 VSS.t1010 VSS.n524 192.042
R1848 VSS.t1005 VSS.n517 192.042
R1849 VSS.n2232 VSS.n2231 191.474
R1850 VSS.t774 VSS.n364 191.417
R1851 VSS.t778 VSS.n368 191.417
R1852 VSS.t781 VSS.n372 191.417
R1853 VSS.t784 VSS.n376 191.417
R1854 VSS.t787 VSS.n380 191.417
R1855 VSS.t790 VSS.n384 191.417
R1856 VSS.n1167 VSS.t864 191.417
R1857 VSS.t866 VSS.n1153 191.417
R1858 VSS.t858 VSS.n1146 191.417
R1859 VSS.n1180 VSS.t873 191.417
R1860 VSS.n1183 VSS.t860 191.417
R1861 VSS.t920 VSS.n1389 191.417
R1862 VSS.t282 VSS.t1132 189.113
R1863 VSS.t888 VSS.n1708 187.143
R1864 VSS.t1077 VSS.n1563 186.502
R1865 VSS.t833 VSS.n401 186.502
R1866 VSS.n2466 VSS.n2465 185.846
R1867 VSS.n1225 VSS.t803 184.286
R1868 VSS.t776 VSS.n1224 184.286
R1869 VSS.t779 VSS.n1223 184.286
R1870 VSS.t782 VSS.n1222 184.286
R1871 VSS.t785 VSS.n1221 184.286
R1872 VSS.t788 VSS.n1220 184.286
R1873 VSS.t791 VSS.n1219 184.286
R1874 VSS.n1162 VSS.t863 184.286
R1875 VSS.n1168 VSS.t865 184.286
R1876 VSS.t867 VSS.n1152 184.286
R1877 VSS.t859 VSS.n1145 184.286
R1878 VSS.t872 VSS.n1143 184.286
R1879 VSS.n1181 VSS.t874 184.286
R1880 VSS.n1184 VSS.t861 184.286
R1881 VSS.n1706 VSS.t885 184.286
R1882 VSS.t917 VSS.n1395 184.286
R1883 VSS.n1420 VSS.t919 184.286
R1884 VSS.t921 VSS.n1388 184.286
R1885 VSS.n2234 VSS.n2233 180.287
R1886 VSS.t1078 VSS.n1562 179.167
R1887 VSS.n1085 VSS.t743 179.167
R1888 VSS.n1243 VSS.t797 179.167
R1889 VSS.t835 VSS.n1265 179.167
R1890 VSS.t908 VSS.n1374 179.167
R1891 VSS.n1650 VSS.t951 179.167
R1892 VSS.t1262 VSS.t638 177.45
R1893 VSS.n670 VSS.n1 178.216
R1894 VSS.t891 VSS.t1251 176.219
R1895 VSS.t924 VSS.n1667 176.219
R1896 VSS.t1001 VSS.n1629 176.219
R1897 VSS.t752 VSS.n1110 175.714
R1898 VSS.t801 VSS.n1226 175.714
R1899 VSS.t804 VSS.n1224 175.714
R1900 VSS.t806 VSS.n1223 175.714
R1901 VSS.t808 VSS.n1222 175.714
R1902 VSS.t810 VSS.n1221 175.714
R1903 VSS.t812 VSS.n1220 175.714
R1904 VSS.t814 VSS.n1219 175.714
R1905 VSS.n1161 VSS.t862 175.714
R1906 VSS.t848 VSS.n1155 175.714
R1907 VSS.n1169 VSS.t850 175.714
R1908 VSS.t853 VSS.n1151 175.714
R1909 VSS.n1173 VSS.t856 175.714
R1910 VSS.t869 VSS.n1145 175.714
R1911 VSS.t871 VSS.n1144 175.714
R1912 VSS.t875 VSS.n1138 175.714
R1913 VSS.n1187 VSS.t879 175.714
R1914 VSS.t882 VSS.n1331 175.714
R1915 VSS.t916 VSS.n1396 175.714
R1916 VSS.n1419 VSS.t918 175.714
R1917 VSS.t932 VSS.n1387 175.714
R1918 VSS.t949 VSS.t249 175.714
R1919 VSS.t1003 VSS.n1624 175.714
R1920 VSS.t1260 VSS.t185 175
R1921 VSS.t1231 VSS.t112 175
R1922 VSS.t226 VSS.n1279 174.325
R1923 VSS.t292 VSS.t641 171.875
R1924 VSS.t526 VSS.t1173 171.429
R1925 VSS.t408 VSS.t1003 171.429
R1926 VSS.t744 VSS.n1082 170.833
R1927 VSS.n1721 VSS.n1720 170.833
R1928 VSS.n1372 VSS.t905 170.833
R1929 VSS.t659 VSS.n1692 169.989
R1930 VSS.n1698 VSS.t50 169.989
R1931 VSS.n507 VSS.t388 169.989
R1932 VSS.n2236 VSS.n2235 169.101
R1933 VSS.t493 VSS.n1270 168.103
R1934 VSS.t354 VSS.t877 167.143
R1935 VSS.n1702 VSS.t1194 167.143
R1936 VSS.t64 VSS.n1400 167.143
R1937 VSS.n1567 VSS.t1145 166.667
R1938 VSS.n1082 VSS.t464 166.667
R1939 VSS.t1261 VSS.n1216 166.667
R1940 VSS.n1264 VSS.t524 166.667
R1941 VSS.n1301 VSS.t4 166.667
R1942 VSS.n1709 VSS.t273 166.667
R1943 VSS.n1720 VSS.t306 166.667
R1944 VSS.n1723 VSS.t1231 166.667
R1945 VSS.t1269 VSS.n1347 166.667
R1946 VSS.t201 VSS.n1357 166.667
R1947 VSS.t299 VSS.n1373 166.667
R1948 VSS.n1672 VSS.t710 166.667
R1949 VSS.t622 VSS.n1430 166.667
R1950 VSS.n1613 VSS.t1186 166.667
R1951 VSS.n1633 VSS.t520 166.667
R1952 VSS.n1599 VSS.t606 166.667
R1953 VSS.n1061 VSS.t467 166.667
R1954 VSS.t608 VSS.n1561 165.669
R1955 VSS.n1081 VSS.t745 165.669
R1956 VSS.t837 VSS.n404 165.669
R1957 VSS.t153 VSS.n1317 165.669
R1958 VSS.n2468 VSS.n4 164.373
R1959 VSS.t873 VSS.t167 162.857
R1960 VSS.t1133 VSS.t259 162.5
R1961 VSS.n1277 VSS.t683 162.162
R1962 VSS.t1287 VSS.t689 158.571
R1963 VSS.n2230 VSS.n320 158.077
R1964 VSS.n1856 VSS.n1754 158.077
R1965 VSS.n2158 VSS.n1752 158.077
R1966 VSS.n1784 VSS.n1750 158.077
R1967 VSS.n2105 VSS.n2104 158.077
R1968 VSS.n1975 VSS.n1919 158.077
R1969 VSS.n1083 VSS.t191 157.335
R1970 VSS.n349 VSS.t636 157.335
R1971 VSS.n1302 VSS.t24 157.335
R1972 VSS.n1710 VSS.t1250 157.335
R1973 VSS.t185 VSS.n1722 157.335
R1974 VSS.t320 VSS.n1356 157.335
R1975 VSS.n1673 VSS.t471 157.335
R1976 VSS.n1634 VSS.t204 157.335
R1977 VSS.n1600 VSS.t1133 157.335
R1978 VSS.n1072 VSS.t1148 157.335
R1979 VSS.t80 VSS.n1060 157.335
R1980 VSS.t74 VSS.t1227 156.25
R1981 VSS.t568 VSS.n1206 154.286
R1982 VSS.n1257 VSS.t217 154.286
R1983 VSS.t1225 VSS.n1203 154.286
R1984 VSS.t110 VSS.n1157 154.286
R1985 VSS.n1165 VSS.t489 154.286
R1986 VSS.n1173 VSS.t312 154.286
R1987 VSS.t689 VSS.n1130 154.286
R1988 VSS.n1192 VSS.t496 154.286
R1989 VSS.n1332 VSS.t567 154.286
R1990 VSS.t429 VSS.n1327 154.286
R1991 VSS.t346 VSS.n1433 154.286
R1992 VSS.n1649 VSS.t61 154.286
R1993 VSS.n2074 VSS.n1765 154.186
R1994 VSS.n1564 VSS.t452 154.167
R1995 VSS.t124 VSS.n1086 154.167
R1996 VSS.t134 VSS.n1244 154.167
R1997 VSS.n1266 VSS.t119 154.167
R1998 VSS.t538 VSS.n1325 154.167
R1999 VSS.n1715 VSS.t541 154.167
R2000 VSS.t552 VSS.n1320 154.167
R2001 VSS.n1343 VSS.t458 154.167
R2002 VSS.n1363 VSS.t247 154.167
R2003 VSS.n1676 VSS.t1239 154.167
R2004 VSS.t1241 VSS.n1651 154.167
R2005 VSS.t1207 VSS.n1618 154.167
R2006 VSS.t603 VSS.n1637 154.167
R2007 VSS.t1308 VSS.n1604 154.167
R2008 VSS.t1305 VSS.n1048 154.167
R2009 VSS.n1079 VSS.t527 153.243
R2010 VSS.n350 VSS.t282 153.243
R2011 VSS.n405 VSS.t442 153.243
R2012 VSS.n1668 VSS.t447 153.243
R2013 VSS.n1610 VSS.t707 153.243
R2014 VSS.n2208 VSS.n242 151.203
R2015 VSS.t4 VSS.t1153 150
R2016 VSS.t106 VSS.t201 150
R2017 VSS.t909 VSS.n1375 150
R2018 VSS.t1298 VSS.n1428 150
R2019 VSS.t1311 VSS.t630 150
R2020 VSS.t467 VSS.t1249 150
R2021 VSS.n712 VSS.n669 149.077
R2022 VSS.n2050 VSS.n2049 146.728
R2023 VSS.n2048 VSS.n2047 146.728
R2024 VSS.n1276 VSS.n1275 145.946
R2025 VSS.n1426 VSS.t641 145.946
R2026 VSS.t36 VSS.t607 143.763
R2027 VSS.t607 VSS.t21 143.763
R2028 VSS.t21 VSS.t369 143.763
R2029 VSS.t369 VSS.t14 143.763
R2030 VSS.t14 VSS.n1748 143.763
R2031 VSS.n1748 VSS.n1747 143.763
R2032 VSS.n1747 VSS.n1746 143.763
R2033 VSS.n1746 VSS.t60 143.763
R2034 VSS.t60 VSS.n1745 143.763
R2035 VSS.n1745 VSS.t125 143.763
R2036 VSS.t1253 VSS.n1566 141.667
R2037 VSS.n1268 VSS.t1293 141.667
R2038 VSS.t525 VSS.t132 141.667
R2039 VSS.t242 VSS.t1270 141.667
R2040 VSS.t8 VSS.n1372 141.667
R2041 VSS.n1659 VSS.t670 141.667
R2042 VSS.n1614 VSS.t18 141.667
R2043 VSS.t450 VSS.t1146 141.667
R2044 VSS.t439 VSS.t878 141.429
R2045 VSS.t1164 VSS.t1169 141.429
R2046 VSS.n748 VSS.n668 139.846
R2047 VSS.n1272 VSS.t556 137.931
R2048 VSS.n1271 VSS.t493 137.931
R2049 VSS.n2440 VSS.n2439 137.845
R2050 VSS.n1280 VSS.t226 137.839
R2051 VSS.n1278 VSS.t684 137.839
R2052 VSS.n1664 VSS.t586 137.839
R2053 VSS.n1297 VSS.t445 137.536
R2054 VSS.t286 VSS.n1324 137.536
R2055 VSS.t528 VSS.n1361 137.536
R2056 VSS.n1629 VSS.t558 137.536
R2057 VSS.n1596 VSS.t53 137.536
R2058 VSS.n1594 VSS.t444 137.536
R2059 VSS.n1069 VSS.t291 137.536
R2060 VSS.t555 VSS.n1052 137.536
R2061 VSS.t345 VSS.n1054 137.536
R2062 VSS.n2456 VSS.n198 136.364
R2063 VSS.n983 VSS.n982 136.364
R2064 VSS.n993 VSS.n991 136.364
R2065 VSS.n50 VSS.n1007 135.126
R2066 VSS.n830 VSS.n677 133.846
R2067 VSS.n803 VSS.n676 133.846
R2068 VSS.n755 VSS.n675 133.846
R2069 VSS.n727 VSS.n674 133.846
R2070 VSS.n695 VSS.n673 133.846
R2071 VSS.n2478 VSS.n664 133.846
R2072 VSS.n2404 VSS.n672 133.846
R2073 VSS.n1249 VSS.t446 133.706
R2074 VSS.n1656 VSS.t339 132.857
R2075 VSS.t544 VSS.n1654 132.857
R2076 VSS.n775 VSS.n667 130.615
R2077 VSS.t3 VSS.t1187 129.167
R2078 VSS.t67 VSS.t913 128.571
R2079 VSS.n2294 VSS.n2293 128.084
R2080 VSS.n2231 VSS.n915 128.084
R2081 VSS.n2233 VSS.n2232 128.084
R2082 VSS.n2235 VSS.n2234 128.084
R2083 VSS.n2237 VSS.n2236 128.084
R2084 VSS.n1765 VSS.n1749 128.084
R2085 VSS.n2074 VSS.n2050 128.084
R2086 VSS.n2049 VSS.n2048 128.084
R2087 VSS.t647 VSS.n1329 124.287
R2088 VSS.n1415 VSS.t1220 124.287
R2089 VSS.n541 VSS.t251 122.564
R2090 VSS.t675 VSS.n1284 121.496
R2091 VSS.n847 VSS.n665 121.385
R2092 VSS.n824 VSS.n666 121.385
R2093 VSS.t634 VSS.n1157 120.001
R2094 VSS.n1165 VSS.t577 120.001
R2095 VSS.t378 VSS.n1148 120.001
R2096 VSS.t651 VSS.n1689 120.001
R2097 VSS.n1695 VSS.t262 120.001
R2098 VSS.t617 VSS.n1695 120.001
R2099 VSS.n1648 VSS.t526 120.001
R2100 VSS.t1173 VSS.n1432 120.001
R2101 VSS.t1192 VSS.n1083 119.835
R2102 VSS.n349 VSS.t676 119.835
R2103 VSS.t1136 VSS.n1710 119.835
R2104 VSS.n1722 VSS.t1286 119.835
R2105 VSS.t288 VSS.n1673 119.835
R2106 VSS.t1191 VSS.n1600 119.835
R2107 VSS.t1199 VSS.n1072 119.835
R2108 VSS.n1663 VSS.n1427 117.569
R2109 VSS.t694 VSS.n477 116.987
R2110 VSS.n2238 VSS.n1749 115.594
R2111 VSS.t36 VSS.n2238 110.484
R2112 VSS.n1594 VSS.t466 107.451
R2113 VSS.t704 VSS.n1051 107.451
R2114 VSS.t614 VSS.n1054 107.451
R2115 VSS.t170 VSS.n1087 107.144
R2116 VSS.n1253 VSS.t632 107.144
R2117 VSS.t414 VSS.n1245 107.144
R2118 VSS.t153 VSS.n1316 107.144
R2119 VSS.n1706 VSS.t94 107.144
R2120 VSS.t909 VSS.n1370 107.144
R2121 VSS.t1176 VSS.n1385 107.144
R2122 VSS.n1657 VSS.t1243 107.144
R2123 VSS.t480 VSS.n1652 107.144
R2124 VSS.t1002 VSS.n1627 107.144
R2125 VSS.t682 VSS.n1619 107.144
R2126 VSS.t460 VSS.t637 104.457
R2127 VSS.n1213 VSS.n1212 104.457
R2128 VSS.t1258 VSS.n1562 104.168
R2129 VSS.t93 VSS.n1265 104.168
R2130 VSS.n1716 VSS.t357 104.168
R2131 VSS.n1345 VSS.t255 104.168
R2132 VSS.n1371 VSS.t151 104.168
R2133 VSS.n1658 VSS.t1292 104.168
R2134 VSS.t358 VSS.n1615 104.168
R2135 VSS.n1256 VSS.t1165 102.858
R2136 VSS.t1166 VSS.n1205 102.858
R2137 VSS.n1131 VSS.t502 102.858
R2138 VSS.t1171 VSS.n1127 102.858
R2139 VSS.n1195 VSS.t1170 102.858
R2140 VSS.t964 VSS.t522 102.858
R2141 VSS.t342 VSS.n1281 101.352
R2142 VSS.t1180 VSS.n1280 101.352
R2143 VSS.t630 VSS.n1427 101.352
R2144 VSS.t1300 VSS.t1311 101.352
R2145 VSS.t447 VSS.t924 98.8544
R2146 VSS.t404 VSS.t708 98.8544
R2147 VSS.n1429 VSS.t221 98.8544
R2148 VSS.t430 VSS.n1611 98.8544
R2149 VSS.n1110 VSS.t691 98.5719
R2150 VSS.n1259 VSS.t503 98.5719
R2151 VSS.n1228 VSS.t332 98.5719
R2152 VSS.n1187 VSS.t220 98.5719
R2153 VSS.t258 VSS.n1132 98.5719
R2154 VSS.n1190 VSS.t1287 98.5719
R2155 VSS.n1191 VSS.t98 98.5719
R2156 VSS.n1732 VSS.t652 98.5719
R2157 VSS.t505 VSS.n1124 98.5719
R2158 VSS.n1734 VSS.t330 98.5719
R2159 VSS.n1685 VSS.t1276 98.5719
R2160 VSS.t168 VSS.n1369 98.5719
R2161 VSS.t463 VSS.n1366 98.5719
R2162 VSS.t381 VSS.n1365 98.5719
R2163 VSS.n427 VSS.t529 97.755
R2164 VSS.t522 VSS.n511 97.755
R2165 VSS.t338 VSS.n1399 97.1319
R2166 VSS.n2485 VSS.n2484 96.9574
R2167 VSS.t680 VSS.n1614 95.8338
R2168 VSS.t1266 VSS.n1635 95.8338
R2169 VSS.t465 VSS.n1602 95.8338
R2170 VSS.t259 VSS.n1599 95.8338
R2171 VSS.n1071 VSS.t1206 95.8338
R2172 VSS.t115 VSS.n1048 95.8338
R2173 VSS.t518 VSS.t714 94.5564
R2174 VSS.t57 VSS.t56 94.5564
R2175 VSS.n2042 VSS.n2019 94.5022
R2176 VSS.n346 VSS.t76 93.4693
R2177 VSS.n1128 VSS.t435 92.8462
R2178 VSS.t474 VSS.n1193 92.8462
R2179 VSS.t304 VSS.n1725 92.8462
R2180 VSS.n2226 VSS.n2214 91.9249
R2181 VSS.n1827 VSS.n1755 91.9249
R2182 VSS.n2120 VSS.n1753 91.9249
R2183 VSS.n2169 VSS.n1751 91.9249
R2184 VSS.n2197 VSS.n2196 91.9249
R2185 VSS.n2100 VSS.n2099 91.9249
R2186 VSS.n1915 VSS.n1876 91.9249
R2187 VSS.n1992 VSS.n1920 91.9249
R2188 VSS.n2369 VSS.n671 91.9249
R2189 VSS.t420 VSS.t84 91.6672
R2190 VSS.t640 VSS.t1188 91.6672
R2191 VSS.n1361 VSS.t233 90.2584
R2192 VSS.n1254 VSS.t530 90.0005
R2193 VSS.t147 VSS.t1168 90.0005
R2194 VSS.t229 VSS.n1292 90.0005
R2195 VSS.t232 VSS.n1142 90.0005
R2196 VSS.t551 VSS.n1315 90.0005
R2197 VSS.t574 VSS.t624 90.0005
R2198 VSS.t241 VSS.n1368 90.0005
R2199 VSS.n1624 VSS.t43 90.0005
R2200 VSS.n1166 VSS.t1161 89.1846
R2201 VSS.n1705 VSS.t626 89.1846
R2202 VSS.t144 VSS.n1158 89.1836
R2203 VSS.t477 VSS.n1147 88.5605
R2204 VSS.t167 VSS.n1179 88.5605
R2205 VSS.t1213 VSS.n509 88.5605
R2206 VSS.t328 VSS.n506 88.5605
R2207 VSS.n505 VSS.t1228 88.5605
R2208 VSS.t191 VSS.t744 87.5005
R2209 VSS.n1721 VSS.t459 87.5005
R2210 VSS.n1344 VSS.t271 87.1423
R2211 VSS.n1073 VSS.t1275 87.1413
R2212 VSS.n1305 VSS.t301 86.5025
R2213 VSS.n418 VSS.t1144 86.5025
R2214 VSS.t724 VSS.n1341 86.5025
R2215 VSS.t411 VSS.n1636 86.5025
R2216 VSS.t195 VSS.n1057 86.5025
R2217 VSS.t1132 VSS.n1210 85.9604
R2218 VSS.n1255 VSS.t565 85.7148
R2219 VSS.t479 VSS.n1288 85.7148
R2220 VSS.t589 VSS.n1314 85.7148
R2221 VSS.t298 VSS.n1367 85.7148
R2222 VSS.t1234 VSS.n1621 85.7148
R2223 VSS.n822 VSS.n677 84.9236
R2224 VSS.n782 VSS.n676 84.9236
R2225 VSS.n747 VSS.n675 84.9236
R2226 VSS.n711 VSS.n674 84.9236
R2227 VSS.n102 VSS.n672 84.9236
R2228 VSS.t198 VSS.n1282 84.5541
R2229 VSS.t1153 VSS.n1300 83.3338
R2230 VSS.n1723 VSS.t1260 83.3338
R2231 VSS.n1358 VSS.t106 83.3338
R2232 VSS.t1249 VSS.n1055 83.3338
R2233 VSS.t547 VSS.t278 81.6624
R2234 VSS.t427 VSS.n1718 81.6624
R2235 VSS.t376 VSS.t1147 81.6624
R2236 VSS.n1247 VSS.t1318 81.4291
R2237 VSS.t1284 VSS.n1159 81.4291
R2238 VSS.n1177 VSS.t1297 81.4291
R2239 VSS.t580 VSS.n1701 81.4291
R2240 VSS.n1413 VSS.t1221 81.4291
R2241 VSS.t1212 VSS.n1398 81.4291
R2242 VSS.n1416 VSS.t693 81.4291
R2243 VSS.t281 VSS.n1393 81.4291
R2244 VSS.t101 VSS.n1392 81.4291
R2245 VSS.t441 VSS.n1391 81.4291
R2246 VSS.t349 VSS.n1435 81.4291
R2247 VSS.t129 VSS.t492 81.0816
R2248 VSS.t6 VSS.n347 80.6121
R2249 VSS.n1625 VSS.t408 80.6121
R2250 VSS.n1179 VSS.t45 79.9891
R2251 VSS.n2291 VSS.n2278 79.7787
R2252 VSS.t715 VSS.n1346 79.1672
R2253 VSS.n1670 VSS.t1159 79.1672
R2254 VSS.n2415 VSS.n2355 79.0383
R2255 VSS.t359 VSS.n1297 77.3644
R2256 VSS.t486 VSS.t174 77.3644
R2257 VSS.t413 VSS.n1207 77.1434
R2258 VSS.t385 VSS.n1204 77.1434
R2259 VSS.n1189 VSS.t655 77.1434
R2260 VSS.n1365 VSS.t89 77.1434
R2261 VSS.t63 VSS.n1400 77.1434
R2262 VSS.t337 VSS.n1386 77.1434
R2263 VSS.n1647 VSS.t197 77.1434
R2264 VSS.n1279 VSS.n1278 77.0275
R2265 VSS.t275 VSS.t276 75.4129
R2266 VSS.n1717 VSS.t640 75.0005
R2267 VSS.t1174 VSS.n1299 74.0263
R2268 VSS.n1359 VSS.t374 74.0263
R2269 VSS.n1062 VSS.t1210 74.0263
R2270 VSS.t112 VSS.n1317 74.0025
R2271 VSS.n865 VSS.n864 73.9291
R2272 VSS.n1290 VSS.t1215 72.8576
R2273 VSS.n1691 VSS.t34 72.8576
R2274 VSS.t1229 VSS.n1693 72.8576
R2275 VSS.n1697 VSS.t673 72.8576
R2276 VSS.t66 VSS.n1403 72.0655
R2277 VSS.n2250 VSS.n1015 72.0543
R2278 VSS.t478 VSS.n1289 72.0417
R2279 VSS.n1404 VSS.t67 72.0407
R2280 VSS.n414 VSS.t547 71.5807
R2281 VSS.n1727 VSS.t588 71.4177
R2282 VSS.n1407 VSS.t545 71.4177
R2283 VSS.n508 VSS.t1158 71.4177
R2284 VSS.t1233 VSS.n1623 71.4177
R2285 VSS.n1249 VSS.t643 71.0311
R2286 VSS.n1565 VSS.t22 70.8338
R2287 VSS.t329 VSS.n1085 70.8338
R2288 VSS.t256 VSS.n1243 70.8338
R2289 VSS.n1267 VSS.t1264 70.8338
R2290 VSS.t253 VSS.n1322 70.8338
R2291 VSS.t1135 VSS.n1319 70.8338
R2292 VSS.n1364 VSS.t398 70.8338
R2293 VSS.t343 VSS.n1675 70.8338
R2294 VSS.t582 VSS.n1650 70.8338
R2295 VSS.t566 VSS.n1617 70.8338
R2296 VSS.t417 VSS.n1603 70.8338
R2297 VSS.t121 VSS.t37 70.1247
R2298 VSS.t1152 VSS.n1302 69.8359
R2299 VSS.n1356 VSS.t105 69.8359
R2300 VSS.n1060 VSS.t1248 69.8359
R2301 VSS.t492 VSS.n1283 68.9194
R2302 VSS.n1662 VSS.t218 68.9194
R2303 VSS.t746 VSS.t41 68.7684
R2304 VSS.t742 VSS.t170 68.5719
R2305 VSS.t796 VSS.t414 68.5719
R2306 VSS.t950 VSS.t480 68.5719
R2307 VSS.t192 VSS.n1079 67.2827
R2308 VSS.t1141 VSS.n350 67.2827
R2309 VSS.t1294 VSS.n405 67.2827
R2310 VSS.n414 VSS.t421 67.2827
R2311 VSS.t472 VSS.n1668 67.2827
R2312 VSS.t671 VSS.n514 67.2827
R2313 VSS.t418 VSS.t460 66.8529
R2314 VSS.t179 VSS.t452 66.6672
R2315 VSS.t224 VSS.t119 66.6672
R2316 VSS.n1307 VSS.t132 66.6672
R2317 VSS.t885 VSS.t538 66.6672
R2318 VSS.t541 VSS.t30 66.6672
R2319 VSS.n1719 VSS.t552 66.6672
R2320 VSS.t103 VSS.t458 66.6672
R2321 VSS.n1353 VSS.t242 66.6672
R2322 VSS.t202 VSS.t247 66.6672
R2323 VSS.t0 VSS.t603 66.6672
R2324 VSS.t618 VSS.t1157 66.6672
R2325 VSS.t176 VSS.t1308 66.6672
R2326 VSS.t36 VSS.t1305 66.6672
R2327 VSS.n1569 VSS.t450 66.6672
R2328 VSS.t140 VSS.t129 64.8654
R2329 VSS.t1227 VSS.t1298 64.8654
R2330 VSS.n1362 VSS.t562 64.4704
R2331 VSS.t268 VSS.n1291 64.2862
R2332 VSS.n1291 VSS.t423 64.2862
R2333 VSS.n1726 VSS.t364 64.2862
R2334 VSS.t719 VSS.t551 64.2862
R2335 VSS.n1378 VSS.t723 64.2862
R2336 VSS.t273 VSS.t888 62.5005
R2337 VSS.t306 VSS.n1319 62.5005
R2338 VSS.t667 VSS.t715 62.5005
R2339 VSS.n1212 VSS.n1211 60.9987
R2340 VSS.n2295 VSS.n897 60.9641
R2341 VSS.t211 VSS.n1052 60.1724
R2342 VSS.t1142 VSS.n1209 60.0005
R2343 VSS.t108 VSS.n1207 60.0005
R2344 VSS.t27 VSS.n1294 60.0005
R2345 VSS.t1203 VSS.n1287 60.0005
R2346 VSS.n1724 VSS.t188 60.0005
R2347 VSS.n1729 VSS.t1279 60.0005
R2348 VSS.n1376 VSS.t11 60.0005
R2349 VSS.n1380 VSS.t78 60.0005
R2350 VSS.t207 VSS.n1626 60.0005
R2351 VSS.t269 VSS.n1620 60.0005
R2352 VSS.t636 VSS.t798 58.3338
R2353 VSS.t670 VSS.t953 58.3338
R2354 VSS.n1252 VSS.t1131 55.8744
R2355 VSS.n62 VSS.t512 55.7148
R2356 VSS.t510 VSS.n62 55.7148
R2357 VSS.n1248 VSS.t171 55.7148
R2358 VSS.n1162 VSS.t335 55.7148
R2359 VSS.t677 VSS.n1144 55.7148
R2360 VSS.t28 VSS.n1330 55.7148
R2361 VSS.n1379 VSS.t297 55.7148
R2362 VSS.t722 VSS.n1396 55.7148
R2363 VSS.n1418 VSS.t573 55.7148
R2364 VSS.n1420 VSS.t1178 55.7148
R2365 VSS.t250 VSS.n1136 54.9227
R2366 VSS.n514 VSS.t404 54.3887
R2367 VSS.t32 VSS.n1610 54.3887
R2368 VSS.n1111 VSS.t39 54.2748
R2369 VSS.t432 VSS.n345 54.2748
R2370 VSS.t402 VSS.n1128 54.2748
R2371 VSS.t416 VSS.n1076 54.2748
R2372 VSS.t382 VSS.n1684 54.2748
R2373 VSS.n439 VSS.t1151 54.2748
R2374 VSS.t644 VSS.n438 54.2748
R2375 VSS.t1259 VSS.n1318 54.1672
R2376 VSS.t572 VSS.n1345 54.1672
R2377 VSS.n1671 VSS.t1175 54.1672
R2378 VSS.t1150 VSS.n1598 53.8094
R2379 VSS.t456 VSS.n1344 53.8079
R2380 VSS.n1563 VSS.t454 53.1692
R2381 VSS.n1084 VSS.t117 53.1692
R2382 VSS.n401 VSS.t141 53.1692
R2383 VSS.t540 VSS.n415 53.1692
R2384 VSS.t245 VSS.n434 53.1692
R2385 VSS.n1674 VSS.t1240 53.1692
R2386 VSS.n1616 VSS.t1209 53.1692
R2387 VSS.t1157 VSS.n1634 53.1692
R2388 VSS.n2293 VSS.n916 53.1362
R2389 VSS.n1282 VSS.t143 52.1217
R2390 VSS.n477 VSS.t1300 52.1217
R2391 VSS.t227 VSS.n1273 51.7246
R2392 VSS.t685 VSS.n1272 51.7246
R2393 VSS.t25 VSS.n1298 51.5764
R2394 VSS.t336 VSS.n1296 51.5764
R2395 VSS.t1251 VSS.n1707 51.5764
R2396 VSS.n1350 VSS.t668 51.5764
R2397 VSS.n1360 VSS.t321 51.5764
R2398 VSS.t205 VSS.n1630 51.5764
R2399 VSS.t1134 VSS.n1597 51.5764
R2400 VSS.t174 VSS.n1592 51.5764
R2401 VSS.t1147 VSS.n1050 51.5764
R2402 VSS.n1066 VSS.t661 51.5764
R2403 VSS.n1063 VSS.t81 51.5764
R2404 VSS.t726 VSS.t754 51.4291
R2405 VSS.t728 VSS.t756 51.4291
R2406 VSS.t731 VSS.t758 51.4291
R2407 VSS.t733 VSS.t760 51.4291
R2408 VSS.t735 VSS.t762 51.4291
R2409 VSS.t738 VSS.t764 51.4291
R2410 VSS.t438 VSS.n1286 51.4291
R2411 VSS.n1381 VSS.t1271 51.4291
R2412 VSS.n1414 VSS.t1222 51.4291
R2413 VSS.n1422 VSS.t713 51.4291
R2414 VSS.t266 VSS.n1434 51.4291
R2415 VSS.t637 VSS.n1215 50.1398
R2416 VSS.t138 VSS.t142 50.0005
R2417 VSS.t488 VSS.t1152 50.0005
R2418 VSS.t84 VSS.n1321 50.0005
R2419 VSS.t494 VSS.t244 50.0005
R2420 VSS.t105 VSS.t196 50.0005
R2421 VSS.t453 VSS.t451 50.0005
R2422 VSS.t1248 VSS.t294 50.0005
R2423 VSS.n837 VSS.n665 49.3851
R2424 VSS.n794 VSS.n666 49.3851
R2425 VSS.n762 VSS.n667 49.3851
R2426 VSS.n718 VSS.n668 49.3851
R2427 VSS.n687 VSS.n669 49.3851
R2428 VSS.n2469 VSS.n2468 49.3851
R2429 VSS.n2395 VSS.n670 49.3851
R2430 VSS.n2484 VSS.n2483 47.7744
R2431 VSS.t653 VSS.t1134 47.2784
R2432 VSS.n1064 VSS.t345 47.2784
R2433 VSS.t409 VSS.n1327 47.1434
R2434 VSS.n2238 VSS.n2237 46.0511
R2435 VSS.n1692 VSS.t403 45.7034
R2436 VSS.t543 VSS.n1698 45.7034
R2437 VSS.t249 VSS.n507 45.7034
R2438 VSS.n1065 VSS.t100 45.021
R2439 VSS.n1306 VSS.n1305 44.8359
R2440 VSS.n1354 VSS.n1341 44.8359
R2441 VSS.n1568 VSS.n1057 44.8359
R2442 VSS.t1288 VSS.n1663 44.5951
R2443 VSS.t714 VSS.n1351 42.9804
R2444 VSS.t564 VSS.t1224 42.8576
R2445 VSS.n1182 VSS.t360 42.8576
R2446 VSS.n1186 VSS.t439 42.8576
R2447 VSS.t646 VSS.n1133 42.8576
R2448 VSS.n1729 VSS.t1272 42.8576
R2449 VSS.t1195 VSS.n1285 42.0417
R2450 VSS.t639 VSS.n1322 41.6672
R2451 VSS.t295 VSS.n439 41.4177
R2452 VSS.n509 VSS.t440 41.4177
R2453 VSS.t82 VSS.n1064 41.194
R2454 VSS.n1005 VSS.n42 40.111
R2455 VSS.n2444 VSS.n660 39.4956
R2456 VSS.t712 VSS.n1596 38.6824
R2457 VSS.t352 VSS.n1226 38.5719
R2458 VSS.n1188 VSS.t380 38.5719
R2459 VSS.t611 VSS.n1129 38.5719
R2460 VSS.n1732 VSS.t550 38.5719
R2461 VSS.t581 VSS.n1124 38.5719
R2462 VSS.t364 VSS.t86 38.5719
R2463 VSS.n1378 VSS.t1190 38.5719
R2464 VSS.t145 VSS.t349 38.5719
R2465 VSS.n1454 VSS.n1448 38.4686
R2466 VSS.n1450 VSS.n1448 38.4686
R2467 VSS.n1534 VSS.n1533 38.4686
R2468 VSS.n1533 VSS.n1452 38.4686
R2469 VSS.n1463 VSS.n1462 38.4686
R2470 VSS.n1466 VSS.n1463 38.4686
R2471 VSS.n1510 VSS.n1509 38.4686
R2472 VSS.n1510 VSS.n612 38.4686
R2473 VSS.n2521 VSS.n2520 38.4686
R2474 VSS.n2520 VSS.n632 38.4686
R2475 VSS.n2246 VSS.n640 38.4686
R2476 VSS.n2244 VSS.n2243 38.4686
R2477 VSS.n2243 VSS.n1021 38.4686
R2478 VSS.n1031 VSS.n1030 38.4686
R2479 VSS.t130 VSS.n1217 37.5005
R2480 VSS.n1303 VSS.t138 37.5005
R2481 VSS.n1711 VSS.t536 37.5005
R2482 VSS.t553 VSS.n1318 37.5005
R2483 VSS.t244 VSS.n1355 37.5005
R2484 VSS.n489 VSS.t1242 53.1692
R2485 VSS.t1280 VSS.n1613 37.5005
R2486 VSS.n1635 VSS.t604 37.5005
R2487 VSS.t267 VSS.n1601 37.5005
R2488 VSS.n1601 VSS.t1309 37.5005
R2489 VSS.t1187 VSS.n1049 37.5005
R2490 VSS.t451 VSS.n1056 37.5005
R2491 VSS.n428 VSS.t425 37.1319
R2492 VSS.n1281 VSS.t127 36.487
R2493 VSS.n1662 VSS.t1247 36.487
R2494 VSS.n348 VSS.t418 35.9683
R2495 VSS.t661 VSS.t625 34.3845
R2496 VSS.n1034 VSS.t705 34.054
R2497 VSS.n1523 VSS.n1488 34.0298
R2498 VSS.n1035 VSS.t375 33.4198
R2499 VSS.n1306 VSS.t619 33.3338
R2500 VSS.t656 VSS.n1354 33.3338
R2501 VSS.t350 VSS.t1307 33.3338
R2502 VSS.n1568 VSS.t16 33.3338
R2503 VSS.t69 VSS.n1185 32.8462
R2504 VSS.n1134 VSS.t70 32.8462
R2505 VSS.n2161 VSS.n2137 31.3579
R2506 VSS.n1270 VSS.n1077 31.2505
R2507 VSS.n1031 VSS.t1156 31.1763
R2508 VSS.n2170 VSS.n2169 30.9283
R2509 VSS.n1993 VSS.n1992 30.9283
R2510 VSS.t276 VSS.t1289 30.6368
R2511 VSS.n1821 VSS.n1798 30.4988
R2512 VSS.n2019 VSS.n1933 30.4988
R2513 VSS.n2031 VSS.n1921 30.4988
R2514 VSS.n1540 VSS.n1446 30.438
R2515 VSS.n2195 VSS.n1777 30.0692
R2516 VSS.n113 VSS.n2366 18.1082
R2517 VSS.n1163 VSS.t326 30.0005
R2518 VSS.t1283 VSS.n1156 30.0005
R2519 VSS.t557 VSS.n1150 30.0005
R2520 VSS.n1685 VSS.t239 30.0005
R2521 VSS.n1703 VSS.t361 30.0005
R2522 VSS.n1704 VSS.t574 30.0005
R2523 VSS.n1647 VSS.t1198 30.0005
R2524 VSS.n1431 VSS.t213 30.0005
R2525 VSS.n1457 VSS.n1455 29.591
R2526 VSS.n2248 VSS.n2247 29.591
R2527 VSS.n1975 VSS.n1963 29.2101
R2528 VSS.n347 VSS.t1143 29.1846
R2529 VSS.t521 VSS.n1625 29.1846
R2530 VSS.t1224 VSS.n351 28.5605
R2531 VSS.n351 VSS.t148 28.5605
R2532 VSS.n1725 VSS.t1232 28.5605
R2533 VSS.t88 VSS.n1312 28.5605
R2534 VSS.n1312 VSS.t720 28.5605
R2535 VSS.t497 VSS.n440 28.5605
R2536 VSS.n440 VSS.t90 28.5605
R2537 VSS.t265 VSS.n1394 28.5605
R2538 VSS.n1394 VSS.t1304 28.5605
R2539 VSS.t37 VSS.t1291 28.4884
R2540 VSS.n2527 VSS.n628 28.3228
R2541 VSS.t695 VSS.n1028 27.5845
R2542 VSS.t410 VSS.n1027 27.5845
R2543 VSS.t397 VSS.n1026 27.5845
R2544 VSS.n1763 VSS.n1762 27.4919
R2545 VSS.t509 VSS.n859 26.9901
R2546 VSS.n859 VSS.t507 26.9901
R2547 VSS.t164 VSS.n2372 26.9901
R2548 VSS.t163 VSS.n2372 26.9901
R2549 VSS.n1460 VSS.n1459 26.6333
R2550 VSS.n2461 VSS.n869 26.07
R2551 VSS.t579 VSS.n1295 25.7148
R2552 VSS.t1235 VSS.n1412 25.7148
R2553 VSS.n1423 VSS.t405 25.7148
R2554 VSS.n1036 VSS.t690 25.0481
R2555 VSS.n1716 VSS.t629 25.0005
R2556 VSS.n2046 VSS.n2045 24.9146
R2557 VSS.t1087 VSS.n1449 24.5422
R2558 VSS.t1126 VSS.n1029 24.5422
R2559 VSS.t684 VSS.t1290 24.3248
R2560 VSS.n1185 VSS.t354 24.2748
R2561 VSS.t1185 VSS.n1134 24.2748
R2562 VSS.n2113 VSS.t511 24.1169
R2563 VSS.t189 VSS.n1016 24.0672
R2564 VSS.t1084 VSS.n1449 23.909
R2565 VSS.n1029 VSS.t1123 23.909
R2566 VSS.n2278 VSS.n918 22.8872
R2567 VSS.t162 VSS.n136 22.7668
R2568 VSS.n654 VSS.n651 21.8775
R2569 VSS.n1455 VSS.t1082 21.6646
R2570 VSS.t1092 VSS.n1461 21.6646
R2571 VSS.t1102 VSS.n1488 21.6646
R2572 VSS.t1112 VSS.n628 21.6646
R2573 VSS.t741 VSS.t766 21.4291
R2574 VSS.n2464 VSS.t507 21.3956
R2575 VSS.n2462 VSS.t509 21.3954
R2576 VSS.n2499 VSS.n640 21.3475
R2577 VSS.n2247 VSS.t1119 21.0304
R2578 VSS.n1495 VSS.n1476 20.9263
R2579 VSS.n1073 VSS.t350 20.4756
R2580 VSS.n913 VSS.n903 20.3282
R2581 VSS.n624 VSS.n613 20.2922
R2582 VSS.n2292 VSS.n2291 20.1261
R2583 VSS.n423 VSS.t1205 19.9891
R2584 VSS.t559 VSS.n428 19.9891
R2585 VSS.n1033 VSS.n1032 19.7864
R2586 VSS.n2387 VSS.n2384 19.7269
R2587 VSS.n2315 VSS.n900 19.6529
R2588 VSS.n2379 VSS.n2367 19.3898
R2589 VSS.n1516 VSS.n1515 19.341
R2590 VSS.n1987 VSS.n1986 19.3346
R2591 VSS.n1497 VSS.n1473 19.024
R2592 VSS.n2394 VSS.n2393 18.8341
R2593 VSS.n2407 VSS.n2406 18.8341
R2594 VSS.n2481 VSS.n2480 18.8341
R2595 VSS.n733 VSS.n732 18.8341
R2596 VSS.n2203 VSS.n1769 18.8341
R2597 VSS.n2135 VSS.n2134 18.8341
R2598 VSS.n1845 VSS.n1844 18.8341
R2599 VSS.n2215 VSS.n899 18.8341
R2600 VSS.n2494 VSS.n641 18.7069
R2601 VSS.t600 VSS.n1025 18.7069
R2602 VSS.n699 VSS.n698 18.7057
R2603 VSS.n768 VSS.n767 18.7057
R2604 VSS.n810 VSS.n809 18.7057
R2605 VSS.n843 VSS.n842 18.7057
R2606 VSS.n1912 VSS.n1873 18.7057
R2607 VSS.n2066 VSS.n1874 18.7057
R2608 VSS.n2188 VSS.n2187 18.7057
R2609 VSS.n2315 VSS.n2314 18.7057
R2610 VSS.n2411 VSS.n2408 18.6757
R2611 VSS.n715 VSS.n714 18.6757
R2612 VSS.n751 VSS.n750 18.6757
R2613 VSS.n791 VSS.n790 18.6757
R2614 VSS.n827 VSS.n826 18.6757
R2615 VSS.n845 VSS.n844 18.6757
R2616 VSS.n1986 VSS.n1985 18.6757
R2617 VSS.n2111 VSS.n2110 18.6757
R2618 VSS.n2091 VSS.n2090 18.6757
R2619 VSS.n2190 VSS.n2189 18.6757
R2620 VSS.n2165 VSS.n2164 18.6757
R2621 VSS.n1872 VSS.n1871 18.6757
R2622 VSS.n1825 VSS.n1824 18.6757
R2623 VSS.n2317 VSS.n2316 18.6757
R2624 VSS.n2114 VSS.n2113 18.4647
R2625 VSS.t514 VSS.n2112 18.4647
R2626 VSS.n2384 VSS.n661 18.4647
R2627 VSS.n2483 VSS.n2482 18.4647
R2628 VSS.n2299 VSS.n2295 18.462
R2629 VSS.n1307 VSS.t1139 18.2932
R2630 VSS.n1353 VSS.t1154 18.2932
R2631 VSS.t608 VSS.n1569 18.2932
R2632 VSS.n2249 VSS.n1016 18.2181
R2633 VSS.t512 VSS.n69 18.2148
R2634 VSS.n68 VSS.t510 18.2148
R2635 VSS.t365 VSS.t602 18.1327
R2636 VSS.n1038 VSS.t323 18.1327
R2637 VSS.n1770 VSS.n253 17.968
R2638 VSS.n1834 VSS.n1833 17.4756
R2639 VSS.n2177 VSS.n2176 17.4756
R2640 VSS.n2060 VSS.n2051 17.4756
R2641 VSS.n1917 VSS.n219 17.4756
R2642 VSS.n1996 VSS.n204 17.4756
R2643 VSS.t1079 VSS.n1446 17.4387
R2644 VSS.n1450 VSS.t1084 17.4387
R2645 VSS.t1089 VSS.n1452 17.4387
R2646 VSS.n612 VSS.t1104 17.4387
R2647 VSS.n630 VSS.t1109 17.4387
R2648 VSS.t1114 VSS.n632 17.4387
R2649 VSS.t1119 VSS.n2246 17.4387
R2650 VSS.t1123 VSS.n1021 17.4387
R2651 VSS.n2082 VSS.n2075 17.4176
R2652 VSS.n1858 VSS.n1857 17.3587
R2653 VSS.n1948 VSS.n1944 17.2395
R2654 VSS.t73 VSS.n1350 17.1925
R2655 VSS.t1215 VSS.t136 17.1434
R2656 VSS.t504 VSS.t1203 17.1434
R2657 VSS.t68 VSS.n1141 17.1434
R2658 VSS.t72 VSS.n1314 17.1434
R2659 VSS.n2515 VSS.n652 17.1216
R2660 VSS.n1540 VSS.n1539 17.001
R2661 VSS.n361 VSS.n359 0.649832
R2662 VSS.n493 VSS.n492 0.649832
R2663 VSS.n520 VSS.n519 0.649832
R2664 VSS.n2540 VSS.n2539 17.0005
R2665 VSS.n2540 VSS.n614 17.0005
R2666 VSS.n2517 VSS.n2516 17.0005
R2667 VSS.n648 VSS.n633 17.0005
R2668 VSS.n2492 VSS.n633 17.0005
R2669 VSS.n652 VSS.n633 17.0005
R2670 VSS.n2500 VSS.n633 17.0005
R2671 VSS.n633 VSS.n632 17.0005
R2672 VSS.n2522 VSS.n2521 17.0005
R2673 VSS.n2523 VSS.n2522 17.0005
R2674 VSS.n2522 VSS.n630 17.0005
R2675 VSS.n2540 VSS.n608 17.0005
R2676 VSS.n2540 VSS.n610 17.0005
R2677 VSS.n2540 VSS.n613 17.0005
R2678 VSS.n2540 VSS.n611 17.0005
R2679 VSS.n2540 VSS.n612 17.0005
R2680 VSS.n1509 VSS.n1508 17.0005
R2681 VSS.n1508 VSS.n1490 17.0005
R2682 VSS.n1508 VSS.n1507 17.0005
R2683 VSS.n1515 VSS.n1514 17.0005
R2684 VSS.n1514 VSS.n1506 17.0005
R2685 VSS.n1527 VSS.n1526 17.0005
R2686 VSS.n1527 VSS.n1464 17.0005
R2687 VSS.n1527 VSS.n1467 17.0005
R2688 VSS.n1527 VSS.n1465 17.0005
R2689 VSS.n1527 VSS.n1466 17.0005
R2690 VSS.n1462 VSS.n1453 17.0005
R2691 VSS.n1459 VSS.n1453 17.0005
R2692 VSS.n1453 VSS.n1452 17.0005
R2693 VSS.n1535 VSS.n1534 17.0005
R2694 VSS.n1535 VSS.n1450 17.0005
R2695 VSS.n1454 VSS.n1447 17.0005
R2696 VSS.n1456 VSS.n1447 17.0005
R2697 VSS.n1447 VSS.n1446 17.0005
R2698 VSS.n2517 VSS.n637 17.0005
R2699 VSS.n2517 VSS.n641 17.0005
R2700 VSS.t290 VSS.n1017 17.0005
R2701 VSS.t290 VSS.n1038 17.0005
R2702 VSS.t290 VSS.n1036 17.0005
R2703 VSS.t290 VSS.n1025 17.0005
R2704 VSS.t290 VSS.n1026 17.0005
R2705 VSS.t290 VSS.n1027 17.0005
R2706 VSS.t290 VSS.n1028 17.0005
R2707 VSS.n1030 VSS.n1022 17.0005
R2708 VSS.n1022 VSS.n1021 17.0005
R2709 VSS.n2245 VSS.n2244 17.0005
R2710 VSS.n2245 VSS.n1019 17.0005
R2711 VSS.n2246 VSS.n2245 17.0005
R2712 VSS.n2517 VSS.n639 17.0005
R2713 VSS.n2517 VSS.n638 17.0005
R2714 VSS.t290 VSS.n1045 17.0005
R2715 VSS.t290 VSS.n1043 17.0005
R2716 VSS.t290 VSS.n1041 17.0005
R2717 VSS.t82 VSS.n1048 17.0005
R2718 VSS.t82 VSS.n1049 17.0005
R2719 VSS.t82 VSS.n1071 17.0005
R2720 VSS.t82 VSS.n1050 17.0005
R2721 VSS.t82 VSS.n1069 17.0005
R2722 VSS.t82 VSS.n1051 17.0005
R2723 VSS.t82 VSS.n1067 17.0005
R2724 VSS.t82 VSS.n1052 17.0005
R2725 VSS.t82 VSS.n1066 17.0005
R2726 VSS.t82 VSS.n1053 17.0005
R2727 VSS.t82 VSS.n1054 17.0005
R2728 VSS.t82 VSS.n1063 17.0005
R2729 VSS.t82 VSS.n1055 17.0005
R2730 VSS.t82 VSS.n1061 17.0005
R2731 VSS.t82 VSS.n1056 17.0005
R2732 VSS.t82 VSS.n1059 17.0005
R2733 VSS.t532 VSS.n1567 17.0005
R2734 VSS.t532 VSS.n1566 17.0005
R2735 VSS.t532 VSS.n1562 17.0005
R2736 VSS.t532 VSS.n1565 17.0005
R2737 VSS.n1564 VSS.n1541 17.0005
R2738 VSS.t179 VSS.n1541 17.0005
R2739 VSS.n620 VSS.n602 17.0005
R2740 VSS.n629 VSS.n602 17.0005
R2741 VSS.n621 VSS.n602 17.0005
R2742 VSS.n602 VSS.n600 17.0005
R2743 VSS.t182 VSS.n602 17.0005
R2744 VSS.n616 VSS.n602 17.0005
R2745 VSS.n623 VSS.n602 17.0005
R2746 VSS.n624 VSS.n602 17.0005
R2747 VSS.n2537 VSS.n620 17.0005
R2748 VSS.n2537 VSS.n600 17.0005
R2749 VSS.n2537 VSS.n623 17.0005
R2750 VSS.n2537 VSS.n624 17.0005
R2751 VSS.n2537 VSS.n2536 17.0005
R2752 VSS.n598 VSS.n1494 17.0005
R2753 VSS.n598 VSS.n1516 17.0005
R2754 VSS.n598 VSS.n1495 17.0005
R2755 VSS.n598 VSS.t703 17.0005
R2756 VSS.n598 VSS.n1496 17.0005
R2757 VSS.n598 VSS.n597 17.0005
R2758 VSS.n598 VSS.n1497 17.0005
R2759 VSS.n1494 VSS.n1491 17.0005
R2760 VSS.n1516 VSS.n1491 17.0005
R2761 VSS.n1495 VSS.n1491 17.0005
R2762 VSS.t703 VSS.n1491 17.0005
R2763 VSS.n1496 VSS.n1491 17.0005
R2764 VSS.n1491 VSS.n597 17.0005
R2765 VSS.n1497 VSS.n1491 17.0005
R2766 VSS.n644 VSS.n642 17.0005
R2767 VSS.n646 VSS.n642 17.0005
R2768 VSS.n647 VSS.n642 17.0005
R2769 VSS.t495 VSS.n642 17.0005
R2770 VSS.n649 VSS.n642 17.0005
R2771 VSS.n650 VSS.n642 17.0005
R2772 VSS.n651 VSS.n642 17.0005
R2773 VSS.n592 VSS.n644 17.0005
R2774 VSS.n592 VSS.n646 17.0005
R2775 VSS.n592 VSS.n647 17.0005
R2776 VSS.t495 VSS.n592 17.0005
R2777 VSS.n592 VSS.n649 17.0005
R2778 VSS.n592 VSS.n650 17.0005
R2779 VSS.n592 VSS.n651 17.0005
R2780 VSS.n956 VSS.n926 17.0005
R2781 VSS.n956 VSS.n927 17.0005
R2782 VSS.n956 VSS.n922 17.0005
R2783 VSS.n956 VSS.n930 17.0005
R2784 VSS.n956 VSS.n931 17.0005
R2785 VSS.n957 VSS.n956 17.0005
R2786 VSS.n956 VSS.n934 17.0005
R2787 VSS.n956 VSS.n935 17.0005
R2788 VSS.n956 VSS.n946 17.0005
R2789 VSS.n2267 VSS.n926 17.0005
R2790 VSS.n2267 VSS.n927 17.0005
R2791 VSS.n2267 VSS.n922 17.0005
R2792 VSS.n2268 VSS.n2267 17.0005
R2793 VSS.n2267 VSS.n929 17.0005
R2794 VSS.n2267 VSS.n930 17.0005
R2795 VSS.n2267 VSS.n931 17.0005
R2796 VSS.n2267 VSS.n932 17.0005
R2797 VSS.n2267 VSS.n934 17.0005
R2798 VSS.n2267 VSS.n935 17.0005
R2799 VSS.n2304 VSS.n904 17.0005
R2800 VSS.n2304 VSS.n2303 17.0005
R2801 VSS.n2304 VSS.n907 17.0005
R2802 VSS.n2304 VSS.n910 17.0005
R2803 VSS.n2304 VSS.n908 17.0005
R2804 VSS.n904 VSS.n574 17.0005
R2805 VSS.n910 VSS.n574 17.0005
R2806 VSS.n908 VSS.n574 17.0005
R2807 VSS.n338 VSS.t1179 17.0005
R2808 VSS.n2327 VSS.n338 17.0005
R2809 VSS.n887 VSS.n338 17.0005
R2810 VSS.n889 VSS.n338 17.0005
R2811 VSS.n891 VSS.n338 17.0005
R2812 VSS.n892 VSS.n338 17.0005
R2813 VSS.n894 VSS.n338 17.0005
R2814 VSS.n2326 VSS.n879 17.0005
R2815 VSS.n2327 VSS.n2326 17.0005
R2816 VSS.n2326 VSS.n887 17.0005
R2817 VSS.n2326 VSS.n889 17.0005
R2818 VSS.n2326 VSS.n891 17.0005
R2819 VSS.n2326 VSS.n892 17.0005
R2820 VSS.n2326 VSS.n894 17.0005
R2821 VSS.n2259 VSS.n941 17.0005
R2822 VSS.n2259 VSS.n942 17.0005
R2823 VSS.n2259 VSS.n943 17.0005
R2824 VSS.n2259 VSS.t700 17.0005
R2825 VSS.n2259 VSS.n958 17.0005
R2826 VSS.n2259 VSS.n936 17.0005
R2827 VSS.n2264 VSS.n941 17.0005
R2828 VSS.n2264 VSS.n942 17.0005
R2829 VSS.n2264 VSS.n943 17.0005
R2830 VSS.n2264 VSS.t700 17.0005
R2831 VSS.n2264 VSS.n958 17.0005
R2832 VSS.n2264 VSS.n936 17.0005
R2833 VSS.n2265 VSS.n2264 17.0005
R2834 VSS.n328 VSS.n1762 17.0005
R2835 VSS.n1822 VSS.n1798 17.0005
R2836 VSS.n1822 VSS.n1804 17.0005
R2837 VSS.n1822 VSS.n1799 17.0005
R2838 VSS.n1823 VSS.n1822 17.0005
R2839 VSS.n307 VSS.n306 1.38587
R2840 VSS.n283 VSS.n284 2.56192
R2841 VSS.n2162 VSS.n2137 17.0005
R2842 VSS.n2163 VSS.n2162 17.0005
R2843 VSS.n2159 VSS.n2150 17.0005
R2844 VSS.n2159 VSS.n2151 17.0005
R2845 VSS.n2170 VSS.n266 17.0005
R2846 VSS.n1795 VSS.n1777 17.0005
R2847 VSS.n1790 VSS.n259 17.0005
R2848 VSS.n1789 VSS.n259 17.0005
R2849 VSS.n1983 VSS.n1963 17.0005
R2850 VSS.n1984 VSS.n1983 17.0005
R2851 VSS.n1993 VSS.n201 17.0005
R2852 VSS.n2002 VSS.n1933 17.0005
R2853 VSS.n2017 VSS.n1941 17.0005
R2854 VSS.n2017 VSS.n1942 17.0005
R2855 VSS.n2024 VSS.n1921 17.0005
R2856 VSS.n2044 VSS.n1921 17.0005
R2857 VSS.n2045 VSS.n2044 17.0005
R2858 VSS.n2044 VSS.n1926 17.0005
R2859 VSS.n2044 VSS.n1927 17.0005
R2860 VSS.n191 VSS.n2432 17.0005
R2861 VSS.n191 VSS.n190 1.43105
R2862 VSS.n870 VSS.n869 17.0005
R2863 VSS.t1129 VSS.n870 17.0005
R2864 VSS.n988 VSS.n987 17.0005
R2865 VSS.n47 VSS.n63 4.18749
R2866 VSS.n115 VSS.n2370 17.0005
R2867 VSS.n115 VSS.n2389 17.0005
R2868 VSS.n115 VSS.n2371 17.0005
R2869 VSS.n115 VSS.n2377 17.0005
R2870 VSS.n115 VSS.n2372 17.0005
R2871 VSS.n115 VSS.n2376 17.0005
R2872 VSS.n115 VSS.n2373 17.0005
R2873 VSS.n115 VSS.n2375 17.0005
R2874 VSS.n115 VSS.n2374 17.0005
R2875 VSS.n2463 VSS.n859 17.0005
R2876 VSS.n2463 VSS.n860 17.0005
R2877 VSS.n2463 VSS.n861 17.0005
R2878 VSS.n2463 VSS.n862 17.0005
R2879 VSS.n2463 VSS.n69 17.0005
R2880 VSS.n2463 VSS.n62 17.0005
R2881 VSS.n2463 VSS.n68 17.0005
R2882 VSS.n2463 VSS.n864 17.0005
R2883 VSS.n868 VSS.n29 1.13878
R2884 VSS.n31 VSS.n32 0.795927
R2885 VSS.n31 VSS.n33 1.45453
R2886 VSS.n154 VSS.n740 12.7655
R2887 VSS.n83 VSS.n742 17.0005
R2888 VSS.n83 VSS.n743 17.0005
R2889 VSS.n147 VSS.n705 13.1512
R2890 VSS.n28 VSS.n707 17.0005
R2891 VSS.n28 VSS.n708 17.0005
R2892 VSS.n2417 VSS.n103 17.0005
R2893 VSS.n113 VSS.n103 1.14645
R2894 VSS.n103 VSS.n130 17.0005
R2895 VSS.n107 VSS.n136 17.0005
R2896 VSS.n1078 VSS.t193 17.0005
R2897 VSS.n1080 VSS.t193 17.0005
R2898 VSS.n1082 VSS.t193 17.0005
R2899 VSS.n1085 VSS.t193 17.0005
R2900 VSS.n1086 VSS.t193 17.0005
R2901 VSS.n1087 VSS.t193 17.0005
R2902 VSS.n1090 VSS.t193 17.0005
R2903 VSS.n1093 VSS.t193 17.0005
R2904 VSS.n1096 VSS.t193 17.0005
R2905 VSS.n1099 VSS.t193 17.0005
R2906 VSS.n1102 VSS.t193 17.0005
R2907 VSS.n1105 VSS.t193 17.0005
R2908 VSS.n1108 VSS.t193 17.0005
R2909 VSS.n1110 VSS.t193 17.0005
R2910 VSS.t283 VSS.n353 17.0005
R2911 VSS.t283 VSS.n1259 17.0005
R2912 VSS.t283 VSS.n1203 17.0005
R2913 VSS.t283 VSS.n1258 17.0005
R2914 VSS.t283 VSS.n1204 17.0005
R2915 VSS.t283 VSS.n1257 17.0005
R2916 VSS.t283 VSS.n1205 17.0005
R2917 VSS.t283 VSS.n1206 17.0005
R2918 VSS.t283 VSS.n1256 17.0005
R2919 VSS.t283 VSS.n1207 17.0005
R2920 VSS.t283 VSS.n1255 17.0005
R2921 VSS.t283 VSS.n1208 17.0005
R2922 VSS.t283 VSS.n1254 17.0005
R2923 VSS.t283 VSS.n1209 17.0005
R2924 VSS.t283 VSS.n1253 17.0005
R2925 VSS.t283 VSS.n1210 17.0005
R2926 VSS.t283 VSS.n1252 17.0005
R2927 VSS.t283 VSS.n1214 17.0005
R2928 VSS.t283 VSS.n1249 17.0005
R2929 VSS.t283 VSS.n1215 17.0005
R2930 VSS.t283 VSS.n1216 17.0005
R2931 VSS.t283 VSS.n1217 17.0005
R2932 VSS.n1242 VSS.n343 17.0005
R2933 VSS.n1243 VSS.n343 17.0005
R2934 VSS.n1244 VSS.n343 17.0005
R2935 VSS.n1245 VSS.n343 17.0005
R2936 VSS.n1247 VSS.n343 17.0005
R2937 VSS.n386 VSS.n1248 17.0005
R2938 VSS.n386 VSS.n1218 17.0005
R2939 VSS.n382 VSS.n1241 17.0005
R2940 VSS.n382 VSS.n1219 17.0005
R2941 VSS.n382 VSS.n1240 17.0005
R2942 VSS.n1239 VSS.n378 17.0005
R2943 VSS.n378 VSS.n1220 17.0005
R2944 VSS.n378 VSS.n1238 17.0005
R2945 VSS.n1237 VSS.n374 17.0005
R2946 VSS.n374 VSS.n1221 17.0005
R2947 VSS.n374 VSS.n1236 17.0005
R2948 VSS.n1235 VSS.n370 17.0005
R2949 VSS.n370 VSS.n1222 17.0005
R2950 VSS.n370 VSS.n1234 17.0005
R2951 VSS.n1233 VSS.n366 17.0005
R2952 VSS.n366 VSS.n1223 17.0005
R2953 VSS.n366 VSS.n1232 17.0005
R2954 VSS.n1231 VSS.n355 17.0005
R2955 VSS.n355 VSS.n1224 17.0005
R2956 VSS.n355 VSS.n1230 17.0005
R2957 VSS.n1229 VSS.n356 17.0005
R2958 VSS.n356 VSS.n1225 17.0005
R2959 VSS.n356 VSS.n1228 17.0005
R2960 VSS.n356 VSS.n1226 17.0005
R2961 VSS.n356 VSS.n357 0.0258175
R2962 VSS.n1227 VSS.n361 17.0005
R2963 VSS.n1270 VSS.t26 17.0005
R2964 VSS.n1271 VSS.t26 17.0005
R2965 VSS.n1272 VSS.t26 17.0005
R2966 VSS.n1273 VSS.t26 17.0005
R2967 VSS.n1274 VSS.t26 17.0005
R2968 VSS.n1276 VSS.t26 17.0005
R2969 VSS.n1277 VSS.t26 17.0005
R2970 VSS.n1278 VSS.t26 17.0005
R2971 VSS.n1280 VSS.t26 17.0005
R2972 VSS.n1281 VSS.t26 17.0005
R2973 VSS.n1283 VSS.t26 17.0005
R2974 VSS.n1286 VSS.t26 17.0005
R2975 VSS.n1287 VSS.t26 17.0005
R2976 VSS.n1288 VSS.t26 17.0005
R2977 VSS.n1290 VSS.t26 17.0005
R2978 VSS.n1291 VSS.t26 17.0005
R2979 VSS.n1292 VSS.t26 17.0005
R2980 VSS.n1293 VSS.t26 17.0005
R2981 VSS.n1294 VSS.t26 17.0005
R2982 VSS.n1295 VSS.t26 17.0005
R2983 VSS.n1296 VSS.t26 17.0005
R2984 VSS.n1297 VSS.t26 17.0005
R2985 VSS.n1298 VSS.t26 17.0005
R2986 VSS.n1300 VSS.t26 17.0005
R2987 VSS.n1301 VSS.t26 17.0005
R2988 VSS.n1303 VSS.t26 17.0005
R2989 VSS.n1304 VSS.t26 17.0005
R2990 VSS.t443 VSS.n1263 17.0005
R2991 VSS.t443 VSS.n1269 17.0005
R2992 VSS.t443 VSS.n1264 17.0005
R2993 VSS.n402 VSS.n1268 17.0005
R2994 VSS.n402 VSS.n1265 17.0005
R2995 VSS.n402 VSS.n1267 17.0005
R2996 VSS.n1266 VSS.n400 17.0005
R2997 VSS.t224 VSS.n399 4.25103
R2998 VSS.n1742 VSS.t225 17.0005
R2999 VSS.n1735 VSS.n1734 17.0005
R3000 VSS.n1735 VSS.n1124 17.0005
R3001 VSS.n1735 VSS.n1732 17.0005
R3002 VSS.n1735 VSS.n1125 17.0005
R3003 VSS.n1735 VSS.n1195 17.0005
R3004 VSS.n1735 VSS.n1126 17.0005
R3005 VSS.n1735 VSS.n1192 17.0005
R3006 VSS.n1735 VSS.n1127 17.0005
R3007 VSS.n1735 VSS.n1191 17.0005
R3008 VSS.n1735 VSS.n1129 17.0005
R3009 VSS.n1735 VSS.n1190 17.0005
R3010 VSS.n1735 VSS.n1130 17.0005
R3011 VSS.n1735 VSS.n1131 17.0005
R3012 VSS.n1735 VSS.n1189 17.0005
R3013 VSS.n1735 VSS.n1132 17.0005
R3014 VSS.n1735 VSS.n1188 17.0005
R3015 VSS.n1735 VSS.n1133 17.0005
R3016 VSS.n1735 VSS.n1187 17.0005
R3017 VSS.n1735 VSS.n1186 17.0005
R3018 VSS.n1735 VSS.n1184 17.0005
R3019 VSS.n1735 VSS.n1138 17.0005
R3020 VSS.n1735 VSS.n1182 17.0005
R3021 VSS.n1735 VSS.n1141 17.0005
R3022 VSS.n1735 VSS.n1181 17.0005
R3023 VSS.n1735 VSS.n1142 17.0005
R3024 VSS.n1735 VSS.n1178 17.0005
R3025 VSS.n1735 VSS.n1143 17.0005
R3026 VSS.n1735 VSS.n1177 17.0005
R3027 VSS.n1735 VSS.n1144 17.0005
R3028 VSS.n1735 VSS.n1145 17.0005
R3029 VSS.n1735 VSS.n1174 17.0005
R3030 VSS.n1735 VSS.n1148 17.0005
R3031 VSS.n1735 VSS.n1173 17.0005
R3032 VSS.n1735 VSS.n1150 17.0005
R3033 VSS.n1735 VSS.n1151 17.0005
R3034 VSS.n1735 VSS.n1152 17.0005
R3035 VSS.n1735 VSS.n1169 17.0005
R3036 VSS.n1735 VSS.n1168 17.0005
R3037 VSS.n1735 VSS.n1155 17.0005
R3038 VSS.n1735 VSS.n1156 17.0005
R3039 VSS.n1735 VSS.n1165 17.0005
R3040 VSS.n1735 VSS.n1157 17.0005
R3041 VSS.n1735 VSS.n1163 17.0005
R3042 VSS.n1735 VSS.n1162 17.0005
R3043 VSS.n1735 VSS.n1159 17.0005
R3044 VSS.n1735 VSS.n1161 17.0005
R3045 VSS.t187 VSS.n1729 17.0005
R3046 VSS.t187 VSS.n1314 17.0005
R3047 VSS.t187 VSS.n1728 17.0005
R3048 VSS.t187 VSS.n1315 17.0005
R3049 VSS.t187 VSS.n1726 17.0005
R3050 VSS.t187 VSS.n1724 17.0005
R3051 VSS.t187 VSS.n1316 17.0005
R3052 VSS.t187 VSS.n1723 17.0005
R3053 VSS.t187 VSS.n1318 17.0005
R3054 VSS.t187 VSS.n1721 17.0005
R3055 VSS.t187 VSS.n1319 17.0005
R3056 VSS.t187 VSS.n1320 17.0005
R3057 VSS.n1718 VSS.t279 17.0005
R3058 VSS.t279 VSS.n1717 17.0005
R3059 VSS.t279 VSS.n1321 17.0005
R3060 VSS.t279 VSS.n1716 17.0005
R3061 VSS.t279 VSS.n1322 17.0005
R3062 VSS.t279 VSS.n1715 17.0005
R3063 VSS.n410 VSS.n409 5.6463
R3064 VSS.t287 VSS.n1712 17.0005
R3065 VSS.t287 VSS.n1324 17.0005
R3066 VSS.n1707 VSS.n417 17.0005
R3067 VSS.n1709 VSS.n417 17.0005
R3068 VSS.n420 VSS.n1711 17.0005
R3069 VSS.n420 VSS.n1325 17.0005
R3070 VSS.n420 VSS.n1706 17.0005
R3071 VSS.n422 VSS.n1326 17.0005
R3072 VSS.n422 VSS.n1704 17.0005
R3073 VSS.n422 VSS.n1327 17.0005
R3074 VSS.n422 VSS.n1703 17.0005
R3075 VSS.n422 VSS.n1328 17.0005
R3076 VSS.n422 VSS.n1702 17.0005
R3077 VSS.n422 VSS.n1329 17.0005
R3078 VSS.n422 VSS.n1701 17.0005
R3079 VSS.n422 VSS.n1330 17.0005
R3080 VSS.n424 VSS.n1700 17.0005
R3081 VSS.n424 VSS.n1331 17.0005
R3082 VSS.n424 VSS.n1699 17.0005
R3083 VSS.n1697 VSS.n424 17.0005
R3084 VSS.n1696 VSS.n424 17.0005
R3085 VSS.n1695 VSS.n424 17.0005
R3086 VSS.n1694 VSS.n424 17.0005
R3087 VSS.n1693 VSS.n424 17.0005
R3088 VSS.n1691 VSS.n424 17.0005
R3089 VSS.n1690 VSS.n424 17.0005
R3090 VSS.n1689 VSS.n424 17.0005
R3091 VSS.n1688 VSS.n424 17.0005
R3092 VSS.n1687 VSS.n1686 17.0005
R3093 VSS.n1686 VSS.n1332 17.0005
R3094 VSS.n1686 VSS.n1685 17.0005
R3095 VSS.n442 VSS.n1365 17.0005
R3096 VSS.n442 VSS.n1381 17.0005
R3097 VSS.n442 VSS.n1366 17.0005
R3098 VSS.n442 VSS.n1380 17.0005
R3099 VSS.n442 VSS.n1367 17.0005
R3100 VSS.n442 VSS.n1379 17.0005
R3101 VSS.n442 VSS.n1368 17.0005
R3102 VSS.n442 VSS.n1378 17.0005
R3103 VSS.n442 VSS.n1369 17.0005
R3104 VSS.n442 VSS.n1377 17.0005
R3105 VSS.n442 VSS.n1376 17.0005
R3106 VSS.n442 VSS.n1370 17.0005
R3107 VSS.n1375 VSS.t10 17.0005
R3108 VSS.n1374 VSS.t10 17.0005
R3109 VSS.n1373 VSS.t10 17.0005
R3110 VSS.n1372 VSS.t10 17.0005
R3111 VSS.n1371 VSS.t10 17.0005
R3112 VSS.n1364 VSS.n435 17.0005
R3113 VSS.n1363 VSS.n435 17.0005
R3114 VSS.n1362 VSS.t322 17.0005
R3115 VSS.n1361 VSS.t322 17.0005
R3116 VSS.n1360 VSS.t322 17.0005
R3117 VSS.n1358 VSS.t322 17.0005
R3118 VSS.n1357 VSS.t322 17.0005
R3119 VSS.n1355 VSS.t322 17.0005
R3120 VSS.n1342 VSS.t322 17.0005
R3121 VSS.n1352 VSS.t519 17.0005
R3122 VSS.n1351 VSS.t519 17.0005
R3123 VSS.n1350 VSS.t519 17.0005
R3124 VSS.n1349 VSS.t519 17.0005
R3125 VSS.n1347 VSS.t519 17.0005
R3126 VSS.n1346 VSS.t519 17.0005
R3127 VSS.n1345 VSS.t519 17.0005
R3128 VSS.n1343 VSS.t519 17.0005
R3129 VSS.n459 VSS.n460 5.64548
R3130 VSS.n1337 VSS.n1680 17.0005
R3131 VSS.n465 VSS.t1204 17.0005
R3132 VSS.n1667 VSS.t448 17.0005
R3133 VSS.n1669 VSS.t448 17.0005
R3134 VSS.n1670 VSS.t448 17.0005
R3135 VSS.n1671 VSS.t448 17.0005
R3136 VSS.n1672 VSS.t448 17.0005
R3137 VSS.n1675 VSS.t448 17.0005
R3138 VSS.n1411 VSS.n1676 17.0005
R3139 VSS.n1411 VSS.n1385 17.0005
R3140 VSS.n1411 VSS.n1423 17.0005
R3141 VSS.n1411 VSS.n1422 17.0005
R3142 VSS.n1411 VSS.n1386 17.0005
R3143 VSS.n1411 VSS.n1387 17.0005
R3144 VSS.n1411 VSS.n1388 17.0005
R3145 VSS.n1411 VSS.n1421 17.0005
R3146 VSS.n1411 VSS.n1420 17.0005
R3147 VSS.n1411 VSS.n1391 17.0005
R3148 VSS.n1411 VSS.n1419 17.0005
R3149 VSS.n1411 VSS.n1392 17.0005
R3150 VSS.n1411 VSS.n1418 17.0005
R3151 VSS.n1411 VSS.n1393 17.0005
R3152 VSS.n1411 VSS.n1417 17.0005
R3153 VSS.n1411 VSS.n1395 17.0005
R3154 VSS.n1411 VSS.n1416 17.0005
R3155 VSS.n1411 VSS.n1396 17.0005
R3156 VSS.n1411 VSS.n1398 17.0005
R3157 VSS.n1411 VSS.n1415 17.0005
R3158 VSS.n1411 VSS.n1400 17.0005
R3159 VSS.n1411 VSS.n1414 17.0005
R3160 VSS.n1411 VSS.n1412 17.0005
R3161 VSS.n1411 VSS.n1413 17.0005
R3162 VSS.n478 VSS.n1426 17.0005
R3163 VSS.n478 VSS.n1664 17.0005
R3164 VSS.n478 VSS.n1427 17.0005
R3165 VSS.n478 VSS.n1662 17.0005
R3166 VSS.n478 VSS.n1428 17.0005
R3167 VSS.t672 VSS.n1429 17.0005
R3168 VSS.t672 VSS.n1430 17.0005
R3169 VSS.t672 VSS.n1659 17.0005
R3170 VSS.n1658 VSS.n488 17.0005
R3171 VSS.n488 VSS.n489 0.666899
R3172 VSS.n1650 VSS.n488 17.0005
R3173 VSS.n1651 VSS.n488 17.0005
R3174 VSS.n1652 VSS.n488 17.0005
R3175 VSS.n1654 VSS.n488 17.0005
R3176 VSS.n1655 VSS.n488 17.0005
R3177 VSS.n1656 VSS.n488 17.0005
R3178 VSS.n504 VSS.n1657 17.0005
R3179 VSS.n504 VSS.n1431 17.0005
R3180 VSS.n503 VSS.n1649 17.0005
R3181 VSS.n503 VSS.n1432 17.0005
R3182 VSS.n503 VSS.n1648 17.0005
R3183 VSS.n503 VSS.n1433 17.0005
R3184 VSS.n503 VSS.n1647 17.0005
R3185 VSS.n503 VSS.n1434 17.0005
R3186 VSS.n503 VSS.n1646 17.0005
R3187 VSS.n503 VSS.n1435 17.0005
R3188 VSS.n503 VSS.n1645 17.0005
R3189 VSS.n1643 VSS.n499 17.0005
R3190 VSS.n499 VSS.n1436 17.0005
R3191 VSS.n495 VSS.n1642 17.0005
R3192 VSS.n495 VSS.n1437 17.0005
R3193 VSS.n492 VSS.n1640 17.0005
R3194 VSS.n1609 VSS.t20 17.0005
R3195 VSS.n1611 VSS.t20 17.0005
R3196 VSS.n1613 VSS.t20 17.0005
R3197 VSS.n1614 VSS.t20 17.0005
R3198 VSS.n1615 VSS.t20 17.0005
R3199 VSS.n1617 VSS.t20 17.0005
R3200 VSS.n1618 VSS.t206 17.0005
R3201 VSS.n1619 VSS.t206 17.0005
R3202 VSS.n1620 VSS.t206 17.0005
R3203 VSS.n1621 VSS.t206 17.0005
R3204 VSS.n1622 VSS.t206 17.0005
R3205 VSS.n1624 VSS.t206 17.0005
R3206 VSS.n1626 VSS.t206 17.0005
R3207 VSS.n1627 VSS.t206 17.0005
R3208 VSS.n1628 VSS.t206 17.0005
R3209 VSS.n1629 VSS.t206 17.0005
R3210 VSS.n1630 VSS.t206 17.0005
R3211 VSS.n1632 VSS.t206 17.0005
R3212 VSS.n1633 VSS.t206 17.0005
R3213 VSS.n1635 VSS.t206 17.0005
R3214 VSS.n1637 VSS.t206 17.0005
R3215 VSS.n1595 VSS.t54 17.0005
R3216 VSS.n1596 VSS.t54 17.0005
R3217 VSS.n1597 VSS.t54 17.0005
R3218 VSS.n1599 VSS.t54 17.0005
R3219 VSS.n1601 VSS.t54 17.0005
R3220 VSS.n1602 VSS.t54 17.0005
R3221 VSS.n1603 VSS.t54 17.0005
R3222 VSS.n1604 VSS.t54 17.0005
R3223 VSS.t175 VSS.n1591 17.0005
R3224 VSS.t175 VSS.n1594 17.0005
R3225 VSS.t175 VSS.n1592 17.0005
R3226 VSS.t175 VSS.n1593 17.0005
R3227 VSS.n538 VSS.n1606 17.0005
R3228 VSS.n538 VSS.n1441 17.0005
R3229 VSS.n534 VSS.n1590 17.0005
R3230 VSS.n534 VSS.n1442 17.0005
R3231 VSS.n530 VSS.n1588 17.0005
R3232 VSS.n530 VSS.n1443 17.0005
R3233 VSS.n526 VSS.n1586 17.0005
R3234 VSS.n526 VSS.n1444 17.0005
R3235 VSS.n522 VSS.n1584 17.0005
R3236 VSS.n522 VSS.n1445 17.0005
R3237 VSS.n519 VSS.n1582 17.0005
R3238 VSS.n2107 VSS.n1878 16.9343
R3239 VSS.n1966 VSS.n1965 16.9343
R3240 VSS.n2458 VSS.n2457 16.8959
R3241 VSS.n978 VSS.n975 16.8959
R3242 VSS.n966 VSS.n965 16.8959
R3243 VSS.n970 VSS.n173 16.8958
R3244 VSS.n712 VSS.n147 1.8806
R3245 VSS.t1082 VSS.n1454 16.8046
R3246 VSS.n1534 VSS.t1087 16.8046
R3247 VSS.n1462 VSS.t1092 16.8046
R3248 VSS.n1486 VSS.t1094 16.8046
R3249 VSS.n1506 VSS.n1475 16.8046
R3250 VSS.n1509 VSS.t1102 16.8046
R3251 VSS.t1107 VSS.n614 16.8046
R3252 VSS.n2521 VSS.t1112 16.8046
R3253 VSS.n2499 VSS.t371 16.8046
R3254 VSS.n2244 VSS.t1121 16.8046
R3255 VSS.n1030 VSS.t1126 16.8046
R3256 VSS.n2283 VSS.n2281 16.7392
R3257 VSS.n1715 VSS.t71 16.6672
R3258 VSS.n2516 VSS.t495 16.4875
R3259 VSS.n2153 VSS.n2139 16.3141
R3260 VSS.n2148 VSS.n2138 16.3141
R3261 VSS.n1761 VSS.n1760 16.2556
R3262 VSS.n1829 VSS.n1828 16.2556
R3263 VSS.n2122 VSS.n2117 16.2556
R3264 VSS.n2119 VSS.n2118 16.2556
R3265 VSS.n2152 VSS.n2142 16.2556
R3266 VSS.n2176 VSS.n2175 16.2556
R3267 VSS.n2172 VSS.n2171 16.2556
R3268 VSS.n1771 VSS.n1770 16.2556
R3269 VSS.n1775 VSS.n1774 16.2556
R3270 VSS.n2059 VSS.n2056 16.2556
R3271 VSS.n1902 VSS.n1899 16.2556
R3272 VSS.n1951 VSS.n204 16.2556
R3273 VSS.n1994 VSS.n205 16.2556
R3274 VSS.n1760 VSS.n1759 16.2556
R3275 VSS.n1758 VSS.n1756 16.2556
R3276 VSS.n2227 VSS.n1756 16.2556
R3277 VSS.n2228 VSS.n2227 16.2556
R3278 VSS.n1830 VSS.n1829 16.2556
R3279 VSS.n1832 VSS.n1831 16.2556
R3280 VSS.n1833 VSS.n1832 16.2556
R3281 VSS.n2121 VSS.n2118 16.2556
R3282 VSS.n2123 VSS.n2122 16.2556
R3283 VSS.n2117 VSS.n2116 16.2556
R3284 VSS.n2153 VSS.n2141 16.2556
R3285 VSS.n2152 VSS.n2139 16.2556
R3286 VSS.n2149 VSS.n2143 16.2556
R3287 VSS.n2149 VSS.n2138 16.2556
R3288 VSS.n2173 VSS.n2172 16.2556
R3289 VSS.n2175 VSS.n2174 16.2556
R3290 VSS.n249 VSS.n1775 17.9687
R3291 VSS.n1774 VSS.n1773 16.2556
R3292 VSS.n1772 VSS.n1771 16.2556
R3293 VSS.n233 VSS.n2056 16.2556
R3294 VSS.n2059 VSS.n2055 16.2556
R3295 VSS.n2058 VSS.n2054 16.2556
R3296 VSS.n2060 VSS.n2054 16.2556
R3297 VSS.n220 VSS.n1899 16.2556
R3298 VSS.n1902 VSS.n1898 16.2556
R3299 VSS.n1901 VSS.n1897 16.2556
R3300 VSS.n1897 VSS.n219 16.2556
R3301 VSS.n205 VSS.n1952 16.2556
R3302 VSS.n1953 VSS.n1951 16.2556
R3303 VSS.n137 VSS.n2368 17.9687
R3304 VSS.t690 VSS.n1024 16.235
R3305 VSS.n1865 VSS.n1864 16.1971
R3306 VSS.n1859 VSS.n1858 16.1971
R3307 VSS.n2082 VSS.n2078 16.1971
R3308 VSS.n2083 VSS.n2079 16.1971
R3309 VSS.n2084 VSS.n2080 16.1971
R3310 VSS.n2085 VSS.n2081 16.1971
R3311 VSS.n1862 VSS.n1861 16.1971
R3312 VSS.n1868 VSS.n1867 16.1971
R3313 VSS.n2086 VSS.n2081 16.1971
R3314 VSS.n2085 VSS.n2080 16.1971
R3315 VSS.n2083 VSS.n2078 16.1971
R3316 VSS.n579 VSS.t697 16.1543
R3317 VSS.n748 VSS.n154 1.83672
R3318 VSS.n1867 VSS.n1866 16.1378
R3319 VSS.n1861 VSS.n1860 16.1378
R3320 VSS.n1860 VSS.n1859 16.1378
R3321 VSS.n1864 VSS.n1863 16.1378
R3322 VSS.n1866 VSS.n1865 16.1378
R3323 VSS.n1809 VSS.n1806 16.0785
R3324 VSS.n2001 VSS.n1940 16.0785
R3325 VSS.n1999 VSS.n1944 16.0785
R3326 VSS.n1925 VSS.n1922 16.0785
R3327 VSS.n2022 VSS.n1928 16.0785
R3328 VSS.n1813 VSS.n1800 16.0785
R3329 VSS.n1812 VSS.n1800 16.0785
R3330 VSS.n1808 VSS.n1806 16.0785
R3331 VSS.n1999 VSS.n1943 16.0785
R3332 VSS.n1998 VSS.n1943 16.0785
R3333 VSS.n2000 VSS.n1940 16.0785
R3334 VSS.n2001 VSS.n1939 16.0785
R3335 VSS.n2021 VSS.n1929 16.0785
R3336 VSS.n2021 VSS.n1928 16.0785
R3337 VSS.n2023 VSS.n1925 16.0785
R3338 VSS.n1810 VSS.n1805 16.0185
R3339 VSS.n1812 VSS.n1803 16.0185
R3340 VSS.n1813 VSS.n1802 16.0185
R3341 VSS.n1811 VSS.n1803 16.0185
R3342 VSS.n1809 VSS.n1805 16.0185
R3343 VSS.n2020 VSS.n1929 16.0185
R3344 VSS.n2365 VSS.n2364 15.9584
R3345 VSS.n2363 VSS.n2362 15.9584
R3346 VSS.n2357 VSS.n2356 15.9584
R3347 VSS.n2358 VSS.n2357 15.9584
R3348 VSS.n2359 VSS.n2358 15.9584
R3349 VSS.n2360 VSS.n2359 15.9584
R3350 VSS.n2362 VSS.n2361 15.9584
R3351 VSS.n2364 VSS.n2363 15.9584
R3352 VSS.n2366 VSS.n2365 15.9584
R3353 VSS.t700 VSS.n934 15.9236
R3354 VSS.n942 VSS.n931 15.9236
R3355 VSS.n2151 VSS.t303 15.894
R3356 VSS.n1037 VSS.n1018 15.8785
R3357 VSS.n2508 VSS.n638 15.8534
R3358 VSS.n1794 VSS.n1793 15.8366
R3359 VSS.n1788 VSS.n1787 15.8366
R3360 VSS.n1787 VSS.n1785 15.8366
R3361 VSS.n1788 VSS.n1786 15.8366
R3362 VSS.n1786 VSS.n1780 15.8366
R3363 VSS.n1793 VSS.n1791 15.8366
R3364 VSS.n1794 VSS.n1792 15.8366
R3365 VSS.n1884 VSS.n1883 15.7131
R3366 VSS.n1886 VSS.n1885 15.7131
R3367 VSS.n1888 VSS.n1887 15.7131
R3368 VSS.n1968 VSS.n1961 15.7131
R3369 VSS.n1969 VSS.n1962 15.7131
R3370 VSS.n1889 VSS.n1888 15.7131
R3371 VSS.n1887 VSS.n1886 15.7131
R3372 VSS.n1883 VSS.n1882 15.7131
R3373 VSS.n1882 VSS.n1878 15.7131
R3374 VSS.n1970 VSS.n1964 15.7131
R3375 VSS.n1969 VSS.n1964 15.7131
R3376 VSS.n1967 VSS.n1961 15.7131
R3377 VSS.n1967 VSS.n1965 15.7131
R3378 VSS.n926 VSS.n919 15.6928
R3379 VSS.n2424 VSS.n2422 15.6747
R3380 VSS.n2438 VSS.n2437 15.6747
R3381 VSS.n2459 VSS.n2458 15.6747
R3382 VSS.n976 VSS.n970 15.6747
R3383 VSS.n978 VSS.n974 15.6747
R3384 VSS.n998 VSS.n962 15.6747
R3385 VSS.n965 VSS.n964 15.6747
R3386 VSS.n2437 VSS.n2423 15.6747
R3387 VSS.n2431 VSS.n2422 15.6747
R3388 VSS.n2460 VSS.n2459 15.6747
R3389 VSS.n981 VSS.n980 15.6747
R3390 VSS.n977 VSS.n974 15.6747
R3391 VSS.n976 VSS.n973 15.6747
R3392 VSS.n967 VSS.n964 15.6747
R3393 VSS.n968 VSS.n962 15.6747
R3394 VSS.n999 VSS.n998 15.6747
R3395 VSS.t292 VSS.n1074 15.6255
R3396 VSS.n1472 VSS.n1467 15.5363
R3397 VSS.t214 VSS.n1799 15.4644
R3398 VSS.t303 VSS.n2150 15.4644
R3399 VSS.n1942 VSS.t513 15.4644
R3400 VSS.n1927 VSS.t516 15.4644
R3401 VSS.n958 VSS.n935 15.462
R3402 VSS.n941 VSS.n930 15.462
R3403 VSS.n927 VSS.n920 15.462
R3404 VSS.n2539 VSS.n600 15.2193
R3405 VSS.n600 VSS.n608 15.2193
R3406 VSS.n1804 VSS.t214 15.0349
R3407 VSS.t200 VSS.n1789 15.0349
R3408 VSS.t513 VSS.n1941 15.0349
R3409 VSS.t516 VSS.n1926 15.0349
R3410 VSS.n1037 VSS.t365 15.0011
R3411 VSS.n2266 VSS.n936 15.0005
R3412 VSS.n2303 VSS.n2301 15.0005
R3413 VSS.n911 VSS.n904 15.0005
R3414 VSS.n1472 VSS.n1465 14.9022
R3415 VSS.n922 VSS.n921 14.7697
R3416 VSS.n2209 VSS.n879 14.7697
R3417 VSS.n1790 VSS.t200 14.6053
R3418 VSS.n2269 VSS.n2268 14.539
R3419 VSS.n1284 VSS.t1219 14.3531
R3420 VSS.n1032 VSS.t310 14.2681
R3421 VSS.n1035 VSS.t397 13.7631
R3422 VSS.n1034 VSS.t410 13.7631
R3423 VSS.n1033 VSS.t695 13.7631
R3424 VSS.n2113 VSS.t514 13.6405
R3425 VSS.t1097 VSS.n1464 13.634
R3426 VSS.t1117 VSS.n2492 13.634
R3427 VSS.t1121 VSS.n1019 13.634
R3428 VSS.n2325 VSS.n897 13.6068
R3429 VSS.n2285 VSS.n910 13.3851
R3430 VSS.t602 VSS.n1024 13.3407
R3431 VSS.n2515 VSS.n2500 13.3169
R3432 VSS.n2284 VSS.n908 13.1543
R3433 VSS.n2287 VSS.n907 13.1543
R3434 VSS.n1456 VSS.t1079 12.9999
R3435 VSS.n1459 VSS.t1089 12.9999
R3436 VSS.n1490 VSS.t1099 12.9999
R3437 VSS.t1104 VSS.n611 12.9999
R3438 VSS.n2500 VSS.t1114 12.9999
R3439 VSS.t469 VSS.n1044 12.9486
R3440 VSS.n1252 VSS.n1250 12.8945
R3441 VSS.t19 VSS.t32 12.8945
R3442 VSS.n2418 VSS.n130 12.8871
R3443 VSS.t687 VSS.n1204 12.8576
R3444 VSS.n1258 VSS.t147 12.8576
R3445 VSS.t5 VSS.n1293 12.8576
R3446 VSS.n1192 VSS.t149 12.8576
R3447 VSS.t215 VSS.n1126 12.8576
R3448 VSS.n1195 VSS.t688 12.8576
R3449 VSS.t1169 VSS.n1125 12.8576
R3450 VSS.n1377 VSS.t300 12.8576
R3451 VSS.n725 VSS.n724 12.8313
R3452 VSS.n1304 VSS.t525 12.5005
R3453 VSS.t1270 VSS.n1342 12.5005
R3454 VSS.t1146 VSS.n1059 12.5005
R3455 VSS.n832 VSS.n831 12.3456
R3456 VSS.n801 VSS.n800 12.3456
R3457 VSS.n694 VSS.n693 12.3456
R3458 VSS.n2476 VSS.n2475 12.3456
R3459 VSS.n2402 VSS.n2401 12.3456
R3460 VSS.n839 VSS.n838 12.3414
R3461 VSS.n710 VSS.n700 12.3414
R3462 VSS.n777 VSS.n774 12.2896
R3463 VSS.n648 VSS.n583 12.0487
R3464 VSS.n2328 VSS.n2327 12.0005
R3465 VSS.n41 VSS.t389 11.9462
R3466 VSS.t395 VSS.n1010 11.9462
R3467 VSS.n50 VSS.t392 11.9461
R3468 VSS.n57 VSS.t396 11.9451
R3469 VSS.n48 VSS.t392 11.9011
R3470 VSS.n58 VSS.t396 11.9076
R3471 VSS.n67 VSS.t395 11.9046
R3472 VSS.n686 VSS.n680 11.8468
R3473 VSS.n82 VSS.n812 11.8468
R3474 VSS.n1461 VSS.n1460 11.8358
R3475 VSS.t389 VSS.n42 11.8329
R3476 VSS.n1507 VSS.n1494 11.7316
R3477 VSS.n1036 VSS.t600 11.7316
R3478 VSS.n1038 VSS.t189 11.6987
R3479 VSS.n865 VSS.n863 11.6456
R3480 VSS.n867 VSS.n862 11.6456
R3481 VSS.n866 VSS.n861 11.6456
R3482 VSS.n33 VSS.n69 6.32111
R3483 VSS.n866 VSS.n860 11.6456
R3484 VSS.n867 VSS.n861 11.6456
R3485 VSS.n32 VSS.n68 6.91272
R3486 VSS.n32 VSS.n863 18.5572
R3487 VSS.n2440 VSS.t165 11.56
R3488 VSS.n1719 VSS.t1162 11.539
R3489 VSS.n2419 VSS.n2347 11.535
R3490 VSS.t165 VSS.n2347 11.4932
R3491 VSS.n623 VSS.n610 11.4146
R3492 VSS.n2523 VSS.n620 11.4146
R3493 VSS.n655 VSS.t368 11.4146
R3494 VSS.n887 VSS.n878 11.3082
R3495 VSS.n710 VSS.n701 11.2662
R3496 VSS.n705 VSS.n704 11.2662
R3497 VSS.n2302 VSS.n905 11.2144
R3498 VSS.n839 VSS.n836 11.2144
R3499 VSS.n796 VSS.n795 11.2144
R3500 VSS.n758 VSS.n757 11.2144
R3501 VSS.n724 VSS.n723 11.2144
R3502 VSS.n706 VSS.n704 11.2144
R3503 VSS.n709 VSS.n702 11.2144
R3504 VSS.n693 VSS.n692 11.2144
R3505 VSS.n689 VSS.n688 11.2144
R3506 VSS.n2475 VSS.n2474 11.2144
R3507 VSS.n2471 VSS.n2470 11.2144
R3508 VSS.n2401 VSS.n2400 11.2144
R3509 VSS.n2397 VSS.n2396 11.2144
R3510 VSS.n836 VSS.n835 11.2144
R3511 VSS.n834 VSS.n833 11.2144
R3512 VSS.n833 VSS.n832 11.2144
R3513 VSS.n795 VSS.n160 13.2654
R3514 VSS.n797 VSS.n796 11.2144
R3515 VSS.n799 VSS.n798 11.2144
R3516 VSS.n800 VSS.n799 11.2144
R3517 VSS.n763 VSS.n156 13.4711
R3518 VSS.n763 VSS.n761 11.2144
R3519 VSS.n761 VSS.n760 11.2144
R3520 VSS.n759 VSS.n758 11.2144
R3521 VSS.n757 VSS.n756 11.2144
R3522 VSS.n719 VSS.n148 12.8251
R3523 VSS.n720 VSS.n719 11.2144
R3524 VSS.n721 VSS.n720 11.2144
R3525 VSS.n723 VSS.n722 11.2144
R3526 VSS.n709 VSS.n701 11.2144
R3527 VSS.n706 VSS.n703 11.2144
R3528 VSS.n688 VSS.n143 12.8251
R3529 VSS.n690 VSS.n689 11.2144
R3530 VSS.n692 VSS.n691 11.2144
R3531 VSS.n2470 VSS.n141 12.8251
R3532 VSS.n2472 VSS.n2471 11.2144
R3533 VSS.n2474 VSS.n2473 11.2144
R3534 VSS.n2396 VSS.n139 12.8251
R3535 VSS.n2398 VSS.n2397 11.2144
R3536 VSS.n2400 VSS.n2399 11.2144
R3537 VSS.t325 VSS.n1040 11.1874
R3538 VSS.n2386 VSS.n2370 11.186
R3539 VSS.n781 VSS.n770 11.1626
R3540 VSS.n781 VSS.n771 11.1626
R3541 VSS.n780 VSS.n771 11.1626
R3542 VSS.n780 VSS.n772 11.1626
R3543 VSS.n779 VSS.n773 11.1626
R3544 VSS.n778 VSS.n773 11.1626
R3545 VSS.n778 VSS.n774 11.1626
R3546 VSS.t491 VSS.n4 9.70035
R3547 VSS.t97 VSS.n2 14.4826
R3548 VSS.n928 VSS.n923 11.0052
R3549 VSS.n944 VSS.n928 11.0052
R3550 VSS.n2483 VSS.n661 11.0005
R3551 VSS.n884 VSS.n883 10.9524
R3552 VSS.n886 VSS.n885 10.9524
R3553 VSS.n885 VSS.n884 10.9524
R3554 VSS.n883 VSS.n882 10.9524
R3555 VSS.n882 VSS.n881 10.9524
R3556 VSS.n889 VSS.n888 10.8467
R3557 VSS.n741 VSS.n739 10.8459
R3558 VSS.n745 VSS.n737 10.8459
R3559 VSS.n745 VSS.n736 10.8459
R3560 VSS.n744 VSS.n737 10.8459
R3561 VSS.n744 VSS.n735 10.8459
R3562 VSS.n741 VSS.n738 10.8459
R3563 VSS.n740 VSS.n739 10.8459
R3564 VSS.n2507 VSS.n637 10.7805
R3565 VSS.n854 VSS.n853 10.7383
R3566 VSS.n817 VSS.n812 10.7383
R3567 VSS.n818 VSS.n813 10.7383
R3568 VSS.n820 VSS.n814 10.7383
R3569 VSS.n854 VSS.n164 12.7619
R3570 VSS.n853 VSS.n683 10.7383
R3571 VSS.n684 VSS.n683 10.7383
R3572 VSS.n685 VSS.n682 10.7383
R3573 VSS.n685 VSS.n681 10.7383
R3574 VSS.n686 VSS.n681 10.7383
R3575 VSS.n820 VSS.n815 10.7383
R3576 VSS.n819 VSS.n814 10.7383
R3577 VSS.n819 VSS.n816 10.7383
R3578 VSS.n817 VSS.n813 10.7383
R3579 VSS.n844 VSS.n660 10.1922
R3580 VSS.n891 VSS.n890 10.1543
R3581 VSS.n1507 VSS.n1478 10.1463
R3582 VSS.n624 VSS.n610 10.1463
R3583 VSS.n2527 VSS.n2523 10.1463
R3584 VSS.n2388 VSS.n2370 9.93141
R3585 VSS.n2385 VSS.n2373 9.93141
R3586 VSS.n2383 VSS.n2375 9.93141
R3587 VSS.n653 VSS.n639 9.91764
R3588 VSS.n892 VSS.t561 9.69281
R3589 VSS.n2300 VSS.n2299 9.68102
R3590 VSS.n2300 VSS.t1181 9.64205
R3591 VSS.n1040 VSS.t289 9.50978
R3592 VSS.n2418 VSS.n2417 9.23127
R3593 VSS.n894 VSS.n893 9.0005
R3594 VSS.t1181 VSS.n913 8.90387
R3595 VSS.n1457 VSS.n1456 8.87812
R3596 VSS.n1526 VSS.n1525 8.87812
R3597 VSS.n649 VSS.n648 8.87812
R3598 VSS.n2248 VSS.n1019 8.87812
R3599 VSS.n2377 VSS.t164 8.82403
R3600 VSS.n2376 VSS.t163 8.82403
R3601 VSS.n2382 VSS.n2375 8.72176
R3602 VSS.n2382 VSS.n2373 8.72176
R3603 VSS.t190 VSS.n1041 8.66994
R3604 VSS.n2239 VSS.t116 8.60839
R3605 VSS.n1349 VSS.t499 8.59649
R3606 VSS.n1181 VSS.t1183 8.57193
R3607 VSS.n1728 VSS.t657 8.57193
R3608 VSS.n1496 VSS.t96 8.56106
R3609 VSS.t368 VSS.n647 8.56106
R3610 VSS.n2325 VSS.n895 8.53896
R3611 VSS.n708 VSS.t1218 8.53896
R3612 VSS.n1579 VSS.t180 8.50337
R3613 VSS.n2239 VSS.t36 8.50175
R3614 VSS.n1743 VSS.t816 8.50175
R3615 VSS.t1118 VSS.n634 8.501
R3616 VSS.n2518 VSS.t1115 8.501
R3617 VSS.t1113 VSS.n631 8.501
R3618 VSS.n609 VSS.t1110 8.501
R3619 VSS.t1105 VSS.n607 8.501
R3620 VSS.t1103 VSS.n1512 8.501
R3621 VSS.n1513 VSS.t1100 8.501
R3622 VSS.t1098 VSS.n1468 8.501
R3623 VSS.n1528 VSS.t1095 8.501
R3624 VSS.t1093 VSS.n1530 8.501
R3625 VSS.n1531 VSS.t1090 8.501
R3626 VSS.t1088 VSS.n1451 8.501
R3627 VSS.n1536 VSS.t1085 8.501
R3628 VSS.t1083 VSS.n1538 8.501
R3629 VSS.n1539 VSS.t1080 8.501
R3630 VSS.t696 VSS.n1023 8.501
R3631 VSS.n2241 VSS.t1124 8.501
R3632 VSS.t1122 VSS.n1020 8.501
R3633 VSS.t372 VSS.n636 8.501
R3634 VSS.n1569 VSS.n1058 8.501
R3635 VSS.t23 VSS.n1570 8.501
R3636 VSS.t1076 VSS.n1571 8.501
R3637 VSS.t179 VSS.n1542 8.501
R3638 VSS.t179 VSS.n1543 8.501
R3639 VSS.t179 VSS.n1544 8.501
R3640 VSS.t179 VSS.n1547 8.501
R3641 VSS.t179 VSS.n1553 8.501
R3642 VSS.n602 VSS.n2527 4.251
R3643 VSS.n2527 VSS.n603 2.12602
R3644 VSS.n1523 VSS.n598 4.251
R3645 VSS.n1505 VSS.n595 4.25113
R3646 VSS.n598 VSS.n599 0.00149997
R3647 VSS.n2515 VSS.n588 3.4011
R3648 VSS.n594 VSS.n2508 4.251
R3649 VSS.n594 VSS.n593 0.00149997
R3650 VSS.n586 VSS.n587 0.00212469
R3651 VSS.n578 VSS.n579 2.42956
R3652 VSS.n2283 VSS.n572 4.25113
R3653 VSS.n2278 VSS.n567 2.42951
R3654 VSS.n567 VSS.n568 0.00271416
R3655 VSS.n2287 VSS.n561 2.12597
R3656 VSS.n2299 VSS.n557 1.701
R3657 VSS.n552 VSS.n2328 2.8345
R3658 VSS.n2328 VSS.n555 3.40102
R3659 VSS.n546 VSS.n2251 2.83433
R3660 VSS.n2257 VSS.n547 2.12602
R3661 VSS.n2213 VSS.n338 8.501
R3662 VSS.n2213 VSS.n340 4.25113
R3663 VSS.n2213 VSS.n342 3.40102
R3664 VSS.n328 VSS.n2226 8.501
R3665 VSS.n2229 VSS.n333 4.251
R3666 VSS.n333 VSS.n332 0.00149997
R3667 VSS.n2229 VSS.n335 2.83417
R3668 VSS.n335 VSS.n334 0.00166658
R3669 VSS.n334 VSS.n336 0.00149997
R3670 VSS.n318 VSS.n319 0.00159992
R3671 VSS.n319 VSS.n320 2.42945
R3672 VSS.n1821 VSS.n325 2.42956
R3673 VSS.n1827 VSS.n308 2.42957
R3674 VSS.n1827 VSS.n307 2.52048
R3675 VSS.n313 VSS.n1835 2.83439
R3676 VSS.n313 VSS.n316 0.00141665
R3677 VSS.n1856 VSS.n296 3.40102
R3678 VSS.n294 VSS.n293 0.00149997
R3679 VSS.n1856 VSS.n294 4.251
R3680 VSS.n300 VSS.n1869 2.83428
R3681 VSS.n300 VSS.n299 0.00158329
R3682 VSS.n1869 VSS.n303 4.251
R3683 VSS.n303 VSS.n297 0.00149997
R3684 VSS.n284 VSS.n2120 4.66004
R3685 VSS.n285 VSS.n288 0.00252208
R3686 VSS.n2120 VSS.n285 1.88982
R3687 VSS.n2115 VSS.n292 2.4296
R3688 VSS.n2158 VSS.n276 2.42957
R3689 VSS.n2161 VSS.n279 2.42956
R3690 VSS.n266 VSS.n2178 8.501
R3691 VSS.n2169 VSS.n268 4.25113
R3692 VSS.n2178 VSS.n271 2.42951
R3693 VSS.n271 VSS.n273 0.00271416
R3694 VSS.n1784 VSS.n256 2.42967
R3695 VSS.n2195 VSS.n262 2.12578
R3696 VSS.n262 VSS.n263 0.00274975
R3697 VSS.n263 VSS.n264 0.00149997
R3698 VSS.n2206 VSS.n248 8.501
R3699 VSS.n2197 VSS.n252 3.40102
R3700 VSS.n249 VSS.n248 1.79863
R3701 VSS.n240 VSS.n242 3.40102
R3702 VSS.n2098 VSS.n244 2.83428
R3703 VSS.n244 VSS.n245 0.00249992
R3704 VSS.n2103 VSS.n234 8.501
R3705 VSS.n2100 VSS.n2073 8.501
R3706 VSS.n2103 VSS.n236 4.251
R3707 VSS.n236 VSS.n235 0.00149997
R3708 VSS.n2105 VSS.n224 2.42967
R3709 VSS.n227 VSS.n2108 2.83439
R3710 VSS.n227 VSS.n230 0.00141665
R3711 VSS.n1918 VSS.n221 8.501
R3712 VSS.n1915 VSS.n216 2.42967
R3713 VSS.n1918 VSS.n223 4.251
R3714 VSS.n223 VSS.n222 0.00149997
R3715 VSS.n1975 VSS.n210 4.25113
R3716 VSS.n1982 VSS.n213 1.88985
R3717 VSS.n214 VSS.n215 0.00149997
R3718 VSS.n1997 VSS.n201 8.501
R3719 VSS.n1992 VSS.n203 4.25113
R3720 VSS.n1997 VSS.n207 2.42951
R3721 VSS.n207 VSS.n208 0.00271416
R3722 VSS.n2015 VSS.n1946 8.501
R3723 VSS.n2015 VSS.n1947 8.501
R3724 VSS.n2015 VSS.n2014 8.501
R3725 VSS.n2019 VSS.n1936 8.501
R3726 VSS.n2042 VSS.n2041 8.501
R3727 VSS.n2042 VSS.n1931 8.501
R3728 VSS.n2031 VSS.n2030 8.501
R3729 VSS.n2419 VSS.n2354 8.501
R3730 VSS.n2419 VSS.n2346 8.501
R3731 VSS.n2439 VSS.n190 2.46389
R3732 VSS.n194 VSS.n193 0.00159992
R3733 VSS.n2439 VSS.n194 2.42945
R3734 VSS.n189 VSS.n198 8.501
R3735 VSS.n199 VSS.n198 3.4011
R3736 VSS.n195 VSS.n200 1.44263
R3737 VSS.n180 VSS.n179 0.0016189
R3738 VSS.n2456 VSS.n180 1.88973
R3739 VSS.n982 VSS.n186 3.40102
R3740 VSS.n982 VSS.n188 3.17587
R3741 VSS.n983 VSS.n172 3.40102
R3742 VSS.n983 VSS.n170 4.25113
R3743 VSS.n991 VSS.n176 4.25113
R3744 VSS.n991 VSS.n177 3.4011
R3745 VSS.n1000 VSS.n47 3.40098
R3746 VSS.n993 VSS.n38 3.40102
R3747 VSS.n993 VSS.n46 4.25113
R3748 VSS.n1000 VSS.n168 3.40102
R3749 VSS.n114 VSS.n134 2.83436
R3750 VSS.n31 VSS.n865 8.501
R3751 VSS.n44 VSS.n43 0.0024989
R3752 VSS.n1008 VSS.n48 4.95839
R3753 VSS.n1011 VSS.n67 2.6431
R3754 VSS.n1011 VSS.n56 3.40224
R3755 VSS.n1014 VSS.n58 2.01564
R3756 VSS.n856 VSS.n165 2.83433
R3757 VSS.n164 VSS.n35 1.60262
R3758 VSS.n837 VSS.n163 3.40102
R3759 VSS.n10 VSS.n70 0.00266598
R3760 VSS.n830 VSS.n10 1.88946
R3761 VSS.n822 VSS.n161 2.42945
R3762 VSS.n76 VSS.n74 0.00388863
R3763 VSS.n824 VSS.n74 1.88968
R3764 VSS.n794 VSS.n160 1.52739
R3765 VSS.n782 VSS.n16 1.70097
R3766 VSS.n755 VSS.n155 8.501
R3767 VSS.n762 VSS.n156 1.12067
R3768 VSS.n747 VSS.n151 2.42945
R3769 VSS.n154 VSS.n153 1.93287
R3770 VSS.n89 VSS.n87 0.00249966
R3771 VSS.n748 VSS.n89 2.42945
R3772 VSS.n93 VSS.n727 8.501
R3773 VSS.n718 VSS.n17 2.12586
R3774 VSS.n718 VSS.n148 2.39804
R3775 VSS.n711 VSS.n19 1.88922
R3776 VSS.n19 VSS.n18 0.00313778
R3777 VSS.n147 VSS.n22 1.89776
R3778 VSS.n712 VSS.n21 2.42967
R3779 VSS.n687 VSS.n100 2.12562
R3780 VSS.n687 VSS.n143 2.39804
R3781 VSS.n96 VSS.n695 4.251
R3782 VSS.n695 VSS.n146 3.4011
R3783 VSS.n141 VSS.n124 2.45352
R3784 VSS.n2478 VSS.n110 2.83422
R3785 VSS.n139 VSS.n128 2.45352
R3786 VSS.n2404 VSS.n112 2.83422
R3787 VSS.n105 VSS.n104 0.00205508
R3788 VSS.n2415 VSS.n113 2.02702
R3789 VSS.n2369 VSS.n116 2.12586
R3790 VSS.n2369 VSS.n137 3.27123
R3791 VSS.n354 VSS.t131 0.541264
R3792 VSS.n344 VSS.n343 2.31514
R3793 VSS.n389 VSS.n386 3.33079
R3794 VSS.n387 VSS.n382 2.31581
R3795 VSS.n383 VSS.n378 2.31585
R3796 VSS.n379 VSS.n374 2.31585
R3797 VSS.n375 VSS.n370 2.31585
R3798 VSS.n371 VSS.n366 2.31585
R3799 VSS.n367 VSS.n355 2.31585
R3800 VSS.n363 VSS.n356 3.33087
R3801 VSS.n356 VSS.t773 8.501
R3802 VSS.n362 VSS.n361 3.33079
R3803 VSS.t26 VSS.n1307 8.501
R3804 VSS.t836 VSS.n406 0.23168
R3805 VSS.n403 VSS.t120 0.129991
R3806 VSS.t832 VSS.n400 8.501
R3807 VSS.t224 VSS.n397 3.4011
R3808 VSS.n395 VSS.n396 0.00257133
R3809 VSS.t224 VSS.n395 2.42951
R3810 VSS.n392 VSS.n393 0.00257133
R3811 VSS.t224 VSS.n392 2.42951
R3812 VSS.t224 VSS.n391 8.501
R3813 VSS.t224 VSS.n1743 8.501
R3814 VSS.t30 VSS.t279 8.501
R3815 VSS.n412 VSS.t462 4.23277
R3816 VSS.t30 VSS.n407 3.40102
R3817 VSS.n410 VSS.t894 0.0333775
R3818 VSS.n417 VSS.t892 8.501
R3819 VSS.t889 VSS.n421 0.130189
R3820 VSS.t537 VSS.n419 8.501
R3821 VSS.t575 VSS.n420 8.501
R3822 VSS.n429 VSS.n422 0.734091
R3823 VSS.n426 VSS.n424 3.33087
R3824 VSS.n424 VSS.n425 1.09214
R3825 VSS.t169 VSS.n443 0.431727
R3826 VSS.n437 VSS.t906 0.215686
R3827 VSS.t246 VSS.n436 8.501
R3828 VSS.n433 VSS.n432 5.6463
R3829 VSS.t202 VSS.n430 8.501
R3830 VSS.t902 VSS.n445 8.501
R3831 VSS.t202 VSS.n444 3.40102
R3832 VSS.n449 VSS.t901 5.6463
R3833 VSS.n448 VSS.n447 0.00149997
R3834 VSS.n448 VSS.t202 4.251
R3835 VSS.n1353 VSS.t322 8.501
R3836 VSS.t103 VSS.n450 3.4011
R3837 VSS.n460 VSS.t900 0.0346178
R3838 VSS.t103 VSS.n452 3.40102
R3839 VSS.t899 VSS.n1681 8.501
R3840 VSS.n456 VSS.n457 0.00149997
R3841 VSS.n454 VSS.n456 0.00166658
R3842 VSS.n455 VSS.n454 0.00205508
R3843 VSS.t103 VSS.n469 4.251
R3844 VSS.n468 VSS.n463 0.00249992
R3845 VSS.t103 VSS.n468 2.83428
R3846 VSS.t103 VSS.n466 3.4013
R3847 VSS.t448 VSS.n470 0.321554
R3848 VSS.n478 VSS.t293 0.00166658
R3849 VSS.t292 VSS.n478 2.83417
R3850 VSS.t74 VSS.n476 1.70081
R3851 VSS.n476 VSS.n487 0.00309967
R3852 VSS.t74 VSS.n486 4.251
R3853 VSS.n485 VSS.t222 5.64879
R3854 VSS.t74 VSS.n483 8.501
R3855 VSS.n482 VSS.t672 1.53219
R3856 VSS.n488 VSS.t952 8.501
R3857 VSS.n513 VSS.n488 1.5303
R3858 VSS.t62 VSS.n512 0.130189
R3859 VSS.t146 VSS.n510 0.762889
R3860 VSS.n500 VSS.t948 8.501
R3861 VSS.t945 VSS.n502 0.130189
R3862 VSS.t943 VSS.n496 8.501
R3863 VSS.t940 VSS.n498 0.130189
R3864 VSS.t938 VSS.n491 8.501
R3865 VSS.n494 VSS.n492 3.33079
R3866 VSS.n516 VSS.t270 0.61301
R3867 VSS.n543 VSS.t194 0.928581
R3868 VSS.t1034 VSS.n542 0.0712474
R3869 VSS.t1031 VSS.n540 0.130189
R3870 VSS.t1029 VSS.n535 8.501
R3871 VSS.t1026 VSS.n537 0.130189
R3872 VSS.t1024 VSS.n531 8.501
R3873 VSS.t1021 VSS.n533 0.130189
R3874 VSS.t1019 VSS.n527 8.501
R3875 VSS.t1016 VSS.n529 0.130189
R3876 VSS.t1014 VSS.n523 8.501
R3877 VSS.t1011 VSS.n525 0.130189
R3878 VSS.t1009 VSS.n518 8.501
R3879 VSS.n521 VSS.n519 3.33079
R3880 VSS.n31 VSS.n62 8.50158
R3881 VSS.n1524 VSS.n1479 8.5005
R3882 VSS.n1524 VSS.n1478 8.5005
R3883 VSS.n1524 VSS.n1477 8.5005
R3884 VSS.n1524 VSS.n1476 8.5005
R3885 VSS.n1524 VSS.n1475 8.5005
R3886 VSS.n1525 VSS.n1524 8.5005
R3887 VSS.n1524 VSS.n1474 8.5005
R3888 VSS.n1524 VSS.n1473 8.5005
R3889 VSS.n1524 VSS.n1472 8.5005
R3890 VSS.n1524 VSS.n1471 8.5005
R3891 VSS.n586 VSS.n2494 8.5005
R3892 VSS.n586 VSS.n582 8.5005
R3893 VSS.n586 VSS.n2493 8.5005
R3894 VSS.n586 VSS.n2491 8.5005
R3895 VSS.n2507 VSS.n586 8.5005
R3896 VSS.n586 VSS.n655 8.5005
R3897 VSS.n586 VSS.n583 8.5005
R3898 VSS.n586 VSS.n654 8.5005
R3899 VSS.n2270 VSS.n921 8.5005
R3900 VSS.n2270 VSS.n920 8.5005
R3901 VSS.n2270 VSS.n919 8.5005
R3902 VSS.n2290 VSS.n2285 8.5005
R3903 VSS.n2290 VSS.n2284 8.5005
R3904 VSS.n556 VSS.n911 8.5005
R3905 VSS.n878 VSS.n551 8.5005
R3906 VSS.n888 VSS.n551 8.5005
R3907 VSS.n890 VSS.n551 8.5005
R3908 VSS.t561 VSS.n551 8.5005
R3909 VSS.n893 VSS.n551 8.5005
R3910 VSS.n895 VSS.n551 8.5005
R3911 VSS.n2379 VSS.n2370 8.5005
R3912 VSS.n2379 VSS.n2377 8.5005
R3913 VSS.n2379 VSS.n2372 8.5005
R3914 VSS.n2379 VSS.n2376 8.5005
R3915 VSS.n2379 VSS.n2373 8.5005
R3916 VSS.n2379 VSS.n2375 8.5005
R3917 VSS.n2387 VSS.n2372 8.5005
R3918 VSS.t898 VSS.t462 0.0377146
R3919 VSS.n441 VSS.t9 4.25075
R3920 VSS.n441 VSS.t10 0.00149997
R3921 VSS.n592 VSS.n643 8.4847
R3922 VSS.n2450 VSS.n870 8.4847
R3923 VSS.n2202 VSS.n248 8.47497
R3924 VSS.n2067 VSS.n234 8.47497
R3925 VSS.n35 VSS.n846 8.47497
R3926 VSS.n808 VSS.n159 8.47497
R3927 VSS.n15 VSS.n769 8.47497
R3928 VSS.n766 VSS.n155 8.47497
R3929 VSS.n94 VSS.n93 4.18045
R3930 VSS.n101 VSS.n96 4.18045
R3931 VSS.n2525 VSS.n605 8.47188
R3932 VSS.n604 VSS.n2526 8.47188
R3933 VSS.n2528 VSS.n601 8.47145
R3934 VSS.n2512 VSS.n2511 8.47145
R3935 VSS.n949 VSS.n576 8.47145
R3936 VSS.n951 VSS.n947 8.47145
R3937 VSS.n577 VSS.n955 8.47145
R3938 VSS.n954 VSS.n581 8.47145
R3939 VSS.n2311 VSS.n571 8.47145
R3940 VSS.n2312 VSS.n572 8.47145
R3941 VSS.n2308 VSS.n573 8.47145
R3942 VSS.n2309 VSS.n575 8.47145
R3943 VSS.n2320 VSS.n569 8.47145
R3944 VSS.n2323 VSS.n2322 8.47145
R3945 VSS.n2288 VSS.n563 8.47145
R3946 VSS.n562 VSS.n564 8.47145
R3947 VSS.n2296 VSS.n558 8.47145
R3948 VSS.n2297 VSS.n560 8.47145
R3949 VSS.n559 VSS.n2298 8.47145
R3950 VSS.n2331 VSS.n554 8.47145
R3951 VSS.n2332 VSS.n553 8.47145
R3952 VSS.n2255 VSS.n549 8.47145
R3953 VSS.n548 VSS.n2256 8.47145
R3954 VSS.n337 VSS.n898 8.47145
R3955 VSS.n2211 VSS.n340 8.47145
R3956 VSS.n339 VSS.n2212 8.47145
R3957 VSS.n2210 VSS.n341 8.47145
R3958 VSS.n2216 VSS.n327 8.47145
R3959 VSS.n2220 VSS.n332 8.47145
R3960 VSS.n2221 VSS.n2219 8.47145
R3961 VSS.n2222 VSS.n334 8.47145
R3962 VSS.n2223 VSS.n336 8.47145
R3963 VSS.n1816 VSS.n322 8.47145
R3964 VSS.n318 VSS.n317 8.47145
R3965 VSS.n324 VSS.n323 8.47145
R3966 VSS.n326 VSS.n1820 8.47145
R3967 VSS.n1819 VSS.n1818 8.47145
R3968 VSS.n1840 VSS.n310 8.47145
R3969 VSS.n1841 VSS.n311 8.47145
R3970 VSS.n1842 VSS.n309 8.47145
R3971 VSS.n1843 VSS.n305 8.47145
R3972 VSS.n1836 VSS.n314 8.47145
R3973 VSS.n1837 VSS.n316 8.47145
R3974 VSS.n1838 VSS.n315 8.47145
R3975 VSS.n295 VSS.n1855 8.47145
R3976 VSS.n1850 VSS.n1849 8.47145
R3977 VSS.n1848 VSS.n293 8.47145
R3978 VSS.n1870 VSS.n299 8.47145
R3979 VSS.n302 VSS.n301 8.47145
R3980 VSS.n1852 VSS.n1851 8.47145
R3981 VSS.n1853 VSS.n297 8.47145
R3982 VSS.n2130 VSS.n287 8.47145
R3983 VSS.n2131 VSS.n288 8.47145
R3984 VSS.n2132 VSS.n286 8.47145
R3985 VSS.n2133 VSS.n282 8.47145
R3986 VSS.n2127 VSS.n291 8.47145
R3987 VSS.n2128 VSS.n290 8.47145
R3988 VSS.n2156 VSS.n274 8.47145
R3989 VSS.n275 VSS.n2157 8.47145
R3990 VSS.n278 VSS.n277 8.47145
R3991 VSS.n2145 VSS.n280 8.47145
R3992 VSS.n2146 VSS.n2144 8.47145
R3993 VSS.n2185 VSS.n267 8.47145
R3994 VSS.n2186 VSS.n268 8.47145
R3995 VSS.n2180 VSS.n2179 8.47145
R3996 VSS.n2182 VSS.n273 8.47145
R3997 VSS.n260 VSS.n1783 8.47145
R3998 VSS.n1782 VSS.n258 8.47145
R3999 VSS.n257 VSS.n1779 8.47145
R4000 VSS.n2191 VSS.n261 8.47145
R4001 VSS.n2192 VSS.n263 8.47145
R4002 VSS.n2193 VSS.n264 8.47145
R4003 VSS.n265 VSS.n2194 8.47145
R4004 VSS.n2199 VSS.n251 8.47145
R4005 VSS.n2201 VSS.n247 8.47145
R4006 VSS.n241 VSS.n2095 8.47145
R4007 VSS.n239 VSS.n237 8.47145
R4008 VSS.n2089 VSS.n243 8.47145
R4009 VSS.n2088 VSS.n245 8.47145
R4010 VSS.n2087 VSS.n2076 8.47145
R4011 VSS.n2069 VSS.n232 8.47145
R4012 VSS.n2072 VSS.n2071 8.47145
R4013 VSS.n2064 VSS.n2063 8.47145
R4014 VSS.n2062 VSS.n235 8.47145
R4015 VSS.n2061 VSS.n2052 8.47145
R4016 VSS.n1890 VSS.n226 8.47145
R4017 VSS.n1891 VSS.n225 8.47145
R4018 VSS.n1893 VSS.n1892 8.47145
R4019 VSS.n2109 VSS.n229 8.47145
R4020 VSS.n230 VSS.n231 8.47145
R4021 VSS.n1880 VSS.n1879 8.47145
R4022 VSS.n1903 VSS.n218 8.47145
R4023 VSS.n1904 VSS.n217 8.47145
R4024 VSS.n1905 VSS.n1900 8.47145
R4025 VSS.n1911 VSS.n1910 8.47145
R4026 VSS.n1909 VSS.n222 8.47145
R4027 VSS.n1908 VSS.n1907 8.47145
R4028 VSS.n209 VSS.n1972 8.47145
R4029 VSS.n210 VSS.n1974 8.47145
R4030 VSS.n212 VSS.n211 8.47145
R4031 VSS.n214 VSS.n1981 8.47145
R4032 VSS.n1980 VSS.n215 8.47145
R4033 VSS.n202 VSS.n1991 8.47145
R4034 VSS.n1988 VSS.n203 8.47145
R4035 VSS.n1958 VSS.n1957 8.47145
R4036 VSS.n1955 VSS.n208 8.47145
R4037 VSS.n2010 VSS.n1945 8.47145
R4038 VSS.n2011 VSS.n2009 8.47145
R4039 VSS.n2013 VSS.n2012 8.47145
R4040 VSS.n2005 VSS.n2004 8.47145
R4041 VSS.n2003 VSS.n1937 8.47145
R4042 VSS.n2038 VSS.n1930 8.47145
R4043 VSS.n2040 VSS.n2039 8.47145
R4044 VSS.n2027 VSS.n2025 8.47145
R4045 VSS.n2029 VSS.n2028 8.47145
R4046 VSS.n2353 VSS.n2352 8.47145
R4047 VSS.n2350 VSS.n2345 8.47145
R4048 VSS.n2426 VSS.n196 8.47145
R4049 VSS.n2427 VSS.n193 8.47145
R4050 VSS.n2428 VSS.n2425 8.47145
R4051 VSS.n2429 VSS.n192 8.47145
R4052 VSS.n189 VSS.n2436 8.47145
R4053 VSS.n183 VSS.n2455 8.47145
R4054 VSS.n871 VSS.n181 8.47145
R4055 VSS.n2447 VSS.n179 8.47145
R4056 VSS.n2453 VSS.n187 8.47145
R4057 VSS.n985 VSS.n171 8.47145
R4058 VSS.n986 VSS.n169 8.47145
R4059 VSS.n971 VSS.n170 8.47145
R4060 VSS.n989 VSS.n176 8.47145
R4061 VSS.n175 VSS.n990 8.47145
R4062 VSS.n994 VSS.n37 0.82582
R4063 VSS.n39 VSS.n37 4.17744
R4064 VSS.n46 VSS.n992 8.47145
R4065 VSS.n995 VSS.n166 8.47145
R4066 VSS.n64 VSS.n45 3.30804
R4067 VSS.n52 VSS.n6 0.881679
R4068 VSS.n65 VSS.n56 3.30936
R4069 VSS.n65 VSS.n54 1.3344
R4070 VSS.n66 VSS.n61 3.30909
R4071 VSS.n60 VSS.n66 1.30343
R4072 VSS.n678 VSS.n36 1.59512
R4073 VSS.n841 VSS.n72 0.470395
R4074 VSS.n71 VSS.n70 1.52063
R4075 VSS.n9 VSS.n40 3.30804
R4076 VSS.n73 VSS.n823 8.47145
R4077 VSS.n12 VSS.n11 0.568102
R4078 VSS.n78 VSS.n81 1.01128
R4079 VSS.n81 VSS.n80 4.17786
R4080 VSS.n26 VSS.n25 0.80541
R4081 VSS.n16 VSS.n85 3.30804
R4082 VSS.n24 VSS.n23 2.72221
R4083 VSS.n765 VSS.n24 0.988439
R4084 VSS.n86 VSS.n13 3.30804
R4085 VSS.n83 VSS.n84 0.67431
R4086 VSS.n90 VSS.n91 4.17786
R4087 VSS.n88 VSS.n87 4.17786
R4088 VSS.n92 VSS.n17 3.30804
R4089 VSS.n92 VSS.n94 0.528281
R4090 VSS.n27 VSS.n20 1.16441
R4091 VSS.n18 VSS.n20 2.72221
R4092 VSS.n95 VSS.n22 2.72221
R4093 VSS.n95 VSS.n27 1.1698
R4094 VSS.n697 VSS.n144 8.47145
R4095 VSS.n697 VSS.n101 0.35257
R4096 VSS.n118 VSS.n117 0.670732
R4097 VSS.n125 VSS.n124 4.18045
R4098 VSS.n123 VSS.n110 4.17786
R4099 VSS.n2479 VSS.n109 8.47145
R4100 VSS.n662 VSS.n0 19.3976
R4101 VSS.n120 VSS.n119 0.670732
R4102 VSS.n129 VSS.n128 4.18045
R4103 VSS.n127 VSS.n112 4.17786
R4104 VSS.n2405 VSS.n111 8.47145
R4105 VSS.n121 VSS.n108 0.39621
R4106 VSS.n131 VSS.n116 3.30804
R4107 VSS.n132 VSS.n107 4.18045
R4108 VSS.t1075 VSS.n1560 8.47111
R4109 VSS.n1572 VSS.t1065 8.47111
R4110 VSS.n1574 VSS.t1062 8.47111
R4111 VSS.t1055 VSS.n1555 8.47111
R4112 VSS.t823 VSS.n1119 8.47111
R4113 VSS.n394 VSS.t821 8.47111
R4114 VSS.t820 VSS.n1118 8.47111
R4115 VSS.n390 VSS.t818 8.47111
R4116 VSS.t817 VSS.n391 8.47111
R4117 VSS.t31 VSS.n1323 8.47111
R4118 VSS.t895 VSS.n408 8.47111
R4119 VSS.t248 VSS.n435 8.47111
R4120 VSS.n446 VSS.t351 8.47111
R4121 VSS.t554 VSS.n447 8.47111
R4122 VSS.n1382 VSS.t107 8.47111
R4123 VSS.n453 VSS.t650 8.47111
R4124 VSS.n1336 VSS.n457 8.47111
R4125 VSS.n456 VSS.t649 8.47111
R4126 VSS.n462 VSS.n461 4.177
R4127 VSS.n462 VSS.n464 0.479287
R4128 VSS.n463 VSS.n464 4.177
R4129 VSS.t355 VSS.n467 8.47111
R4130 VSS.n1682 VSS.n1335 8.47111
R4131 VSS.t293 VSS.n479 8.47111
R4132 VSS.n474 VSS.n473 3.34093
R4133 VSS.n1661 VSS.n487 8.47111
R4134 VSS.n480 VSS.n481 4.177
R4135 VSS.t235 VSS.n481 0.119605
R4136 VSS.t252 VSS.n1660 8.47111
R4137 VSS.n1500 VSS.n1499 8.47103
R4138 VSS.n595 VSS.n596 8.47103
R4139 VSS.n1518 VSS.n599 8.47103
R4140 VSS.n2513 VSS.n589 8.47103
R4141 VSS.n2509 VSS.n593 8.47103
R4142 VSS.n2274 VSS.n568 8.47103
R4143 VSS.n545 VSS.n2263 8.47103
R4144 VSS.n2434 VSS.n2433 8.47103
R4145 VSS.n2451 VSS.n185 8.47103
R4146 VSS.t737 VSS.n1122 8.36235
R4147 VSS.t501 VSS.n2240 8.36235
R4148 VSS.n1260 VSS.t42 8.36235
R4149 VSS.t1218 VSS.n707 8.30819
R4150 VSS.t786 VSS.n1122 8.3005
R4151 VSS.t832 VSS.n1737 8.3005
R4152 VSS.n1736 VSS.t313 8.3005
R4153 VSS.t539 VSS.n1123 8.3005
R4154 VSS.t457 VSS.n1678 8.3005
R4155 VSS.n1677 VSS.t102 8.3005
R4156 VSS.t62 VSS.n1383 8.3005
R4157 VSS.t979 VSS.n1608 8.3005
R4158 VSS.n1607 VSS.t1034 8.3005
R4159 VSS.t455 VSS.n606 8.3005
R4160 VSS.n2541 VSS.t1108 8.3005
R4161 VSS.n1260 VSS.t109 8.3005
R4162 VSS.n1309 VSS.t122 8.3005
R4163 VSS.t506 VSS.n1731 8.3005
R4164 VSS.n1730 VSS.t87 8.3005
R4165 VSS.t498 VSS.n1310 8.3005
R4166 VSS.t210 VSS.n1666 8.3005
R4167 VSS.n1665 VSS.t373 8.3005
R4168 VSS.t33 VSS.n1424 8.3005
R4169 VSS.t635 VSS.n1046 8.3005
R4170 VSS.n2240 VSS.t309 8.3005
R4171 VSS.n644 VSS.n637 8.244
R4172 VSS.n2229 VSS.n2228 8.15732
R4173 VSS.n1759 VSS.t407 8.15732
R4174 VSS.t1314 VSS.n1830 8.15732
R4175 VSS.n2116 VSS.n2115 8.15732
R4176 VSS.t406 VSS.n2121 8.15732
R4177 VSS.n2150 VSS.n2143 8.15732
R4178 VSS.n2148 VSS.n2137 8.15732
R4179 VSS.t1316 VSS.n2173 8.15732
R4180 VSS.n1773 VSS.t560 8.15732
R4181 VSS.t1201 VSS.n2055 8.15732
R4182 VSS.t591 VSS.n1898 8.15732
R4183 VSS.t590 VSS.n1952 8.15732
R4184 VSS.n1762 VSS.n1761 8.15732
R4185 VSS.n1828 VSS.n307 18.2343
R4186 VSS.n284 VSS.n2119 17.4754
R4187 VSS.n2151 VSS.n2142 8.15732
R4188 VSS.n2171 VSS.n2170 8.15732
R4189 VSS.n1994 VSS.n1993 8.15732
R4190 VSS.n2368 VSS.n136 8.15732
R4191 VSS.t407 VSS.n1758 8.09881
R4192 VSS.n1831 VSS.t1314 8.09881
R4193 VSS.n1869 VSS.n1868 8.09881
R4194 VSS.t254 VSS.n1862 8.09881
R4195 VSS.n2158 VSS.n2141 8.09881
R4196 VSS.n2174 VSS.t1316 8.09881
R4197 VSS.t560 VSS.n1772 8.09881
R4198 VSS.n2058 VSS.t1201 8.09881
R4199 VSS.n1901 VSS.t591 8.09881
R4200 VSS.n1953 VSS.t590 8.09881
R4201 VSS.n2123 VSS.t406 8.09881
R4202 VSS.n2197 VSS.n249 3.27123
R4203 VSS.n2086 VSS.n242 8.09881
R4204 VSS.n2084 VSS.t1236 8.09881
R4205 VSS.t1236 VSS.n2079 8.09881
R4206 VSS.n2100 VSS.n233 8.09881
R4207 VSS.n1915 VSS.n220 8.09881
R4208 VSS.t49 VSS.n929 8.07742
R4209 VSS.n743 VSS.t415 8.07742
R4210 VSS.n1808 VSS.n1798 8.03952
R4211 VSS.n1811 VSS.n1799 8.03952
R4212 VSS.n2000 VSS.n1941 8.03952
R4213 VSS.n1998 VSS.n1942 8.03952
R4214 VSS.n1939 VSS.n1933 8.03952
R4215 VSS.n2023 VSS.n1926 8.03952
R4216 VSS.n1810 VSS.n1804 8.03952
R4217 VSS.n1863 VSS.t254 8.03952
R4218 VSS.n2022 VSS.n1927 8.03952
R4219 VSS.n2045 VSS.n1922 8.03952
R4220 VSS.n2042 VSS.n2020 7.97944
R4221 VSS.n1802 VSS.n320 7.97944
R4222 VSS.t571 VSS.n2360 7.97944
R4223 VSS.n2356 VSS.n130 7.97944
R4224 VSS.n2361 VSS.t571 7.97944
R4225 VSS.t375 VSS.n1025 7.92694
R4226 VSS.n1791 VSS.n1790 7.91854
R4227 VSS.n1789 VSS.n1780 7.91854
R4228 VSS.n1792 VSS.n1777 7.91854
R4229 VSS.n1785 VSS.n1784 7.91854
R4230 VSS.n2431 VSS.t166 7.86671
R4231 VSS.t592 VSS.n973 7.86671
R4232 VSS.n968 VSS.t533 7.86671
R4233 VSS.n2105 VSS.n1889 7.85682
R4234 VSS.n1885 VSS.t1196 7.85682
R4235 VSS.t1196 VSS.n1884 7.85682
R4236 VSS.n1970 VSS.n1963 7.85682
R4237 VSS.t1128 VSS.n1962 7.85682
R4238 VSS.n1968 VSS.t1128 7.85682
R4239 VSS.t415 VSS.n742 7.84665
R4240 VSS.t324 VSS.n1017 7.83145
R4241 VSS.t166 VSS.n2423 7.80845
R4242 VSS.n188 VSS.n981 17.392
R4243 VSS.t1129 VSS.n2460 7.80845
R4244 VSS.n977 VSS.t592 7.80845
R4245 VSS.n1000 VSS.n999 7.80845
R4246 VSS.t533 VSS.n967 7.80845
R4247 VSS.n2438 VSS.n190 17.6594
R4248 VSS.n980 VSS.n869 7.80845
R4249 VSS.n2536 VSS.n2535 7.79
R4250 VSS.n653 VSS.n638 7.69771
R4251 VSS.n1045 VSS.t563 7.64452
R4252 VSS.n895 VSS.n894 7.61588
R4253 VSS.n1471 VSS.n1465 7.60988
R4254 VSS.n2534 VSS.n611 7.60988
R4255 VSS.n1043 VSS.t500 7.5513
R4256 VSS.n30 VSS.n864 7.50896
R4257 VSS.t1156 VSS.n1028 7.29283
R4258 VSS.t310 VSS.n1027 7.29283
R4259 VSS.t705 VSS.n1026 7.29283
R4260 VSS.t500 VSS.n1042 7.26218
R4261 VSS.t186 VSS.t153 7.1604
R4262 VSS.t9 VSS.t909 7.1604
R4263 VSS.t531 VSS.t608 7.1604
R4264 VSS.n893 VSS.n892 7.15435
R4265 VSS.n1044 VSS.t468 7.07637
R4266 VSS.n2257 VSS.t49 6.92358
R4267 VSS.n2208 VSS.n2207 6.87335
R4268 VSS.t1130 VSS.n917 6.7646
R4269 VSS.n2378 VSS.n2374 6.72996
R4270 VSS.t290 VSS.n916 6.72989
R4271 VSS.t290 VSS.n1040 6.72983
R4272 VSS.t290 VSS.n1039 6.72981
R4273 VSS.n2281 VSS.t1130 6.70851
R4274 VSS.n2265 VSS.n939 6.70851
R4275 VSS.n629 VSS.n622 6.59782
R4276 VSS.t182 VSS.n2538 6.59782
R4277 VSS.n2538 VSS.n616 6.59782
R4278 VSS.n622 VSS.n621 6.59782
R4279 VSS.n2417 VSS.n2416 6.5938
R4280 VSS.t289 VSS.n1039 6.5266
R4281 VSS.t561 VSS.n891 6.46204
R4282 VSS.n2539 VSS.t182 6.34165
R4283 VSS.n621 VSS.n608 6.34165
R4284 VSS.n2493 VSS.t1117 6.34165
R4285 VSS.n1042 VSS.t190 6.14417
R4286 VSS.t697 VSS.n918 6.04054
R4287 VSS.n890 VSS.n889 6.0005
R4288 VSS.n2292 VSS.n917 5.92111
R4289 VSS.n35 VSS.n686 5.81679
R4290 VSS.n35 VSS.n685 5.81679
R4291 VSS.n35 VSS.n684 5.81679
R4292 VSS.n853 VSS.n35 5.81679
R4293 VSS.n855 VSS.n681 5.81679
R4294 VSS.n855 VSS.n682 5.81679
R4295 VSS.n855 VSS.n683 5.81679
R4296 VSS.n855 VSS.n854 5.81679
R4297 VSS.n76 VSS.n812 5.81679
R4298 VSS.n76 VSS.n813 5.81679
R4299 VSS.n76 VSS.n816 5.81679
R4300 VSS.n76 VSS.n814 5.81679
R4301 VSS.n76 VSS.n815 5.81679
R4302 VSS.n11 VSS.n817 5.81679
R4303 VSS.n11 VSS.n818 5.81679
R4304 VSS.n11 VSS.n819 5.81679
R4305 VSS.n11 VSS.n820 5.81679
R4306 VSS.n153 VSS.n739 5.78991
R4307 VSS.n153 VSS.n738 5.78991
R4308 VSS.n153 VSS.n735 5.78991
R4309 VSS.n153 VSS.n737 5.78991
R4310 VSS.n153 VSS.n736 5.78991
R4311 VSS.n83 VSS.n740 5.78991
R4312 VSS.n83 VSS.n741 5.78991
R4313 VSS.n83 VSS.n744 5.78991
R4314 VSS.n83 VSS.n745 5.78991
R4315 VSS.t468 VSS.t601 5.78013
R4316 VSS.n466 VSS.t665 5.77734
R4317 VSS.n2381 VSS.n2377 5.76584
R4318 VSS.n2381 VSS.n2371 5.76525
R4319 VSS.n2380 VSS.n2371 5.76494
R4320 VSS.n2389 VSS.n2380 5.76494
R4321 VSS.n2267 VSS.n928 5.76327
R4322 VSS.n2267 VSS.n933 5.76327
R4323 VSS.n881 VSS.n338 5.76327
R4324 VSS.n883 VSS.n338 5.76327
R4325 VSS.n885 VSS.n338 5.76327
R4326 VSS.n2326 VSS.n882 5.76327
R4327 VSS.n2326 VSS.n884 5.76327
R4328 VSS.n2326 VSS.n886 5.76327
R4329 VSS.n956 VSS.n923 5.73688
R4330 VSS.n956 VSS.n944 5.73688
R4331 VSS.n956 VSS.n945 5.73688
R4332 VSS.n0 VSS.n2 0.00179702
R4333 VSS.n2304 VSS.n905 5.71073
R4334 VSS.n832 VSS.n70 5.71073
R4335 VSS.n834 VSS.n70 5.71073
R4336 VSS.n836 VSS.n70 5.71073
R4337 VSS.n800 VSS.n159 5.71073
R4338 VSS.n798 VSS.n159 5.71073
R4339 VSS.n796 VSS.n159 5.71073
R4340 VSS.n160 VSS.n159 1.56272
R4341 VSS.n15 VSS.n774 5.71073
R4342 VSS.n15 VSS.n773 5.71073
R4343 VSS.n15 VSS.n772 5.71073
R4344 VSS.n15 VSS.n771 5.71073
R4345 VSS.n15 VSS.n770 5.71073
R4346 VSS.n25 VSS.n778 5.71073
R4347 VSS.n25 VSS.n779 5.71073
R4348 VSS.n25 VSS.n780 5.71073
R4349 VSS.n25 VSS.n781 5.71073
R4350 VSS.n757 VSS.n155 5.71073
R4351 VSS.n759 VSS.n155 5.71073
R4352 VSS.n761 VSS.n155 5.71073
R4353 VSS.n156 VSS.n155 1.14659
R4354 VSS.n724 VSS.n93 5.71073
R4355 VSS.n722 VSS.n93 5.71073
R4356 VSS.n720 VSS.n93 5.71073
R4357 VSS.n148 VSS.n93 2.45352
R4358 VSS.n28 VSS.n706 5.71073
R4359 VSS.n28 VSS.n709 5.71073
R4360 VSS.n693 VSS.n96 5.71073
R4361 VSS.n691 VSS.n96 5.71073
R4362 VSS.n689 VSS.n96 5.71073
R4363 VSS.n143 VSS.n96 2.45352
R4364 VSS.n3 VSS.n5 0.0022209
R4365 VSS.n2475 VSS.n124 5.71073
R4366 VSS.n2473 VSS.n124 5.71073
R4367 VSS.n2471 VSS.n124 5.71073
R4368 VSS.n2401 VSS.n128 5.71073
R4369 VSS.n2399 VSS.n128 5.71073
R4370 VSS.n2397 VSS.n128 5.71073
R4371 VSS.n2302 VSS.n574 5.68481
R4372 VSS.n906 VSS.n574 5.68481
R4373 VSS.n8 VSS.n833 5.68481
R4374 VSS.n8 VSS.n835 5.68481
R4375 VSS.n8 VSS.n839 5.68481
R4376 VSS.n799 VSS.n77 5.68481
R4377 VSS.n797 VSS.n77 5.68481
R4378 VSS.n795 VSS.n77 5.68481
R4379 VSS.n764 VSS.n756 5.68481
R4380 VSS.n764 VSS.n758 5.68481
R4381 VSS.n764 VSS.n760 5.68481
R4382 VSS.n764 VSS.n763 5.68481
R4383 VSS.n723 VSS.n149 5.68481
R4384 VSS.n721 VSS.n149 5.68481
R4385 VSS.n719 VSS.n149 5.68481
R4386 VSS.n22 VSS.n704 5.68481
R4387 VSS.n22 VSS.n703 5.68481
R4388 VSS.n22 VSS.n702 5.68481
R4389 VSS.n22 VSS.n701 5.68481
R4390 VSS.n28 VSS.n705 5.68481
R4391 VSS.n28 VSS.n710 5.68481
R4392 VSS.n692 VSS.n98 5.68481
R4393 VSS.n690 VSS.n98 5.68481
R4394 VSS.n688 VSS.n98 5.68481
R4395 VSS.n2474 VSS.n117 5.68481
R4396 VSS.n2472 VSS.n117 5.68481
R4397 VSS.n2470 VSS.n117 5.68481
R4398 VSS.n2400 VSS.n119 5.68481
R4399 VSS.n2398 VSS.n119 5.68481
R4400 VSS.n2396 VSS.n119 5.68481
R4401 VSS.t179 VSS.n1545 5.66778
R4402 VSS.t179 VSS.n1546 5.66778
R4403 VSS.t179 VSS.n1548 5.66778
R4404 VSS.t179 VSS.n1549 5.66778
R4405 VSS.t179 VSS.n1550 5.66778
R4406 VSS.t179 VSS.n1551 5.66778
R4407 VSS.t179 VSS.n1552 5.66778
R4408 VSS.t179 VSS.n1554 5.66778
R4409 VSS.n2534 VSS.n2533 5.66778
R4410 VSS.n2534 VSS.n625 5.66778
R4411 VSS.n603 VSS.n2524 0.00256238
R4412 VSS.n1505 VSS.n1498 5.66778
R4413 VSS.n1523 VSS.n1489 5.66778
R4414 VSS.n2515 VSS.n2501 5.66778
R4415 VSS.n588 VSS.n2511 0.00249999
R4416 VSS.n2508 VSS.n2506 5.66778
R4417 VSS.n1486 VSS.n1485 5.66778
R4418 VSS.n2499 VSS.n2498 5.66778
R4419 VSS.n2266 VSS.n937 5.66778
R4420 VSS.n2266 VSS.n938 5.66778
R4421 VSS.n956 VSS.n578 0.00249991
R4422 VSS.n2305 VSS.n903 5.66778
R4423 VSS.n2283 VSS.n909 5.66778
R4424 VSS.n903 VSS.n902 5.66778
R4425 VSS.n2325 VSS.n2324 5.66778
R4426 VSS.n2325 VSS.n896 5.66778
R4427 VSS.n2258 VSS.n2257 5.66778
R4428 VSS.n567 VSS.n566 0.00228546
R4429 VSS.n2287 VSS.n2279 5.66778
R4430 VSS.n557 VSS.n556 0.00264986
R4431 VSS.n555 VSS.n2329 0.00229996
R4432 VSS.n2260 VSS.n2251 5.66778
R4433 VSS.n547 VSS.n2253 0.00256238
R4434 VSS.n329 VSS.n2217 0.0025833
R4435 VSS.n2226 VSS.n1764 5.66778
R4436 VSS.n1801 VSS.n320 5.66778
R4437 VSS.n1835 VSS.n1826 5.66778
R4438 VSS.n2124 VSS.n2115 5.66778
R4439 VSS.n292 VSS.n2125 0.0024999
R4440 VSS.n2158 VSS.n2140 5.66778
R4441 VSS.n2169 VSS.n2167 5.66778
R4442 VSS.n271 VSS.n270 0.00228546
R4443 VSS.n1784 VSS.n1781 5.66778
R4444 VSS.n2197 VSS.n1776 5.66778
R4445 VSS.n2206 VSS.n1766 5.66778
R4446 VSS.n2206 VSS.n254 5.66778
R4447 VSS.n2093 VSS.n240 0.00229996
R4448 VSS.n2098 VSS.n2097 5.66778
R4449 VSS.n2100 VSS.n2057 5.66778
R4450 VSS.n2103 VSS.n2102 5.66778
R4451 VSS.n2105 VSS.n1894 5.66778
R4452 VSS.n2108 VSS.n1877 5.66778
R4453 VSS.n1915 VSS.n1914 5.66778
R4454 VSS.n1918 VSS.n1895 5.66778
R4455 VSS.n1983 VSS.n213 0.00261099
R4456 VSS.n1975 VSS.n1973 5.66778
R4457 VSS.n1992 VSS.n1954 5.66778
R4458 VSS.n207 VSS.n206 0.00228546
R4459 VSS.n2019 VSS.n1934 5.66778
R4460 VSS.n2019 VSS.n1935 5.66778
R4461 VSS.n2032 VSS.n2031 5.66778
R4462 VSS.n2042 VSS.n1932 5.66778
R4463 VSS.n2031 VSS.n2026 5.66778
R4464 VSS.n2419 VSS.n2349 5.66778
R4465 VSS.n2434 VSS.n199 0.00249999
R4466 VSS.n186 VSS.n870 0.00229996
R4467 VSS.n982 VSS.n979 5.66778
R4468 VSS.n177 VSS.n174 0.00249999
R4469 VSS.n47 VSS.n996 0.00269996
R4470 VSS.n168 VSS.n996 0.00229996
R4471 VSS.n115 VSS.n106 5.66778
R4472 VSS.n107 VSS.n106 5.66778
R4473 VSS.n43 VSS.n45 0.00233299
R4474 VSS.n7 VSS.n51 0.00158926
R4475 VSS.n1014 VSS.n61 5.66876
R4476 VSS.n34 VSS.n847 5.66778
R4477 VSS.n848 VSS.n847 5.66778
R4478 VSS.n847 VSS.n679 5.66778
R4479 VSS.n163 VSS.n828 0.00229996
R4480 VSS.n822 VSS.n75 5.66778
R4481 VSS.n74 VSS.n73 0.00211079
R4482 VSS.n804 VSS.n803 5.66778
R4483 VSS.n794 VSS.n79 2.83415
R4484 VSS.n803 VSS.n793 5.66778
R4485 VSS.n803 VSS.n802 5.66778
R4486 VSS.n16 VSS.n15 0.00344965
R4487 VSS.n788 VSS.n775 5.66778
R4488 VSS.n776 VSS.n775 5.66778
R4489 VSS.n783 VSS.n775 5.66778
R4490 VSS.n14 VSS.n754 0.00324989
R4491 VSS.n755 VSS.n14 2.12601
R4492 VSS.n747 VSS.n152 5.66778
R4493 VSS.n17 VSS.n93 0.00331224
R4494 VSS.n727 VSS.n717 5.66778
R4495 VSS.n727 VSS.n726 5.66778
R4496 VSS.n146 VSS.n98 0.00249999
R4497 VSS.n2469 VSS.n122 2.12584
R4498 VSS.n2478 VSS.n2477 5.66778
R4499 VSS.n2395 VSS.n126 2.12584
R4500 VSS.n2404 VSS.n2403 5.66778
R4501 VSS.n104 VSS.n102 1.8894
R4502 VSS.n103 VSS.n2414 0.00249999
R4503 VSS.n116 VSS.n107 0.00331224
R4504 VSS.n399 VSS.n1738 0.00224999
R4505 VSS.n397 VSS.n1121 0.00249999
R4506 VSS.t224 VSS.n1112 5.66778
R4507 VSS.t224 VSS.n1113 5.66778
R4508 VSS.t224 VSS.n1114 5.66778
R4509 VSS.t224 VSS.n1115 5.66778
R4510 VSS.t224 VSS.n1116 5.66778
R4511 VSS.n395 VSS.n394 0.00242827
R4512 VSS.n392 VSS.n390 0.00242827
R4513 VSS.n1719 VSS.n413 5.66778
R4514 VSS.t30 VSS.n1714 5.66778
R4515 VSS.n407 VSS.n409 0.00229996
R4516 VSS.t202 VSS.n431 5.66778
R4517 VSS.n444 VSS.n449 0.00279996
R4518 VSS.t202 VSS.n1340 5.66778
R4519 VSS.n450 VSS.n1679 0.00249999
R4520 VSS.n452 VSS.n1680 0.00229996
R4521 VSS.t103 VSS.n455 1.8894
R4522 VSS.t74 VSS.n472 5.66778
R4523 VSS.n476 VSS.n475 0.00189974
R4524 VSS.t74 VSS.n484 5.66778
R4525 VSS.n592 VSS.n2515 5.66767
R4526 VSS.n576 VSS.n2266 3.40114
R4527 VSS.n903 VSS.n575 3.40114
R4528 VSS.n569 VSS.n2325 3.40114
R4529 VSS.n560 VSS.n559 0.00139998
R4530 VSS.n342 VSS.n341 0.00139998
R4531 VSS.n2226 VSS.n329 2.8344
R4532 VSS.n322 VSS.n318 0.00139998
R4533 VSS.n308 VSS.n311 0.00151425
R4534 VSS.n296 VSS.n298 0.00139998
R4535 VSS.n275 VSS.n276 0.00151425
R4536 VSS.n256 VSS.n260 0.00137142
R4537 VSS.n2195 VSS.n259 5.66767
R4538 VSS.n255 VSS.n252 0.00139998
R4539 VSS.n241 VSS.n242 3.40114
R4540 VSS.n232 VSS.n2100 3.40114
R4541 VSS.n226 VSS.n224 0.00137142
R4542 VSS.n218 VSS.n216 0.00137142
R4543 VSS.n2016 VSS.n2015 5.66767
R4544 VSS.n2019 VSS.n2018 5.66767
R4545 VSS.n2043 VSS.n2042 5.66767
R4546 VSS.n2031 VSS.n1924 5.66767
R4547 VSS.n2420 VSS.n2419 5.66767
R4548 VSS.n193 VSS.n196 0.00139998
R4549 VSS.n179 VSS.n181 0.00151425
R4550 VSS.n174 VSS.n172 0.00139998
R4551 VSS.n167 VSS.n38 0.00139998
R4552 VSS.n1008 VSS.n7 2.12743
R4553 VSS.n79 VSS.n77 0.0019165
R4554 VSS.n89 VSS.n83 0.0024999
R4555 VSS.n28 VSS.n19 0.00361021
R4556 VSS.n100 VSS.n98 0.00274939
R4557 VSS.n122 VSS.n117 0.00179984
R4558 VSS.n1 VSS.n0 0.00180292
R4559 VSS.n126 VSS.n119 0.00179984
R4560 VSS.n108 VSS.n2415 2.83432
R4561 VSS.n2463 VSS.n868 5.66717
R4562 VSS.n2463 VSS.n858 5.66717
R4563 VSS.t175 VSS.n542 3.36544
R4564 VSS.t968 VSS.n474 0.0801178
R4565 VSS.n2303 VSS.n2302 5.63337
R4566 VSS.n906 VSS.t1315 5.63337
R4567 VSS.n907 VSS.n906 5.63337
R4568 VSS.n835 VSS.t155 5.63337
R4569 VSS.t156 VSS.n797 5.63337
R4570 VSS.n756 VSS.n755 5.63337
R4571 VSS.n760 VSS.t157 5.63337
R4572 VSS.t158 VSS.n721 5.63337
R4573 VSS.n707 VSS.n703 5.63337
R4574 VSS.t159 VSS.n690 5.63337
R4575 VSS.t160 VSS.n2472 5.63337
R4576 VSS.t161 VSS.n2398 5.63337
R4577 VSS.n708 VSS.n702 5.63337
R4578 VSS.n2537 VSS.n618 5.62753
R4579 VSS.n1501 VSS.n1491 5.62715
R4580 VSS.n1524 VSS.n1480 5.62715
R4581 VSS.n586 VSS.n2490 5.62715
R4582 VSS.n2259 VSS.n2252 5.62715
R4583 VSS.n221 VSS.n1906 5.61857
R4584 VSS.n72 VSS.n70 3.31014
R4585 VSS.n2530 VSS.n626 5.61584
R4586 VSS.n2532 VSS.n2531 5.61584
R4587 VSS.n2524 VSS.n627 5.61584
R4588 VSS.n1482 VSS.n1481 5.61547
R4589 VSS.n1484 VSS.n1483 5.61547
R4590 VSS.n2495 VSS.n585 5.61547
R4591 VSS.n2497 VSS.n2496 5.61547
R4592 VSS.n950 VSS.n948 5.61547
R4593 VSS.n580 VSS.n953 5.61547
R4594 VSS.n2313 VSS.n570 5.61547
R4595 VSS.n2307 VSS.n2306 5.61547
R4596 VSS.n2321 VSS.n2319 5.61547
R4597 VSS.n2330 VSS.n2329 5.61547
R4598 VSS.n331 VSS.n2225 5.61547
R4599 VSS.n2218 VSS.n2217 5.61547
R4600 VSS.n1815 VSS.n1814 5.61547
R4601 VSS.n2126 VSS.n2125 5.61547
R4602 VSS.n2155 VSS.n2154 5.61547
R4603 VSS.n2184 VSS.n2166 5.61547
R4604 VSS.n2181 VSS.n270 5.61547
R4605 VSS.n2200 VSS.n250 5.61547
R4606 VSS.n246 VSS.n2205 5.61547
R4607 VSS.n1768 VSS.n1767 5.61547
R4608 VSS.n2094 VSS.n2093 5.61547
R4609 VSS.n2070 VSS.n2068 5.61547
R4610 VSS.n1978 VSS.n1977 5.61547
R4611 VSS.n1990 VSS.n1989 5.61547
R4612 VSS.n1956 VSS.n206 5.61547
R4613 VSS.n2007 VSS.n2006 5.61547
R4614 VSS.n2037 VSS.n2036 5.61547
R4615 VSS.n2034 VSS.n2033 5.61547
R4616 VSS.n2351 VSS.n2348 5.61547
R4617 VSS.n1004 VSS.n1003 5.61547
R4618 VSS.n52 VSS.n51 1.20928
R4619 VSS.n852 VSS.n851 5.61547
R4620 VSS.n850 VSS.n849 5.61547
R4621 VSS.n841 VSS.n828 5.61547
R4622 VSS.n821 VSS.n811 5.61547
R4623 VSS.n76 VSS.n162 5.61547
R4624 VSS.n806 VSS.n805 5.61547
R4625 VSS.n807 VSS.n792 5.61547
R4626 VSS.n787 VSS.n786 5.61547
R4627 VSS.n785 VSS.n784 5.61547
R4628 VSS.n754 VSS.n753 5.61547
R4629 VSS.n746 VSS.n734 5.61547
R4630 VSS.n729 VSS.n728 5.61547
R4631 VSS.n730 VSS.n716 5.61547
R4632 VSS.n696 VSS.n145 5.61547
R4633 VSS.n2409 VSS.n105 5.61547
R4634 VSS.n2412 VSS.n103 5.61547
R4635 VSS.n2414 VSS.n2413 5.61547
R4636 VSS.n1503 VSS.n1502 5.61509
R4637 VSS.n1519 VSS.n1493 5.61509
R4638 VSS.n1521 VSS.n1520 5.61509
R4639 VSS.n590 VSS.n2514 5.61509
R4640 VSS.n2505 VSS.n2502 5.61509
R4641 VSS.n2504 VSS.n2503 5.61509
R4642 VSS.n2273 VSS.n566 5.61509
R4643 VSS.n2276 VSS.n2275 5.61509
R4644 VSS.n565 VSS.n2286 5.61509
R4645 VSS.n2262 VSS.n2261 5.61509
R4646 VSS.n2254 VSS.n2253 5.61509
R4647 VSS.n2435 VSS.n197 5.61509
R4648 VSS.n2452 VSS.n184 5.61509
R4649 VSS.n969 VSS.n178 5.61509
R4650 VSS.n997 VSS.n996 5.61509
R4651 VSS.t1116 VSS.n633 5.61485
R4652 VSS.n2522 VSS.t1111 5.61485
R4653 VSS.t1101 VSS.n1508 5.61485
R4654 VSS.n1527 VSS.t1096 5.61485
R4655 VSS.t1091 VSS.n1453 5.61485
R4656 VSS.n1535 VSS.t1086 5.61485
R4657 VSS.t1081 VSS.n1447 5.61485
R4658 VSS.t1125 VSS.n1022 5.61485
R4659 VSS.n2245 VSS.t1120 5.61485
R4660 VSS.n1573 VSS.t1064 5.61485
R4661 VSS.t1063 VSS.n1559 5.61485
R4662 VSS.t1061 VSS.n1558 5.61485
R4663 VSS.n1575 VSS.t1060 5.61485
R4664 VSS.n1576 VSS.t1059 5.61485
R4665 VSS.t1057 VSS.n1557 5.61485
R4666 VSS.t1056 VSS.n1556 5.61485
R4667 VSS.n1577 VSS.t1054 5.61485
R4668 VSS.n1578 VSS.t1053 5.61485
R4669 VSS.t794 VSS.n389 0.0863258
R4670 VSS.n363 VSS.t333 0.0861948
R4671 VSS.n362 VSS.t771 0.0863258
R4672 VSS.n402 VSS.n403 3.33087
R4673 VSS.n1738 VSS.t831 5.61485
R4674 VSS.t829 VSS.n398 5.61485
R4675 VSS.t828 VSS.n1121 5.61485
R4676 VSS.n1739 VSS.t827 5.61485
R4677 VSS.n1740 VSS.t826 5.61485
R4678 VSS.t825 VSS.n1120 5.61485
R4679 VSS.n1741 VSS.t824 5.61485
R4680 VSS.n396 VSS.t822 5.61485
R4681 VSS.n393 VSS.t819 5.61485
R4682 VSS.n1713 VSS.t85 5.61485
R4683 VSS.n421 VSS.n417 3.33079
R4684 VSS.n420 VSS.t886 5.61485
R4685 VSS.n426 VSS.t883 0.0861948
R4686 VSS.n451 VSS.t104 5.61485
R4687 VSS.n1679 VSS.t362 5.61485
R4688 VSS.t199 VSS.n454 5.61485
R4689 VSS.n475 VSS.t237 5.61485
R4690 VSS.n512 VSS.n504 3.33079
R4691 VSS.n499 VSS.n502 3.33079
R4692 VSS.n498 VSS.n495 3.33079
R4693 VSS.t936 VSS.n494 0.0863258
R4694 VSS.n540 VSS.n538 3.33079
R4695 VSS.n537 VSS.n534 3.33079
R4696 VSS.n533 VSS.n530 3.33079
R4697 VSS.n529 VSS.n526 3.33079
R4698 VSS.n525 VSS.n522 3.33079
R4699 VSS.t1007 VSS.n521 0.0863258
R4700 VSS.n107 VSS.n135 5.61283
R4701 VSS.n2391 VSS.n2390 5.61283
R4702 VSS.n2249 VSS.n1017 5.59404
R4703 VSS.n2046 VSS.n1921 5.58469
R4704 VSS.t1315 VSS.n905 5.58155
R4705 VSS.t52 VSS.n772 5.58155
R4706 VSS.n722 VSS.t158 5.58155
R4707 VSS.n691 VSS.t159 5.58155
R4708 VSS.t491 VSS.n5 9.74144
R4709 VSS.n2473 VSS.t160 5.58155
R4710 VSS.n2399 VSS.t161 5.58155
R4711 VSS.t155 VSS.n834 5.58155
R4712 VSS.n798 VSS.t156 5.58155
R4713 VSS.n782 VSS.n770 5.58155
R4714 VSS.n779 VSS.t52 5.58155
R4715 VSS.t157 VSS.n759 5.58155
R4716 VSS.n141 VSS.n2469 2.39804
R4717 VSS.n139 VSS.n2395 2.39804
R4718 VSS.n1251 VSS.n1211 5.54579
R4719 VSS.n945 VSS.n943 5.52924
R4720 VSS.n945 VSS.n932 5.52924
R4721 VSS.n944 VSS.n929 5.52924
R4722 VSS.n2268 VSS.n923 5.52924
R4723 VSS.n673 VSS.n5 86.3724
R4724 VSS.n664 VSS.n2 86.371
R4725 VSS.t97 VSS.n1 14.2528
R4726 VSS.n943 VSS.n933 5.47646
R4727 VSS.n881 VSS.n879 5.47646
R4728 VSS.n957 VSS.n933 5.47646
R4729 VSS.n886 VSS.t1179 5.47646
R4730 VSS.n2489 VSS.n2488 5.47483
R4731 VSS.n742 VSS.n738 5.42319
R4732 VSS.n743 VSS.n735 5.42319
R4733 VSS.n747 VSS.n736 5.42319
R4734 VSS.t1094 VSS.n1471 5.39048
R4735 VSS.n2491 VSS.n652 5.39048
R4736 VSS.n684 VSS.t1127 5.36942
R4737 VSS.t356 VSS.n816 5.36942
R4738 VSS.n822 VSS.n815 5.36942
R4739 VSS.n856 VSS.n164 1.47943
R4740 VSS.t1127 VSS.n682 5.36942
R4741 VSS.n818 VSS.t356 5.36942
R4742 VSS.n888 VSS.n887 5.30819
R4743 VSS.n2485 VSS.n659 5.2915
R4744 VSS.n2537 VSS.n622 5.20259
R4745 VSS.n2538 VSS.n2537 5.20259
R4746 VSS.n597 VSS.t1097 5.07342
R4747 VSS.t1099 VSS.n1479 5.07342
R4748 VSS.n2385 VSS.n2376 4.96599
R4749 VSS.n2389 VSS.n2388 4.96599
R4750 VSS.n2383 VSS.n2374 4.96599
R4751 VSS.t563 VSS.n916 4.84829
R4752 VSS.n2327 VSS.n878 4.84665
R4753 VSS.n1835 VSS.n1834 4.68896
R4754 VSS.n2178 VSS.n2177 4.68896
R4755 VSS.n2103 VSS.n2051 4.68896
R4756 VSS.n1918 VSS.n1917 4.68896
R4757 VSS.n1997 VSS.n1996 4.68896
R4758 VSS.n1039 VSS.t324 4.66209
R4759 VSS.n2098 VSS.n2075 4.65994
R4760 VSS.t290 VSS.n1016 4.65661
R4761 VSS.t290 VSS.n1037 4.65661
R4762 VSS.n1857 VSS.n1856 4.63048
R4763 VSS.n2015 VSS.n1948 4.60056
R4764 VSS.n195 VSS.n2422 4.59728
R4765 VSS.n195 VSS.n2423 4.59728
R4766 VSS.n195 VSS.n2438 4.59728
R4767 VSS.n188 VSS.n182 1.87014
R4768 VSS.n980 VSS.n182 4.59728
R4769 VSS.n2460 VSS.n182 4.59728
R4770 VSS.n2458 VSS.n182 4.59728
R4771 VSS.n174 VSS.n976 4.59728
R4772 VSS.n174 VSS.n977 4.59728
R4773 VSS.n174 VSS.n978 4.59728
R4774 VSS.n999 VSS.n167 4.59728
R4775 VSS.n962 VSS.n167 4.59728
R4776 VSS.n967 VSS.n167 4.59728
R4777 VSS.n965 VSS.n167 4.59728
R4778 VSS.n1878 VSS.n228 4.57309
R4779 VSS.n1883 VSS.n228 4.57309
R4780 VSS.n1885 VSS.n228 4.57309
R4781 VSS.n1887 VSS.n228 4.57309
R4782 VSS.n1889 VSS.n228 4.57309
R4783 VSS.n2106 VSS.n1882 4.57309
R4784 VSS.n2106 VSS.n1884 4.57309
R4785 VSS.n2106 VSS.n1886 4.57309
R4786 VSS.n2106 VSS.n1888 4.57309
R4787 VSS.n1983 VSS.n1965 4.57309
R4788 VSS.n1983 VSS.n1961 4.57309
R4789 VSS.n1983 VSS.n1962 4.57309
R4790 VSS.n1983 VSS.n1964 4.57309
R4791 VSS.n1971 VSS.n1967 4.57309
R4792 VSS.n1971 VSS.n1968 4.57309
R4793 VSS.n1971 VSS.n1969 4.57309
R4794 VSS.n1971 VSS.n1970 4.57309
R4795 VSS.n191 VSS.n2424 4.56814
R4796 VSS.n191 VSS.n2431 4.56814
R4797 VSS.n2437 VSS.n191 4.56814
R4798 VSS.n981 VSS.n870 4.56814
R4799 VSS.n2459 VSS.n870 4.56814
R4800 VSS.n987 VSS.n970 4.56814
R4801 VSS.n987 VSS.n973 4.56814
R4802 VSS.n987 VSS.n974 4.56814
R4803 VSS.n998 VSS.n47 4.56814
R4804 VSS.n47 VSS.n968 4.56814
R4805 VSS.n47 VSS.n964 4.56814
R4806 VSS.n983 VSS.n975 4.54426
R4807 VSS.n993 VSS.n966 4.54426
R4808 VSS.n2457 VSS.n2456 4.54426
R4809 VSS.n1795 VSS.n1794 4.54223
R4810 VSS.n1795 VSS.n1791 4.54223
R4811 VSS.n1795 VSS.n1780 4.54223
R4812 VSS.n1795 VSS.n1788 4.54223
R4813 VSS.n1795 VSS.n1785 4.54223
R4814 VSS.n1792 VSS.n259 4.54223
R4815 VSS.n1793 VSS.n259 4.54223
R4816 VSS.n1786 VSS.n259 4.54223
R4817 VSS.n1787 VSS.n259 4.54223
R4818 VSS.n2108 VSS.n2107 4.53931
R4819 VSS.n1982 VSS.n1966 4.53931
R4820 VSS.n200 VSS.n198 2.44953
R4821 VSS.n991 VSS.n173 4.51508
R4822 VSS.n1822 VSS.n1805 4.51178
R4823 VSS.n1822 VSS.n1803 4.51178
R4824 VSS.n1822 VSS.n1802 4.51178
R4825 VSS.n2024 VSS.n2020 4.51178
R4826 VSS.n2365 VSS.n103 4.51178
R4827 VSS.n2363 VSS.n103 4.51178
R4828 VSS.n2361 VSS.n103 4.51178
R4829 VSS.n2359 VSS.n103 4.51178
R4830 VSS.n2357 VSS.n103 4.51178
R4831 VSS.n108 VSS.n2366 4.51178
R4832 VSS.n108 VSS.n2364 4.51178
R4833 VSS.n108 VSS.n2362 4.51178
R4834 VSS.n108 VSS.n2360 4.51178
R4835 VSS.n108 VSS.n2358 4.51178
R4836 VSS.n108 VSS.n2356 4.51178
R4837 VSS.n2520 VSS.n2519 4.48596
R4838 VSS.n2522 VSS.n628 4.48596
R4839 VSS.n1511 VSS.n1510 4.48596
R4840 VSS.n1508 VSS.n1488 4.48596
R4841 VSS.n1529 VSS.n1463 4.48596
R4842 VSS.n1461 VSS.n1453 4.48596
R4843 VSS.n1533 VSS.n1532 4.48596
R4844 VSS.n1537 VSS.n1448 4.48596
R4845 VSS.n1455 VSS.n1447 4.48596
R4846 VSS.t290 VSS.n1031 4.48596
R4847 VSS.n2243 VSS.n2242 4.48596
R4848 VSS.n2247 VSS.n2245 4.48596
R4849 VSS.n2517 VSS.n640 4.48596
R4850 VSS.n1822 VSS.n1806 4.48174
R4851 VSS.n1822 VSS.n1800 4.48174
R4852 VSS.n321 VSS.n1808 4.48174
R4853 VSS.n321 VSS.n1809 4.48174
R4854 VSS.n321 VSS.n1810 4.48174
R4855 VSS.n321 VSS.n1811 4.48174
R4856 VSS.n321 VSS.n1812 4.48174
R4857 VSS.n321 VSS.n1813 4.48174
R4858 VSS.n1863 VSS.n1847 4.48174
R4859 VSS.n1866 VSS.n298 4.48174
R4860 VSS.n1860 VSS.n298 4.48174
R4861 VSS.n2002 VSS.n2001 4.48174
R4862 VSS.n2002 VSS.n2000 4.48174
R4863 VSS.n2002 VSS.n1998 4.48174
R4864 VSS.n2002 VSS.n1999 4.48174
R4865 VSS.n2017 VSS.n1939 4.48174
R4866 VSS.n2017 VSS.n1940 4.48174
R4867 VSS.n2017 VSS.n1943 4.48174
R4868 VSS.n2017 VSS.n1944 4.48174
R4869 VSS.n2024 VSS.n1922 4.48174
R4870 VSS.n2024 VSS.n2023 4.48174
R4871 VSS.n2024 VSS.n2022 4.48174
R4872 VSS.n2024 VSS.n2021 4.48174
R4873 VSS.n2044 VSS.n1925 4.48174
R4874 VSS.n2044 VSS.n1928 4.48174
R4875 VSS.n2044 VSS.n1929 4.48174
R4876 VSS.n2227 VSS.n328 4.4521
R4877 VSS.n328 VSS.n1758 4.4521
R4878 VSS.n328 VSS.n1760 4.4521
R4879 VSS.n1833 VSS.n306 4.4521
R4880 VSS.n1831 VSS.n306 4.4521
R4881 VSS.n1829 VSS.n306 4.4521
R4882 VSS.n1867 VSS.n1847 4.4521
R4883 VSS.n1865 VSS.n1847 4.4521
R4884 VSS.n1861 VSS.n1847 4.4521
R4885 VSS.n1859 VSS.n1847 4.4521
R4886 VSS.n1868 VSS.n298 4.4521
R4887 VSS.n1864 VSS.n298 4.4521
R4888 VSS.n1862 VSS.n298 4.4521
R4889 VSS.n1858 VSS.n298 4.4521
R4890 VSS.n283 VSS.n2117 4.4521
R4891 VSS.n283 VSS.n2123 4.4521
R4892 VSS.n283 VSS.n2118 4.4521
R4893 VSS.n2162 VSS.n2141 4.4521
R4894 VSS.n2159 VSS.n2149 4.4521
R4895 VSS.n2159 VSS.n2152 4.4521
R4896 VSS.n2176 VSS.n266 4.4521
R4897 VSS.n2174 VSS.n266 4.4521
R4898 VSS.n2172 VSS.n266 4.4521
R4899 VSS.n1770 VSS.n248 4.4521
R4900 VSS.n1772 VSS.n248 4.4521
R4901 VSS.n1774 VSS.n248 4.4521
R4902 VSS.n238 VSS.n2082 4.4521
R4903 VSS.n238 VSS.n2083 4.4521
R4904 VSS.n238 VSS.n2084 4.4521
R4905 VSS.n238 VSS.n2085 4.4521
R4906 VSS.n238 VSS.n2086 4.4521
R4907 VSS.n2096 VSS.n2078 4.4521
R4908 VSS.n2096 VSS.n2079 4.4521
R4909 VSS.n2096 VSS.n2080 4.4521
R4910 VSS.n2096 VSS.n2081 4.4521
R4911 VSS.n234 VSS.n2060 4.4521
R4912 VSS.n234 VSS.n2058 4.4521
R4913 VSS.n234 VSS.n2059 4.4521
R4914 VSS.n234 VSS.n233 4.4521
R4915 VSS.n221 VSS.n219 4.4521
R4916 VSS.n221 VSS.n1901 4.4521
R4917 VSS.n221 VSS.n1902 4.4521
R4918 VSS.n221 VSS.n220 4.4521
R4919 VSS.n201 VSS.n204 4.4521
R4920 VSS.n201 VSS.n1953 4.4521
R4921 VSS.n201 VSS.n205 4.4521
R4922 VSS.n137 VSS.n107 1.79863
R4923 VSS.n1523 VSS.n1490 4.43931
R4924 VSS.n2228 VSS.n330 4.42284
R4925 VSS.n1756 VSS.n330 4.42284
R4926 VSS.n1759 VSS.n330 4.42284
R4927 VSS.n1761 VSS.n330 4.42284
R4928 VSS.n1832 VSS.n312 4.42284
R4929 VSS.n1830 VSS.n312 4.42284
R4930 VSS.n1828 VSS.n312 4.42284
R4931 VSS.n2116 VSS.n289 4.42284
R4932 VSS.n2122 VSS.n289 4.42284
R4933 VSS.n2121 VSS.n289 4.42284
R4934 VSS.n2119 VSS.n289 4.42284
R4935 VSS.n2162 VSS.n2138 4.42284
R4936 VSS.n2162 VSS.n2143 4.42284
R4937 VSS.n2162 VSS.n2142 4.42284
R4938 VSS.n2162 VSS.n2139 4.42284
R4939 VSS.n2159 VSS.n2148 4.42284
R4940 VSS.n2159 VSS.n2153 4.42284
R4941 VSS.n2175 VSS.n272 4.42284
R4942 VSS.n2173 VSS.n272 4.42284
R4943 VSS.n2171 VSS.n272 4.42284
R4944 VSS.n255 VSS.n1771 4.42284
R4945 VSS.n255 VSS.n1773 4.42284
R4946 VSS.n255 VSS.n1775 4.42284
R4947 VSS.n2101 VSS.n2054 4.42284
R4948 VSS.n2101 VSS.n2055 4.42284
R4949 VSS.n2101 VSS.n2056 4.42284
R4950 VSS.n1916 VSS.n1897 4.42284
R4951 VSS.n1916 VSS.n1898 4.42284
R4952 VSS.n1916 VSS.n1899 4.42284
R4953 VSS.n1995 VSS.n1951 4.42284
R4954 VSS.n1995 VSS.n1952 4.42284
R4955 VSS.n1995 VSS.n1994 4.42284
R4956 VSS.n138 VSS.n2368 4.42284
R4957 VSS.t284 VSS.n1329 4.28621
R4958 VSS.t347 VSS.n1388 4.28621
R4959 VSS.t179 VSS.n1579 4.25119
R4960 VSS.n1523 VSS.n1522 4.25119
R4961 VSS.n2508 VSS.n591 4.25119
R4962 VSS.n579 VSS.n925 4.25119
R4963 VSS.n2278 VSS.n2277 4.25119
R4964 VSS.n1005 VSS.n44 1.54567
R4965 VSS.t30 VSS.n411 4.25119
R4966 VSS.n1486 VSS.n1470 4.25113
R4967 VSS.n138 VSS.n114 0.00308329
R4968 VSS.t103 VSS.n458 4.25113
R4969 VSS.n2534 VSS.n617 4.251
R4970 VSS.n1505 VSS.n1504 4.251
R4971 VSS.n1487 VSS.n1486 4.251
R4972 VSS.n2283 VSS.n2282 4.251
R4973 VSS.n2264 VSS.n546 0.00216663
R4974 VSS.n1821 VSS.n1807 4.251
R4975 VSS.n2161 VSS.n2160 4.251
R4976 VSS.n2169 VSS.n2168 4.251
R4977 VSS.n1976 VSS.n1975 4.251
R4978 VSS.n1992 VSS.n1949 4.251
R4979 VSS.n165 VSS.n855 0.00216663
R4980 VSS.n837 VSS.n829 4.251
R4981 VSS.n762 VSS.n752 4.251
R4982 VSS.t532 VSS.t531 4.2505
R4983 VSS.t187 VSS.t186 4.2505
R4984 VSS.n1686 VSS.n1333 4.24487
R4985 VSS.n471 VSS.t587 2.72093
R4986 VSS.t133 VSS.t26 4.177
R4987 VSS.t272 VSS.t519 4.177
R4988 VSS.n1632 VSS.t484 4.16717
R4989 VSS.n2328 VSS.t1179 4.15435
R4990 VSS.n2387 VSS.n2382 4.14062
R4991 VSS.n2516 VSS.n582 4.12225
R4992 VSS.n1065 VSS.t83 4.09327
R4993 VSS.n2535 VSS.n2534 3.89533
R4994 VSS.n1505 VSS.n1473 3.80519
R4995 VSS.n1506 VSS.t703 3.80519
R4996 VSS.n2508 VSS.n2507 3.80519
R4997 VSS.n855 VSS.n680 3.50911
R4998 VSS.n11 VSS.n82 3.50911
R4999 VSS.t47 VSS.t173 3.50108
R5000 VSS.n1497 VSS.n1474 3.48813
R5001 VSS.n2494 VSS.n644 3.48813
R5002 VSS.n2416 VSS.n108 3.47007
R5003 VSS.n2284 VSS.n2283 3.46204
R5004 VSS.n2285 VSS.n908 3.46204
R5005 VSS.n2287 VSS.n910 3.46204
R5006 VSS.n2226 VSS.n1763 3.43693
R5007 VSS.n2290 VSS.n2281 3.43223
R5008 VSS.n2259 VSS.n939 3.43223
R5009 VSS.n838 VSS.n70 3.43223
R5010 VSS.n25 VSS.n777 3.43223
R5011 VSS.n22 VSS.n700 3.43223
R5012 VSS.n3 VSS.n4 0.00218593
R5013 VSS.n2290 VSS.n917 3.41353
R5014 VSS.n8 VSS.n831 3.41353
R5015 VSS.n801 VSS.n77 3.41353
R5016 VSS.n694 VSS.n98 3.41353
R5017 VSS.n2476 VSS.n117 3.41353
R5018 VSS.n2402 VSS.n119 3.41353
R5019 VSS.n831 VSS.n830 3.38265
R5020 VSS.n803 VSS.n801 3.38265
R5021 VSS.n695 VSS.n694 3.38265
R5022 VSS.n2478 VSS.n2476 3.38265
R5023 VSS.n2404 VSS.n2402 3.38265
R5024 VSS.n2251 VSS.n939 3.35461
R5025 VSS.n777 VSS.n775 3.35461
R5026 VSS.n838 VSS.n837 3.35461
R5027 VSS.n711 VSS.n700 3.35461
R5028 VSS.n2339 VSS.n2338 3.33717
R5029 VSS.t1106 VSS.n2540 3.32876
R5030 VSS.n437 VSS.t10 2.33238
R5031 VSS.t135 VSS.n344 0.0933
R5032 VSS.n2517 VSS.n635 3.30711
R5033 VSS.n1735 VSS.n1194 3.30688
R5034 VSS.n2416 VSS.n102 3.2974
R5035 VSS.n2206 VSS.n253 3.29039
R5036 VSS.n847 VSS.n680 3.23928
R5037 VSS.n824 VSS.n82 3.23928
R5038 VSS.n2461 VSS.t1129 3.20906
R5039 VSS.n1505 VSS.n1467 3.17108
R5040 VSS.t290 VSS.n1044 3.15936
R5041 VSS.t290 VSS.n1042 3.15936
R5042 VSS.n2488 VSS.n656 3.0915
R5043 VSS.n2486 VSS.n658 3.0915
R5044 VSS.n2535 VSS.n602 3.07174
R5045 VSS.n1525 VSS.n597 2.85402
R5046 VSS.n655 VSS.n646 2.85402
R5047 VSS.n2499 VSS.n587 2.12611
R5048 VSS.t283 VSS.n1211 2.83383
R5049 VSS.n2392 VSS.n138 2.72473
R5050 VSS.t739 VSS.t193 2.72092
R5051 VSS.n2463 VSS.n863 2.6787
R5052 VSS.n31 VSS.n867 2.6787
R5053 VSS.n31 VSS.n866 2.6787
R5054 VSS.n33 VSS.n862 12.6418
R5055 VSS.n2340 VSS.n2339 2.67717
R5056 VSS.n200 VSS.n2424 17.6619
R5057 VSS.n174 VSS.n173 2.65857
R5058 VSS.n2107 VSS.n2106 2.64242
R5059 VSS.n1971 VSS.n1966 2.64242
R5060 VSS.n2457 VSS.n870 2.63912
R5061 VSS.n987 VSS.n975 2.63912
R5062 VSS.n47 VSS.n966 2.63912
R5063 VSS.n2002 VSS.n1948 2.60158
R5064 VSS.n1857 VSS.n1847 2.58164
R5065 VSS.n2213 VSS.n2209 2.57782
R5066 VSS.n2096 VSS.n2075 2.56199
R5067 VSS.t21 VSS.t12 2.54935
R5068 VSS.t607 VSS.t91 2.54935
R5069 VSS.n1834 VSS.n312 2.54265
R5070 VSS.n2177 VSS.n272 2.54265
R5071 VSS.n2101 VSS.n2051 2.54265
R5072 VSS.n1917 VSS.n1916 2.54265
R5073 VSS.n1996 VSS.n1995 2.54265
R5074 VSS.n1526 VSS.t96 2.53696
R5075 VSS.n1496 VSS.n1475 2.53696
R5076 VSS.n616 VSS.n614 2.53696
R5077 VSS.n630 VSS.n629 2.53696
R5078 VSS.n647 VSS.n582 2.53696
R5079 VSS.t393 VSS.n2340 2.5305
R5080 VSS.n725 VSS.n149 2.43937
R5081 VSS.n2394 VSS.n2367 2.42417
R5082 VSS.n727 VSS.n725 2.41731
R5083 VSS.n2387 VSS.n2383 2.35796
R5084 VSS.n2388 VSS.n2387 2.35796
R5085 VSS.n2387 VSS.n2385 2.35796
R5086 VSS.t369 VSS.n1074 2.35714
R5087 VSS.n2408 VSS.n2407 2.349
R5088 VSS.n2316 VSS.n2315 2.34717
R5089 VSS.n406 VSS.t443 1.77248
R5090 VSS.n1825 VSS.n899 2.29583
R5091 VSS.t508 VSS.n661 2.2841
R5092 VSS.t30 VSS.t893 2.28014
R5093 VSS.n1872 VSS.n1845 2.24083
R5094 VSS.n699 VSS.n663 2.239
R5095 VSS.n1515 VSS.n1477 2.2199
R5096 VSS.n623 VSS.t1107 2.2199
R5097 VSS.t60 VSS.n1077 2.19188
R5098 VSS.n2165 VSS.n2135 2.184
R5099 VSS.n733 VSS.n715 2.184
R5100 VSS.n2189 VSS.n2188 2.14733
R5101 VSS.n768 VSS.n751 2.14733
R5102 VSS.t82 VSS.n1065 2.1255
R5103 VSS.n2090 VSS.n1769 2.1125
R5104 VSS.n810 VSS.n791 2.11067
R5105 VSS.n2111 VSS.n1874 2.074
R5106 VSS.n1986 VSS.n1873 2.074
R5107 VSS.n843 VSS.n827 2.074
R5108 VSS.t583 VSS.n513 0.0922034
R5109 VSS.t82 VSS.n1047 1.97642
R5110 VSS.t654 VSS.t54 1.97613
R5111 VSS.n2272 VSS.n2270 1.9715
R5112 VSS.n2204 VSS.n248 1.9715
R5113 VSS.n2065 VSS.n234 1.9715
R5114 VSS.n221 VSS.n1913 1.9715
R5115 VSS.n191 VSS.n2430 1.9715
R5116 VSS.n155 VSS.n157 1.9715
R5117 VSS.n93 VSS.n150 1.9715
R5118 VSS.n96 VSS.n97 1.20982
R5119 VSS.n124 VSS.n142 1.9715
R5120 VSS.n128 VSS.n140 1.9715
R5121 VSS.n2290 VSS.n2289 1.97073
R5122 VSS.n1002 VSS.n43 1.97073
R5123 VSS.n55 VSS.n960 1.97073
R5124 VSS.t601 VSS.n1043 1.95812
R5125 VSS.n2482 VSS.n662 1.92367
R5126 VSS VSS.n2541 1.90715
R5127 VSS.t703 VSS.n1476 1.90285
R5128 VSS.t495 VSS.n583 1.90285
R5129 VSS.n2387 VSS.n134 1.89014
R5130 VSS.t202 VSS.t549 1.87082
R5131 VSS.n1045 VSS.t469 1.8649
R5132 VSS.n2266 VSS.n2265 1.84665
R5133 VSS.n2269 VSS.n922 1.84665
R5134 VSS.n911 VSS.n903 1.84665
R5135 VSS.n586 VSS.n653 1.8299
R5136 VSS.n255 VSS.n253 1.78455
R5137 VSS.t323 VSS.n1018 1.75523
R5138 VSS.n328 VSS.n1757 1.7268
R5139 VSS.n306 VSS.n304 1.7268
R5140 VSS.n266 VSS.n269 1.7268
R5141 VSS.n1959 VSS.n201 1.7268
R5142 VSS.n442 VSS.n443 1.36086
R5143 VSS.n2442 VSS.n2441 1.72314
R5144 VSS.n159 VSS.n158 1.72275
R5145 VSS.n2259 VSS.n875 1.72264
R5146 VSS.n1492 VSS.n1491 1.72207
R5147 VSS.n592 VSS.n645 1.72207
R5148 VSS.n551 VSS.n550 1.72206
R5149 VSS.n52 VSS.n873 0.690212
R5150 VSS.n1013 VSS.n59 1.72206
R5151 VSS.n1517 VSS.n598 1.71799
R5152 VSS.t173 VSS.n541 1.71424
R5153 VSS.n2301 VSS.n904 1.61588
R5154 VSS.n1261 VSS.t26 1.61234
R5155 VSS.n1068 VSS.t2 1.60135
R5156 VSS.n1068 VSS.t58 1.60135
R5157 VSS.t74 VSS.t234 1.58612
R5158 VSS.n1495 VSS.n1477 1.58579
R5159 VSS.t1109 VSS.n620 1.58579
R5160 VSS.n2492 VSS.n650 1.58579
R5161 VSS.n2493 VSS.n649 1.58579
R5162 VSS.n1425 VSS.t587 1.57195
R5163 VSS.n1524 VSS.n1523 1.54595
R5164 VSS.n2515 VSS.n586 1.54595
R5165 VSS.n2270 VSS.n2269 1.54595
R5166 VSS.n2301 VSS.n556 1.54595
R5167 VSS.t470 VSS.t290 1.54302
R5168 VSS.t13 VSS.t20 1.54251
R5169 VSS.t92 VSS.t54 1.54251
R5170 VSS.t152 VSS.t193 1.54233
R5171 VSS.n1735 VSS.n1197 1.54233
R5172 VSS.t114 VSS.t448 1.54233
R5173 VSS.n442 VSS.t79 1.54229
R5174 VSS.t187 VSS.n1311 1.53843
R5175 VSS.t283 VSS.t433 1.53612
R5176 VSS.n2304 VSS.n901 1.52457
R5177 VSS.n283 VSS.n281 1.52457
R5178 VSS.n2448 VSS.n870 1.52092
R5179 VSS.n987 VSS.n972 1.52092
R5180 VSS.n47 VSS.n963 1.52092
R5181 VSS.n556 VSS.n914 1.51985
R5182 VSS.n478 VSS.t219 1.51768
R5183 VSS.n2510 VSS.n642 1.51712
R5184 VSS.n2335 VSS.n2334 1.51483
R5185 VSS.t17 VSS.t621 1.47392
R5186 VSS.t428 VSS.t307 1.46674
R5187 VSS.t21 VSS.t20 1.41717
R5188 VSS.t607 VSS.t54 1.41717
R5189 VSS.n1483 VSS.n1469 1.40038
R5190 VSS.n2495 VSS.n584 1.39084
R5191 VSS.n2257 VSS.n930 1.38512
R5192 VSS.n927 VSS.n921 1.38512
R5193 VSS.n2387 VSS.n2381 1.36935
R5194 VSS.n2380 VSS.n2379 1.36903
R5195 VSS.n1983 VSS.n1960 1.36088
R5196 VSS.n35 VSS.n36 0.740331
R5197 VSS.n2537 VSS.n619 1.35611
R5198 VSS.n2454 VSS.n182 1.34922
R5199 VSS.n994 VSS.n167 1.34922
R5200 VSS.n2224 VSS.n330 1.34922
R5201 VSS.n2129 VSS.n289 1.34922
R5202 VSS.t401 VSS.t448 1.34803
R5203 VSS.t35 VSS.n425 0.0842465
R5204 VSS.n1338 VSS.t519 1.34777
R5205 VSS.n789 VSS.n15 1.3476
R5206 VSS.n1284 VSS.t26 1.32495
R5207 VSS.t290 VSS.n1024 1.31699
R5208 VSS.t369 VSS.t587 1.30819
R5209 VSS.t175 VSS.n544 0.00159348
R5210 VSS.n1041 VSS.t325 1.30558
R5211 VSS.n2489 VSS.n584 1.27928
R5212 VSS.n1469 VSS.n659 1.27396
R5213 VSS.n1535 VSS.n1449 1.27287
R5214 VSS.t290 VSS.n1035 1.27287
R5215 VSS.t290 VSS.n1034 1.27287
R5216 VSS.t290 VSS.n1033 1.27287
R5217 VSS.n1029 VSS.n1022 1.27287
R5218 VSS.n2536 VSS.n613 1.26873
R5219 VSS.n30 VSS.n858 1.25321
R5220 VSS.t311 VSS.t696 1.25009
R5221 VSS.n2386 VSS.n106 1.24378
R5222 VSS.n29 VSS.n860 13.6501
R5223 VSS.n2488 VSS.t183 1.23892
R5224 VSS.t532 VSS.t621 1.23186
R5225 VSS.n825 VSS.n76 1.22049
R5226 VSS.n133 VSS.n115 0.895643
R5227 VSS.t60 VSS.t26 1.21479
R5228 VSS.n238 VSS.n2092 1.20997
R5229 VSS.n765 VSS.n764 1.20816
R5230 VSS.n2310 VSS.n574 1.20816
R5231 VSS.n2264 VSS.n940 1.20805
R5232 VSS.n78 VSS.n77 0.889273
R5233 VSS.n99 VSS.n98 0.889273
R5234 VSS.n195 VSS.n2421 1.20771
R5235 VSS.n984 VSS.n174 1.20771
R5236 VSS.t578 VSS.t82 1.20437
R5237 VSS.t390 VSS.t393 1.19217
R5238 VSS.t311 VSS.t501 1.17656
R5239 VSS.t99 VSS.t216 1.17401
R5240 VSS.n2286 VSS.n2280 1.15793
R5241 VSS.n2487 VSS.n2486 1.15733
R5242 VSS.n936 VSS.n935 1.15435
R5243 VSS.n1439 VSS.t1 1.14991
R5244 VSS.n1338 VSS.t243 1.14146
R5245 VSS.t42 VSS.n1198 1.13922
R5246 VSS.t194 VSS.t481 1.13822
R5247 VSS.n2275 VSS.n2271 1.12203
R5248 VSS.n2351 VSS.n2344 1.11884
R5249 VSS.n1003 VSS.n1001 1.11864
R5250 VSS.t46 VSS.n1140 1.11246
R5251 VSS.t511 VSS.t508 1.1005
R5252 VSS.n228 VSS.n1875 1.09941
R5253 VSS.n54 VSS.n53 0.998015
R5254 VSS.n749 VSS.n153 1.09433
R5255 VSS.n2529 VSS.n602 1.09362
R5256 VSS.t344 VSS.t348 1.08754
R5257 VSS.n543 VSS.t260 1.12924
R5258 VSS.n2183 VSS.n272 1.08703
R5259 VSS.n1995 VSS.n1950 1.08703
R5260 VSS.n840 VSS.n8 1.08703
R5261 VSS.n1839 VSS.n312 1.08666
R5262 VSS.n2198 VSS.n255 1.08666
R5263 VSS.n2101 VSS.n2053 1.08666
R5264 VSS.n1916 VSS.n1896 1.08666
R5265 VSS.n731 VSS.n149 1.08666
R5266 VSS.n2479 VSS.n118 1.00229
R5267 VSS.n2405 VSS.n120 1.00229
R5268 VSS.n2162 VSS.n2136 1.08419
R5269 VSS.n516 VSS.t20 0.891152
R5270 VSS.n470 VSS.t344 0.918487
R5271 VSS.n2379 VSS.n106 1.063
R5272 VSS.t102 VSS.n1384 1.06278
R5273 VSS.n2298 VSS.n912 1.06212
R5274 VSS.n60 VSS.n874 0.970953
R5275 VSS.n6 VSS.n49 1.17704
R5276 VSS.n2333 VSS.n2332 1.0593
R5277 VSS.n1262 VSS.t128 1.05903
R5278 VSS.n953 VSS.n924 1.05471
R5279 VSS.t46 VSS.t99 1.05259
R5280 VSS.t970 VSS.t975 1.04852
R5281 VSS.t481 VSS.t48 1.04151
R5282 VSS.t128 VSS.n1308 1.03737
R5283 VSS.t212 VSS.t178 1.03315
R5284 VSS.n1198 VSS.t126 1.03242
R5285 VSS.n1140 VSS.t313 1.03033
R5286 VSS.n1308 VSS.t137 1.02522
R5287 VSS.t17 VSS.t449 1.02484
R5288 VSS.t85 VSS.t428 1.02339
R5289 VSS.t851 VSS.t111 1.02168
R5290 VSS.n1199 VSS.t118 1.02079
R5291 VSS.t122 VSS.n1262 1.01828
R5292 VSS.t109 VSS.n1202 1.01722
R5293 VSS.n1200 VSS.t730 1.01278
R5294 VSS.t44 VSS.t270 1.0061
R5295 VSS.n1439 VSS.t979 1.00259
R5296 VSS.n949 VSS.n924 0.997339
R5297 VSS.n1796 VSS.n1795 0.989654
R5298 VSS.n823 VSS.n12 1.0538
R5299 VSS.t87 VSS.t113 0.988003
R5300 VSS.t730 VSS.n1201 0.987788
R5301 VSS.n2413 VSS.n121 1.23621
R5302 VSS.t737 VSS.n1200 0.9876
R5303 VSS.t176 VSS.t57 0.986045
R5304 VSS.t283 VSS.n354 0.826863
R5305 VSS.n1440 VSS.t979 0.984476
R5306 VSS.n88 VSS.n84 1.09373
R5307 VSS.n1778 VSS.n259 0.983165
R5308 VSS.n713 VSS.n22 0.979694
R5309 VSS.n2035 VSS.n2024 0.979316
R5310 VSS.n2017 VSS.n1938 0.978291
R5311 VSS.n2044 VSS.n1923 0.978291
R5312 VSS.n26 VSS.n785 0.986349
R5313 VSS.n28 VSS.n27 0.80164
R5314 VSS.n1339 VSS.t107 0.963704
R5315 VSS.n1819 VSS.n1817 0.962697
R5316 VSS.n952 VSS.n951 0.961586
R5317 VSS.n1817 VSS.n1816 0.958707
R5318 VSS.n2320 VSS.n880 0.954977
R5319 VSS.n1440 VSS.t975 0.952301
R5320 VSS.n2210 VSS.n880 0.952068
R5321 VSS.n1474 VSS.n1464 0.951673
R5322 VSS.n1516 VSS.n1478 0.951673
R5323 VSS.n654 VSS.n650 0.951673
R5324 VSS.n646 VSS.n641 0.951673
R5325 VSS.n2280 VSS.n876 0.945045
R5326 VSS.n1814 VSS.n1797 0.93989
R5327 VSS.n2008 VSS.n2007 0.934692
R5328 VSS.t348 VSS.t102 0.930397
R5329 VSS.n510 VSS.t62 0.993067
R5330 VSS.n2410 VSS.n2409 0.925656
R5331 VSS.n958 VSS.n934 0.923577
R5332 VSS.n926 VSS.n920 0.923577
R5333 VSS.n1979 VSS.n1978 0.922034
R5334 VSS.n850 VSS.n678 0.921801
R5335 VSS.n2322 VSS.n2318 0.916222
R5336 VSS.n2271 VSS.t698 0.914903
R5337 VSS.n912 VSS.n877 0.914903
R5338 VSS.n49 VSS.n873 0.911715
R5339 VSS.n1001 VSS.n872 0.911715
R5340 VSS.n2334 VSS.n2333 0.911715
R5341 VSS.n556 VSS.n913 0.910317
R5342 VSS.n2443 VSS.n2344 0.910304
R5343 VSS.t851 VSS.t855 0.91001
R5344 VSS.t95 VSS.t970 0.905709
R5345 VSS.n2316 VSS.n899 0.904333
R5346 VSS.n2408 VSS.n2394 0.904333
R5347 VSS.n2037 VSS.n2035 0.898908
R5348 VSS.n1979 VSS.n1971 0.896908
R5349 VSS.n855 VSS.n678 0.896877
R5350 VSS.n2106 VSS.n1881 0.896462
R5351 VSS.t176 VSS.n544 0.532009
R5352 VSS.t449 VSS.t212 0.895187
R5353 VSS.n2147 VSS.n2146 0.895118
R5354 VSS.t126 VSS.n1199 0.894885
R5355 VSS.n2035 VSS.n2034 0.894351
R5356 VSS.n2156 VSS.n2147 0.892156
R5357 VSS.n2087 VSS.n2077 0.891901
R5358 VSS.n1848 VSS.n1846 0.890251
R5359 VSS.n1822 VSS.n1797 0.888918
R5360 VSS.n1847 VSS.n1846 0.888651
R5361 VSS.n2008 VSS.n2002 0.888205
R5362 VSS.n1855 VSS.n1854 0.887123
R5363 VSS.n2012 VSS.n2008 0.886795
R5364 VSS.n2410 VSS.n103 0.88679
R5365 VSS.n2096 VSS.n2077 0.886313
R5366 VSS.n1854 VSS.n1853 0.885703
R5367 VSS.n2095 VSS.n2077 0.884105
R5368 VSS.n1854 VSS.n298 0.882547
R5369 VSS.n429 VSS.t575 0.921068
R5370 VSS.n2159 VSS.n2147 0.882028
R5371 VSS.t1 VSS.t44 0.879697
R5372 VSS.n1881 VSS.n1880 0.870393
R5373 VSS.n731 VSS.n730 0.864634
R5374 VSS.n2198 VSS.n1768 0.864634
R5375 VSS.n2155 VSS.n2136 0.863732
R5376 VSS.t40 VSS.n1201 0.863441
R5377 VSS.n1980 VSS.n1979 0.862553
R5378 VSS.t14 VSS.t177 0.862321
R5379 VSS.n840 VSS.n40 0.976486
R5380 VSS.n2184 VSS.n2183 0.859485
R5381 VSS.n1990 VSS.n1950 0.859485
R5382 VSS.n841 VSS.n840 0.859485
R5383 VSS.n1890 VSS.n1881 0.854594
R5384 VSS.n713 VSS.n20 1.0845
R5385 VSS.t82 VSS.n1068 0.8505
R5386 VSS.n1845 VSS.n1825 0.8475
R5387 VSS.n2407 VSS.n662 0.8475
R5388 VSS.n429 VSS.t29 0.70302
R5389 VSS.t313 VSS.t855 0.844114
R5390 VSS.n2445 VSS.n2444 0.843833
R5391 VSS.n2446 VSS.n2445 0.843833
R5392 VSS.n2446 VSS.n2342 0.843833
R5393 VSS.n2342 VSS.n2341 0.843833
R5394 VSS.n2338 VSS.n2337 0.843833
R5395 VSS.n2337 VSS.n2336 0.843833
R5396 VSS.n2336 VSS.n2335 0.843833
R5397 VSS.n2530 VSS.n2529 0.842396
R5398 VSS.n2378 VSS.n134 0.84212
R5399 VSS.n749 VSS.n734 0.838385
R5400 VSS.n2038 VSS.n1923 0.837853
R5401 VSS.n2010 VSS.n1938 0.837853
R5402 VSS.n2028 VSS.n1923 0.836451
R5403 VSS.n2003 VSS.n1938 0.836451
R5404 VSS.n1796 VSS.n1779 0.830036
R5405 VSS.n1783 VSS.n1778 0.824137
R5406 VSS.n2194 VSS.n1778 0.823699
R5407 VSS.n984 VSS.n969 0.817611
R5408 VSS.n99 VSS.n696 0.944022
R5409 VSS.n78 VSS.n807 0.944022
R5410 VSS.n133 VSS.n2391 0.941205
R5411 VSS.n765 VSS.n86 0.926276
R5412 VSS.n2318 VSS.n338 0.808296
R5413 VSS.n1908 VSS.n1896 0.805286
R5414 VSS.n2061 VSS.n2053 0.805286
R5415 VSS.n1839 VSS.n1838 0.805286
R5416 VSS.t279 VSS.t428 0.801167
R5417 VSS.n2183 VSS.n2182 0.800775
R5418 VSS.n1955 VSS.n1950 0.800775
R5419 VSS.n1339 VSS.t322 0.800756
R5420 VSS.t82 VSS.t17 0.80028
R5421 VSS.n1840 VSS.n1839 0.795635
R5422 VSS.n2199 VSS.n2198 0.795635
R5423 VSS.n2069 VSS.n2053 0.795635
R5424 VSS.n1903 VSS.n1896 0.795635
R5425 VSS.n2481 VSS.n663 0.7925
R5426 VSS.n825 VSS.n811 0.784708
R5427 VSS.n1892 VSS.n1875 0.779129
R5428 VSS.n789 VSS.n85 0.884299
R5429 VSS.n2225 VSS.n2224 0.763945
R5430 VSS.n2263 VSS.n940 0.758687
R5431 VSS.n2433 VSS.n2421 0.757985
R5432 VSS.n2529 VSS.n2528 0.757882
R5433 VSS.n2311 VSS.n2310 0.756348
R5434 VSS.n985 VSS.n984 0.753129
R5435 VSS.n2426 VSS.n2421 0.753129
R5436 VSS.n2256 VSS.n940 0.752402
R5437 VSS.n2092 VSS.n237 0.751422
R5438 VSS.n1735 VSS.t855 0.75077
R5439 VSS.n2310 VSS.n2309 0.750565
R5440 VSS.n1202 VSS.t7 0.750143
R5441 VSS.n516 VSS.t681 0.0788445
R5442 VSS.n2188 VSS.n2165 0.741167
R5443 VSS.n715 VSS.n699 0.741167
R5444 VSS.n952 VSS.n900 0.73991
R5445 VSS.n956 VSS.n952 0.733564
R5446 VSS.n2326 VSS.n880 0.731917
R5447 VSS.n1817 VSS.n321 0.731478
R5448 VSS.n510 VSS.n503 0.611137
R5449 VSS.n2384 VSS.n2367 0.721
R5450 VSS.t178 VSS.t578 0.713596
R5451 VSS.n2455 VSS.n2454 0.707242
R5452 VSS.n2126 VSS.n281 0.707059
R5453 VSS.n2307 VSS.n901 0.707059
R5454 VSS.n995 VSS.n994 0.705408
R5455 VSS.n2454 VSS.n2453 0.705408
R5456 VSS.n2130 VSS.n2129 0.704937
R5457 VSS.n2129 VSS.n2128 0.704275
R5458 VSS.n2224 VSS.n2223 0.704275
R5459 VSS.n2189 VSS.n1769 0.700833
R5460 VSS.n751 VSS.n733 0.700833
R5461 VSS.t968 VSS.t219 0.699539
R5462 VSS.n2318 VSS.n2317 0.694465
R5463 VSS.n941 VSS.n931 0.692808
R5464 VSS.n579 VSS.n919 0.692808
R5465 VSS.t219 VSS.n479 0.692419
R5466 VSS.t125 VSS.t41 0.690949
R5467 VSS.t681 VSS.t33 0.685962
R5468 VSS.n1282 VSS.t26 0.68391
R5469 VSS.n478 VSS.n477 0.68391
R5470 VSS.n2526 VSS.n619 0.679162
R5471 VSS.n2487 VSS.n657 0.6715
R5472 VSS.n2444 VSS.n2443 0.6715
R5473 VSS.n2341 VSS.t534 0.6715
R5474 VSS.n2342 VSS.t593 0.6715
R5475 VSS.n2449 VSS.n2446 0.6715
R5476 VSS.n2445 VSS.n2343 0.6715
R5477 VSS.n2338 VSS.t701 0.6715
R5478 VSS.n2337 VSS.t698 0.6715
R5479 VSS.n2336 VSS.n876 0.6715
R5480 VSS.n2335 VSS.n877 0.6715
R5481 VSS.n1974 VSS.n1960 0.668204
R5482 VSS.t82 VSS.n1072 0.666899
R5483 VSS.t82 VSS.n1060 0.666899
R5484 VSS.t82 VSS.n1057 0.666899
R5485 VSS.t532 VSS.n1561 0.666899
R5486 VSS.t532 VSS.n1563 0.666899
R5487 VSS.n1081 VSS.t193 0.666899
R5488 VSS.n1083 VSS.t193 0.666899
R5489 VSS.n1084 VSS.t193 0.666899
R5490 VSS.t283 VSS.n349 0.666899
R5491 VSS.n1302 VSS.t26 0.666899
R5492 VSS.n1305 VSS.t26 0.666899
R5493 VSS.t443 VSS.n404 0.666899
R5494 VSS.n402 VSS.n401 0.666899
R5495 VSS.t187 VSS.n1317 0.666899
R5496 VSS.t187 VSS.n1722 0.666899
R5497 VSS.t279 VSS.n415 0.666899
R5498 VSS.n1710 VSS.n419 0.666899
R5499 VSS.n420 VSS.n418 0.666899
R5500 VSS.n436 VSS.n434 0.666899
R5501 VSS.n1356 VSS.t322 0.666899
R5502 VSS.n1341 VSS.t322 0.666899
R5503 VSS.n1348 VSS.t519 0.666899
R5504 VSS.n1673 VSS.t448 0.666899
R5505 VSS.n1674 VSS.t448 0.666899
R5506 VSS.n1612 VSS.t20 0.666899
R5507 VSS.n1616 VSS.t20 0.666899
R5508 VSS.n1634 VSS.t206 0.666899
R5509 VSS.n1636 VSS.t206 0.666899
R5510 VSS.n1600 VSS.t54 0.666899
R5511 VSS.n1871 VSS.n1846 0.666342
R5512 VSS.n2090 VSS.n1874 0.666
R5513 VSS.n791 VSS.n768 0.666
R5514 VSS.t35 VSS.t51 0.665198
R5515 VSS.n1520 VSS.n1492 0.665094
R5516 VSS.n875 VSS.n2254 0.664765
R5517 VSS.n2267 VSS.n924 0.664507
R5518 VSS.n2330 VSS.n550 0.664193
R5519 VSS.n2448 VSS.n2447 0.664013
R5520 VSS.n972 VSS.n971 0.664013
R5521 VSS.n992 VSS.n963 0.664013
R5522 VSS.n806 VSS.n158 0.662873
R5523 VSS.n2296 VSS.n914 0.662566
R5524 VSS.n2512 VSS.n2510 0.661853
R5525 VSS.n1824 VSS.n1797 0.661065
R5526 VSS.n2411 VSS.n2410 0.658286
R5527 VSS.t82 VSS.n1070 0.655024
R5528 VSS.t82 VSS.n1062 0.655024
R5529 VSS.n1299 VSS.t26 0.655024
R5530 VSS.n1359 VSS.t322 0.655024
R5531 VSS.n1631 VSS.t206 0.655024
R5532 VSS.n2341 VSS.t390 0.653167
R5533 VSS.n1109 VSS.t193 0.649813
R5534 VSS.n1111 VSS.t193 0.649813
R5535 VSS.t283 VSS.n345 0.649813
R5536 VSS.t283 VSS.n352 0.649813
R5537 VSS.t283 VSS.n351 0.649813
R5538 VSS.n1246 VSS.n343 0.649813
R5539 VSS.n382 VSS.n385 0.649813
R5540 VSS.n382 VSS.n384 0.649813
R5541 VSS.n378 VSS.n381 0.649813
R5542 VSS.n378 VSS.n380 0.649813
R5543 VSS.n374 VSS.n377 0.649813
R5544 VSS.n374 VSS.n376 0.649813
R5545 VSS.n370 VSS.n373 0.649813
R5546 VSS.n370 VSS.n372 0.649813
R5547 VSS.n366 VSS.n369 0.649813
R5548 VSS.n366 VSS.n368 0.649813
R5549 VSS.n355 VSS.n365 0.649813
R5550 VSS.n355 VSS.n364 0.649813
R5551 VSS.n1227 VSS.n357 427.755
R5552 VSS.n1735 VSS.n1076 0.649813
R5553 VSS.n1735 VSS.n1733 0.649813
R5554 VSS.n1735 VSS.n1196 0.649813
R5555 VSS.n1735 VSS.n1193 0.649813
R5556 VSS.n1735 VSS.n1128 0.649813
R5557 VSS.n1735 VSS.n1134 0.649813
R5558 VSS.n1735 VSS.n1135 0.649813
R5559 VSS.n1735 VSS.n1185 0.649813
R5560 VSS.n1735 VSS.n1183 0.649813
R5561 VSS.n1735 VSS.n1139 0.649813
R5562 VSS.n1735 VSS.n1180 0.649813
R5563 VSS.n1735 VSS.n1179 0.649813
R5564 VSS.n1735 VSS.n1175 0.649813
R5565 VSS.n1735 VSS.n1146 0.649813
R5566 VSS.n1735 VSS.n1147 0.649813
R5567 VSS.n1735 VSS.n1149 0.649813
R5568 VSS.n1735 VSS.n1171 0.649813
R5569 VSS.n1735 VSS.n1153 0.649813
R5570 VSS.n1735 VSS.n1167 0.649813
R5571 VSS.n1735 VSS.n1164 0.649813
R5572 VSS.n1735 VSS.n1160 0.649813
R5573 VSS.t187 VSS.n1075 0.649813
R5574 VSS.t187 VSS.n1312 0.649813
R5575 VSS.t187 VSS.n1313 0.649813
R5576 VSS.t187 VSS.n1727 0.649813
R5577 VSS.t187 VSS.n1725 0.649813
R5578 VSS.n422 VSS.n428 0.649813
R5579 VSS.n424 VSS.n423 0.649813
R5580 VSS.n1698 VSS.n424 0.649813
R5581 VSS.n1692 VSS.n424 0.649813
R5582 VSS.n1686 VSS.n1684 0.649813
R5583 VSS.n442 VSS.n438 0.649813
R5584 VSS.n442 VSS.n439 0.649813
R5585 VSS.n442 VSS.n440 0.649813
R5586 VSS.n1411 VSS.n1409 0.649813
R5587 VSS.n1411 VSS.n1389 0.649813
R5588 VSS.n1411 VSS.n1407 0.649813
R5589 VSS.n1411 VSS.n1394 0.649813
R5590 VSS.n1411 VSS.n1399 0.649813
R5591 VSS.n1411 VSS.n1401 0.649813
R5592 VSS.n503 VSS.n505 0.649813
R5593 VSS.n503 VSS.n506 0.649813
R5594 VSS.n503 VSS.n509 0.649813
R5595 VSS.n503 VSS.n508 0.649813
R5596 VSS.n503 VSS.n507 0.649813
R5597 VSS.n1644 VSS.n500 0.649813
R5598 VSS.n1641 VSS.n496 0.649813
R5599 VSS.n1639 VSS.n491 0.649813
R5600 VSS.n1623 VSS.t206 0.649813
R5601 VSS.n1605 VSS.t175 0.649813
R5602 VSS.n1589 VSS.n535 0.649813
R5603 VSS.n1587 VSS.n531 0.649813
R5604 VSS.n1585 VSS.n527 0.649813
R5605 VSS.n1583 VSS.n523 0.649813
R5606 VSS.n1581 VSS.n518 0.649813
R5607 VSS.t240 VSS.n425 0.526214
R5608 VSS.n2510 VSS.n2509 0.648763
R5609 VSS.n1079 VSS.t193 0.648101
R5610 VSS.t283 VSS.n350 0.648101
R5611 VSS.t443 VSS.n405 0.648101
R5612 VSS.t279 VSS.n414 0.648101
R5613 VSS.n1668 VSS.t448 0.648101
R5614 VSS.t672 VSS.n514 0.648101
R5615 VSS.n1610 VSS.t20 0.648101
R5616 VSS.t7 VSS.n354 1.11239
R5617 VSS.t578 VSS.t309 0.639704
R5618 VSS.t15 VSS.t401 0.638121
R5619 VSS.n1486 VSS.n1466 0.634615
R5620 VSS.n1494 VSS.n1479 0.634615
R5621 VSS.n2491 VSS.n651 0.634615
R5622 VSS.n714 VSS.n713 0.631953
R5623 VSS.n844 VSS.n843 0.629333
R5624 VSS.n827 VSS.n810 0.629333
R5625 VSS.n663 VSS.n3 19.4042
R5626 VSS.t222 VSS.n482 0.61736
R5627 VSS.n657 VSS.n619 0.614021
R5628 VSS.n2273 VSS.n2272 0.607979
R5629 VSS.n2442 VSS.n2345 0.606739
R5630 VSS.n2513 VSS.n645 0.606208
R5631 VSS.n1200 VSS.t193 0.605685
R5632 VSS.t206 VSS.n1440 0.604703
R5633 VSS.n753 VSS.n157 0.604633
R5634 VSS.n729 VSS.n150 0.604633
R5635 VSS.n2205 VSS.n2204 0.604633
R5636 VSS.n1517 VSS.n596 0.603955
R5637 VSS.n1518 VSS.n1517 0.601371
R5638 VSS.n2190 VSS.n1796 0.600502
R5639 VSS.n2339 VSS.n874 0.598167
R5640 VSS.n2340 VSS.n53 0.598167
R5641 VSS.t393 VSS.n873 0.598167
R5642 VSS.t390 VSS.n872 0.598167
R5643 VSS.n790 VSS.n789 0.59578
R5644 VSS.n914 VSS.n877 0.59547
R5645 VSS.n2449 VSS.n2448 0.594145
R5646 VSS.n972 VSS.t593 0.594145
R5647 VSS.n963 VSS.t534 0.594145
R5648 VSS.n1338 VSS.t457 0.592647
R5649 VSS.t401 VSS.t210 0.5912
R5650 VSS.n2220 VSS.n1757 0.59069
R5651 VSS.n1836 VSS.n304 0.59069
R5652 VSS.n1959 VSS.n1958 0.59069
R5653 VSS.n2180 VSS.n269 0.59069
R5654 VSS.n2164 VSS.n2136 0.589466
R5655 VSS.t109 VSS.t433 0.583382
R5656 VSS.n2387 VSS.n2386 0.582501
R5657 VSS.n1311 VSS.t87 0.580782
R5658 VSS.t33 VSS.t13 0.578007
R5659 VSS.t635 VSS.t92 0.578007
R5660 VSS.n1197 VSS.t506 0.577642
R5661 VSS.t210 VSS.t114 0.577642
R5662 VSS.t42 VSS.t152 0.577642
R5663 VSS.t498 VSS.t79 0.577588
R5664 VSS.t501 VSS.t470 0.576411
R5665 VSS.n2441 VSS.n2344 0.560553
R5666 VSS.n2333 VSS.n551 0.560228
R5667 VSS.n1001 VSS.n43 0.560228
R5668 VSS.n51 VSS.n49 0.560228
R5669 VSS.n60 VSS.n59 0.470938
R5670 VSS.n2271 VSS.n2270 0.559471
R5671 VSS.n556 VSS.n912 0.559471
R5672 VSS.n750 VSS.n749 0.55905
R5673 VSS.t621 VSS.t455 0.554589
R5674 VSS.n2430 VSS.n2429 0.548407
R5675 VSS.t373 VSS.n1425 0.547565
R5676 VSS.t701 VSS.n875 0.547462
R5677 VSS.n1492 VSS.n658 0.54743
R5678 VSS.n1013 VSS.n874 0.546892
R5679 VSS.n2334 VSS.n550 0.546892
R5680 VSS.n656 VSS.n645 0.546688
R5681 VSS.n2289 VSS.n2288 0.54655
R5682 VSS.n2110 VSS.n1875 0.546277
R5683 VSS.n2392 VSS.n133 1.13727
R5684 VSS.n443 VSS.t498 0.578335
R5685 VSS.n1913 VSS.n1911 0.545625
R5686 VSS.n2065 VSS.n2064 0.545625
R5687 VSS.n2443 VSS.n2442 0.54549
R5688 VSS.n2092 VSS.n2091 0.535239
R5689 VSS.t952 VSS.t583 0.513674
R5690 VSS.n55 VSS.n54 0.432088
R5691 VSS.n2290 VSS.n2280 0.512636
R5692 VSS.n513 VSS.t340 0.393345
R5693 VSS.t122 VSS.n1261 0.507234
R5694 VSS.t187 VSS.t113 0.505074
R5695 VSS.n826 VSS.n825 0.503621
R5696 VSS.n960 VSS.n53 0.498096
R5697 VSS.n1002 VSS.n872 0.498096
R5698 VSS.n2289 VSS.n876 0.498096
R5699 VSS.n809 VSS.n158 0.496784
R5700 VSS.t309 VSS.n1047 0.496347
R5701 VSS.n2430 VSS.n2343 0.496347
R5702 VSS.n2272 VSS.t698 0.496347
R5703 VSS.n897 VSS.n551 0.493752
R5704 VSS.t954 VSS.n482 0.383012
R5705 VSS.t183 VSS.n2487 0.490917
R5706 VSS.t260 VSS.t654 0.484697
R5707 VSS.t14 VSS.t448 0.472722
R5708 VSS.n2114 VSS.n1872 0.471667
R5709 VSS.n1201 VSS.t193 0.467653
R5710 VSS.t206 VSS.t970 0.464129
R5711 VSS.n1262 VSS.t26 0.463057
R5712 VSS.n1308 VSS.t26 0.462243
R5713 VSS.n1202 VSS.t283 0.462095
R5714 VSS.t700 VSS.n957 0.462038
R5715 VSS.n942 VSS.n932 0.462038
R5716 VSS.n1985 VSS.n1960 0.460402
R5717 VSS.t116 VSS.n1047 0.449793
R5718 VSS.n2406 VSS.n140 0.447566
R5719 VSS.n2480 VSS.n142 0.447566
R5720 VSS.n698 VSS.n97 0.639884
R5721 VSS.n732 VSS.n150 0.447566
R5722 VSS.n767 VSS.n157 0.447566
R5723 VSS.n842 VSS.n71 0.545858
R5724 VSS.n1913 VSS.n1912 0.447566
R5725 VSS.n2066 VSS.n2065 0.447566
R5726 VSS.n2204 VSS.n2203 0.447566
R5727 VSS.n2314 VSS.n901 0.440921
R5728 VSS.n2134 VSS.n281 0.440921
R5729 VSS.t206 VSS.t44 0.439023
R5730 VSS.t654 VSS.t635 0.436429
R5731 VSS.n2112 VSS.n2111 0.424
R5732 VSS.t82 VSS.t212 0.423128
R5733 VSS.t206 VSS.n1439 0.422485
R5734 VSS.t272 VSS.t104 0.420219
R5735 VSS.n1735 VSS.t99 0.418461
R5736 VSS.t65 VSS.n1384 0.411982
R5737 VSS.n1735 VSS.t111 0.404364
R5738 VSS.t307 VSS.t113 0.398048
R5739 VSS.t175 VSS.t481 0.396726
R5740 VSS.n2215 VSS.n1757 0.393331
R5741 VSS.n1844 VSS.n304 0.393331
R5742 VSS.n2187 VSS.n269 0.393331
R5743 VSS.n1987 VSS.n1959 0.393331
R5744 VSS.t125 VSS.t193 0.378278
R5745 VSS.t15 VSS.n470 1.0648
R5746 VSS.n2391 VSS.n135 0.374799
R5747 VSS.n2482 VSS.n2481 0.372667
R5748 VSS.n543 VSS.t54 0.317174
R5749 VSS.n1411 VSS.t348 0.370777
R5750 VSS.t1060 VSS.t1061 0.36115
R5751 VSS.t824 VSS.t825 0.36115
R5752 VSS.t827 VSS.t828 0.36115
R5753 VSS.t828 VSS.t829 0.360811
R5754 VSS.t1056 VSS.t1057 0.360811
R5755 VSS.t1060 VSS.t1059 0.360811
R5756 VSS.t362 VSS.t104 0.360811
R5757 VSS.t826 VSS.t827 0.360811
R5758 VSS.t373 VSS.n471 0.32563
R5759 VSS.t1063 VSS.t1064 0.360471
R5760 VSS.t1057 VSS.t1059 0.360471
R5761 VSS.t1053 VSS.t1054 0.360471
R5762 VSS.t829 VSS.t831 0.360471
R5763 VSS.t825 VSS.t826 0.360471
R5764 VSS.n2503 VSS.n2502 0.359477
R5765 VSS.n1520 VSS.n1519 0.359477
R5766 VSS.n63 VSS.n997 0.404823
R5767 VSS.t118 VSS.t739 0.358388
R5768 VSS.n1003 VSS.n64 0.472995
R5769 VSS.n2413 VSS.n2412 0.356631
R5770 VSS.n730 VSS.n729 0.356631
R5771 VSS.n786 VSS.n785 0.356631
R5772 VSS.n807 VSS.n806 0.356631
R5773 VSS.n851 VSS.n850 0.356631
R5774 VSS.n2225 VSS.n2218 0.356631
R5775 VSS.n2205 VSS.n1768 0.356631
R5776 VSS.n2496 VSS.n2495 0.356631
R5777 VSS.n1483 VSS.n1482 0.356631
R5778 VSS.n2531 VSS.n2530 0.354368
R5779 VSS.n1199 VSS.t193 0.346862
R5780 VSS.t131 VSS.t135 0.344562
R5781 VSS.n367 VSS.t777 0.433869
R5782 VSS.n371 VSS.t780 0.433869
R5783 VSS.n375 VSS.t783 0.433869
R5784 VSS.n379 VSS.t786 0.433869
R5785 VSS.n383 VSS.t789 0.433869
R5786 VSS.t792 VSS.n387 0.433709
R5787 VSS.t372 VSS.n635 0.341845
R5788 VSS.n2262 VSS.n2252 0.341742
R5789 VSS.n1502 VSS.n1501 0.341064
R5790 VSS.t1118 VSS.n635 0.339761
R5791 VSS.n344 VSS.t172 0.238281
R5792 VSS.n2496 VSS.n2490 0.339121
R5793 VSS.n1482 VSS.n1480 0.338782
R5794 VSS.t789 VSS.n387 0.235876
R5795 VSS.t775 VSS.n367 0.235729
R5796 VSS.t777 VSS.n371 0.235729
R5797 VSS.t780 VSS.n375 0.235729
R5798 VSS.t783 VSS.n379 0.235729
R5799 VSS.t786 VSS.n383 0.235729
R5800 VSS.n2531 VSS.n618 0.335366
R5801 VSS.n1339 VSS.t243 0.32591
R5802 VSS.t739 VSS.t737 0.32553
R5803 VSS.n2135 VSS.n2114 0.321333
R5804 VSS.t371 VSS.n639 0.317558
R5805 VSS.n437 VSS.t907 0.0850573
R5806 VSS.t1105 VSS.t1106 0.306984
R5807 VSS.n1311 VSS.t721 0.306727
R5808 VSS.t133 VSS.n406 0.689467
R5809 VSS.t1054 VSS.t1055 0.301114
R5810 VSS.t341 VSS.t199 0.301114
R5811 VSS.t85 VSS.t31 0.301114
R5812 VSS.t1055 VSS.t1056 0.301114
R5813 VSS.t819 VSS.t820 0.301114
R5814 VSS.t822 VSS.t823 0.301114
R5815 VSS.t1065 VSS.t1064 0.301114
R5816 VSS.t1062 VSS.t1063 0.301114
R5817 VSS.t431 VSS.t237 0.301114
R5818 VSS.n1661 VSS.t237 0.300775
R5819 VSS.t1061 VSS.t1062 0.300775
R5820 VSS.t199 VSS.t649 0.300775
R5821 VSS.t823 VSS.t824 0.300775
R5822 VSS.t821 VSS.t822 0.300775
R5823 VSS.t818 VSS.t819 0.300775
R5824 VSS.n997 VSS.n995 0.299905
R5825 VSS.n2453 VSS.n2452 0.299905
R5826 VSS.n2255 VSS.n2254 0.299905
R5827 VSS.n2514 VSS.n2512 0.299905
R5828 VSS.n2435 VSS.n2433 0.299608
R5829 VSS.n2274 VSS.n2273 0.299608
R5830 VSS.n1502 VSS.n1500 0.299608
R5831 VSS.n990 VSS.n969 0.299566
R5832 VSS.n2436 VSS.n2435 0.299566
R5833 VSS.n2286 VSS.n564 0.299566
R5834 VSS.n2452 VSS.n2451 0.299268
R5835 VSS.n2263 VSS.n2262 0.299268
R5836 VSS.n2275 VSS.n2274 0.299268
R5837 VSS.n2514 VSS.n2513 0.299268
R5838 VSS.n2509 VSS.n2502 0.299268
R5839 VSS.n1519 VSS.n1518 0.299268
R5840 VSS.n2034 VSS.n2025 0.297623
R5841 VSS.n2007 VSS.n2005 0.297623
R5842 VSS.n1991 VSS.n1990 0.297623
R5843 VSS.n2352 VSS.n2351 0.297623
R5844 VSS.n697 VSS.n99 0.893541
R5845 VSS.n823 VSS.n162 0.297623
R5846 VSS.n2071 VSS.n2070 0.297623
R5847 VSS.n2201 VSS.n2200 0.297623
R5848 VSS.n2185 VSS.n2184 0.297623
R5849 VSS.n2218 VSS.n2216 0.297623
R5850 VSS.n1956 VSS.n1955 0.297623
R5851 VSS.n1978 VSS.n1972 0.297623
R5852 VSS.n2094 VSS.n237 0.297623
R5853 VSS.n2182 VSS.n2181 0.297623
R5854 VSS.n2127 VSS.n2126 0.297623
R5855 VSS.n2331 VSS.n2330 0.297623
R5856 VSS.n2322 VSS.n2321 0.297623
R5857 VSS.n2308 VSS.n2307 0.297623
R5858 VSS.n951 VSS.n950 0.297623
R5859 VSS.n2039 VSS.n2037 0.297283
R5860 VSS.n66 VSS.n1013 0.780481
R5861 VSS.n960 VSS.n65 0.721846
R5862 VSS.n64 VSS.n1002 0.721846
R5863 VSS.n131 VSS.n2392 0.612194
R5864 VSS.n2409 VSS.n121 1.24739
R5865 VSS.n129 VSS.n120 1.12715
R5866 VSS.n125 VSS.n118 1.12715
R5867 VSS.n696 VSS.n97 0.822065
R5868 VSS.n92 VSS.n731 0.970931
R5869 VSS.n84 VSS.n734 1.05982
R5870 VSS.n753 VSS.n86 0.472919
R5871 VSS.n26 VSS.n85 1.10739
R5872 VSS.n12 VSS.n811 1.11864
R5873 VSS.n71 VSS.n40 0.834359
R5874 VSS.n2070 VSS.n2069 0.297283
R5875 VSS.n2200 VSS.n2199 0.297283
R5876 VSS.n2313 VSS.n2312 0.297283
R5877 VSS.n954 VSS.n953 0.297283
R5878 VSS.n1958 VSS.n1956 0.297283
R5879 VSS.n2095 VSS.n2094 0.297283
R5880 VSS.n2181 VSS.n2180 0.297283
R5881 VSS.n2157 VSS.n2155 0.297283
R5882 VSS.n1814 VSS.n317 0.297283
R5883 VSS.n2321 VSS.n2320 0.297283
R5884 VSS.n950 VSS.n949 0.297283
R5885 VSS.n2525 VSS.n627 0.295638
R5886 VSS.n2528 VSS.n627 0.295001
R5887 VSS.n1906 VSS.n1905 0.292973
R5888 VSS.n786 VSS.n769 0.290245
R5889 VSS.n851 VSS.n846 0.290245
R5890 VSS.n1198 VSS.t193 0.28416
R5891 VSS.n31 VSS.n29 0.259251
R5892 VSS.n2503 VSS.n643 0.272257
R5893 VSS.n1411 VSS.n1384 0.271246
R5894 VSS.t1053 VSS.t180 0.269974
R5895 VSS.t272 VSS.t457 0.269894
R5896 VSS.t506 VSS.n1194 0.268308
R5897 VSS.t0 VSS.t206 0.266125
R5898 VSS.t137 VSS.t133 0.262394
R5899 VSS.t311 VSS.t290 0.25236
R5900 VSS.n462 VSS.t341 0.119605
R5901 VSS.t208 VSS.n464 0.119605
R5902 VSS.t649 VSS.n1336 0.241078
R5903 VSS.n471 VSS.n479 0.47606
R5904 VSS.n1682 VSS.t355 0.241078
R5905 VSS.t75 VSS.n1661 0.241078
R5906 VSS.t1065 VSS.t1075 0.241078
R5907 VSS.t75 VSS.n481 0.119605
R5908 VSS.t235 VSS.t252 0.241078
R5909 VSS.t554 VSS.t107 0.241078
R5910 VSS.t355 VSS.t208 0.241078
R5911 VSS.t820 VSS.t821 0.241078
R5912 VSS.t817 VSS.t818 0.241078
R5913 VSS.t648 VSS.t362 0.240486
R5914 VSS.n992 VSS.n37 0.358572
R5915 VSS.n971 VSS.n986 0.239994
R5916 VSS.n986 VSS.n985 0.239994
R5917 VSS.n990 VSS.n989 0.239994
R5918 VSS.n2447 VSS.n871 0.239994
R5919 VSS.n2455 VSS.n871 0.239994
R5920 VSS.n2429 VSS.n2428 0.239994
R5921 VSS.n2428 VSS.n2427 0.239994
R5922 VSS.n2427 VSS.n2426 0.239994
R5923 VSS.n2256 VSS.n2255 0.239994
R5924 VSS.n2297 VSS.n2296 0.239994
R5925 VSS.n2298 VSS.n2297 0.239994
R5926 VSS.n2288 VSS.n564 0.239994
R5927 VSS.n1500 VSS.n596 0.239982
R5928 VSS.n2039 VSS.n2038 0.238275
R5929 VSS.n2028 VSS.n2025 0.238275
R5930 VSS.n2012 VSS.n2011 0.238275
R5931 VSS.n2011 VSS.n2010 0.238275
R5932 VSS.n2005 VSS.n2003 0.238275
R5933 VSS.n1991 VSS.n1988 0.238275
R5934 VSS.n2352 VSS.n2345 0.238275
R5935 VSS.n127 VSS.n140 0.663367
R5936 VSS.n2405 VSS.n127 0.356017
R5937 VSS.n123 VSS.n142 0.663367
R5938 VSS.n2479 VSS.n123 0.356017
R5939 VSS.n95 VSS.n714 0.396963
R5940 VSS.n91 VSS.n750 0.282257
R5941 VSS.n88 VSS.n91 0.47376
R5942 VSS.n845 VSS.n36 0.809287
R5943 VSS.n1905 VSS.n1904 0.238275
R5944 VSS.n1904 VSS.n1903 0.238275
R5945 VSS.n1981 VSS.n211 0.238275
R5946 VSS.n1981 VSS.n1980 0.238275
R5947 VSS.n2109 VSS.n231 0.238275
R5948 VSS.n1880 VSS.n231 0.238275
R5949 VSS.n2089 VSS.n2088 0.238275
R5950 VSS.n2088 VSS.n2087 0.238275
R5951 VSS.n2192 VSS.n2191 0.238275
R5952 VSS.n2193 VSS.n2192 0.238275
R5953 VSS.n2194 VSS.n2193 0.238275
R5954 VSS.n2186 VSS.n2185 0.238275
R5955 VSS.n2145 VSS.n277 0.238275
R5956 VSS.n2146 VSS.n2145 0.238275
R5957 VSS.n2133 VSS.n2132 0.238275
R5958 VSS.n2132 VSS.n2131 0.238275
R5959 VSS.n2131 VSS.n2130 0.238275
R5960 VSS.n1870 VSS.n301 0.238275
R5961 VSS.n1852 VSS.n301 0.238275
R5962 VSS.n1853 VSS.n1852 0.238275
R5963 VSS.n1843 VSS.n1842 0.238275
R5964 VSS.n1842 VSS.n1841 0.238275
R5965 VSS.n1841 VSS.n1840 0.238275
R5966 VSS.n1820 VSS.n323 0.238275
R5967 VSS.n1820 VSS.n1819 0.238275
R5968 VSS.n2211 VSS.n898 0.238275
R5969 VSS.n2212 VSS.n2211 0.238275
R5970 VSS.n2212 VSS.n2210 0.238275
R5971 VSS.n2312 VSS.n2311 0.238275
R5972 VSS.n955 VSS.n954 0.238275
R5973 VSS.n1974 VSS.n1972 0.238275
R5974 VSS.n1911 VSS.n1909 0.238275
R5975 VSS.n1909 VSS.n1908 0.238275
R5976 VSS.n1892 VSS.n1891 0.238275
R5977 VSS.n1891 VSS.n1890 0.238275
R5978 VSS.n2064 VSS.n2062 0.238275
R5979 VSS.n2062 VSS.n2061 0.238275
R5980 VSS.n1782 VSS.n1779 0.238275
R5981 VSS.n1783 VSS.n1782 0.238275
R5982 VSS.n2157 VSS.n2156 0.238275
R5983 VSS.n2128 VSS.n2127 0.238275
R5984 VSS.n1850 VSS.n1848 0.238275
R5985 VSS.n1855 VSS.n1850 0.238275
R5986 VSS.n1837 VSS.n1836 0.238275
R5987 VSS.n1838 VSS.n1837 0.238275
R5988 VSS.n1816 VSS.n317 0.238275
R5989 VSS.n2221 VSS.n2220 0.238275
R5990 VSS.n2222 VSS.n2221 0.238275
R5991 VSS.n2223 VSS.n2222 0.238275
R5992 VSS.n2332 VSS.n2331 0.238275
R5993 VSS.n2309 VSS.n2308 0.238275
R5994 VSS.n2526 VSS.n2525 0.236568
R5995 VSS.n132 VSS.n131 0.528281
R5996 VSS.n766 VSS.n24 0.463685
R5997 VSS.n808 VSS.n81 0.348979
R5998 VSS.n2071 VSS.n2067 0.231236
R5999 VSS.n2202 VSS.n2201 0.231236
R6000 VSS.t277 VSS.n1425 0.227596
R6001 VSS.t29 VSS.t883 0.227075
R6002 VSS.t537 VSS.t886 0.227075
R6003 VSS.t836 VSS.t834 0.227075
R6004 VSS.t832 VSS.t831 0.227075
R6005 VSS.t1125 VSS.t696 0.226736
R6006 VSS.t1122 VSS.t1120 0.226736
R6007 VSS.t1116 VSS.t1118 0.226736
R6008 VSS.t1113 VSS.t1111 0.226736
R6009 VSS.t773 VSS.t771 0.226736
R6010 VSS.t892 VSS.t890 0.226736
R6011 VSS.t938 VSS.t936 0.226736
R6012 VSS.t943 VSS.t941 0.226736
R6013 VSS.t948 VSS.t946 0.226736
R6014 VSS.t340 VSS.t963 0.226736
R6015 VSS.t1009 VSS.t1007 0.226736
R6016 VSS.t1014 VSS.t1012 0.226736
R6017 VSS.t1019 VSS.t1017 0.226736
R6018 VSS.t1024 VSS.t1022 0.226736
R6019 VSS.t1029 VSS.t1027 0.226736
R6020 VSS.t1034 VSS.t1032 0.226736
R6021 VSS.t1081 VSS.t1083 0.226736
R6022 VSS.t1088 VSS.t1086 0.226736
R6023 VSS.t1091 VSS.t1093 0.226736
R6024 VSS.t1098 VSS.t1096 0.226736
R6025 VSS.t1101 VSS.t1103 0.226736
R6026 VSS.t172 VSS.t794 0.226736
R6027 VSS.t333 VSS.t775 0.224575
R6028 VSS.n2314 VSS.n2313 0.223862
R6029 VSS.n2412 VSS.n2411 0.223523
R6030 VSS.n826 VSS.n162 0.223523
R6031 VSS.n2484 VSS.n660 0.2205
R6032 VSS.t1115 VSS.t1116 0.218325
R6033 VSS.t1124 VSS.t1125 0.218325
R6034 VSS.t890 VSS.n421 0.0863258
R6035 VSS.t946 VSS.n502 0.0863258
R6036 VSS.t1080 VSS.t1081 0.218325
R6037 VSS.t1090 VSS.t1091 0.218325
R6038 VSS.t1100 VSS.t1101 0.218325
R6039 VSS.t1096 VSS.t1095 0.218325
R6040 VSS.t1086 VSS.t1085 0.218325
R6041 VSS.n521 VSS.t1006 0.130189
R6042 VSS.t1012 VSS.n525 0.0863258
R6043 VSS.t1017 VSS.n529 0.0863258
R6044 VSS.t1022 VSS.n533 0.0863258
R6045 VSS.t1027 VSS.n537 0.0863258
R6046 VSS.t1032 VSS.n540 0.0863258
R6047 VSS.n494 VSS.t935 0.130189
R6048 VSS.t941 VSS.n498 0.0863258
R6049 VSS.t963 VSS.n512 0.0863258
R6050 VSS.n362 VSS.t770 0.130189
R6051 VSS.n389 VSS.t792 0.130189
R6052 VSS.t1120 VSS.t372 0.218325
R6053 VSS.t1111 VSS.t1110 0.218325
R6054 VSS.t51 VSS.n426 0.129991
R6055 VSS.n403 VSS.t834 0.0861948
R6056 VSS.t802 VSS.n363 0.129991
R6057 VSS.n1735 VSS.n1140 0.215211
R6058 VSS.n2451 VSS.n2450 0.212632
R6059 VSS.t907 VSS.t169 0.209256
R6060 VSS.n2112 VSS.n1873 0.205833
R6061 VSS.n1197 VSS.t331 0.204125
R6062 VSS.t240 VSS.n1333 0.204087
R6063 VSS.n474 VSS.t431 0.119725
R6064 VSS.n2379 VSS.n2378 0.197782
R6065 VSS.t38 VSS.n1261 0.190555
R6066 VSS.n586 VSS.n584 0.187792
R6067 VSS.n1524 VSS.n1469 0.186001
R6068 VSS.t534 VSS.n63 0.186678
R6069 VSS.n2486 VSS.n2485 0.183833
R6070 VSS.t225 VSS.t817 0.180789
R6071 VSS.t895 VSS.n410 0.24604
R6072 VSS.t1204 VSS.n1682 0.180789
R6073 VSS.t252 VSS.t222 0.238594
R6074 VSS.n433 VSS.t248 0.24604
R6075 VSS.t351 VSS.t901 0.24604
R6076 VSS.t462 VSS.t895 0.204256
R6077 VSS.t901 VSS.t554 0.197416
R6078 VSS.t650 VSS.n1337 0.180789
R6079 VSS.n1984 VSS.n211 0.178685
R6080 VSS.n2163 VSS.n277 0.178685
R6081 VSS.n1823 VSS.n323 0.178685
R6082 VSS.n955 VSS.n946 0.178685
R6083 VSS.n1194 VSS.t216 0.17801
R6084 VSS.t1075 VSS.t1076 0.167039
R6085 VSS.t351 VSS.t902 0.167039
R6086 VSS.t248 VSS.t246 0.167039
R6087 VSS.n1336 VSS.t899 0.164539
R6088 VSS.n1988 VSS.n1987 0.164514
R6089 VSS.n2110 VSS.n2109 0.164514
R6090 VSS.n2091 VSS.n2089 0.164514
R6091 VSS.n2191 VSS.n2190 0.164514
R6092 VSS.n2187 VSS.n2186 0.164514
R6093 VSS.n2134 VSS.n2133 0.164514
R6094 VSS.n1871 VSS.n1870 0.164514
R6095 VSS.n1844 VSS.n1843 0.164514
R6096 VSS.n2216 VSS.n2215 0.164514
R6097 VSS.n2317 VSS.n898 0.164514
R6098 VSS.t175 VSS.n541 0.159098
R6099 VSS.t899 VSS.t650 0.158289
R6100 VSS.n2270 VSS.n918 0.157436
R6101 VSS.t539 VSS.t886 0.150486
R6102 VSS.n2393 VSS.n135 0.149715
R6103 VSS.t31 VSS.t898 0.147039
R6104 VSS.t283 VSS.n348 0.145678
R6105 VSS.n2291 VSS.n2290 0.1373
R6106 VSS.t1108 VSS.t1106 0.135506
R6107 VSS.n2490 VSS.n2489 0.13242
R6108 VSS.n1501 VSS.n658 0.13242
R6109 VSS.n1480 VSS.n659 0.13242
R6110 VSS.n2252 VSS.t701 0.132082
R6111 VSS.n657 VSS.n618 0.131854
R6112 VSS.n989 VSS.n988 0.125403
R6113 VSS.n2436 VSS.n2432 0.125403
R6114 VSS.n542 VSS.t1050 0.0476546
R6115 VSS.n1912 VSS.n1906 0.109767
R6116 VSS.n842 VSS.n72 0.224521
R6117 VSS.n1337 VSS.t900 0.10675
R6118 VSS.n556 VSS.n2300 0.105495
R6119 VSS.n1985 VSS.n1984 0.104924
R6120 VSS.n2164 VSS.n2163 0.104924
R6121 VSS.n1824 VSS.n1823 0.104924
R6122 VSS.n946 VSS.n900 0.104924
R6123 VSS.t648 VSS.n460 0.0682317
R6124 VSS.t903 VSS.n433 0.0333775
R6125 VSS.t225 VSS.t816 0.098
R6126 VSS.t1124 VSS.t1122 0.0855
R6127 VSS.t1115 VSS.t1113 0.0855
R6128 VSS.t1108 VSS.t1110 0.0855
R6129 VSS.t1076 VSS.t23 0.0855
R6130 VSS.t773 VSS.t802 0.0855
R6131 VSS.t832 VSS.t120 0.0855
R6132 VSS.t889 VSS.t537 0.0855
R6133 VSS.t892 VSS.t894 0.0855
R6134 VSS.t902 VSS.t903 0.0855
R6135 VSS.t940 VSS.t938 0.0855
R6136 VSS.t945 VSS.t943 0.0855
R6137 VSS.t1011 VSS.t1009 0.0855
R6138 VSS.t1016 VSS.t1014 0.0855
R6139 VSS.t1021 VSS.t1019 0.0855
R6140 VSS.t1026 VSS.t1024 0.0855
R6141 VSS.t1031 VSS.t1029 0.0855
R6142 VSS.t1083 VSS.t1085 0.0855
R6143 VSS.t1090 VSS.t1088 0.0855
R6144 VSS.t1093 VSS.t1095 0.0855
R6145 VSS.t1100 VSS.t1098 0.0855
R6146 VSS.t1103 VSS.t1105 0.0855
R6147 VSS.t906 VSS.t246 0.0855
R6148 VSS.t48 VSS.t1050 0.0845024
R6149 VSS.n656 VSS.n643 0.0817186
R6150 VSS.n2450 VSS.n2449 0.0817186
R6151 VSS.t1204 VSS.t665 0.078
R6152 VSS.n43 VSS.n42 0.0770708
R6153 VSS.t948 VSS.t146 0.07425
R6154 VSS.t952 VSS.t954 0.07425
R6155 VSS.t23 VSS.t455 0.068
R6156 VSS.t575 VSS.t539 0.068
R6157 VSS.n2541 VSS.n606 0.0623545
R6158 VSS.n1607 VSS.n606 0.0623545
R6159 VSS.n1608 VSS.n1607 0.0623545
R6160 VSS.n1608 VSS.n1383 0.0623545
R6161 VSS.n1677 VSS.n1383 0.0623545
R6162 VSS.n1678 VSS.n1677 0.0623545
R6163 VSS.n1678 VSS.n1123 0.0623545
R6164 VSS.n1736 VSS.n1123 0.0623545
R6165 VSS.n1737 VSS.n1736 0.0623545
R6166 VSS.n1737 VSS.n1122 0.0623545
R6167 VSS.n2240 VSS.n1046 0.0623545
R6168 VSS.n1424 VSS.n1046 0.0623545
R6169 VSS.n1665 VSS.n1424 0.0623545
R6170 VSS.n1666 VSS.n1665 0.0623545
R6171 VSS.n1666 VSS.n1310 0.0623545
R6172 VSS.n1730 VSS.n1310 0.0623545
R6173 VSS.n1731 VSS.n1730 0.0623545
R6174 VSS.n1731 VSS.n1309 0.0623545
R6175 VSS.n1309 VSS.n1260 0.0623545
R6176 VSS.n2203 VSS.n2202 0.0530519
R6177 VSS.n2067 VSS.n2066 0.0530519
R6178 VSS.n809 VSS.n808 0.0530519
R6179 VSS.n767 VSS.n766 0.0530519
R6180 VSS.n732 VSS.n94 0.167394
R6181 VSS.n698 VSS.n101 0.167394
R6182 VSS.n2480 VSS.n125 0.167394
R6183 VSS.n2406 VSS.n129 0.167394
R6184 VSS.n2393 VSS.n132 0.167394
R6185 VSS.n31 VSS.n30 0.145164
R6186 VSS.n790 VSS.n769 0.0530519
R6187 VSS.n846 VSS.n845 0.0530519
R6188 VSS.n988 VSS.t593 0.048625
R6189 VSS.n2432 VSS.n2343 0.048625
R6190 VSS.n1333 VSS.t383 0.0381133
R6191 VSS.n2441 VSS.n2347 0.0319807
R6192 VSS.t82 VSS.n1073 0.0271432
R6193 VSS.n1344 VSS.t519 0.0271432
R6194 VSS.t279 VSS.n416 0.0266763
R6195 VSS.n1708 VSS.n417 0.0266763
R6196 VSS.t672 VSS.n515 0.0266763
R6197 VSS.n1598 VSS.t54 0.0266763
R6198 VSS.n1089 VSS.t193 0.0258175
R6199 VSS.n1091 VSS.t193 0.0258175
R6200 VSS.n1092 VSS.t193 0.0258175
R6201 VSS.n1094 VSS.t193 0.0258175
R6202 VSS.n1095 VSS.t193 0.0258175
R6203 VSS.n1097 VSS.t193 0.0258175
R6204 VSS.n1098 VSS.t193 0.0258175
R6205 VSS.n1100 VSS.t193 0.0258175
R6206 VSS.n1101 VSS.t193 0.0258175
R6207 VSS.n1103 VSS.t193 0.0258175
R6208 VSS.n1104 VSS.t193 0.0258175
R6209 VSS.n1106 VSS.t193 0.0258175
R6210 VSS.n1107 VSS.t193 0.0258175
R6211 VSS.t283 VSS.n346 0.0258175
R6212 VSS.t283 VSS.n347 0.0258175
R6213 VSS.n386 VSS.n388 0.0258175
R6214 VSS.n361 VSS.n360 0.0258175
R6215 VSS.n1285 VSS.t26 0.0258175
R6216 VSS.n1289 VSS.t26 0.0258175
R6217 VSS.n1735 VSS.n1137 0.0258175
R6218 VSS.n1735 VSS.n1172 0.0258175
R6219 VSS.n1735 VSS.n1170 0.0258175
R6220 VSS.n1735 VSS.n1154 0.0258175
R6221 VSS.n1735 VSS.n1166 0.0258175
R6222 VSS.n1735 VSS.n1158 0.0258175
R6223 VSS.n1705 VSS.n422 0.0258175
R6224 VSS.n422 VSS.n427 0.0258175
R6225 VSS.n1411 VSS.n1410 0.0258175
R6226 VSS.n1411 VSS.n1408 0.0258175
R6227 VSS.n1411 VSS.n1390 0.0258175
R6228 VSS.n1411 VSS.n1397 0.0258175
R6229 VSS.n1411 VSS.n1405 0.0258175
R6230 VSS.n1411 VSS.n1404 0.0258175
R6231 VSS.n1411 VSS.n1402 0.0258175
R6232 VSS.n1653 VSS.n488 0.0258175
R6233 VSS.n504 VSS.n511 0.0258175
R6234 VSS.n499 VSS.n501 0.0258175
R6235 VSS.n495 VSS.n497 0.0258175
R6236 VSS.n492 VSS.n490 0.0258175
R6237 VSS.n1625 VSS.t206 0.0258175
R6238 VSS.n538 VSS.n539 0.0258175
R6239 VSS.n534 VSS.n536 0.0258175
R6240 VSS.n530 VSS.n532 0.0258175
R6241 VSS.n526 VSS.n528 0.0258175
R6242 VSS.n522 VSS.n524 0.0258175
R6243 VSS.n519 VSS.n517 0.0258175
R6244 VSS.n51 VSS.n48 0.0106048
R6245 VSS.n59 VSS.n58 0.00516532
R6246 VSS.n67 VSS.n55 0.00622613
R6247 VSS.n2463 VSS.n2462 0.01139
R6248 VSS.n2464 VSS.n2463 0.0113687
R6249 VSS.n2441 VSS.n2440 0.00507208
R6250 VSS.n108 VSS.n2414 0.00449987
R6251 VSS.n558 VSS.n560 0.00409958
R6252 VSS.n59 VSS.n57 0.00399853
R6253 VSS.n51 VSS.n50 0.00391309
R6254 VSS.n43 VSS.n41 0.00384234
R6255 VSS.n1010 VSS.n55 0.00384234
R6256 VSS.n2497 VSS.n587 0.00387493
R6257 VSS.n478 VSS.n472 0.0036664
R6258 VSS.n602 VSS.n601 0.00299994
R6259 VSS.n605 VSS.n604 0.00299993
R6260 VSS.n598 VSS.n595 0.00324996
R6261 VSS.n581 VSS.n577 0.00299994
R6262 VSS.n549 VSS.n548 0.00299993
R6263 VSS.n473 VSS.n475 0.00299993
R6264 VSS.n563 VSS.n562 0.00249999
R6265 VSS.n469 VSS.n463 0.00249997
R6266 VSS.n1499 VSS.n595 0.00224999
R6267 VSS.n572 VSS.n571 0.00224999
R6268 VSS.n2267 VSS.n576 0.0022
R6269 VSS.n575 VSS.n574 0.0022
R6270 VSS.n2326 VSS.n569 0.0022
R6271 VSS.n400 VSS.n399 0.00224988
R6272 VSS.n459 VSS.n458 0.002125
R6273 VSS.n1484 VSS.n1470 0.002125
R6274 VSS.n1088 VSS.t193 0.00194928
R6275 VSS.n1735 VSS.n1136 0.00194928
R6276 VSS.n1735 VSS.n1176 0.00194928
R6277 VSS.n1411 VSS.n1406 0.00194928
R6278 VSS.n1524 VSS.n1470 0.00187493
R6279 VSS.n115 VSS.n114 0.0019165
R6280 VSS.n1679 VSS.n458 0.00187493
R6281 VSS.n752 VSS.n23 0.00175
R6282 VSS.n829 VSS.n828 0.00175
R6283 VSS.n1989 VSS.n1949 0.00175
R6284 VSS.n1977 VSS.n1976 0.00175
R6285 VSS.n2168 VSS.n2166 0.00175
R6286 VSS.n2160 VSS.n2144 0.00175
R6287 VSS.n1818 VSS.n1807 0.00175
R6288 VSS.n546 VSS.n545 0.00183324
R6289 VSS.n563 VSS.n561 0.00162492
R6290 VSS.n2282 VSS.n571 0.00175
R6291 VSS.n1487 VSS.n1481 0.00175
R6292 VSS.n1504 VSS.n1503 0.00175
R6293 VSS.n2532 VSS.n617 0.00175
R6294 VSS.n1578 VSS.n1554 0.00166667
R6295 VSS.n1555 VSS.n1552 0.00166667
R6296 VSS.n1556 VSS.n1551 0.00166667
R6297 VSS.n1557 VSS.n1550 0.00166667
R6298 VSS.n1576 VSS.n1549 0.00166667
R6299 VSS.n1575 VSS.n1548 0.00166667
R6300 VSS.n1574 VSS.n1546 0.00166667
R6301 VSS.n1559 VSS.n1545 0.00166667
R6302 VSS.n2306 VSS.n2305 0.00166667
R6303 VSS.n2258 VSS.n2253 0.00166667
R6304 VSS.n2125 VSS.n2124 0.00166667
R6305 VSS.n257 VSS.n1781 0.00166667
R6306 VSS.n2102 VSS.n2052 0.00166667
R6307 VSS.n1894 VSS.n1893 0.00166667
R6308 VSS.n1914 VSS.n1900 0.00166667
R6309 VSS.n1907 VSS.n1895 0.00166667
R6310 VSS.n213 VSS.n212 0.00138884
R6311 VSS.n2006 VSS.n1934 0.00166667
R6312 VSS.n2033 VSS.n2032 0.00166667
R6313 VSS.n2024 VSS.n1932 0.00166667
R6314 VSS.n2027 VSS.n2026 0.00166667
R6315 VSS.n2004 VSS.n1935 0.00166667
R6316 VSS.n2353 VSS.n2349 0.00166667
R6317 VSS.n1004 VSS.n45 0.00166667
R6318 VSS.n805 VSS.n804 0.00166667
R6319 VSS.n2477 VSS.n109 0.00166667
R6320 VSS.n2403 VSS.n111 0.00166667
R6321 VSS.n126 VSS.n128 0.00349963
R6322 VSS.n122 VSS.n124 0.00349963
R6323 VSS.n717 VSS.n716 0.00166667
R6324 VSS.n726 VSS.n149 0.00166667
R6325 VSS.n153 VSS.n152 0.00166667
R6326 VSS.n14 VSS.n13 0.00174984
R6327 VSS.n788 VSS.n787 0.00166667
R6328 VSS.n784 VSS.n776 0.00166667
R6329 VSS.n793 VSS.n792 0.00166667
R6330 VSS.n802 VSS.n77 0.00166667
R6331 VSS.n76 VSS.n75 0.00166667
R6332 VSS.n34 VSS.n852 0.00166667
R6333 VSS.n849 VSS.n848 0.00166667
R6334 VSS.n855 VSS.n679 0.00166667
R6335 VSS.n166 VSS.n168 0.00169993
R6336 VSS.n186 VSS.n185 0.00169993
R6337 VSS.n979 VSS.n187 0.00166667
R6338 VSS.n202 VSS.n1954 0.00166667
R6339 VSS.n209 VSS.n1973 0.00166667
R6340 VSS.n1879 VSS.n1877 0.00166667
R6341 VSS.n2072 VSS.n2057 0.00166667
R6342 VSS.n240 VSS.n239 0.00169993
R6343 VSS.n2097 VSS.n2076 0.00166667
R6344 VSS.n1776 VSS.n247 0.00166667
R6345 VSS.n1767 VSS.n1766 0.00166667
R6346 VSS.n255 VSS.n254 0.00166667
R6347 VSS.n2167 VSS.n267 0.00166667
R6348 VSS.n2162 VSS.n2140 0.00166667
R6349 VSS.n279 VSS.n278 0.00149995
R6350 VSS.n292 VSS.n291 0.00149995
R6351 VSS.n1826 VSS.n315 0.00166667
R6352 VSS.n1822 VSS.n1801 0.00166667
R6353 VSS.n325 VSS.n324 0.00149995
R6354 VSS.n1764 VSS.n327 0.00166667
R6355 VSS.n1119 VSS.n1116 0.00166667
R6356 VSS.n1741 VSS.n1115 0.00166667
R6357 VSS.n1120 VSS.n1114 0.00166667
R6358 VSS.n1740 VSS.n1113 0.00166667
R6359 VSS.n1739 VSS.n1112 0.00166667
R6360 VSS.n408 VSS.n407 0.00169993
R6361 VSS.n1714 VSS.n1323 0.00166667
R6362 VSS.t187 VSS.n413 0.00166667
R6363 VSS.n435 VSS.n431 0.00166667
R6364 VSS.n1382 VSS.n1340 0.00166667
R6365 VSS.n446 VSS.n444 0.00169993
R6366 VSS.n453 VSS.n452 0.00169993
R6367 VSS.n461 VSS.n455 0.00427681
R6368 VSS.n212 VSS.n214 0.00399966
R6369 VSS.n138 VSS.n116 0.00368731
R6370 VSS.n104 VSS.n103 0.00627676
R6371 VSS.n22 VSS.n21 0.00467842
R6372 VSS.n1004 VSS.n44 0.00449826
R6373 VSS.n9 VSS.n8 0.00449994
R6374 VSS.n165 VSS.n35 0.00433321
R6375 VSS.n144 VSS.n96 0.00399997
R6376 VSS.n754 VSS.n155 0.00366647
R6377 VSS.n180 VSS.n870 0.00366585
R6378 VSS.n2390 VSS.n115 0.00349999
R6379 VSS.n2390 VSS.n107 0.00349999
R6380 VSS.n112 VSS.n111 0.00349999
R6381 VSS.n110 VSS.n109 0.00349999
R6382 VSS.n128 VSS.n112 0.00349969
R6383 VSS.n124 VSS.n110 0.00349969
R6384 VSS.n144 VSS.n100 0.00324964
R6385 VSS.n108 VSS.n105 0.00316655
R6386 VSS.n2403 VSS.n119 0.00303332
R6387 VSS.n2477 VSS.n117 0.00303332
R6388 VSS.n324 VSS.n326 0.00299994
R6389 VSS.n278 VSS.n280 0.00299994
R6390 VSS.n191 VSS.n192 0.00299994
R6391 VSS.n335 VSS.n2219 0.00283308
R6392 VSS.n319 VSS.n1815 0.00299966
R6393 VSS.n1660 VSS.n484 0.00166667
R6394 VSS.n2260 VSS.n2259 0.00166667
R6395 VSS.n549 VSS.n547 0.00143746
R6396 VSS.n555 VSS.n554 0.00169993
R6397 VSS.n558 VSS.n557 0.00134996
R6398 VSS.n2290 VSS.n2279 0.00166667
R6399 VSS.n2324 VSS.n2323 0.00166667
R6400 VSS.n2323 VSS.n896 0.00166667
R6401 VSS.n2304 VSS.n909 0.00166667
R6402 VSS.n902 VSS.n573 0.00166667
R6403 VSS.n947 VSS.n938 0.00166667
R6404 VSS.n947 VSS.n937 0.00166667
R6405 VSS.n578 VSS.n577 0.00149995
R6406 VSS.n2498 VSS.n2497 0.00166667
R6407 VSS.n1485 VSS.n1484 0.00166667
R6408 VSS.n2511 VSS.n2501 0.00166667
R6409 VSS.n2506 VSS.n2504 0.00166667
R6410 VSS.n1499 VSS.n1498 0.00166667
R6411 VSS.n1521 VSS.n1489 0.00166667
R6412 VSS.n625 VSS.n602 0.00166667
R6413 VSS.n2533 VSS.n626 0.00166667
R6414 VSS.n605 VSS.n603 0.00143746
R6415 VSS.n1323 VSS.n411 0.00162501
R6416 VSS.n552 VSS.n553 0.00241667
R6417 VSS.n2277 VSS.n2270 0.00162501
R6418 VSS.n2267 VSS.n925 0.00162501
R6419 VSS.n592 VSS.n591 0.00162501
R6420 VSS.n1522 VSS.n1491 0.00162501
R6421 VSS.n1571 VSS.n1542 0.0015
R6422 VSS.n432 VSS.n430 0.0015
R6423 VSS.n445 VSS.n430 0.0015
R6424 VSS.n449 VSS.n447 0.0015
R6425 VSS.n1681 VSS.n457 0.0015
R6426 VSS.n485 VSS.n483 0.0015
R6427 VSS.n594 VSS.n642 0.00199997
R6428 VSS.n592 VSS.n589 0.0015
R6429 VSS.n590 VSS.n589 0.0015
R6430 VSS.n586 VSS.n585 0.0015
R6431 VSS.n1579 VSS.n1578 0.00137498
R6432 VSS.n1522 VSS.n1521 0.00137498
R6433 VSS.n2504 VSS.n591 0.00137498
R6434 VSS.n580 VSS.n925 0.00137498
R6435 VSS.n2277 VSS.n2276 0.00137498
R6436 VSS.n552 VSS.n551 0.00158326
R6437 VSS.n1573 VSS.n1545 0.00133332
R6438 VSS.n1559 VSS.n1546 0.00133332
R6439 VSS.n1558 VSS.n1548 0.00133332
R6440 VSS.n1575 VSS.n1549 0.00133332
R6441 VSS.n1576 VSS.n1550 0.00133332
R6442 VSS.n1557 VSS.n1551 0.00133332
R6443 VSS.n1556 VSS.n1552 0.00133332
R6444 VSS.n1577 VSS.n1554 0.00133332
R6445 VSS.n2533 VSS.n2532 0.00133332
R6446 VSS.n626 VSS.n625 0.00133332
R6447 VSS.n1503 VSS.n1498 0.00133332
R6448 VSS.n1493 VSS.n1489 0.00133332
R6449 VSS.n590 VSS.n588 0.00149995
R6450 VSS.n2501 VSS.n642 0.00133332
R6451 VSS.n2506 VSS.n2505 0.00133332
R6452 VSS.n1485 VSS.n1481 0.00133332
R6453 VSS.n2498 VSS.n585 0.00133332
R6454 VSS.n956 VSS.n938 0.00133332
R6455 VSS.n948 VSS.n937 0.00133332
R6456 VSS.n909 VSS.n570 0.00133332
R6457 VSS.n2306 VSS.n902 0.00133332
R6458 VSS.n2319 VSS.n896 0.00133332
R6459 VSS.n2324 VSS.n338 0.00133332
R6460 VSS.n565 VSS.n2279 0.00133332
R6461 VSS.n2261 VSS.n2260 0.00133332
R6462 VSS.n331 VSS.n329 0.00141663
R6463 VSS.n2217 VSS.n1764 0.00133332
R6464 VSS.n1822 VSS.n325 0.00249991
R6465 VSS.n1815 VSS.n1801 0.00133332
R6466 VSS.n1826 VSS.n312 0.00133332
R6467 VSS.n2162 VSS.n279 0.00249991
R6468 VSS.n2154 VSS.n2140 0.00133332
R6469 VSS.n2167 VSS.n2166 0.00133332
R6470 VSS.n1776 VSS.n250 0.00133332
R6471 VSS.n246 VSS.n1766 0.00133332
R6472 VSS.n1767 VSS.n254 0.00133332
R6473 VSS.n2097 VSS.n2096 0.00133332
R6474 VSS.n2068 VSS.n2057 0.00133332
R6475 VSS.n2106 VSS.n1877 0.00133332
R6476 VSS.n1977 VSS.n1973 0.00133332
R6477 VSS.n1989 VSS.n1954 0.00133332
R6478 VSS.n2006 VSS.n1935 0.00133332
R6479 VSS.n2036 VSS.n1932 0.00133332
R6480 VSS.n2033 VSS.n2026 0.00133332
R6481 VSS.n2032 VSS.n2024 0.00133332
R6482 VSS.n2002 VSS.n1934 0.00133332
R6483 VSS.n2349 VSS.n2348 0.00133332
R6484 VSS.n197 VSS.n199 0.00149995
R6485 VSS.n979 VSS.n184 0.00133332
R6486 VSS.n178 VSS.n177 0.00149995
R6487 VSS.n852 VSS.n848 0.00133332
R6488 VSS.n849 VSS.n679 0.00133332
R6489 VSS.n821 VSS.n75 0.00133332
R6490 VSS.n805 VSS.n793 0.00133332
R6491 VSS.n802 VSS.n792 0.00133332
R6492 VSS.n15 VSS.n788 0.00133332
R6493 VSS.n787 VSS.n776 0.00133332
R6494 VSS.n784 VSS.n783 0.00133332
R6495 VSS.n746 VSS.n152 0.00133332
R6496 VSS.n728 VSS.n717 0.00133332
R6497 VSS.n726 VSS.n716 0.00133332
R6498 VSS.n146 VSS.n145 0.00149995
R6499 VSS.n804 VSS.n159 0.00133332
R6500 VSS.n1914 VSS.n221 0.00133332
R6501 VSS.n1916 VSS.n1895 0.00133332
R6502 VSS.n1894 VSS.n228 0.00133332
R6503 VSS.n2102 VSS.n2101 0.00133332
R6504 VSS.n1795 VSS.n1781 0.00133332
R6505 VSS.n2124 VSS.n283 0.00133332
R6506 VSS.n398 VSS.n397 0.00149995
R6507 VSS.n1121 VSS.n1112 0.00133332
R6508 VSS.n1739 VSS.n1113 0.00133332
R6509 VSS.n1740 VSS.n1114 0.00133332
R6510 VSS.n1120 VSS.n1115 0.00133332
R6511 VSS.n1741 VSS.n1116 0.00133332
R6512 VSS.t279 VSS.n413 0.00133332
R6513 VSS.n1714 VSS.n1713 0.00133332
R6514 VSS.n1340 VSS.t322 0.00133332
R6515 VSS.n451 VSS.n450 0.00149995
R6516 VSS.n2259 VSS.n2258 0.00133332
R6517 VSS.n2305 VSS.n2304 0.00133332
R6518 VSS.n466 VSS.n465 0.00149876
R6519 VSS.n1743 VSS.n1742 0.00124999
R6520 VSS.n2537 VSS.n617 0.00124998
R6521 VSS.n1504 VSS.n1491 0.00124998
R6522 VSS.n1524 VSS.n1487 0.00124998
R6523 VSS.n2282 VSS.n574 0.00124998
R6524 VSS.n2290 VSS.n561 0.00237488
R6525 VSS.n309 VSS.n308 0.00278546
R6526 VSS.n306 VSS.n305 0.00249999
R6527 VSS.n340 VSS.n339 0.00224999
R6528 VSS.n316 VSS.n315 0.00224999
R6529 VSS.n300 VSS.n1847 0.00266647
R6530 VSS.n291 VSS.n290 0.00249999
R6531 VSS.n286 VSS.n285 0.00277715
R6532 VSS.n276 VSS.n2154 0.00278546
R6533 VSS.n262 VSS.n261 0.00274942
R6534 VSS.n194 VSS.n2425 0.00299966
R6535 VSS.n35 VSS.n34 0.00283329
R6536 VSS.n821 VSS.n161 0.00299966
R6537 VSS.n746 VSS.n151 0.00299966
R6538 VSS.n159 VSS.n80 0.00249999
R6539 VSS.n153 VSS.n90 0.00249999
R6540 VSS.n268 VSS.n267 0.00224999
R6541 VSS.n1879 VSS.n230 0.00224999
R6542 VSS.n210 VSS.n209 0.00224999
R6543 VSS.n260 VSS.n259 0.0022
R6544 VSS.n2096 VSS.n241 0.0022
R6545 VSS.n2101 VSS.n232 0.0022
R6546 VSS.n2106 VSS.n226 0.0022
R6547 VSS.n1916 VSS.n218 0.0022
R6548 VSS.n473 VSS.n472 0.00216667
R6549 VSS.n519 VSS.n518 0.002
R6550 VSS.n492 VSS.n491 0.002
R6551 VSS.n488 VSS.t672 0.002
R6552 VSS.n1681 VSS.n453 0.002
R6553 VSS.n446 VSS.n445 0.002
R6554 VSS.n1686 VSS.n424 0.002
R6555 VSS.n420 VSS.n419 0.002
R6556 VSS.n412 VSS.n408 0.002
R6557 VSS.n402 VSS.n400 0.002
R6558 VSS.n361 VSS.n356 0.002
R6559 VSS.n356 VSS.n355 0.002
R6560 VSS.n386 VSS.n343 0.002
R6561 VSS.n321 VSS.n1807 0.00124998
R6562 VSS.n2160 VSS.n2159 0.00124998
R6563 VSS.n2168 VSS.n272 0.00124998
R6564 VSS.n1976 VSS.n1971 0.00124998
R6565 VSS.n1995 VSS.n1949 0.00124998
R6566 VSS.n8 VSS.n829 0.00124998
R6567 VSS.n764 VSS.n752 0.00124998
R6568 VSS.t82 VSS.n2239 0.00124911
R6569 VSS.n1411 VSS.n1403 0.00105539
R6570 VSS.n634 VSS.n633 0.001
R6571 VSS.n2519 VSS.n2518 0.001
R6572 VSS.n2522 VSS.n631 0.001
R6573 VSS.n2540 VSS.n609 0.001
R6574 VSS.n1511 VSS.n607 0.001
R6575 VSS.n1512 VSS.n1508 0.001
R6576 VSS.n1514 VSS.n1513 0.001
R6577 VSS.n1527 VSS.n1468 0.001
R6578 VSS.n1529 VSS.n1528 0.001
R6579 VSS.n1530 VSS.n1453 0.001
R6580 VSS.n1532 VSS.n1531 0.001
R6581 VSS.n1535 VSS.n1451 0.001
R6582 VSS.n1537 VSS.n1536 0.001
R6583 VSS.n1538 VSS.n1447 0.001
R6584 VSS.n1539 VSS.n1447 0.001
R6585 VSS.n1538 VSS.n1537 0.001
R6586 VSS.n1536 VSS.n1535 0.001
R6587 VSS.n1532 VSS.n1451 0.001
R6588 VSS.n1531 VSS.n1453 0.001
R6589 VSS.n1530 VSS.n1529 0.001
R6590 VSS.n1528 VSS.n1527 0.001
R6591 VSS.n1514 VSS.n1468 0.001
R6592 VSS.n1513 VSS.n1508 0.001
R6593 VSS.n1512 VSS.n1511 0.001
R6594 VSS.n2540 VSS.n607 0.001
R6595 VSS.n2522 VSS.n609 0.001
R6596 VSS.n2519 VSS.n631 0.001
R6597 VSS.n2518 VSS.n633 0.001
R6598 VSS.n2517 VSS.n634 0.001
R6599 VSS.n1023 VSS.n1022 0.001
R6600 VSS.n2242 VSS.n2241 0.001
R6601 VSS.n2245 VSS.n1020 0.001
R6602 VSS.n2517 VSS.n636 0.001
R6603 VSS.n2245 VSS.n636 0.001
R6604 VSS.n2242 VSS.n1020 0.001
R6605 VSS.n2241 VSS.n1022 0.001
R6606 VSS.t290 VSS.n1023 0.001
R6607 VSS.t532 VSS.n1058 0.001
R6608 VSS.n1570 VSS.n1541 0.001
R6609 VSS.n1560 VSS.n1542 0.001
R6610 VSS.n1571 VSS.n1541 0.001
R6611 VSS.n1570 VSS.t532 0.001
R6612 VSS.t82 VSS.n1058 0.001
R6613 VSS.n1560 VSS.n1543 0.001
R6614 VSS.n1572 VSS.n1543 0.001
R6615 VSS.n1572 VSS.n1544 0.001
R6616 VSS.n1574 VSS.n1547 0.001
R6617 VSS.n1555 VSS.n1553 0.001
R6618 VSS.n1577 VSS.n1553 0.001
R6619 VSS.n1558 VSS.n1547 0.001
R6620 VSS.n1573 VSS.n1544 0.001
R6621 VSS.n2524 VSS.n601 0.001
R6622 VSS.n2537 VSS.n604 0.001
R6623 VSS.n1493 VSS.n599 0.001
R6624 VSS.n2505 VSS.n593 0.001
R6625 VSS.n948 VSS.n576 0.00179999
R6626 VSS.n581 VSS.n580 0.001
R6627 VSS.n572 VSS.n570 0.00174999
R6628 VSS.n575 VSS.n573 0.00179999
R6629 VSS.n2319 VSS.n569 0.00179999
R6630 VSS.n2276 VSS.n568 0.0015
R6631 VSS.n2270 VSS.n566 0.0015
R6632 VSS.n562 VSS.n565 0.0015
R6633 VSS.n554 VSS.n553 0.0015
R6634 VSS.n2329 VSS.n551 0.0015
R6635 VSS.n2261 VSS.n545 0.0015
R6636 VSS.n538 VSS.t175 0.0015
R6637 VSS.n535 VSS.n538 0.0015
R6638 VSS.n534 VSS.n535 0.0015
R6639 VSS.n531 VSS.n534 0.0015
R6640 VSS.n530 VSS.n531 0.0015
R6641 VSS.n527 VSS.n530 0.0015
R6642 VSS.n526 VSS.n527 0.0015
R6643 VSS.n523 VSS.n526 0.0015
R6644 VSS.n522 VSS.n523 0.0015
R6645 VSS.n518 VSS.n522 0.0015
R6646 VSS.t206 VSS.t20 0.0015
R6647 VSS.t672 VSS.n483 0.0015
R6648 VSS.n504 VSS.n488 0.0015
R6649 VSS.n503 VSS.n504 0.0015
R6650 VSS.n500 VSS.n503 0.0015
R6651 VSS.n499 VSS.n500 0.0015
R6652 VSS.n496 VSS.n499 0.0015
R6653 VSS.n495 VSS.n496 0.0015
R6654 VSS.n491 VSS.n495 0.0015
R6655 VSS.n487 VSS.n480 0.0015
R6656 VSS.n486 VSS.n1660 0.00199997
R6657 VSS.n486 VSS.n480 0.00199997
R6658 VSS.t587 VSS.t293 0.00199997
R6659 VSS.n469 VSS.n461 0.00199997
R6660 VSS.n485 VSS.n484 0.00183332
R6661 VSS.n1411 VSS.t448 0.0015
R6662 VSS.n468 VSS.n467 0.00199984
R6663 VSS.n1335 VSS.n467 0.0015
R6664 VSS.n1335 VSS.n465 0.0015
R6665 VSS.n1680 VSS.n459 0.0015
R6666 VSS.t519 VSS.n451 0.0015
R6667 VSS.t322 VSS.t519 0.0015
R6668 VSS.n1382 VSS.n448 0.00199997
R6669 VSS.n412 VSS.n411 0.00187498
R6670 VSS.n432 VSS.n431 0.00183332
R6671 VSS.n436 VSS.t10 0.0015
R6672 VSS.n436 VSS.n435 0.0015
R6673 VSS.n422 VSS.n420 0.0015
R6674 VSS.n424 VSS.n422 0.0015
R6675 VSS.n419 VSS.n417 0.0015
R6676 VSS.t287 VSS.n417 0.0015
R6677 VSS.n1713 VSS.t279 0.0015
R6678 VSS.n409 VSS.t287 0.0015
R6679 VSS.t443 VSS.t26 0.0015
R6680 VSS.n402 VSS.t443 0.0015
R6681 VSS.n1738 VSS.n398 0.0015
R6682 VSS.n1119 VSS.n396 0.0015
R6683 VSS.n1118 VSS.n394 0.0015
R6684 VSS.n1118 VSS.n393 0.0015
R6685 VSS.n391 VSS.n390 0.0015
R6686 VSS.n1742 VSS.n391 0.0015
R6687 VSS.n382 VSS.n386 0.0015
R6688 VSS.n378 VSS.n382 0.0015
R6689 VSS.n374 VSS.n378 0.0015
R6690 VSS.n370 VSS.n374 0.0015
R6691 VSS.n366 VSS.n370 0.0015
R6692 VSS.n355 VSS.n366 0.0015
R6693 VSS.t283 VSS.n343 0.0015
R6694 VSS.n342 VSS.n339 0.00209995
R6695 VSS.n442 VSS.n441 0.00149997
R6696 VSS.n544 VSS.t54 0.00140607
R6697 VSS.n556 VSS.n559 0.001
R6698 VSS.n2264 VSS.n548 0.001
R6699 VSS.n337 VSS.n340 0.00174999
R6700 VSS.n338 VSS.n337 0.0015
R6701 VSS.n333 VSS.n328 0.00199997
R6702 VSS.n331 VSS.n330 0.0015
R6703 VSS.n328 VSS.n327 0.0015
R6704 VSS.n2326 VSS.n341 0.001
R6705 VSS.n2219 VSS.n332 0.001
R6706 VSS.n330 VSS.n336 0.001
R6707 VSS.n1818 VSS.n326 0.001
R6708 VSS.n322 VSS.n321 0.001
R6709 VSS.n311 VSS.n310 0.0012
R6710 VSS.n314 VSS.n313 0.00183322
R6711 VSS.n314 VSS.n306 0.0015
R6712 VSS.n310 VSS.n312 0.0015
R6713 VSS.n305 VSS.n309 0.0015
R6714 VSS.n303 VSS.n1851 0.00199997
R6715 VSS.n1851 VSS.n302 0.0015
R6716 VSS.n296 VSS.n295 0.00159995
R6717 VSS.n1849 VSS.n295 0.0015
R6718 VSS.n294 VSS.n1847 0.00199997
R6719 VSS.n290 VSS.n289 0.0015
R6720 VSS.n287 VSS.n289 0.0015
R6721 VSS.n286 VSS.n282 0.0015
R6722 VSS.n283 VSS.n282 0.0015
R6723 VSS.n2159 VSS.n274 0.0015
R6724 VSS.n273 VSS.n272 0.0015
R6725 VSS.n2179 VSS.n270 0.0015
R6726 VSS.n2179 VSS.n266 0.0015
R6727 VSS.n1849 VSS.n293 0.001
R6728 VSS.n302 VSS.n299 0.00124999
R6729 VSS.n298 VSS.n297 0.001
R6730 VSS.n288 VSS.n287 0.0012
R6731 VSS.n275 VSS.n274 0.0012
R6732 VSS.n2144 VSS.n280 0.001
R6733 VSS.n268 VSS.n266 0.00174999
R6734 VSS.n259 VSS.n265 0.0015
R6735 VSS.n1795 VSS.n261 0.0015
R6736 VSS.n258 VSS.n256 0.00192843
R6737 VSS.n258 VSS.n257 0.0015
R6738 VSS.n248 VSS.n246 0.0015
R6739 VSS.n252 VSS.n251 0.00159995
R6740 VSS.n251 VSS.n250 0.0015
R6741 VSS.n248 VSS.n247 0.0015
R6742 VSS.n244 VSS.n243 0.00199984
R6743 VSS.n238 VSS.n243 0.0015
R6744 VSS.n265 VSS.n264 0.001
R6745 VSS.n2093 VSS.n241 0.00179999
R6746 VSS.n239 VSS.n238 0.0015
R6747 VSS.n236 VSS.n2063 0.00199997
R6748 VSS.n2073 VSS.n234 0.0015
R6749 VSS.n2076 VSS.n245 0.001
R6750 VSS.n2068 VSS.n232 0.00179999
R6751 VSS.n2073 VSS.n2072 0.001
R6752 VSS.n2063 VSS.n234 0.001
R6753 VSS.n2052 VSS.n235 0.001
R6754 VSS.n225 VSS.n224 0.00192843
R6755 VSS.n229 VSS.n227 0.00183322
R6756 VSS.n229 VSS.n228 0.0015
R6757 VSS.n1893 VSS.n225 0.0015
R6758 VSS.n223 VSS.n1910 0.00199997
R6759 VSS.n1910 VSS.n221 0.0015
R6760 VSS.n217 VSS.n216 0.00192843
R6761 VSS.n1900 VSS.n217 0.0015
R6762 VSS.n1907 VSS.n222 0.001
R6763 VSS.n1983 VSS.n210 0.00174999
R6764 VSS.n1995 VSS.n208 0.0015
R6765 VSS.n1957 VSS.n206 0.0015
R6766 VSS.n203 VSS.n201 0.00224999
R6767 VSS.n203 VSS.n202 0.00224999
R6768 VSS.n176 VSS.n175 0.00224999
R6769 VSS.n170 VSS.n169 0.00224999
R6770 VSS.n196 VSS.n195 0.0015
R6771 VSS.n189 VSS.n197 0.0015
R6772 VSS.n191 VSS.n189 0.0015
R6773 VSS.n182 VSS.n187 0.0015
R6774 VSS.n185 VSS.n184 0.0015
R6775 VSS.n183 VSS.n182 0.0015
R6776 VSS.n175 VSS.n178 0.0015
R6777 VSS.n1971 VSS.n215 0.001
R6778 VSS.n1957 VSS.n201 0.001
R6779 VSS.n2009 VSS.n1946 0.001
R6780 VSS.n2013 VSS.n1947 0.001
R6781 VSS.n2014 VSS.n2013 0.001
R6782 VSS.n1937 VSS.n1936 0.001
R6783 VSS.n2018 VSS.n2017 0.001
R6784 VSS.n2017 VSS.n2016 0.001
R6785 VSS.n2041 VSS.n1930 0.001
R6786 VSS.n2036 VSS.n1931 0.001
R6787 VSS.n2030 VSS.n2029 0.001
R6788 VSS.n2044 VSS.n1924 0.001
R6789 VSS.n2044 VSS.n2043 0.001
R6790 VSS.n2040 VSS.n1931 0.001
R6791 VSS.n2041 VSS.n2040 0.001
R6792 VSS.n2043 VSS.n1930 0.001
R6793 VSS.n2030 VSS.n2027 0.001
R6794 VSS.n2029 VSS.n1924 0.001
R6795 VSS.n2014 VSS.n2002 0.001
R6796 VSS.n2009 VSS.n1947 0.001
R6797 VSS.n1946 VSS.n1945 0.001
R6798 VSS.n2016 VSS.n1945 0.001
R6799 VSS.n2004 VSS.n1936 0.001
R6800 VSS.n2018 VSS.n1937 0.001
R6801 VSS.n2420 VSS.n2348 0.001
R6802 VSS.n2354 VSS.n2353 0.001
R6803 VSS.n2350 VSS.n2346 0.001
R6804 VSS.n2441 VSS.n2346 0.001
R6805 VSS.n2354 VSS.n2350 0.001
R6806 VSS.n2441 VSS.n2420 0.001
R6807 VSS.n2425 VSS.n192 0.001
R6808 VSS.n2434 VSS.n195 0.001
R6809 VSS.n183 VSS.n181 0.0012
R6810 VSS.n987 VSS.n176 0.00174999
R6811 VSS.n172 VSS.n171 0.00159995
R6812 VSS.n171 VSS.n169 0.0015
R6813 VSS.n987 VSS.n170 0.00174999
R6814 VSS.n167 VSS.n166 0.0015
R6815 VSS.n46 VSS.n39 0.00224999
R6816 VSS.n22 VSS.n18 0.00299999
R6817 VSS.n145 VSS.n96 0.00299997
R6818 VSS.n151 VSS.n83 0.0029999
R6819 VSS.n79 VSS.n80 0.00408319
R6820 VSS.n25 VSS.n16 0.00384977
R6821 VSS.n17 VSS.n149 0.00368731
R6822 VSS.n47 VSS.n46 0.00354989
R6823 VSS.n764 VSS.n13 0.00349999
R6824 VSS.n10 VSS.n9 0.00233283
R6825 VSS.n161 VSS.n11 0.0034999
R6826 VSS.n783 VSS.n25 0.00336667
R6827 VSS.n155 VSS.n23 0.00333328
R6828 VSS.n21 VSS.n28 0.00307141
R6829 VSS.n73 VSS.n11 0.00299994
R6830 VSS.n55 VSS.n56 0.00178569
R6831 VSS.n59 VSS.n61 0.00190277
R6832 VSS.n163 VSS.n70 0.00269993
R6833 VSS.n39 VSS.n38 0.00259995
R6834 VSS.n728 VSS.n93 0.0025
R6835 VSS.n90 VSS.n87 0.0025
R6836 VSS.n6 VSS.n7 4.1792
R6837 oa_sar8_acore18_opt_0.sw_bitcell_opt_term_0.gb.t2 oa_sar8_acore18_opt_0.sw_bitcell_opt_term_0.gb.t1 33.6886
R6838 oa_sar8_acore18_opt_0.sw_bitcell_opt_term_0.gb oa_sar8_acore18_opt_0.sw_bitcell_opt_term_0.gb.t4 24.2374
R6839 oa_sar8_acore18_opt_0.sw_bitcell_opt_term_0.gb oa_sar8_acore18_opt_0.sw_bitcell_opt_term_0.gb.t5 21.7943
R6840 oa_sar8_acore18_opt_0.sw_bitcell_opt_term_0.gb oa_sar8_acore18_opt_0.sw_bitcell_opt_term_0.gb.t6 21.7943
R6841 oa_sar8_acore18_opt_0.sw_bitcell_opt_term_0.gb oa_sar8_acore18_opt_0.sw_bitcell_opt_term_0.gb.t7 21.7943
R6842 oa_sar8_acore18_opt_0.sw_bitcell_opt_term_0.gb oa_sar8_acore18_opt_0.sw_bitcell_opt_term_0.gb.t8 21.7943
R6843 oa_sar8_acore18_opt_0.sw_bitcell_opt_term_0.gb oa_sar8_acore18_opt_0.sw_bitcell_opt_term_0.gb.t9 21.7943
R6844 oa_sar8_acore18_opt_0.sw_bitcell_opt_term_0.gb oa_sar8_acore18_opt_0.sw_bitcell_opt_term_0.gb.t10 21.7943
R6845 oa_sar8_acore18_opt_0.sw_bitcell_opt_term_0.gb oa_sar8_acore18_opt_0.sw_bitcell_opt_term_0.gb.t11 21.7943
R6846 oa_sar8_acore18_opt_0.sw_bitcell_opt_term_0.gb oa_sar8_acore18_opt_0.sw_bitcell_opt_term_0.gb.t12 21.794
R6847 oa_sar8_acore18_opt_0.sw_bitcell_opt_term_0.gb oa_sar8_acore18_opt_0.sw_bitcell_opt_term_0.gb.t0 2.7263
R6848 oa_sar8_acore18_opt_0.sw_bitcell_opt_term_0.gb.t0 oa_sar8_acore18_opt_0.sw_bitcell_opt_term_0.gb.t3 1.8771
R6849 oa_sar8_acore18_opt_0.sw_bitcell_opt_term_0.gb.t3 oa_sar8_acore18_opt_0.sw_bitcell_opt_term_0.gb.t2 1.6637
R6850 oa_sar8_acore18_opt_0.sw_bitcell_opt_term_0.bot oa_sar8_acore18_opt_0.sw_bitcell_opt_term_0.bot.n0 91.1413
R6851 oa_sar8_acore18_opt_0.sw_bitcell_opt_term_0.bot.n0 oa_sar8_acore18_opt_0.sw_bitcell_opt_term_0.bot.t1 30.2721
R6852 oa_sar8_acore18_opt_0.sw_bitcell_opt_term_0.bot.t0 oa_sar8_acore18_opt_0.sw_bitcell_opt_term_0.bot.t3 32.1925
R6853 oa_sar8_acore18_opt_0.sw_bitcell_opt_term_0.bot.n0 oa_sar8_acore18_opt_0.sw_bitcell_opt_term_0.bot 3.46183
R6854 oa_sar8_acore18_opt_0.sw_bitcell_opt_term_0.bot oa_sar8_acore18_opt_0.sw_bitcell_opt_term_0.bot.t0 1.2105
R6855 oa_sar8_acore18_opt_0.sw_bitcell_opt_b0_0.bot oa_sar8_acore18_opt_0.sw_bitcell_opt_b0_0.bot.n0 88.6259
R6856 oa_sar8_acore18_opt_0.sw_bitcell_opt_b0_0.bot.n0 oa_sar8_acore18_opt_0.sw_bitcell_opt_b0_0.bot.t0 42.7308
R6857 oa_sar8_acore18_opt_0.sw_bitcell_opt_b0_0.bot.t2 oa_sar8_acore18_opt_0.sw_bitcell_opt_b0_0.bot.t3 32.1925
R6858 oa_sar8_acore18_opt_0.sw_bitcell_opt_b0_0.bot.n0 oa_sar8_acore18_opt_0.sw_bitcell_opt_b0_0.bot 3.57917
R6859 oa_sar8_acore18_opt_0.sw_bitcell_opt_b0_0.bot oa_sar8_acore18_opt_0.sw_bitcell_opt_b0_0.bot.t2 1.2105
R6860 oa_sar8_acore18_opt_0.sw_bitcell_opt_b1_0.bot oa_sar8_acore18_opt_0.sw_bitcell_opt_b1_0.bot.n1 86.0182
R6861 oa_sar8_acore18_opt_0.sw_bitcell_opt_b1_0.bot.n0 oa_sar8_acore18_opt_0.sw_bitcell_opt_b1_0.bot.t2 37.6963
R6862 oa_sar8_acore18_opt_0.sw_bitcell_opt_b1_0.bot.n0 oa_sar8_acore18_opt_0.sw_bitcell_opt_b1_0.bot.t0 27.8699
R6863 oa_sar8_acore18_opt_0.sw_bitcell_opt_b1_0.bot.t5 oa_sar8_acore18_opt_0.sw_bitcell_opt_b1_0.bot.t4 31.7993
R6864 oa_sar8_acore18_opt_0.sw_bitcell_opt_b1_0.bot.n1 oa_sar8_acore18_opt_0.sw_bitcell_opt_b1_0.bot.n0 4.27324
R6865 oa_sar8_acore18_opt_0.sw_bitcell_opt_b1_0.bot.n1 oa_sar8_acore18_opt_0.sw_bitcell_opt_b1_0.bot 3.6965
R6866 oa_sar8_acore18_opt_0.sw_bitcell_opt_b1_0.bot oa_sar8_acore18_opt_0.sw_bitcell_opt_b1_0.bot.t4 1.2985
R6867 oa_sar8_acore18_opt_0.sw_bitcell_opt_b2_0.bot oa_sar8_acore18_opt_0.sw_bitcell_opt_b2_0.bot.n2 83.3269
R6868 oa_sar8_acore18_opt_0.sw_bitcell_opt_b2_0.bot.t1 oa_sar8_acore18_opt_0.sw_bitcell_opt_b2_0.bot.t0 31.3455
R6869 oa_sar8_acore18_opt_0.sw_bitcell_opt_b2_0.bot.n1 oa_sar8_acore18_opt_0.sw_bitcell_opt_b2_0.bot.t8 28.5267
R6870 oa_sar8_acore18_opt_0.sw_bitcell_opt_b2_0.bot.n0 oa_sar8_acore18_opt_0.sw_bitcell_opt_b2_0.bot.t4 28.1515
R6871 oa_sar8_acore18_opt_0.sw_bitcell_opt_b2_0.bot.n0 oa_sar8_acore18_opt_0.sw_bitcell_opt_b2_0.bot.t2 28.1515
R6872 oa_sar8_acore18_opt_0.sw_bitcell_opt_b2_0.bot.n1 oa_sar8_acore18_opt_0.sw_bitcell_opt_b2_0.bot.t6 27.7749
R6873 oa_sar8_acore18_opt_0.sw_bitcell_opt_b2_0.bot.n0 oa_sar8_acore18_opt_0.sw_bitcell_opt_b2_0.bot.n1 6.62313
R6874 oa_sar8_acore18_opt_0.sw_bitcell_opt_b2_0.bot.n2 oa_sar8_acore18_opt_0.sw_bitcell_opt_b2_0.bot.n0 6.05587
R6875 oa_sar8_acore18_opt_0.sw_bitcell_opt_b2_0.bot.n2 oa_sar8_acore18_opt_0.sw_bitcell_opt_b2_0.bot 3.81383
R6876 oa_sar8_acore18_opt_0.sw_bitcell_opt_b2_0.bot oa_sar8_acore18_opt_0.sw_bitcell_opt_b2_0.bot.t1 1.3865
R6877 oa_sar8_acore18_opt_0.sw_bitcell_opt_b3_0.bot oa_sar8_acore18_opt_0.sw_bitcell_opt_b3_0.bot.n4 80.5475
R6878 oa_sar8_acore18_opt_0.sw_bitcell_opt_b3_0.bot.n0 oa_sar8_acore18_opt_0.sw_bitcell_opt_b3_0.bot.t8 28.4331
R6879 oa_sar8_acore18_opt_0.sw_bitcell_opt_b3_0.bot.n1 oa_sar8_acore18_opt_0.sw_bitcell_opt_b3_0.bot.t6 28.4331
R6880 oa_sar8_acore18_opt_0.sw_bitcell_opt_b3_0.bot.n1 oa_sar8_acore18_opt_0.sw_bitcell_opt_b3_0.bot.t4 28.4331
R6881 oa_sar8_acore18_opt_0.sw_bitcell_opt_b3_0.bot.n3 oa_sar8_acore18_opt_0.sw_bitcell_opt_b3_0.bot.t2 28.4331
R6882 oa_sar8_acore18_opt_0.sw_bitcell_opt_b3_0.bot.n2 oa_sar8_acore18_opt_0.sw_bitcell_opt_b3_0.bot.t16 28.2451
R6883 oa_sar8_acore18_opt_0.sw_bitcell_opt_b3_0.bot.n2 oa_sar8_acore18_opt_0.sw_bitcell_opt_b3_0.bot.t14 27.4933
R6884 oa_sar8_acore18_opt_0.sw_bitcell_opt_b3_0.bot.n2 oa_sar8_acore18_opt_0.sw_bitcell_opt_b3_0.bot.t12 27.4933
R6885 oa_sar8_acore18_opt_0.sw_bitcell_opt_b3_0.bot.n0 oa_sar8_acore18_opt_0.sw_bitcell_opt_b3_0.bot.t10 27.4933
R6886 oa_sar8_acore18_opt_0.sw_bitcell_opt_b3_0.bot.t0 oa_sar8_acore18_opt_0.sw_bitcell_opt_b3_0.bot.t1 31.2836
R6887 oa_sar8_acore18_opt_0.sw_bitcell_opt_b3_0.bot.n4 oa_sar8_acore18_opt_0.sw_bitcell_opt_b3_0.bot.n3 7.08924
R6888 oa_sar8_acore18_opt_0.sw_bitcell_opt_b3_0.bot.n4 oa_sar8_acore18_opt_0.sw_bitcell_opt_b3_0.bot 3.93117
R6889 oa_sar8_acore18_opt_0.sw_bitcell_opt_b3_0.bot.n0 oa_sar8_acore18_opt_0.sw_bitcell_opt_b3_0.bot.n2 1.50404
R6890 oa_sar8_acore18_opt_0.sw_bitcell_opt_b3_0.bot.n3 oa_sar8_acore18_opt_0.sw_bitcell_opt_b3_0.bot.n1 1.50404
R6891 oa_sar8_acore18_opt_0.sw_bitcell_opt_b3_0.bot oa_sar8_acore18_opt_0.sw_bitcell_opt_b3_0.bot.t1 1.4767
R6892 oa_sar8_acore18_opt_0.sw_bitcell_opt_b3_0.bot.n1 oa_sar8_acore18_opt_0.sw_bitcell_opt_b3_0.bot.n0 1.34061
R6893 oa_sar8_acore18_opt_0.sw_bitcell_opt_b4_0.bot oa_sar8_acore18_opt_0.sw_bitcell_opt_b4_0.bot.n7 77.6362
R6894 oa_sar8_acore18_opt_0.sw_bitcell_opt_b4_0.bot.n6 oa_sar8_acore18_opt_0.sw_bitcell_opt_b4_0.bot.t16 29.4665
R6895 oa_sar8_acore18_opt_0.sw_bitcell_opt_b4_0.bot.n6 oa_sar8_acore18_opt_0.sw_bitcell_opt_b4_0.bot.t14 28.7147
R6896 oa_sar8_acore18_opt_0.sw_bitcell_opt_b4_0.bot.n6 oa_sar8_acore18_opt_0.sw_bitcell_opt_b4_0.bot.t12 28.7147
R6897 oa_sar8_acore18_opt_0.sw_bitcell_opt_b4_0.bot.n5 oa_sar8_acore18_opt_0.sw_bitcell_opt_b4_0.bot.t10 28.7147
R6898 oa_sar8_acore18_opt_0.sw_bitcell_opt_b4_0.bot.n5 oa_sar8_acore18_opt_0.sw_bitcell_opt_b4_0.bot.t8 28.7147
R6899 oa_sar8_acore18_opt_0.sw_bitcell_opt_b4_0.bot.n0 oa_sar8_acore18_opt_0.sw_bitcell_opt_b4_0.bot.t6 28.7147
R6900 oa_sar8_acore18_opt_0.sw_bitcell_opt_b4_0.bot.n0 oa_sar8_acore18_opt_0.sw_bitcell_opt_b4_0.bot.t4 28.7147
R6901 oa_sar8_acore18_opt_0.sw_bitcell_opt_b4_0.bot.n1 oa_sar8_acore18_opt_0.sw_bitcell_opt_b4_0.bot.t2 28.7147
R6902 oa_sar8_acore18_opt_0.sw_bitcell_opt_b4_0.bot.n1 oa_sar8_acore18_opt_0.sw_bitcell_opt_b4_0.bot.t32 27.2117
R6903 oa_sar8_acore18_opt_0.sw_bitcell_opt_b4_0.bot.n1 oa_sar8_acore18_opt_0.sw_bitcell_opt_b4_0.bot.t30 27.2117
R6904 oa_sar8_acore18_opt_0.sw_bitcell_opt_b4_0.bot.n4 oa_sar8_acore18_opt_0.sw_bitcell_opt_b4_0.bot.t28 27.2117
R6905 oa_sar8_acore18_opt_0.sw_bitcell_opt_b4_0.bot.n4 oa_sar8_acore18_opt_0.sw_bitcell_opt_b4_0.bot.t26 27.2117
R6906 oa_sar8_acore18_opt_0.sw_bitcell_opt_b4_0.bot.n2 oa_sar8_acore18_opt_0.sw_bitcell_opt_b4_0.bot.t24 27.2117
R6907 oa_sar8_acore18_opt_0.sw_bitcell_opt_b4_0.bot.n2 oa_sar8_acore18_opt_0.sw_bitcell_opt_b4_0.bot.t22 27.2117
R6908 oa_sar8_acore18_opt_0.sw_bitcell_opt_b4_0.bot.n3 oa_sar8_acore18_opt_0.sw_bitcell_opt_b4_0.bot.t20 27.2117
R6909 oa_sar8_acore18_opt_0.sw_bitcell_opt_b4_0.bot.n3 oa_sar8_acore18_opt_0.sw_bitcell_opt_b4_0.bot.t18 27.2117
R6910 oa_sar8_acore18_opt_0.sw_bitcell_opt_b4_0.bot.n7 oa_sar8_acore18_opt_0.sw_bitcell_opt_b4_0.bot.n3 4.18524
R6911 oa_sar8_acore18_opt_0.sw_bitcell_opt_b4_0.bot.n7 oa_sar8_acore18_opt_0.sw_bitcell_opt_b4_0.bot 4.0485
R6912 oa_sar8_acore18_opt_0.sw_bitcell_opt_b4_0.bot.t0 oa_sar8_acore18_opt_0.sw_bitcell_opt_b4_0.bot.t1 30.9415
R6913 oa_sar8_acore18_opt_0.sw_bitcell_opt_b4_0.bot.n4 oa_sar8_acore18_opt_0.sw_bitcell_opt_b4_0.bot.n1 2.41924
R6914 oa_sar8_acore18_opt_0.sw_bitcell_opt_b4_0.bot.n3 oa_sar8_acore18_opt_0.sw_bitcell_opt_b4_0.bot.n2 2.25581
R6915 oa_sar8_acore18_opt_0.sw_bitcell_opt_b4_0.bot oa_sar8_acore18_opt_0.sw_bitcell_opt_b4_0.bot.t1 1.6065
R6916 oa_sar8_acore18_opt_0.sw_bitcell_opt_b4_0.bot.n5 oa_sar8_acore18_opt_0.sw_bitcell_opt_b4_0.bot.n6 1.50404
R6917 oa_sar8_acore18_opt_0.sw_bitcell_opt_b4_0.bot.n0 oa_sar8_acore18_opt_0.sw_bitcell_opt_b4_0.bot.n5 1.50404
R6918 oa_sar8_acore18_opt_0.sw_bitcell_opt_b4_0.bot.n1 oa_sar8_acore18_opt_0.sw_bitcell_opt_b4_0.bot.n0 1.50404
R6919 oa_sar8_acore18_opt_0.sw_bitcell_opt_b4_0.bot.n2 oa_sar8_acore18_opt_0.sw_bitcell_opt_b4_0.bot.n4 1.50404
R6920 oa_sar8_acore18_opt_0.sw_bitcell_opt_b5_0.bot oa_sar8_acore18_opt_0.sw_bitcell_opt_b5_0.bot.n1 78.2287
R6921 oa_sar8_acore18_opt_0.sw_bitcell_opt_b5_0.bot.t0 oa_sar8_acore18_opt_0.sw_bitcell_opt_b5_0.bot.t1 30.8707
R6922 oa_sar8_acore18_opt_0.sw_bitcell_opt_b5_0.bot.n0 oa_sar8_acore18_opt_0.sw_bitcell_opt_b5_0.bot.t2 5.76183
R6923 oa_sar8_acore18_opt_0.sw_bitcell_opt_b5_0.bot.n1 oa_sar8_acore18_opt_0.sw_bitcell_opt_b5_0.bot.t22 5.76183
R6924 oa_sar8_acore18_opt_0.sw_bitcell_opt_b5_0.bot.n0 oa_sar8_acore18_opt_0.sw_bitcell_opt_b5_0.bot 2.76517
R6925 oa_sar8_acore18_opt_0.sw_bitcell_opt_b5_0.bot.n1 oa_sar8_acore18_opt_0.sw_bitcell_opt_b5_0.bot.n0 1.8485
R6926 oa_sar8_acore18_opt_0.sw_bitcell_opt_b5_0.bot oa_sar8_acore18_opt_0.sw_bitcell_opt_b5_0.bot.t1 1.7385
R6927 oa_sar8_acore18_opt_0.sw_bitcell_opt_b5_0.bot.t22 oa_sar8_acore18_opt_0.sw_bitcell_opt_b5_0.bot.t25 1.13277
R6928 oa_sar8_acore18_opt_0.sw_bitcell_opt_b5_0.bot.t25 oa_sar8_acore18_opt_0.sw_bitcell_opt_b5_0.bot.t30 1.13277
R6929 oa_sar8_acore18_opt_0.sw_bitcell_opt_b5_0.bot.t2 oa_sar8_acore18_opt_0.sw_bitcell_opt_b5_0.bot.t5 1.13277
R6930 oa_sar8_acore18_opt_0.sw_bitcell_opt_b5_0.bot.t5 oa_sar8_acore18_opt_0.sw_bitcell_opt_b5_0.bot.t10 1.13277
R6931 oa_sar8_acore18_opt_0.sw_bitcell_opt_b5_0.bot.t10 oa_sar8_acore18_opt_0.sw_bitcell_opt_b5_0.bot.t15 1.13277
R6932 oa_sar8_acore18_opt_0.sw_bitcell_opt_b5_0.bot.t30 oa_sar8_acore18_opt_0.sw_bitcell_opt_b5_0.bot.t35 1.13277
R6933 oa_sar8_acore18_opt_0.sw_bitcell_opt_b6_0.bot oa_sar8_acore18_opt_0.sw_bitcell_opt_b6_0.bot.n0 72.2029
R6934 oa_sar8_acore18_opt_0.sw_bitcell_opt_b6_0.bot.t0 oa_sar8_acore18_opt_0.sw_bitcell_opt_b6_0.bot.t81 30.7555
R6935 oa_sar8_acore18_opt_0.sw_bitcell_opt_b6_0.bot.n1 oa_sar8_acore18_opt_0.sw_bitcell_opt_b6_0.bot.t1 5.92317
R6936 oa_sar8_acore18_opt_0.sw_bitcell_opt_b6_0.bot.n1 oa_sar8_acore18_opt_0.sw_bitcell_opt_b6_0.bot.t21 5.92317
R6937 oa_sar8_acore18_opt_0.sw_bitcell_opt_b6_0.bot.n0 oa_sar8_acore18_opt_0.sw_bitcell_opt_b6_0.bot.t41 5.92317
R6938 oa_sar8_acore18_opt_0.sw_bitcell_opt_b6_0.bot.n0 oa_sar8_acore18_opt_0.sw_bitcell_opt_b6_0.bot.t61 5.92317
R6939 oa_sar8_acore18_opt_0.sw_bitcell_opt_b6_0.bot.n0 oa_sar8_acore18_opt_0.sw_bitcell_opt_b6_0.bot.n1 3.10983
R6940 oa_sar8_acore18_opt_0.sw_bitcell_opt_b6_0.bot.n1 oa_sar8_acore18_opt_0.sw_bitcell_opt_b6_0.bot 2.2665
R6941 oa_sar8_acore18_opt_0.sw_bitcell_opt_b6_0.bot oa_sar8_acore18_opt_0.sw_bitcell_opt_b6_0.bot.t0 1.8705
R6942 oa_sar8_acore18_opt_0.sw_bitcell_opt_b6_0.bot.t61 oa_sar8_acore18_opt_0.sw_bitcell_opt_b6_0.bot.t64 1.13277
R6943 oa_sar8_acore18_opt_0.sw_bitcell_opt_b6_0.bot.t64 oa_sar8_acore18_opt_0.sw_bitcell_opt_b6_0.bot.t69 1.13277
R6944 oa_sar8_acore18_opt_0.sw_bitcell_opt_b6_0.bot.t41 oa_sar8_acore18_opt_0.sw_bitcell_opt_b6_0.bot.t44 1.13277
R6945 oa_sar8_acore18_opt_0.sw_bitcell_opt_b6_0.bot.t44 oa_sar8_acore18_opt_0.sw_bitcell_opt_b6_0.bot.t49 1.13277
R6946 oa_sar8_acore18_opt_0.sw_bitcell_opt_b6_0.bot.t21 oa_sar8_acore18_opt_0.sw_bitcell_opt_b6_0.bot.t24 1.13277
R6947 oa_sar8_acore18_opt_0.sw_bitcell_opt_b6_0.bot.t24 oa_sar8_acore18_opt_0.sw_bitcell_opt_b6_0.bot.t29 1.13277
R6948 oa_sar8_acore18_opt_0.sw_bitcell_opt_b6_0.bot.t1 oa_sar8_acore18_opt_0.sw_bitcell_opt_b6_0.bot.t4 1.13277
R6949 oa_sar8_acore18_opt_0.sw_bitcell_opt_b6_0.bot.t4 oa_sar8_acore18_opt_0.sw_bitcell_opt_b6_0.bot.t9 1.13277
R6950 oa_sar8_acore18_opt_0.sw_bitcell_opt_b6_0.bot.t9 oa_sar8_acore18_opt_0.sw_bitcell_opt_b6_0.bot.t14 1.13277
R6951 oa_sar8_acore18_opt_0.sw_bitcell_opt_b6_0.bot.t29 oa_sar8_acore18_opt_0.sw_bitcell_opt_b6_0.bot.t34 1.13277
R6952 oa_sar8_acore18_opt_0.sw_bitcell_opt_b6_0.bot.t49 oa_sar8_acore18_opt_0.sw_bitcell_opt_b6_0.bot.t54 1.13277
R6953 oa_sar8_acore18_opt_0.sw_bitcell_opt_b6_0.bot.t69 oa_sar8_acore18_opt_0.sw_bitcell_opt_b6_0.bot.t74 1.13277
R6954 oa_sar8_acore18_opt_0.sw_bitcell_opt_b7_0.bot.n8 oa_sar8_acore18_opt_0.sw_bitcell_opt_b7_0.bot.n7 65.072
R6955 oa_sar8_acore18_opt_0.sw_bitcell_opt_b7_0.bot.n0 oa_sar8_acore18_opt_0.sw_bitcell_opt_b7_0.bot.t22 6.0845
R6956 oa_sar8_acore18_opt_0.sw_bitcell_opt_b7_0.bot.n1 oa_sar8_acore18_opt_0.sw_bitcell_opt_b7_0.bot.t2 6.0845
R6957 oa_sar8_acore18_opt_0.sw_bitcell_opt_b7_0.bot.n2 oa_sar8_acore18_opt_0.sw_bitcell_opt_b7_0.bot.t44 6.0845
R6958 oa_sar8_acore18_opt_0.sw_bitcell_opt_b7_0.bot.n3 oa_sar8_acore18_opt_0.sw_bitcell_opt_b7_0.bot.t65 6.0845
R6959 oa_sar8_acore18_opt_0.sw_bitcell_opt_b7_0.bot.n4 oa_sar8_acore18_opt_0.sw_bitcell_opt_b7_0.bot.t86 6.0845
R6960 oa_sar8_acore18_opt_0.sw_bitcell_opt_b7_0.bot.n5 oa_sar8_acore18_opt_0.sw_bitcell_opt_b7_0.bot.t107 6.0845
R6961 oa_sar8_acore18_opt_0.sw_bitcell_opt_b7_0.bot.n6 oa_sar8_acore18_opt_0.sw_bitcell_opt_b7_0.bot.t128 6.0845
R6962 oa_sar8_acore18_opt_0.sw_bitcell_opt_b7_0.bot.n7 oa_sar8_acore18_opt_0.sw_bitcell_opt_b7_0.bot.t149 6.0845
R6963 oa_sar8_acore18_opt_0.sw_bitcell_opt_b7_0.bot.n4 oa_sar8_acore18_opt_0.sw_bitcell_opt_b7_0.bot.n3 4.4885
R6964 oa_sar8_acore18_opt_0.sw_bitcell_opt_b7_0.bot.n8 oa_sar8_acore18_opt_0.sw_bitcell_opt_b7_0.bot.t1 2.0465
R6965 oa_sar8_acore18_opt_0.sw_bitcell_opt_b7_0.bot.t149 oa_sar8_acore18_opt_0.sw_bitcell_opt_b7_0.bot.t152 1.13277
R6966 oa_sar8_acore18_opt_0.sw_bitcell_opt_b7_0.bot.t152 oa_sar8_acore18_opt_0.sw_bitcell_opt_b7_0.bot.t157 1.13277
R6967 oa_sar8_acore18_opt_0.sw_bitcell_opt_b7_0.bot.t157 oa_sar8_acore18_opt_0.sw_bitcell_opt_b7_0.bot.t162 1.13277
R6968 oa_sar8_acore18_opt_0.sw_bitcell_opt_b7_0.bot.t128 oa_sar8_acore18_opt_0.sw_bitcell_opt_b7_0.bot.t131 1.13277
R6969 oa_sar8_acore18_opt_0.sw_bitcell_opt_b7_0.bot.t131 oa_sar8_acore18_opt_0.sw_bitcell_opt_b7_0.bot.t136 1.13277
R6970 oa_sar8_acore18_opt_0.sw_bitcell_opt_b7_0.bot.t136 oa_sar8_acore18_opt_0.sw_bitcell_opt_b7_0.bot.t141 1.13277
R6971 oa_sar8_acore18_opt_0.sw_bitcell_opt_b7_0.bot.t107 oa_sar8_acore18_opt_0.sw_bitcell_opt_b7_0.bot.t110 1.13277
R6972 oa_sar8_acore18_opt_0.sw_bitcell_opt_b7_0.bot.t110 oa_sar8_acore18_opt_0.sw_bitcell_opt_b7_0.bot.t115 1.13277
R6973 oa_sar8_acore18_opt_0.sw_bitcell_opt_b7_0.bot.t115 oa_sar8_acore18_opt_0.sw_bitcell_opt_b7_0.bot.t120 1.13277
R6974 oa_sar8_acore18_opt_0.sw_bitcell_opt_b7_0.bot.t86 oa_sar8_acore18_opt_0.sw_bitcell_opt_b7_0.bot.t89 1.13277
R6975 oa_sar8_acore18_opt_0.sw_bitcell_opt_b7_0.bot.t89 oa_sar8_acore18_opt_0.sw_bitcell_opt_b7_0.bot.t94 1.13277
R6976 oa_sar8_acore18_opt_0.sw_bitcell_opt_b7_0.bot.t94 oa_sar8_acore18_opt_0.sw_bitcell_opt_b7_0.bot.t99 1.13277
R6977 oa_sar8_acore18_opt_0.sw_bitcell_opt_b7_0.bot.t65 oa_sar8_acore18_opt_0.sw_bitcell_opt_b7_0.bot.t68 1.13277
R6978 oa_sar8_acore18_opt_0.sw_bitcell_opt_b7_0.bot.t68 oa_sar8_acore18_opt_0.sw_bitcell_opt_b7_0.bot.t73 1.13277
R6979 oa_sar8_acore18_opt_0.sw_bitcell_opt_b7_0.bot.t73 oa_sar8_acore18_opt_0.sw_bitcell_opt_b7_0.bot.t78 1.13277
R6980 oa_sar8_acore18_opt_0.sw_bitcell_opt_b7_0.bot.t44 oa_sar8_acore18_opt_0.sw_bitcell_opt_b7_0.bot.t47 1.13277
R6981 oa_sar8_acore18_opt_0.sw_bitcell_opt_b7_0.bot.t47 oa_sar8_acore18_opt_0.sw_bitcell_opt_b7_0.bot.t52 1.13277
R6982 oa_sar8_acore18_opt_0.sw_bitcell_opt_b7_0.bot.t52 oa_sar8_acore18_opt_0.sw_bitcell_opt_b7_0.bot.t57 1.13277
R6983 oa_sar8_acore18_opt_0.sw_bitcell_opt_b7_0.bot.t2 oa_sar8_acore18_opt_0.sw_bitcell_opt_b7_0.bot.t5 1.13277
R6984 oa_sar8_acore18_opt_0.sw_bitcell_opt_b7_0.bot.t5 oa_sar8_acore18_opt_0.sw_bitcell_opt_b7_0.bot.t10 1.13277
R6985 oa_sar8_acore18_opt_0.sw_bitcell_opt_b7_0.bot.t10 oa_sar8_acore18_opt_0.sw_bitcell_opt_b7_0.bot.t15 1.13277
R6986 oa_sar8_acore18_opt_0.sw_bitcell_opt_b7_0.bot.t22 oa_sar8_acore18_opt_0.sw_bitcell_opt_b7_0.bot.t25 1.13277
R6987 oa_sar8_acore18_opt_0.sw_bitcell_opt_b7_0.bot.t25 oa_sar8_acore18_opt_0.sw_bitcell_opt_b7_0.bot.t30 1.13277
R6988 oa_sar8_acore18_opt_0.sw_bitcell_opt_b7_0.bot.t30 oa_sar8_acore18_opt_0.sw_bitcell_opt_b7_0.bot.t35 1.13277
R6989 oa_sar8_acore18_opt_0.sw_bitcell_opt_b7_0.bot.t162 oa_sar8_acore18_opt_0.sw_bitcell_opt_b7_0.bot.t167 0.8497
R6990 oa_sar8_acore18_opt_0.sw_bitcell_opt_b7_0.bot.t141 oa_sar8_acore18_opt_0.sw_bitcell_opt_b7_0.bot.t146 0.8497
R6991 oa_sar8_acore18_opt_0.sw_bitcell_opt_b7_0.bot.t120 oa_sar8_acore18_opt_0.sw_bitcell_opt_b7_0.bot.t125 0.8497
R6992 oa_sar8_acore18_opt_0.sw_bitcell_opt_b7_0.bot.t99 oa_sar8_acore18_opt_0.sw_bitcell_opt_b7_0.bot.t104 0.8497
R6993 oa_sar8_acore18_opt_0.sw_bitcell_opt_b7_0.bot.t78 oa_sar8_acore18_opt_0.sw_bitcell_opt_b7_0.bot.t83 0.8497
R6994 oa_sar8_acore18_opt_0.sw_bitcell_opt_b7_0.bot.t57 oa_sar8_acore18_opt_0.sw_bitcell_opt_b7_0.bot.t62 0.8497
R6995 oa_sar8_acore18_opt_0.sw_bitcell_opt_b7_0.bot.t15 oa_sar8_acore18_opt_0.sw_bitcell_opt_b7_0.bot.t20 0.8497
R6996 oa_sar8_acore18_opt_0.sw_bitcell_opt_b7_0.bot.t35 oa_sar8_acore18_opt_0.sw_bitcell_opt_b7_0.bot.t40 0.8497
R6997 oa_sar8_acore18_opt_0.sw_bitcell_opt_b7_0.bot.n7 oa_sar8_acore18_opt_0.sw_bitcell_opt_b7_0.bot.n6 0.381833
R6998 oa_sar8_acore18_opt_0.sw_bitcell_opt_b7_0.bot.n6 oa_sar8_acore18_opt_0.sw_bitcell_opt_b7_0.bot.n5 0.381833
R6999 oa_sar8_acore18_opt_0.sw_bitcell_opt_b7_0.bot.n5 oa_sar8_acore18_opt_0.sw_bitcell_opt_b7_0.bot.n4 0.381833
R7000 oa_sar8_acore18_opt_0.sw_bitcell_opt_b7_0.bot.n3 oa_sar8_acore18_opt_0.sw_bitcell_opt_b7_0.bot.n2 0.381833
R7001 oa_sar8_acore18_opt_0.sw_bitcell_opt_b7_0.bot.n2 oa_sar8_acore18_opt_0.sw_bitcell_opt_b7_0.bot.n1 0.381833
R7002 oa_sar8_acore18_opt_0.sw_bitcell_opt_b7_0.bot.n1 oa_sar8_acore18_opt_0.sw_bitcell_opt_b7_0.bot.n0 0.381833
R7003 oa_sar8_acore18_opt_0.sw_bitcell_opt_b7_0.bot oa_sar8_acore18_opt_0.sw_bitcell_opt_b7_0.bot.n8 0.2634
R7004 oa_sar8_acore18_opt_0.sw_bitcell_opt_b7_0.bot.n0 oa_sar8_acore18_opt_0.sw_bitcell_opt_b7_0.bot 0.125167
R7005 oa_sar8_acore18_opt_0.sw_bitcell_opt_b7_0.bot.t1 oa_sar8_acore18_opt_0.sw_bitcell_opt_b7_0.bot.t0 30.6574
R7006 oa_sar8_acore18_opt_0.sw_bitcell_opt_b7_1.bot.n8 oa_sar8_acore18_opt_0.sw_bitcell_opt_b7_1.bot.n7 47.5985
R7007 oa_sar8_acore18_opt_0.sw_bitcell_opt_b7_1.bot.n0 oa_sar8_acore18_opt_0.sw_bitcell_opt_b7_1.bot.t41 6.0845
R7008 oa_sar8_acore18_opt_0.sw_bitcell_opt_b7_1.bot.n1 oa_sar8_acore18_opt_0.sw_bitcell_opt_b7_1.bot.t20 6.0845
R7009 oa_sar8_acore18_opt_0.sw_bitcell_opt_b7_1.bot.n2 oa_sar8_acore18_opt_0.sw_bitcell_opt_b7_1.bot.t63 6.0845
R7010 oa_sar8_acore18_opt_0.sw_bitcell_opt_b7_1.bot.n3 oa_sar8_acore18_opt_0.sw_bitcell_opt_b7_1.bot.t84 6.0845
R7011 oa_sar8_acore18_opt_0.sw_bitcell_opt_b7_1.bot.n4 oa_sar8_acore18_opt_0.sw_bitcell_opt_b7_1.bot.t105 6.0845
R7012 oa_sar8_acore18_opt_0.sw_bitcell_opt_b7_1.bot.n5 oa_sar8_acore18_opt_0.sw_bitcell_opt_b7_1.bot.t126 6.0845
R7013 oa_sar8_acore18_opt_0.sw_bitcell_opt_b7_1.bot.n6 oa_sar8_acore18_opt_0.sw_bitcell_opt_b7_1.bot.t147 6.0845
R7014 oa_sar8_acore18_opt_0.sw_bitcell_opt_b7_1.bot.n7 oa_sar8_acore18_opt_0.sw_bitcell_opt_b7_1.bot.t168 6.0845
R7015 oa_sar8_acore18_opt_0.sw_bitcell_opt_b7_1.bot.n4 oa_sar8_acore18_opt_0.sw_bitcell_opt_b7_1.bot.n3 4.4885
R7016 oa_sar8_acore18_opt_0.sw_bitcell_opt_b7_1.bot.n8 oa_sar8_acore18_opt_0.sw_bitcell_opt_b7_1.bot.t0 2.0443
R7017 oa_sar8_acore18_opt_0.sw_bitcell_opt_b7_1.bot.t168 oa_sar8_acore18_opt_0.sw_bitcell_opt_b7_1.bot.t163 1.13277
R7018 oa_sar8_acore18_opt_0.sw_bitcell_opt_b7_1.bot.t163 oa_sar8_acore18_opt_0.sw_bitcell_opt_b7_1.bot.t158 1.13277
R7019 oa_sar8_acore18_opt_0.sw_bitcell_opt_b7_1.bot.t158 oa_sar8_acore18_opt_0.sw_bitcell_opt_b7_1.bot.t153 1.13277
R7020 oa_sar8_acore18_opt_0.sw_bitcell_opt_b7_1.bot.t147 oa_sar8_acore18_opt_0.sw_bitcell_opt_b7_1.bot.t142 1.13277
R7021 oa_sar8_acore18_opt_0.sw_bitcell_opt_b7_1.bot.t142 oa_sar8_acore18_opt_0.sw_bitcell_opt_b7_1.bot.t137 1.13277
R7022 oa_sar8_acore18_opt_0.sw_bitcell_opt_b7_1.bot.t137 oa_sar8_acore18_opt_0.sw_bitcell_opt_b7_1.bot.t132 1.13277
R7023 oa_sar8_acore18_opt_0.sw_bitcell_opt_b7_1.bot.t126 oa_sar8_acore18_opt_0.sw_bitcell_opt_b7_1.bot.t121 1.13277
R7024 oa_sar8_acore18_opt_0.sw_bitcell_opt_b7_1.bot.t121 oa_sar8_acore18_opt_0.sw_bitcell_opt_b7_1.bot.t116 1.13277
R7025 oa_sar8_acore18_opt_0.sw_bitcell_opt_b7_1.bot.t116 oa_sar8_acore18_opt_0.sw_bitcell_opt_b7_1.bot.t111 1.13277
R7026 oa_sar8_acore18_opt_0.sw_bitcell_opt_b7_1.bot.t105 oa_sar8_acore18_opt_0.sw_bitcell_opt_b7_1.bot.t100 1.13277
R7027 oa_sar8_acore18_opt_0.sw_bitcell_opt_b7_1.bot.t100 oa_sar8_acore18_opt_0.sw_bitcell_opt_b7_1.bot.t95 1.13277
R7028 oa_sar8_acore18_opt_0.sw_bitcell_opt_b7_1.bot.t95 oa_sar8_acore18_opt_0.sw_bitcell_opt_b7_1.bot.t90 1.13277
R7029 oa_sar8_acore18_opt_0.sw_bitcell_opt_b7_1.bot.t84 oa_sar8_acore18_opt_0.sw_bitcell_opt_b7_1.bot.t79 1.13277
R7030 oa_sar8_acore18_opt_0.sw_bitcell_opt_b7_1.bot.t79 oa_sar8_acore18_opt_0.sw_bitcell_opt_b7_1.bot.t74 1.13277
R7031 oa_sar8_acore18_opt_0.sw_bitcell_opt_b7_1.bot.t74 oa_sar8_acore18_opt_0.sw_bitcell_opt_b7_1.bot.t69 1.13277
R7032 oa_sar8_acore18_opt_0.sw_bitcell_opt_b7_1.bot.t63 oa_sar8_acore18_opt_0.sw_bitcell_opt_b7_1.bot.t58 1.13277
R7033 oa_sar8_acore18_opt_0.sw_bitcell_opt_b7_1.bot.t58 oa_sar8_acore18_opt_0.sw_bitcell_opt_b7_1.bot.t53 1.13277
R7034 oa_sar8_acore18_opt_0.sw_bitcell_opt_b7_1.bot.t53 oa_sar8_acore18_opt_0.sw_bitcell_opt_b7_1.bot.t48 1.13277
R7035 oa_sar8_acore18_opt_0.sw_bitcell_opt_b7_1.bot.t20 oa_sar8_acore18_opt_0.sw_bitcell_opt_b7_1.bot.t15 1.13277
R7036 oa_sar8_acore18_opt_0.sw_bitcell_opt_b7_1.bot.t15 oa_sar8_acore18_opt_0.sw_bitcell_opt_b7_1.bot.t10 1.13277
R7037 oa_sar8_acore18_opt_0.sw_bitcell_opt_b7_1.bot.t10 oa_sar8_acore18_opt_0.sw_bitcell_opt_b7_1.bot.t5 1.13277
R7038 oa_sar8_acore18_opt_0.sw_bitcell_opt_b7_1.bot.t41 oa_sar8_acore18_opt_0.sw_bitcell_opt_b7_1.bot.t36 1.13277
R7039 oa_sar8_acore18_opt_0.sw_bitcell_opt_b7_1.bot.t36 oa_sar8_acore18_opt_0.sw_bitcell_opt_b7_1.bot.t31 1.13277
R7040 oa_sar8_acore18_opt_0.sw_bitcell_opt_b7_1.bot.t31 oa_sar8_acore18_opt_0.sw_bitcell_opt_b7_1.bot.t26 1.13277
R7041 oa_sar8_acore18_opt_0.sw_bitcell_opt_b7_1.bot.t153 oa_sar8_acore18_opt_0.sw_bitcell_opt_b7_1.bot.t149 0.8497
R7042 oa_sar8_acore18_opt_0.sw_bitcell_opt_b7_1.bot.t132 oa_sar8_acore18_opt_0.sw_bitcell_opt_b7_1.bot.t128 0.8497
R7043 oa_sar8_acore18_opt_0.sw_bitcell_opt_b7_1.bot.t111 oa_sar8_acore18_opt_0.sw_bitcell_opt_b7_1.bot.t107 0.8497
R7044 oa_sar8_acore18_opt_0.sw_bitcell_opt_b7_1.bot.t90 oa_sar8_acore18_opt_0.sw_bitcell_opt_b7_1.bot.t86 0.8497
R7045 oa_sar8_acore18_opt_0.sw_bitcell_opt_b7_1.bot.t69 oa_sar8_acore18_opt_0.sw_bitcell_opt_b7_1.bot.t65 0.8497
R7046 oa_sar8_acore18_opt_0.sw_bitcell_opt_b7_1.bot.t48 oa_sar8_acore18_opt_0.sw_bitcell_opt_b7_1.bot.t44 0.8497
R7047 oa_sar8_acore18_opt_0.sw_bitcell_opt_b7_1.bot.t5 oa_sar8_acore18_opt_0.sw_bitcell_opt_b7_1.bot.t2 0.8497
R7048 oa_sar8_acore18_opt_0.sw_bitcell_opt_b7_1.bot.t26 oa_sar8_acore18_opt_0.sw_bitcell_opt_b7_1.bot.t22 0.8497
R7049 oa_sar8_acore18_opt_0.sw_bitcell_opt_b7_1.bot.n7 oa_sar8_acore18_opt_0.sw_bitcell_opt_b7_1.bot.n6 0.381833
R7050 oa_sar8_acore18_opt_0.sw_bitcell_opt_b7_1.bot.n6 oa_sar8_acore18_opt_0.sw_bitcell_opt_b7_1.bot.n5 0.381833
R7051 oa_sar8_acore18_opt_0.sw_bitcell_opt_b7_1.bot.n5 oa_sar8_acore18_opt_0.sw_bitcell_opt_b7_1.bot.n4 0.381833
R7052 oa_sar8_acore18_opt_0.sw_bitcell_opt_b7_1.bot.n3 oa_sar8_acore18_opt_0.sw_bitcell_opt_b7_1.bot.n2 0.381833
R7053 oa_sar8_acore18_opt_0.sw_bitcell_opt_b7_1.bot.n2 oa_sar8_acore18_opt_0.sw_bitcell_opt_b7_1.bot.n1 0.381833
R7054 oa_sar8_acore18_opt_0.sw_bitcell_opt_b7_1.bot.n1 oa_sar8_acore18_opt_0.sw_bitcell_opt_b7_1.bot.n0 0.381833
R7055 oa_sar8_acore18_opt_0.sw_bitcell_opt_b7_1.bot oa_sar8_acore18_opt_0.sw_bitcell_opt_b7_1.bot.n8 0.2656
R7056 oa_sar8_acore18_opt_0.sw_bitcell_opt_b7_1.bot.n0 oa_sar8_acore18_opt_0.sw_bitcell_opt_b7_1.bot 0.125167
R7057 oa_sar8_acore18_opt_0.sw_bitcell_opt_b7_1.bot.t0 oa_sar8_acore18_opt_0.sw_bitcell_opt_b7_1.bot.t1 30.6574
R7058 oa_sar8_acore18_opt_0.sw_bitcell_opt_b6_1.bot oa_sar8_acore18_opt_0.sw_bitcell_opt_b6_1.bot.n0 53.3537
R7059 oa_sar8_acore18_opt_0.sw_bitcell_opt_b6_1.bot.t0 oa_sar8_acore18_opt_0.sw_bitcell_opt_b6_1.bot.t1 30.7555
R7060 oa_sar8_acore18_opt_0.sw_bitcell_opt_b6_1.bot.n1 oa_sar8_acore18_opt_0.sw_bitcell_opt_b6_1.bot.t20 5.92317
R7061 oa_sar8_acore18_opt_0.sw_bitcell_opt_b6_1.bot.n1 oa_sar8_acore18_opt_0.sw_bitcell_opt_b6_1.bot.t40 5.92317
R7062 oa_sar8_acore18_opt_0.sw_bitcell_opt_b6_1.bot.n0 oa_sar8_acore18_opt_0.sw_bitcell_opt_b6_1.bot.t60 5.92317
R7063 oa_sar8_acore18_opt_0.sw_bitcell_opt_b6_1.bot.n0 oa_sar8_acore18_opt_0.sw_bitcell_opt_b6_1.bot.t80 5.92317
R7064 oa_sar8_acore18_opt_0.sw_bitcell_opt_b6_1.bot.n0 oa_sar8_acore18_opt_0.sw_bitcell_opt_b6_1.bot.n1 3.10983
R7065 oa_sar8_acore18_opt_0.sw_bitcell_opt_b6_1.bot.n1 oa_sar8_acore18_opt_0.sw_bitcell_opt_b6_1.bot 2.2665
R7066 oa_sar8_acore18_opt_0.sw_bitcell_opt_b6_1.bot oa_sar8_acore18_opt_0.sw_bitcell_opt_b6_1.bot.t0 1.8683
R7067 oa_sar8_acore18_opt_0.sw_bitcell_opt_b6_1.bot.t80 oa_sar8_acore18_opt_0.sw_bitcell_opt_b6_1.bot.t75 1.13277
R7068 oa_sar8_acore18_opt_0.sw_bitcell_opt_b6_1.bot.t75 oa_sar8_acore18_opt_0.sw_bitcell_opt_b6_1.bot.t70 1.13277
R7069 oa_sar8_acore18_opt_0.sw_bitcell_opt_b6_1.bot.t60 oa_sar8_acore18_opt_0.sw_bitcell_opt_b6_1.bot.t55 1.13277
R7070 oa_sar8_acore18_opt_0.sw_bitcell_opt_b6_1.bot.t55 oa_sar8_acore18_opt_0.sw_bitcell_opt_b6_1.bot.t50 1.13277
R7071 oa_sar8_acore18_opt_0.sw_bitcell_opt_b6_1.bot.t40 oa_sar8_acore18_opt_0.sw_bitcell_opt_b6_1.bot.t35 1.13277
R7072 oa_sar8_acore18_opt_0.sw_bitcell_opt_b6_1.bot.t35 oa_sar8_acore18_opt_0.sw_bitcell_opt_b6_1.bot.t30 1.13277
R7073 oa_sar8_acore18_opt_0.sw_bitcell_opt_b6_1.bot.t20 oa_sar8_acore18_opt_0.sw_bitcell_opt_b6_1.bot.t15 1.13277
R7074 oa_sar8_acore18_opt_0.sw_bitcell_opt_b6_1.bot.t15 oa_sar8_acore18_opt_0.sw_bitcell_opt_b6_1.bot.t10 1.13277
R7075 oa_sar8_acore18_opt_0.sw_bitcell_opt_b6_1.bot.t10 oa_sar8_acore18_opt_0.sw_bitcell_opt_b6_1.bot.t2 1.13277
R7076 oa_sar8_acore18_opt_0.sw_bitcell_opt_b6_1.bot.t30 oa_sar8_acore18_opt_0.sw_bitcell_opt_b6_1.bot.t22 1.13277
R7077 oa_sar8_acore18_opt_0.sw_bitcell_opt_b6_1.bot.t50 oa_sar8_acore18_opt_0.sw_bitcell_opt_b6_1.bot.t42 1.13277
R7078 oa_sar8_acore18_opt_0.sw_bitcell_opt_b6_1.bot.t70 oa_sar8_acore18_opt_0.sw_bitcell_opt_b6_1.bot.t62 1.13277
R7079 oa_sar8_acore18_opt_0.sw_bitcell_opt_b5_1.bot oa_sar8_acore18_opt_0.sw_bitcell_opt_b5_1.bot.n1 58.0925
R7080 oa_sar8_acore18_opt_0.sw_bitcell_opt_b5_1.bot.t1 oa_sar8_acore18_opt_0.sw_bitcell_opt_b5_1.bot.t0 30.8707
R7081 oa_sar8_acore18_opt_0.sw_bitcell_opt_b5_1.bot.n0 oa_sar8_acore18_opt_0.sw_bitcell_opt_b5_1.bot.t20 5.76183
R7082 oa_sar8_acore18_opt_0.sw_bitcell_opt_b5_1.bot.n1 oa_sar8_acore18_opt_0.sw_bitcell_opt_b5_1.bot.t40 5.76183
R7083 oa_sar8_acore18_opt_0.sw_bitcell_opt_b5_1.bot.n0 oa_sar8_acore18_opt_0.sw_bitcell_opt_b5_1.bot 2.76517
R7084 oa_sar8_acore18_opt_0.sw_bitcell_opt_b5_1.bot.n1 oa_sar8_acore18_opt_0.sw_bitcell_opt_b5_1.bot.n0 1.8485
R7085 oa_sar8_acore18_opt_0.sw_bitcell_opt_b5_1.bot oa_sar8_acore18_opt_0.sw_bitcell_opt_b5_1.bot.t0 1.7363
R7086 oa_sar8_acore18_opt_0.sw_bitcell_opt_b5_1.bot.t40 oa_sar8_acore18_opt_0.sw_bitcell_opt_b5_1.bot.t35 1.13277
R7087 oa_sar8_acore18_opt_0.sw_bitcell_opt_b5_1.bot.t35 oa_sar8_acore18_opt_0.sw_bitcell_opt_b5_1.bot.t30 1.13277
R7088 oa_sar8_acore18_opt_0.sw_bitcell_opt_b5_1.bot.t20 oa_sar8_acore18_opt_0.sw_bitcell_opt_b5_1.bot.t15 1.13277
R7089 oa_sar8_acore18_opt_0.sw_bitcell_opt_b5_1.bot.t15 oa_sar8_acore18_opt_0.sw_bitcell_opt_b5_1.bot.t10 1.13277
R7090 oa_sar8_acore18_opt_0.sw_bitcell_opt_b5_1.bot.t10 oa_sar8_acore18_opt_0.sw_bitcell_opt_b5_1.bot.t2 1.13277
R7091 oa_sar8_acore18_opt_0.sw_bitcell_opt_b5_1.bot.t30 oa_sar8_acore18_opt_0.sw_bitcell_opt_b5_1.bot.t22 1.13277
R7092 oa_sar8_acore18_opt_0.sw_bitcell_opt_b4_1.bot oa_sar8_acore18_opt_0.sw_bitcell_opt_b4_1.bot.n7 62.4698
R7093 oa_sar8_acore18_opt_0.sw_bitcell_opt_b4_1.bot.n6 oa_sar8_acore18_opt_0.sw_bitcell_opt_b4_1.bot.t2 29.4665
R7094 oa_sar8_acore18_opt_0.sw_bitcell_opt_b4_1.bot.n6 oa_sar8_acore18_opt_0.sw_bitcell_opt_b4_1.bot.t4 28.7147
R7095 oa_sar8_acore18_opt_0.sw_bitcell_opt_b4_1.bot.n6 oa_sar8_acore18_opt_0.sw_bitcell_opt_b4_1.bot.t6 28.7147
R7096 oa_sar8_acore18_opt_0.sw_bitcell_opt_b4_1.bot.n5 oa_sar8_acore18_opt_0.sw_bitcell_opt_b4_1.bot.t8 28.7147
R7097 oa_sar8_acore18_opt_0.sw_bitcell_opt_b4_1.bot.n5 oa_sar8_acore18_opt_0.sw_bitcell_opt_b4_1.bot.t10 28.7147
R7098 oa_sar8_acore18_opt_0.sw_bitcell_opt_b4_1.bot.n0 oa_sar8_acore18_opt_0.sw_bitcell_opt_b4_1.bot.t12 28.7147
R7099 oa_sar8_acore18_opt_0.sw_bitcell_opt_b4_1.bot.n0 oa_sar8_acore18_opt_0.sw_bitcell_opt_b4_1.bot.t14 28.7147
R7100 oa_sar8_acore18_opt_0.sw_bitcell_opt_b4_1.bot.n1 oa_sar8_acore18_opt_0.sw_bitcell_opt_b4_1.bot.t16 28.7147
R7101 oa_sar8_acore18_opt_0.sw_bitcell_opt_b4_1.bot.n1 oa_sar8_acore18_opt_0.sw_bitcell_opt_b4_1.bot.t18 27.2117
R7102 oa_sar8_acore18_opt_0.sw_bitcell_opt_b4_1.bot.n1 oa_sar8_acore18_opt_0.sw_bitcell_opt_b4_1.bot.t20 27.2117
R7103 oa_sar8_acore18_opt_0.sw_bitcell_opt_b4_1.bot.n4 oa_sar8_acore18_opt_0.sw_bitcell_opt_b4_1.bot.t22 27.2117
R7104 oa_sar8_acore18_opt_0.sw_bitcell_opt_b4_1.bot.n4 oa_sar8_acore18_opt_0.sw_bitcell_opt_b4_1.bot.t24 27.2117
R7105 oa_sar8_acore18_opt_0.sw_bitcell_opt_b4_1.bot.n2 oa_sar8_acore18_opt_0.sw_bitcell_opt_b4_1.bot.t26 27.2117
R7106 oa_sar8_acore18_opt_0.sw_bitcell_opt_b4_1.bot.n2 oa_sar8_acore18_opt_0.sw_bitcell_opt_b4_1.bot.t28 27.2117
R7107 oa_sar8_acore18_opt_0.sw_bitcell_opt_b4_1.bot.n3 oa_sar8_acore18_opt_0.sw_bitcell_opt_b4_1.bot.t30 27.2117
R7108 oa_sar8_acore18_opt_0.sw_bitcell_opt_b4_1.bot.n3 oa_sar8_acore18_opt_0.sw_bitcell_opt_b4_1.bot.t32 27.2117
R7109 oa_sar8_acore18_opt_0.sw_bitcell_opt_b4_1.bot.n7 oa_sar8_acore18_opt_0.sw_bitcell_opt_b4_1.bot.n3 4.18524
R7110 oa_sar8_acore18_opt_0.sw_bitcell_opt_b4_1.bot.n7 oa_sar8_acore18_opt_0.sw_bitcell_opt_b4_1.bot 4.0485
R7111 oa_sar8_acore18_opt_0.sw_bitcell_opt_b4_1.bot.t1 oa_sar8_acore18_opt_0.sw_bitcell_opt_b4_1.bot.t0 30.9415
R7112 oa_sar8_acore18_opt_0.sw_bitcell_opt_b4_1.bot.n4 oa_sar8_acore18_opt_0.sw_bitcell_opt_b4_1.bot.n1 2.41924
R7113 oa_sar8_acore18_opt_0.sw_bitcell_opt_b4_1.bot.n3 oa_sar8_acore18_opt_0.sw_bitcell_opt_b4_1.bot.n2 2.25581
R7114 oa_sar8_acore18_opt_0.sw_bitcell_opt_b4_1.bot oa_sar8_acore18_opt_0.sw_bitcell_opt_b4_1.bot.t0 1.6043
R7115 oa_sar8_acore18_opt_0.sw_bitcell_opt_b4_1.bot.n5 oa_sar8_acore18_opt_0.sw_bitcell_opt_b4_1.bot.n6 1.50404
R7116 oa_sar8_acore18_opt_0.sw_bitcell_opt_b4_1.bot.n0 oa_sar8_acore18_opt_0.sw_bitcell_opt_b4_1.bot.n5 1.50404
R7117 oa_sar8_acore18_opt_0.sw_bitcell_opt_b4_1.bot.n1 oa_sar8_acore18_opt_0.sw_bitcell_opt_b4_1.bot.n0 1.50404
R7118 oa_sar8_acore18_opt_0.sw_bitcell_opt_b4_1.bot.n2 oa_sar8_acore18_opt_0.sw_bitcell_opt_b4_1.bot.n4 1.50404
R7119 oa_sar8_acore18_opt_0.sw_bitcell_opt_b3_1.bot oa_sar8_acore18_opt_0.sw_bitcell_opt_b3_1.bot.n4 66.1797
R7120 oa_sar8_acore18_opt_0.sw_bitcell_opt_b3_1.bot.n0 oa_sar8_acore18_opt_0.sw_bitcell_opt_b3_1.bot.t1 28.4331
R7121 oa_sar8_acore18_opt_0.sw_bitcell_opt_b3_1.bot.n1 oa_sar8_acore18_opt_0.sw_bitcell_opt_b3_1.bot.t3 28.4331
R7122 oa_sar8_acore18_opt_0.sw_bitcell_opt_b3_1.bot.n1 oa_sar8_acore18_opt_0.sw_bitcell_opt_b3_1.bot.t5 28.4331
R7123 oa_sar8_acore18_opt_0.sw_bitcell_opt_b3_1.bot.n3 oa_sar8_acore18_opt_0.sw_bitcell_opt_b3_1.bot.t7 28.4331
R7124 oa_sar8_acore18_opt_0.sw_bitcell_opt_b3_1.bot.n2 oa_sar8_acore18_opt_0.sw_bitcell_opt_b3_1.bot.t9 28.2451
R7125 oa_sar8_acore18_opt_0.sw_bitcell_opt_b3_1.bot.n2 oa_sar8_acore18_opt_0.sw_bitcell_opt_b3_1.bot.t11 27.4933
R7126 oa_sar8_acore18_opt_0.sw_bitcell_opt_b3_1.bot.n2 oa_sar8_acore18_opt_0.sw_bitcell_opt_b3_1.bot.t13 27.4933
R7127 oa_sar8_acore18_opt_0.sw_bitcell_opt_b3_1.bot.n0 oa_sar8_acore18_opt_0.sw_bitcell_opt_b3_1.bot.t15 27.4933
R7128 oa_sar8_acore18_opt_0.sw_bitcell_opt_b3_1.bot.t17 oa_sar8_acore18_opt_0.sw_bitcell_opt_b3_1.bot.t0 31.2836
R7129 oa_sar8_acore18_opt_0.sw_bitcell_opt_b3_1.bot.n4 oa_sar8_acore18_opt_0.sw_bitcell_opt_b3_1.bot.n3 7.08924
R7130 oa_sar8_acore18_opt_0.sw_bitcell_opt_b3_1.bot.n4 oa_sar8_acore18_opt_0.sw_bitcell_opt_b3_1.bot 3.93117
R7131 oa_sar8_acore18_opt_0.sw_bitcell_opt_b3_1.bot.n0 oa_sar8_acore18_opt_0.sw_bitcell_opt_b3_1.bot.n2 1.50404
R7132 oa_sar8_acore18_opt_0.sw_bitcell_opt_b3_1.bot.n3 oa_sar8_acore18_opt_0.sw_bitcell_opt_b3_1.bot.n1 1.50404
R7133 oa_sar8_acore18_opt_0.sw_bitcell_opt_b3_1.bot oa_sar8_acore18_opt_0.sw_bitcell_opt_b3_1.bot.t0 1.4745
R7134 oa_sar8_acore18_opt_0.sw_bitcell_opt_b3_1.bot.n1 oa_sar8_acore18_opt_0.sw_bitcell_opt_b3_1.bot.n0 1.34061
R7135 oa_sar8_acore18_opt_0.sw_bitcell_opt_b2_1.bot oa_sar8_acore18_opt_0.sw_bitcell_opt_b2_1.bot.n2 69.8039
R7136 oa_sar8_acore18_opt_0.sw_bitcell_opt_b2_1.bot.t0 oa_sar8_acore18_opt_0.sw_bitcell_opt_b2_1.bot.t1 31.3455
R7137 oa_sar8_acore18_opt_0.sw_bitcell_opt_b2_1.bot.n1 oa_sar8_acore18_opt_0.sw_bitcell_opt_b2_1.bot.t6 28.5267
R7138 oa_sar8_acore18_opt_0.sw_bitcell_opt_b2_1.bot.n0 oa_sar8_acore18_opt_0.sw_bitcell_opt_b2_1.bot.t2 28.1515
R7139 oa_sar8_acore18_opt_0.sw_bitcell_opt_b2_1.bot.n0 oa_sar8_acore18_opt_0.sw_bitcell_opt_b2_1.bot.t4 28.1515
R7140 oa_sar8_acore18_opt_0.sw_bitcell_opt_b2_1.bot.n1 oa_sar8_acore18_opt_0.sw_bitcell_opt_b2_1.bot.t8 27.7749
R7141 oa_sar8_acore18_opt_0.sw_bitcell_opt_b2_1.bot.n0 oa_sar8_acore18_opt_0.sw_bitcell_opt_b2_1.bot.n1 6.62313
R7142 oa_sar8_acore18_opt_0.sw_bitcell_opt_b2_1.bot.n2 oa_sar8_acore18_opt_0.sw_bitcell_opt_b2_1.bot.n0 6.05587
R7143 oa_sar8_acore18_opt_0.sw_bitcell_opt_b2_1.bot.n2 oa_sar8_acore18_opt_0.sw_bitcell_opt_b2_1.bot 3.81383
R7144 oa_sar8_acore18_opt_0.sw_bitcell_opt_b2_1.bot oa_sar8_acore18_opt_0.sw_bitcell_opt_b2_1.bot.t0 1.3843
R7145 oa_sar8_acore18_opt_0.sw_bitcell_opt_b1_1.bot oa_sar8_acore18_opt_0.sw_bitcell_opt_b1_1.bot.n1 73.3444
R7146 oa_sar8_acore18_opt_0.sw_bitcell_opt_b1_1.bot.n0 oa_sar8_acore18_opt_0.sw_bitcell_opt_b1_1.bot.t4 37.6963
R7147 oa_sar8_acore18_opt_0.sw_bitcell_opt_b1_1.bot.n0 oa_sar8_acore18_opt_0.sw_bitcell_opt_b1_1.bot.t2 27.8699
R7148 oa_sar8_acore18_opt_0.sw_bitcell_opt_b1_1.bot.t1 oa_sar8_acore18_opt_0.sw_bitcell_opt_b1_1.bot.t0 31.7993
R7149 oa_sar8_acore18_opt_0.sw_bitcell_opt_b1_1.bot.n1 oa_sar8_acore18_opt_0.sw_bitcell_opt_b1_1.bot.n0 4.27324
R7150 oa_sar8_acore18_opt_0.sw_bitcell_opt_b1_1.bot.n1 oa_sar8_acore18_opt_0.sw_bitcell_opt_b1_1.bot 3.6965
R7151 oa_sar8_acore18_opt_0.sw_bitcell_opt_b1_1.bot oa_sar8_acore18_opt_0.sw_bitcell_opt_b1_1.bot.t0 1.2963
R7152 oa_sar8_acore18_opt_0.sw_bitcell_opt_b0_1.bot oa_sar8_acore18_opt_0.sw_bitcell_opt_b0_1.bot.n0 76.7925
R7153 oa_sar8_acore18_opt_0.sw_bitcell_opt_b0_1.bot.n0 oa_sar8_acore18_opt_0.sw_bitcell_opt_b0_1.bot.t2 42.7308
R7154 oa_sar8_acore18_opt_0.sw_bitcell_opt_b0_1.bot.t0 oa_sar8_acore18_opt_0.sw_bitcell_opt_b0_1.bot.t1 32.1925
R7155 oa_sar8_acore18_opt_0.sw_bitcell_opt_b0_1.bot.n0 oa_sar8_acore18_opt_0.sw_bitcell_opt_b0_1.bot 3.57917
R7156 oa_sar8_acore18_opt_0.sw_bitcell_opt_b0_1.bot oa_sar8_acore18_opt_0.sw_bitcell_opt_b0_1.bot.t0 1.2083
R7157 oa_sar8_acore18_opt_0.sw_bitcell_opt_term_0.trkb.t0 oa_sar8_acore18_opt_0.sw_bitcell_opt_term_0.trkb.t1 34.1028
R7158 oa_sar8_acore18_opt_0.sw_bitcell_opt_term_0.trkb.n3 oa_sar8_acore18_opt_0.sw_bitcell_opt_term_0.trkb.n2 33.1211
R7159 oa_sar8_acore18_opt_0.sw_bitcell_opt_term_0.trkb.n1 oa_sar8_acore18_opt_0.sw_bitcell_opt_term_0.trkb.t4 30.4509
R7160 oa_sar8_acore18_opt_0.sw_bitcell_opt_term_0.trkb.n6 oa_sar8_acore18_opt_0.sw_bitcell_opt_term_0.trkb.t9 30.4509
R7161 oa_sar8_acore18_opt_0.sw_bitcell_opt_term_0.trkb oa_sar8_acore18_opt_0.sw_bitcell_opt_term_0.trkb.t12 24.7602
R7162 oa_sar8_acore18_opt_0.sw_bitcell_opt_term_0.trkb.n3 oa_sar8_acore18_opt_0.sw_bitcell_opt_term_0.trkb 24.5994
R7163 oa_sar8_acore18_opt_0.sw_bitcell_opt_term_0.trkb.n0 oa_sar8_acore18_opt_0.sw_bitcell_opt_term_0.trkb.t10 22.0333
R7164 oa_sar8_acore18_opt_0.sw_bitcell_opt_term_0.trkb oa_sar8_acore18_opt_0.sw_bitcell_opt_term_0.trkb.t11 22.0333
R7165 oa_sar8_acore18_opt_0.sw_bitcell_opt_term_0.trkb oa_sar8_acore18_opt_0.sw_bitcell_opt_term_0.trkb.t2 22.0333
R7166 oa_sar8_acore18_opt_0.sw_bitcell_opt_term_0.trkb oa_sar8_acore18_opt_0.sw_bitcell_opt_term_0.trkb.t13 22.0333
R7167 oa_sar8_acore18_opt_0.sw_bitcell_opt_term_0.trkb oa_sar8_acore18_opt_0.sw_bitcell_opt_term_0.trkb.t14 22.0333
R7168 oa_sar8_acore18_opt_0.sw_bitcell_opt_term_0.trkb oa_sar8_acore18_opt_0.sw_bitcell_opt_term_0.trkb.t15 22.0333
R7169 oa_sar8_acore18_opt_0.sw_bitcell_opt_term_0.trkb oa_sar8_acore18_opt_0.sw_bitcell_opt_term_0.trkb.t16 22.0333
R7170 oa_sar8_acore18_opt_0.sw_bitcell_opt_term_0.trkb oa_sar8_acore18_opt_0.sw_bitcell_opt_term_0.trkb.t17 22.0333
R7171 oa_sar8_acore18_opt_0.sw_bitcell_opt_term_0.trkb oa_sar8_acore18_opt_0.sw_bitcell_opt_term_0.trkb.t18 22.0333
R7172 oa_sar8_acore18_opt_0.sw_bitcell_opt_term_0.trkb oa_sar8_acore18_opt_0.sw_bitcell_opt_term_0.trkb.t19 22.0333
R7173 oa_sar8_acore18_opt_0.sw_bitcell_opt_term_0.trkb oa_sar8_acore18_opt_0.sw_bitcell_opt_term_0.trkb.t20 22.0333
R7174 oa_sar8_acore18_opt_0.sw_bitcell_opt_term_0.trkb.n2 oa_sar8_acore18_opt_0.sw_bitcell_opt_term_0.trkb.t21 22.0333
R7175 oa_sar8_acore18_opt_0.sw_bitcell_opt_term_0.trkb oa_sar8_acore18_opt_0.sw_bitcell_opt_term_0.trkb.t22 22.0333
R7176 oa_sar8_acore18_opt_0.sw_bitcell_opt_term_0.trkb oa_sar8_acore18_opt_0.sw_bitcell_opt_term_0.trkb.t23 22.0333
R7177 oa_sar8_acore18_opt_0.sw_bitcell_opt_term_0.trkb oa_sar8_acore18_opt_0.sw_bitcell_opt_term_0.trkb.t24 22.0333
R7178 oa_sar8_acore18_opt_0.sw_bitcell_opt_term_0.trkb oa_sar8_acore18_opt_0.sw_bitcell_opt_term_0.trkb.t25 22.0333
R7179 oa_sar8_acore18_opt_0.sw_bitcell_opt_term_0.trkb oa_sar8_acore18_opt_0.sw_bitcell_opt_term_0.trkb.t26 22.0333
R7180 oa_sar8_acore18_opt_0.sw_bitcell_opt_term_0.trkb oa_sar8_acore18_opt_0.sw_bitcell_opt_term_0.trkb.t27 22.0333
R7181 oa_sar8_acore18_opt_0.sw_bitcell_opt_term_0.trkb oa_sar8_acore18_opt_0.sw_bitcell_opt_term_0.trkb.t28 22.0333
R7182 oa_sar8_acore18_opt_0.sw_bitcell_opt_term_0.trkb oa_sar8_acore18_opt_0.sw_bitcell_opt_term_0.trkb.t29 22.0329
R7183 oa_sar8_acore18_opt_0.sw_bitcell_opt_term_0.trkb.n4 oa_sar8_acore18_opt_0.sw_bitcell_opt_term_0.trkb.t7 20.8866
R7184 oa_sar8_acore18_opt_0.sw_bitcell_opt_term_0.trkb.n6 oa_sar8_acore18_opt_0.sw_bitcell_opt_term_0.trkb.t8 20.8866
R7185 oa_sar8_acore18_opt_0.sw_bitcell_opt_term_0.trkb.n1 oa_sar8_acore18_opt_0.sw_bitcell_opt_term_0.trkb.t5 20.8862
R7186 oa_sar8_acore18_opt_0.sw_bitcell_opt_term_0.trkb oa_sar8_acore18_opt_0.sw_bitcell_opt_term_0.trkb.t6 20.8862
R7187 oa_sar8_acore18_opt_0.sw_bitcell_opt_term_0.trkb.n0 oa_sar8_acore18_opt_0.sw_bitcell_opt_term_0.trkb.n3 20.5327
R7188 oa_sar8_acore18_opt_0.sw_bitcell_opt_term_0.trkb oa_sar8_acore18_opt_0.sw_bitcell_opt_term_0.trkb.n5 18.5285
R7189 oa_sar8_acore18_opt_0.sw_bitcell_opt_term_0.trkb.n2 oa_sar8_acore18_opt_0.sw_bitcell_opt_term_0.trkb 3.5634
R7190 oa_sar8_acore18_opt_0.sw_bitcell_opt_term_0.trkb.n0 oa_sar8_acore18_opt_0.sw_bitcell_opt_term_0.trkb 3.0838
R7191 oa_sar8_acore18_opt_0.sw_bitcell_opt_term_0.trkb.n5 oa_sar8_acore18_opt_0.sw_bitcell_opt_term_0.trkb 2.7714
R7192 oa_sar8_acore18_opt_0.sw_bitcell_opt_term_0.trkb oa_sar8_acore18_opt_0.sw_bitcell_opt_term_0.trkb.n0 2.5932
R7193 oa_sar8_acore18_opt_0.sw_bitcell_opt_term_0.trkb oa_sar8_acore18_opt_0.sw_bitcell_opt_term_0.trkb.n1 1.6538
R7194 oa_sar8_acore18_opt_0.sw_bitcell_opt_term_0.trkb.n5 oa_sar8_acore18_opt_0.sw_bitcell_opt_term_0.trkb.n4 1.1247
R7195 oa_sar8_acore18_opt_0.sw_bitcell_opt_term_0.trkb oa_sar8_acore18_opt_0.sw_bitcell_opt_term_0.trkb.t0 1.0169
R7196 oa_sar8_acore18_opt_0.sw_bitcell_opt_term_0.trkb.n4 oa_sar8_acore18_opt_0.sw_bitcell_opt_term_0.trkb.n6 1.0147
R7197 oa_sar8_acore18_opt_0.sw_bitcell_opt_term_1.bot oa_sar8_acore18_opt_0.sw_bitcell_opt_term_1.bot.n0 80.2363
R7198 oa_sar8_acore18_opt_0.sw_bitcell_opt_term_1.bot.n0 oa_sar8_acore18_opt_0.sw_bitcell_opt_term_1.bot.t1 30.2721
R7199 oa_sar8_acore18_opt_0.sw_bitcell_opt_term_1.bot.t0 oa_sar8_acore18_opt_0.sw_bitcell_opt_term_1.bot.t3 32.1925
R7200 oa_sar8_acore18_opt_0.sw_bitcell_opt_term_1.bot.n0 oa_sar8_acore18_opt_0.sw_bitcell_opt_term_1.bot 3.46183
R7201 oa_sar8_acore18_opt_0.sw_bitcell_opt_term_1.bot oa_sar8_acore18_opt_0.sw_bitcell_opt_term_1.bot.t0 1.2083
R7202 oa_sar8_acore18_opt_0.sw_tg_opt_0.bot oa_sar8_acore18_opt_0.sw_tg_opt_0.bot.t3 122.109
R7203 oa_sar8_acore18_opt_0.sw_tg_opt_0.bot.t0 oa_sar8_acore18_opt_0.sw_tg_opt_0.bot.t1 25.1028
R7204 oa_sar8_acore18_opt_0.sw_tg_opt_0.bot oa_sar8_acore18_opt_0.sw_tg_opt_0.bot.t5 11.6667
R7205 oa_sar8_acore18_opt_0.sw_tg_opt_0.bot oa_sar8_acore18_opt_0.sw_tg_opt_0.bot.t0 11.5613
R7206 oa_sar8_acore18_opt_0.sw_tg_opt_0.bot.t3 oa_sar8_acore18_opt_0.sw_tg_opt_0.bot 10.861
R7207 oa_sar8_acore18_opt_0.sw_tg_opt_0.bot.t3 oa_sar8_acore18_opt_0.sw_tg_opt_0.bot.t4 1.40387
R7208 oa_sar8_acore18_opt_0.sw_tg_opt_0.bot.t3 oa_sar8_acore18_opt_0.sw_tg_opt_0.bot.t2 1.02767
R7209 oa_sar8_acore18_opt_0.sw_tg_opt_1.bot oa_sar8_acore18_opt_0.sw_tg_opt_1.bot.t3 119.483
R7210 oa_sar8_acore18_opt_0.sw_tg_opt_1.bot.t0 oa_sar8_acore18_opt_0.sw_tg_opt_1.bot.t1 25.1028
R7211 oa_sar8_acore18_opt_0.sw_tg_opt_1.bot oa_sar8_acore18_opt_0.sw_tg_opt_1.bot.t5 11.6673
R7212 oa_sar8_acore18_opt_0.sw_tg_opt_1.bot oa_sar8_acore18_opt_0.sw_tg_opt_1.bot.t0 11.5613
R7213 oa_sar8_acore18_opt_0.sw_tg_opt_1.bot.t3 oa_sar8_acore18_opt_0.sw_tg_opt_1.bot 10.8611
R7214 oa_sar8_acore18_opt_0.sw_tg_opt_1.bot.t3 oa_sar8_acore18_opt_0.sw_tg_opt_1.bot.t4 1.40387
R7215 oa_sar8_acore18_opt_0.sw_tg_opt_1.bot.t3 oa_sar8_acore18_opt_0.sw_tg_opt_1.bot.t2 1.02767
R7216 sar_ctrl_async_phys_0.sg13g2_buf_1$1_6.X.n2 sar_ctrl_async_phys_0.sg13g2_buf_1$1_6.X 35.2488
R7217 sar_ctrl_async_phys_0.sg13g2_buf_1$1_6.X.t2 sar_ctrl_async_phys_0.sg13g2_buf_1$1_6.X.t1 33.4028
R7218 sar_ctrl_async_phys_0.sg13g2_buf_1$1_6.X.n6 sar_ctrl_async_phys_0.sg13g2_buf_1$1_6.X 31.2448
R7219 sar_ctrl_async_phys_0.sg13g2_buf_1$1_6.X.n0 sar_ctrl_async_phys_0.sg13g2_buf_1$1_6.X 21.8783
R7220 sar_ctrl_async_phys_0.sg13g2_buf_1$1_6.X.n4 sar_ctrl_async_phys_0.sg13g2_buf_1$1_6.X 21.1479
R7221 sar_ctrl_async_phys_0.sg13g2_buf_1$1_6.X.n0 sar_ctrl_async_phys_0.sg13g2_buf_1$1_6.X 19.5502
R7222 sar_ctrl_async_phys_0.sg13g2_buf_1$1_6.X.n1 sar_ctrl_async_phys_0.sg13g2_buf_1$1_6.X 19.0887
R7223 sar_ctrl_async_phys_0.sg13g2_buf_1$1_6.X sar_ctrl_async_phys_0.sg13g2_buf_1$1_6.X.t2 15.0489
R7224 sar_ctrl_async_phys_0.sg13g2_buf_1$1_6.X.n5 sar_ctrl_async_phys_0.sg13g2_buf_1$1_6.X.n4 11.7461
R7225 sar_ctrl_async_phys_0.sg13g2_buf_1$1_6.X.n5 sar_ctrl_async_phys_0.sg13g2_buf_1$1_6.X 10.2611
R7226 sar_ctrl_async_phys_0.sg13g2_buf_1$1_6.X.n3 sar_ctrl_async_phys_0.sg13g2_buf_1$1_6.X.n2 9.50786
R7227 sar_ctrl_async_phys_0.sg13g2_buf_1$1_6.X sar_ctrl_async_phys_0.sg13g2_buf_1$1_6.X.n6 9.10376
R7228 sar_ctrl_async_phys_0.sg13g2_buf_1$1_6.X.n2 sar_ctrl_async_phys_0.sg13g2_buf_1$1_6.X 9.0005
R7229 sar_ctrl_async_phys_0.sg13g2_buf_1$1_6.X sar_ctrl_async_phys_0.sg13g2_buf_1$1_6.X.t0 5.6237
R7230 sar_ctrl_async_phys_0.sg13g2_buf_1$1_6.X.n4 sar_ctrl_async_phys_0.sg13g2_buf_1$1_6.X.n3 5.2805
R7231 sar_ctrl_async_phys_0.sg13g2_buf_1$1_6.X.n3 sar_ctrl_async_phys_0.sg13g2_buf_1$1_6.X.n1 2.7461
R7232 sar_ctrl_async_phys_0.sg13g2_buf_1$1_6.X.n1 sar_ctrl_async_phys_0.sg13g2_buf_1$1_6.X.n0 1.9013
R7233 sar_ctrl_async_phys_0.sg13g2_buf_1$1_6.X.n6 sar_ctrl_async_phys_0.sg13g2_buf_1$1_6.X.n5 1.17235
R7234 sar_ctrl_async_phys_0.sg13g2_buf_1$1_2.X.t0 sar_ctrl_async_phys_0.sg13g2_buf_1$1_6.A 41.4382
R7235 sar_ctrl_async_phys_0.sg13g2_buf_1$1_2.X.t3 sar_ctrl_async_phys_0.sg13g2_buf_1$1_2.X.t2 33.4028
R7236 sar_ctrl_async_phys_0.sg13g2_buf_1$1_2.X.t6 sar_ctrl_async_phys_0.sg13g2_buf_1$1_2.X.t5 33.4028
R7237 sar_ctrl_async_phys_0.sg13g2_buf_1$1_2.X.t0 sar_ctrl_async_phys_0.sg13g2_buf_1$1_2.X.n5 29.4503
R7238 sar_ctrl_async_phys_0.sg13g2_buf_1$1_2.X.n0 sar_ctrl_async_phys_0.sg13g2_nand2_1$1_1.A 21.1919
R7239 sar_ctrl_async_phys_0.sg13g2_buf_1$1_2.X.n1 sar_ctrl_async_phys_0.sg13g2_dfrbpq_1$1_21.RESET_B 20.0303
R7240 sar_ctrl_async_phys_0.sg13g2_buf_1$1_2.X.n2 sar_ctrl_async_phys_0.sg13g2_dfrbpq_1$1_2.RESET_B 19.2911
R7241 sar_ctrl_async_phys_0.sg13g2_buf_1$1_2.X.n0 sar_ctrl_async_phys_0.sg13g2_nand3b_1$1_0.B 18.5519
R7242 sar_ctrl_async_phys_0.sg13g2_dfrbpq_1$1_2.RESET_B sar_ctrl_async_phys_0.sg13g2_buf_1$1_2.X.t6 15.0489
R7243 sar_ctrl_async_phys_0.sg13g2_dfrbpq_1$1_21.RESET_B sar_ctrl_async_phys_0.sg13g2_buf_1$1_2.X.t3 15.0489
R7244 sar_ctrl_async_phys_0.sg13g2_nand2_1$1_1.A sar_ctrl_async_phys_0.sg13g2_buf_1$1_2.X.t7 15.0255
R7245 sar_ctrl_async_phys_0.sg13g2_nand3b_1$1_0.B sar_ctrl_async_phys_0.sg13g2_buf_1$1_2.X.t4 15.0152
R7246 sar_ctrl_async_phys_0.sg13g2_buf_1$1_2.X.n3 sar_ctrl_async_phys_0.sg13g2_buf_1$1_2.X.n2 13.9871
R7247 sar_ctrl_async_phys_0.sg13g2_buf_1$1_2.X.n4 sar_ctrl_async_phys_0.sg13g2_dfrbpq_1$1_3.RESET_B 9.0005
R7248 sar_ctrl_async_phys_0.sg13g2_buf_1$1_2.X.n3 sar_ctrl_async_phys_0.sg13g2_dfrbpq_1$1_8.RESET_B 9.0005
R7249 sar_ctrl_async_phys_0.sg13g2_buf_1$1_2.X.n5 sar_ctrl_async_phys_0.sg13g2_dfrbpq_1$1_0.RESET_B 9.0005
R7250 sar_ctrl_async_phys_0.sg13g2_buf_1$1_2.X.t0 sar_ctrl_async_phys_0.sg13g2_buf_1$1_2.X.t1 6.3941
R7251 sar_ctrl_async_phys_0.sg13g2_buf_1$1_2.X.n5 sar_ctrl_async_phys_0.sg13g2_buf_1$1_2.X.n4 4.0727
R7252 sar_ctrl_async_phys_0.sg13g2_buf_1$1_2.X.n2 sar_ctrl_async_phys_0.sg13g2_buf_1$1_2.X.n1 2.5349
R7253 sar_ctrl_async_phys_0.sg13g2_buf_1$1_2.X.n1 sar_ctrl_async_phys_0.sg13g2_buf_1$1_2.X.n0 2.1125
R7254 sar_ctrl_async_phys_0.sg13g2_buf_1$1_2.X.n4 sar_ctrl_async_phys_0.sg13g2_buf_1$1_2.X.n3 1.8573
R7255 sar_ctrl_async_phys_0.dac_code_n[7].n0 sar_ctrl_async_phys_0.dac_code_n[7].t2 22.7331
R7256 sar_ctrl_async_phys_0.dac_code_n[7].n0 sar_ctrl_async_phys_0.dac_code_n[7].t1 21.1819
R7257 sar_ctrl_async_phys_0.dac_code_n[7] sar_ctrl_async_phys_0.dac_code_n[7].t0 5.73774
R7258 sar_ctrl_async_phys_0.dac_code_n[7] sar_ctrl_async_phys_0.dac_code_n[7].n0 1.4118
R7259 sar_ctrl_async_phys_0.sg13g2_o21ai_1$1_1.B1.t15 sar_ctrl_async_phys_0.sg13g2_o21ai_1$1_1.B1.t14 33.4028
R7260 sar_ctrl_async_phys_0.sg13g2_o21ai_1$1_1.B1.t6 sar_ctrl_async_phys_0.sg13g2_o21ai_1$1_1.B1.t5 33.4028
R7261 sar_ctrl_async_phys_0.sg13g2_o21ai_1$1_1.B1.t8 sar_ctrl_async_phys_0.sg13g2_o21ai_1$1_1.B1.t7 33.4028
R7262 sar_ctrl_async_phys_0.sg13g2_o21ai_1$1_1.B1.t2 sar_ctrl_async_phys_0.sg13g2_o21ai_1$1_1.B1.t1 33.4028
R7263 sar_ctrl_async_phys_0.sg13g2_o21ai_1$1_1.B1.t10 sar_ctrl_async_phys_0.sg13g2_o21ai_1$1_1.B1.t9 33.4028
R7264 sar_ctrl_async_phys_0.sg13g2_o21ai_1$1_1.B1.t4 sar_ctrl_async_phys_0.sg13g2_o21ai_1$1_1.B1.t3 33.4028
R7265 sar_ctrl_async_phys_0.sg13g2_o21ai_1$1_1.B1.t13 sar_ctrl_async_phys_0.sg13g2_o21ai_1$1_1.B1.t12 33.4028
R7266 sar_ctrl_async_phys_0.sg13g2_o21ai_1$1_1.B1.n0 sar_ctrl_async_phys_0.sg13g2_o21ai_1$1_1.B1 31.1009
R7267 sar_ctrl_async_phys_0.sg13g2_o21ai_1$1_1.B1 sar_ctrl_async_phys_0.sg13g2_o21ai_1$1_1.B1.n5 29.1346
R7268 sar_ctrl_async_phys_0.sg13g2_o21ai_1$1_1.B1.n2 sar_ctrl_async_phys_0.sg13g2_o21ai_1$1_1.B1 19.4759
R7269 sar_ctrl_async_phys_0.sg13g2_o21ai_1$1_1.B1.n3 sar_ctrl_async_phys_0.sg13g2_o21ai_1$1_1.B1 18.3671
R7270 sar_ctrl_async_phys_0.sg13g2_o21ai_1$1_1.B1.n5 sar_ctrl_async_phys_0.sg13g2_o21ai_1$1_1.B1 18.1954
R7271 sar_ctrl_async_phys_0.sg13g2_o21ai_1$1_1.B1 sar_ctrl_async_phys_0.sg13g2_o21ai_1$1_1.B1.t0 17.0317
R7272 sar_ctrl_async_phys_0.sg13g2_o21ai_1$1_1.B1 sar_ctrl_async_phys_0.sg13g2_o21ai_1$1_1.B1.t2 15.0489
R7273 sar_ctrl_async_phys_0.sg13g2_o21ai_1$1_1.B1 sar_ctrl_async_phys_0.sg13g2_o21ai_1$1_1.B1.t10 15.0489
R7274 sar_ctrl_async_phys_0.sg13g2_o21ai_1$1_1.B1 sar_ctrl_async_phys_0.sg13g2_o21ai_1$1_1.B1.t4 15.0489
R7275 sar_ctrl_async_phys_0.sg13g2_o21ai_1$1_1.B1 sar_ctrl_async_phys_0.sg13g2_o21ai_1$1_1.B1.t13 15.0489
R7276 sar_ctrl_async_phys_0.sg13g2_o21ai_1$1_1.B1 sar_ctrl_async_phys_0.sg13g2_o21ai_1$1_1.B1.t8 15.0489
R7277 sar_ctrl_async_phys_0.sg13g2_o21ai_1$1_1.B1 sar_ctrl_async_phys_0.sg13g2_o21ai_1$1_1.B1.t6 15.0489
R7278 sar_ctrl_async_phys_0.sg13g2_o21ai_1$1_1.B1 sar_ctrl_async_phys_0.sg13g2_o21ai_1$1_1.B1.t15 15.0489
R7279 sar_ctrl_async_phys_0.sg13g2_o21ai_1$1_1.B1 sar_ctrl_async_phys_0.sg13g2_o21ai_1$1_1.B1.t11 15.0005
R7280 sar_ctrl_async_phys_0.sg13g2_o21ai_1$1_1.B1.n0 sar_ctrl_async_phys_0.sg13g2_o21ai_1$1_1.B1 12.6671
R7281 sar_ctrl_async_phys_0.sg13g2_o21ai_1$1_1.B1.n5 sar_ctrl_async_phys_0.sg13g2_o21ai_1$1_1.B1.n4 11.9433
R7282 sar_ctrl_async_phys_0.sg13g2_o21ai_1$1_1.B1.n2 sar_ctrl_async_phys_0.sg13g2_o21ai_1$1_1.B1.n0 11.3237
R7283 sar_ctrl_async_phys_0.sg13g2_o21ai_1$1_1.B1.n1 sar_ctrl_async_phys_0.sg13g2_o21ai_1$1_1.B1 10.7847
R7284 sar_ctrl_async_phys_0.sg13g2_o21ai_1$1_1.B1.n4 sar_ctrl_async_phys_0.sg13g2_o21ai_1$1_1.B1.n1 10.6901
R7285 sar_ctrl_async_phys_0.sg13g2_o21ai_1$1_1.B1.n1 sar_ctrl_async_phys_0.sg13g2_o21ai_1$1_1.B1 10.6607
R7286 sar_ctrl_async_phys_0.sg13g2_o21ai_1$1_1.B1.n0 sar_ctrl_async_phys_0.sg13g2_o21ai_1$1_1.B1 9.53426
R7287 sar_ctrl_async_phys_0.sg13g2_o21ai_1$1_1.B1.t0 sar_ctrl_async_phys_0.sg13g2_o21ai_1$1_1.B1 8.62605
R7288 sar_ctrl_async_phys_0.sg13g2_o21ai_1$1_1.B1.n3 sar_ctrl_async_phys_0.sg13g2_o21ai_1$1_1.B1.n2 3.1685
R7289 sar_ctrl_async_phys_0.sg13g2_o21ai_1$1_1.B1.n4 sar_ctrl_async_phys_0.sg13g2_o21ai_1$1_1.B1.n3 1.5757
R7290 sar_ctrl_async_phys_0.dac_code_n[1].n0 sar_ctrl_async_phys_0.dac_code_n[1].t2 22.2379
R7291 sar_ctrl_async_phys_0.dac_code_n[1].n0 sar_ctrl_async_phys_0.dac_code_n[1].t1 21.1147
R7292 sar_ctrl_async_phys_0.dac_code_n[1] sar_ctrl_async_phys_0.dac_code_n[1].t0 17.0317
R7293 sar_ctrl_async_phys_0.dac_code_n[1].t0 sar_ctrl_async_phys_0.dac_code_n[1] 8.62605
R7294 sar_ctrl_async_phys_0.dac_code_n[1] sar_ctrl_async_phys_0.dac_code_n[1].n0 1.0378
R7295 sar_ctrl_async_phys_0.sg13g2_dfrbpq_1$1_0.CLK.n11 sar_ctrl_async_phys_0.sg13g2_dfrbpq_1$1_0.CLK 39.5117
R7296 sar_ctrl_async_phys_0.sg13g2_dfrbpq_1$1_0.CLK.n22 sar_ctrl_async_phys_0.sg13g2_dfrbpq_1$1_0.CLK 34.7591
R7297 sar_ctrl_async_phys_0.sg13g2_dfrbpq_1$1_0.CLK.n19 sar_ctrl_async_phys_0.sg13g2_dfrbpq_1$1_0.CLK 29.3237
R7298 sar_ctrl_async_phys_0.sg13g2_dfrbpq_1$1_0.CLK.n25 sar_ctrl_async_phys_0.sg13g2_dfrbpq_1$1_0.CLK 28.4806
R7299 sar_ctrl_async_phys_0.sg13g2_dfrbpq_1$1_0.CLK.n18 sar_ctrl_async_phys_0.sg13g2_dfrbpq_1$1_0.CLK.n17 23.2805
R7300 sar_ctrl_async_phys_0.sg13g2_dfrbpq_1$1_0.CLK.n2 sar_ctrl_async_phys_0.sg13g2_dfrbpq_1$1_0.CLK 21.5351
R7301 sar_ctrl_async_phys_0.sg13g2_dfrbpq_1$1_0.CLK.n1 sar_ctrl_async_phys_0.sg13g2_dfrbpq_1$1_0.CLK 21.3239
R7302 sar_ctrl_async_phys_0.sg13g2_dfrbpq_1$1_0.CLK.n15 sar_ctrl_async_phys_0.sg13g2_dfrbpq_1$1_0.CLK.n14 20.872
R7303 sar_ctrl_async_phys_0.sg13g2_dfrbpq_1$1_0.CLK.n2 sar_ctrl_async_phys_0.sg13g2_dfrbpq_1$1_0.CLK 20.1125
R7304 sar_ctrl_async_phys_0.sg13g2_dfrbpq_1$1_0.CLK.n12 sar_ctrl_async_phys_0.sg13g2_dfrbpq_1$1_0.CLK 19.8807
R7305 sar_ctrl_async_phys_0.sg13g2_dfrbpq_1$1_0.CLK.n21 sar_ctrl_async_phys_0.sg13g2_dfrbpq_1$1_0.CLK 19.4759
R7306 sar_ctrl_async_phys_0.sg13g2_dfrbpq_1$1_0.CLK.n11 sar_ctrl_async_phys_0.sg13g2_dfrbpq_1$1_0.CLK 19.2352
R7307 sar_ctrl_async_phys_0.sg13g2_dfrbpq_1$1_0.CLK sar_ctrl_async_phys_0.sg13g2_dfrbpq_1$1_0.CLK.n26 18.1823
R7308 sar_ctrl_async_phys_0.sg13g2_dfrbpq_1$1_0.CLK.n13 sar_ctrl_async_phys_0.sg13g2_dfrbpq_1$1_0.CLK 18.1823
R7309 sar_ctrl_async_phys_0.sg13g2_dfrbpq_1$1_0.CLK.n0 sar_ctrl_async_phys_0.sg13g2_dfrbpq_1$1_0.CLK 18.0005
R7310 sar_ctrl_async_phys_0.sg13g2_dfrbpq_1$1_0.CLK.n4 sar_ctrl_async_phys_0.sg13g2_dfrbpq_1$1_0.CLK 18.0005
R7311 sar_ctrl_async_phys_0.sg13g2_dfrbpq_1$1_0.CLK sar_ctrl_async_phys_0.sg13g2_dfrbpq_1$1_0.CLK.t15 15.0222
R7312 sar_ctrl_async_phys_0.sg13g2_dfrbpq_1$1_0.CLK sar_ctrl_async_phys_0.sg13g2_dfrbpq_1$1_0.CLK.t21 15.0214
R7313 sar_ctrl_async_phys_0.sg13g2_dfrbpq_1$1_0.CLK sar_ctrl_async_phys_0.sg13g2_dfrbpq_1$1_0.CLK.t12 15.0197
R7314 sar_ctrl_async_phys_0.sg13g2_dfrbpq_1$1_0.CLK sar_ctrl_async_phys_0.sg13g2_dfrbpq_1$1_0.CLK.t1 15.0022
R7315 sar_ctrl_async_phys_0.sg13g2_dfrbpq_1$1_0.CLK sar_ctrl_async_phys_0.sg13g2_dfrbpq_1$1_0.CLK.t6 15.0022
R7316 sar_ctrl_async_phys_0.sg13g2_dfrbpq_1$1_0.CLK sar_ctrl_async_phys_0.sg13g2_dfrbpq_1$1_0.CLK.t8 15.0022
R7317 sar_ctrl_async_phys_0.sg13g2_dfrbpq_1$1_0.CLK sar_ctrl_async_phys_0.sg13g2_dfrbpq_1$1_0.CLK.t13 15.0022
R7318 sar_ctrl_async_phys_0.sg13g2_dfrbpq_1$1_0.CLK sar_ctrl_async_phys_0.sg13g2_dfrbpq_1$1_0.CLK.t10 15.0022
R7319 sar_ctrl_async_phys_0.sg13g2_dfrbpq_1$1_0.CLK sar_ctrl_async_phys_0.sg13g2_dfrbpq_1$1_0.CLK.t9 15.0022
R7320 sar_ctrl_async_phys_0.sg13g2_dfrbpq_1$1_0.CLK sar_ctrl_async_phys_0.sg13g2_dfrbpq_1$1_0.CLK.t14 15.0022
R7321 sar_ctrl_async_phys_0.sg13g2_dfrbpq_1$1_0.CLK sar_ctrl_async_phys_0.sg13g2_dfrbpq_1$1_0.CLK.t26 15.0022
R7322 sar_ctrl_async_phys_0.sg13g2_dfrbpq_1$1_0.CLK sar_ctrl_async_phys_0.sg13g2_dfrbpq_1$1_0.CLK.t24 15.0022
R7323 sar_ctrl_async_phys_0.sg13g2_dfrbpq_1$1_0.CLK sar_ctrl_async_phys_0.sg13g2_dfrbpq_1$1_0.CLK.t22 15.0022
R7324 sar_ctrl_async_phys_0.sg13g2_dfrbpq_1$1_0.CLK sar_ctrl_async_phys_0.sg13g2_dfrbpq_1$1_0.CLK.t17 15.0022
R7325 sar_ctrl_async_phys_0.sg13g2_dfrbpq_1$1_0.CLK sar_ctrl_async_phys_0.sg13g2_dfrbpq_1$1_0.CLK.t20 15.0022
R7326 sar_ctrl_async_phys_0.sg13g2_dfrbpq_1$1_0.CLK sar_ctrl_async_phys_0.sg13g2_dfrbpq_1$1_0.CLK.t28 15.0022
R7327 sar_ctrl_async_phys_0.sg13g2_dfrbpq_1$1_0.CLK sar_ctrl_async_phys_0.sg13g2_dfrbpq_1$1_0.CLK.t25 15.0022
R7328 sar_ctrl_async_phys_0.sg13g2_dfrbpq_1$1_0.CLK sar_ctrl_async_phys_0.sg13g2_dfrbpq_1$1_0.CLK.t27 15.0022
R7329 sar_ctrl_async_phys_0.sg13g2_dfrbpq_1$1_0.CLK sar_ctrl_async_phys_0.sg13g2_dfrbpq_1$1_0.CLK.t29 15.0022
R7330 sar_ctrl_async_phys_0.sg13g2_dfrbpq_1$1_0.CLK sar_ctrl_async_phys_0.sg13g2_dfrbpq_1$1_0.CLK.t30 15.0022
R7331 sar_ctrl_async_phys_0.sg13g2_dfrbpq_1$1_0.CLK sar_ctrl_async_phys_0.sg13g2_dfrbpq_1$1_0.CLK.t16 15.0022
R7332 sar_ctrl_async_phys_0.sg13g2_dfrbpq_1$1_0.CLK sar_ctrl_async_phys_0.sg13g2_dfrbpq_1$1_0.CLK.t18 15.0022
R7333 sar_ctrl_async_phys_0.sg13g2_dfrbpq_1$1_0.CLK sar_ctrl_async_phys_0.sg13g2_dfrbpq_1$1_0.CLK.t19 15.0022
R7334 sar_ctrl_async_phys_0.sg13g2_dfrbpq_1$1_0.CLK sar_ctrl_async_phys_0.sg13g2_dfrbpq_1$1_0.CLK.t11 15.0022
R7335 sar_ctrl_async_phys_0.sg13g2_dfrbpq_1$1_0.CLK sar_ctrl_async_phys_0.sg13g2_dfrbpq_1$1_0.CLK.t4 15.0022
R7336 sar_ctrl_async_phys_0.sg13g2_dfrbpq_1$1_0.CLK sar_ctrl_async_phys_0.sg13g2_dfrbpq_1$1_0.CLK.t3 15.0022
R7337 sar_ctrl_async_phys_0.sg13g2_dfrbpq_1$1_0.CLK sar_ctrl_async_phys_0.sg13g2_dfrbpq_1$1_0.CLK.t7 15.0022
R7338 sar_ctrl_async_phys_0.sg13g2_dfrbpq_1$1_0.CLK sar_ctrl_async_phys_0.sg13g2_dfrbpq_1$1_0.CLK.t5 15.0022
R7339 sar_ctrl_async_phys_0.sg13g2_dfrbpq_1$1_0.CLK sar_ctrl_async_phys_0.sg13g2_dfrbpq_1$1_0.CLK.t2 15.0005
R7340 sar_ctrl_async_phys_0.sg13g2_dfrbpq_1$1_0.CLK sar_ctrl_async_phys_0.sg13g2_dfrbpq_1$1_0.CLK.t23 15.0005
R7341 sar_ctrl_async_phys_0.sg13g2_dfrbpq_1$1_0.CLK.n1 sar_ctrl_async_phys_0.sg13g2_dfrbpq_1$1_0.CLK.n8 13.6439
R7342 sar_ctrl_async_phys_0.sg13g2_dfrbpq_1$1_0.CLK.n5 sar_ctrl_async_phys_0.sg13g2_dfrbpq_1$1_0.CLK.n4 13.5999
R7343 sar_ctrl_async_phys_0.sg13g2_dfrbpq_1$1_0.CLK.n0 sar_ctrl_async_phys_0.sg13g2_dfrbpq_1$1_0.CLK.n22 13.5009
R7344 sar_ctrl_async_phys_0.sg13g2_dfrbpq_1$1_0.CLK.n14 sar_ctrl_async_phys_0.sg13g2_dfrbpq_1$1_0.CLK.n13 13.0133
R7345 sar_ctrl_async_phys_0.sg13g2_dfrbpq_1$1_0.CLK.n23 sar_ctrl_async_phys_0.sg13g2_dfrbpq_1$1_0.CLK.n0 12.3239
R7346 sar_ctrl_async_phys_0.sg13g2_dfrbpq_1$1_0.CLK.n4 sar_ctrl_async_phys_0.sg13g2_dfrbpq_1$1_0.CLK.n3 12.3239
R7347 sar_ctrl_async_phys_0.sg13g2_dfrbpq_1$1_0.CLK.n1 sar_ctrl_async_phys_0.sg13g2_dfrbpq_1$1_0.CLK.n20 12.3239
R7348 sar_ctrl_async_phys_0.sg13g2_dfrbpq_1$1_0.CLK.n26 sar_ctrl_async_phys_0.sg13g2_dfrbpq_1$1_0.CLK.n25 12.004
R7349 sar_ctrl_async_phys_0.sg13g2_dfrbpq_1$1_0.CLK.n10 sar_ctrl_async_phys_0.sg13g2_dfrbpq_1$1_0.CLK 11.0157
R7350 sar_ctrl_async_phys_0.sg13g2_dfrbpq_1$1_0.CLK.n26 sar_ctrl_async_phys_0.sg13g2_dfrbpq_1$1_0.CLK.n24 10.9013
R7351 sar_ctrl_async_phys_0.sg13g2_dfrbpq_1$1_0.CLK.n9 sar_ctrl_async_phys_0.sg13g2_dfrbpq_1$1_0.CLK 10.8573
R7352 sar_ctrl_async_phys_0.sg13g2_dfrbpq_1$1_0.CLK.n6 sar_ctrl_async_phys_0.sg13g2_dfrbpq_1$1_0.CLK 10.6461
R7353 sar_ctrl_async_phys_0.sg13g2_dfrbpq_1$1_0.CLK.n3 sar_ctrl_async_phys_0.sg13g2_dfrbpq_1$1_0.CLK.n2 10.4759
R7354 sar_ctrl_async_phys_0.sg13g2_dfrbpq_1$1_0.CLK.n25 sar_ctrl_async_phys_0.sg13g2_dfrbpq_1$1_0.CLK 10.4759
R7355 sar_ctrl_async_phys_0.sg13g2_dfrbpq_1$1_0.CLK.n10 sar_ctrl_async_phys_0.sg13g2_dfrbpq_1$1_0.CLK 9.00222
R7356 sar_ctrl_async_phys_0.sg13g2_dfrbpq_1$1_0.CLK.n22 sar_ctrl_async_phys_0.sg13g2_dfrbpq_1$1_0.CLK 9.0005
R7357 sar_ctrl_async_phys_0.sg13g2_dfrbpq_1$1_0.CLK.n5 sar_ctrl_async_phys_0.sg13g2_dfrbpq_1$1_0.CLK 9.0005
R7358 sar_ctrl_async_phys_0.sg13g2_dfrbpq_1$1_0.CLK.n3 sar_ctrl_async_phys_0.sg13g2_dfrbpq_1$1_0.CLK 9.0005
R7359 sar_ctrl_async_phys_0.sg13g2_dfrbpq_1$1_0.CLK.n23 sar_ctrl_async_phys_0.sg13g2_dfrbpq_1$1_0.CLK 9.0005
R7360 sar_ctrl_async_phys_0.sg13g2_dfrbpq_1$1_0.CLK.n8 sar_ctrl_async_phys_0.sg13g2_dfrbpq_1$1_0.CLK 9.0005
R7361 sar_ctrl_async_phys_0.sg13g2_dfrbpq_1$1_0.CLK.n7 sar_ctrl_async_phys_0.sg13g2_dfrbpq_1$1_0.CLK 9.0005
R7362 sar_ctrl_async_phys_0.sg13g2_dfrbpq_1$1_0.CLK.n6 sar_ctrl_async_phys_0.sg13g2_dfrbpq_1$1_0.CLK 9.0005
R7363 sar_ctrl_async_phys_0.sg13g2_dfrbpq_1$1_0.CLK.n20 sar_ctrl_async_phys_0.sg13g2_dfrbpq_1$1_0.CLK 9.0005
R7364 sar_ctrl_async_phys_0.sg13g2_dfrbpq_1$1_0.CLK.n18 sar_ctrl_async_phys_0.sg13g2_dfrbpq_1$1_0.CLK 9.0005
R7365 sar_ctrl_async_phys_0.sg13g2_dfrbpq_1$1_0.CLK.n9 sar_ctrl_async_phys_0.sg13g2_dfrbpq_1$1_0.CLK 9.0005
R7366 sar_ctrl_async_phys_0.sg13g2_dfrbpq_1$1_0.CLK.n16 sar_ctrl_async_phys_0.sg13g2_dfrbpq_1$1_0.CLK 9.0005
R7367 sar_ctrl_async_phys_0.sg13g2_dfrbpq_1$1_0.CLK.n15 sar_ctrl_async_phys_0.sg13g2_dfrbpq_1$1_0.CLK 9.0005
R7368 sar_ctrl_async_phys_0.sg13g2_dfrbpq_1$1_0.CLK sar_ctrl_async_phys_0.sg13g2_dfrbpq_1$1_0.CLK.t0 5.62849
R7369 sar_ctrl_async_phys_0.sg13g2_dfrbpq_1$1_0.CLK.n7 sar_ctrl_async_phys_0.sg13g2_dfrbpq_1$1_0.CLK.n6 5.4653
R7370 sar_ctrl_async_phys_0.sg13g2_dfrbpq_1$1_0.CLK.n24 sar_ctrl_async_phys_0.sg13g2_dfrbpq_1$1_0.CLK.n5 4.23026
R7371 sar_ctrl_async_phys_0.sg13g2_dfrbpq_1$1_0.CLK.n16 sar_ctrl_async_phys_0.sg13g2_dfrbpq_1$1_0.CLK.n15 3.61426
R7372 sar_ctrl_async_phys_0.sg13g2_dfrbpq_1$1_0.CLK.n8 sar_ctrl_async_phys_0.sg13g2_dfrbpq_1$1_0.CLK.n7 3.4501
R7373 sar_ctrl_async_phys_0.sg13g2_dfrbpq_1$1_0.CLK.n20 sar_ctrl_async_phys_0.sg13g2_dfrbpq_1$1_0.CLK.n19 3.44706
R7374 sar_ctrl_async_phys_0.sg13g2_dfrbpq_1$1_0.CLK.n13 sar_ctrl_async_phys_0.sg13g2_dfrbpq_1$1_0.CLK.n12 3.1685
R7375 sar_ctrl_async_phys_0.sg13g2_dfrbpq_1$1_0.CLK.n21 sar_ctrl_async_phys_0.sg13g2_dfrbpq_1$1_0.CLK.n1 3.1685
R7376 sar_ctrl_async_phys_0.sg13g2_dfrbpq_1$1_0.CLK.n0 sar_ctrl_async_phys_0.sg13g2_dfrbpq_1$1_0.CLK.n21 3.1685
R7377 sar_ctrl_async_phys_0.sg13g2_dfrbpq_1$1_0.CLK.n24 sar_ctrl_async_phys_0.sg13g2_dfrbpq_1$1_0.CLK.n23 2.58466
R7378 sar_ctrl_async_phys_0.sg13g2_dfrbpq_1$1_0.CLK.n17 sar_ctrl_async_phys_0.sg13g2_dfrbpq_1$1_0.CLK.n9 2.01266
R7379 sar_ctrl_async_phys_0.sg13g2_dfrbpq_1$1_0.CLK.n14 sar_ctrl_async_phys_0.sg13g2_dfrbpq_1$1_0.CLK.n10 1.88066
R7380 sar_ctrl_async_phys_0.sg13g2_dfrbpq_1$1_0.CLK.n19 sar_ctrl_async_phys_0.sg13g2_dfrbpq_1$1_0.CLK.n18 1.84242
R7381 sar_ctrl_async_phys_0.sg13g2_dfrbpq_1$1_0.CLK.n12 sar_ctrl_async_phys_0.sg13g2_dfrbpq_1$1_0.CLK.n11 1.47586
R7382 sar_ctrl_async_phys_0.sg13g2_dfrbpq_1$1_0.CLK.n17 sar_ctrl_async_phys_0.sg13g2_dfrbpq_1$1_0.CLK.n16 1.43186
C0 sar_ctrl_async_phys_0.sg13g2_buf_1$1_3.A a_31830_40898# 0.02115f
C1 sar_ctrl_async_phys_0.sg13g2_buf_1$1_4.A sar_ctrl_async_phys_0.bit_active[3] 1.29612f
C2 sar_ctrl_async_phys_0.dac_code_n[0] sar_ctrl_async_phys_0.sample 0.05119f
C3 sar_ctrl_async_phys_0.sg13g2_dfrbpq_1$1_0.CLK sar_ctrl_async_phys_0.sg13g2_buf_1$1_17.A 0.06836f
C4 sar_ctrl_async_phys_0.sg13g2_dfrbpq_1$1_0.CLK sar_ctrl_async_phys_0.sg13g2_buf_1$1_0.A 0.13437f
C5 sar_ctrl_async_phys_0.sg13g2_a22oi_1$1_1.A2 a_34308_37400# 0.06859f
C6 sar_ctrl_async_phys_0.sg13g2_buf_1$1_6.X a_32991_35239# 0.13292f
C7 sar_ctrl_async_phys_0.sg13g2_nor2b_1$1_0.A a_34596_40424# 0.06155f
C8 oa_sar8_acore18_opt_0.sw_bitcell_opt_b2_0.bot a_35948_n9612# 0.02825f
C9 sar_ctrl_async_phys_0.sg13g2_nor2_1$1_5.A a_29236_38952# 0.06255f
C10 sar_ctrl_async_phys_0.sg13g2_dlygate4sd3_1$1_3.A a_28774_41278# 0.16397f
C11 sar_ctrl_async_phys_0.dac_code_n[4] oa_sar8_acore18_opt_0.sw_bitcell_opt_b4_0.bot 0.183f
C12 a_33652_41528# a_34911_41287# 0.01529f
C13 sar_ctrl_async_phys_0.sg13g2_nor4_1$1_0.C sar_ctrl_async_phys_0.sg13g2_a21oi_1$1_4.B1 0.04052f
C14 sar_ctrl_async_phys_0.sg13g2_buf_1$1_42.A sar_ctrl_async_phys_0.sg13g2_a21oi_1$1_6.B1 0.35755f
C15 a_33654_44234# a_34357_44213# 0.02454f
C16 sar_ctrl_async_phys_0.sg13g2_buf_1$1_17.A a_31446_35162# 0.0325f
C17 sar_ctrl_async_phys_0.sg13g2_nor2b_1$1_0.Y a_31828_37440# 0.03477f
C18 sar_ctrl_async_phys_0.sg13g2_a21oi_1$1_3.B1 sar_ctrl_async_phys_0.sg13g2_nand2b_1$1_1.B 0.14677f
C19 sar_ctrl_async_phys_0.sg13g2_buf_1$1_14.A a_33844_36992# 0.01963f
C20 sar_ctrl_async_phys_0.sg13g2_buf_1$1_2.A a_33211_45868# 0.01015f
C21 sar_ctrl_async_phys_0.sg13g2_a21oi_1$1_0.A1 sar_ctrl_async_phys_0.sg13g2_and2_1$1_6.X 0.18222f
C22 a_33168_32986# VDD 0.07556f
C23 sar_ctrl_async_phys_0.sg13g2_a21oi_1$1_6.A2 a_33211_45868# 0.01263f
C24 a_32576_44454# a_32986_44532# 0.10373f
C25 sar_ctrl_async_phys_0.sg13g2_nand2_1$1_3.B a_34459_44356# 0.0102f
C26 sar_ctrl_async_phys_0.sg13g2_nand2_1$1_3.A sar_ctrl_async_phys_0.sg13g2_buf_1$1_36.A 0.63341f
C27 a_31644_36638# VDD 0.29593f
C28 sar_ctrl_async_phys_0.sg13g2_a22oi_1$1_1.A2 a_33844_36992# 0.01397f
C29 sar_ctrl_async_phys_0.sg13g2_buf_1$1_15.A a_34911_41287# 0.01211f
C30 a_32406_45746# VDD 0.78889f
C31 sar_ctrl_async_phys_0.sample sar_ctrl_async_phys_0.dac_code_n[7] 0.04555f
C32 sar_ctrl_async_phys_0.hold_req track 0.05885f
C33 sar_ctrl_async_phys_0.sg13g2_nor4_1$1_0.C a_31830_40898# 0.01032f
C34 sar_ctrl_async_phys_0.sg13g2_nor2_1$1_4.Y sar_ctrl_async_phys_0.sg13g2_nor4_1$1_0.Y 0.02487f
C35 sar_ctrl_async_phys_0.dac_code[0] oa_sar8_acore18_opt_0.sw_bitcell_opt_term_0.trkb 1.76704f
C36 sar_ctrl_async_phys_0.cmp_fire sar_ctrl_async_phys_0.cmp_p 1.21544f
C37 sar_ctrl_async_phys_0.sg13g2_nor2b_1$1_0.A sar_ctrl_async_phys_0.sg13g2_buf_1$1_13.A 0.10232f
C38 a_32533_40471# a_33281_40821# 0.01058f
C39 sar_ctrl_async_phys_0.dac_code_n[6] oa_sar8_acore18_opt_0.sw_tg_opt_0.bot 0.61835f
C40 sar_ctrl_async_phys_0.bit_active[5] sar_ctrl_async_phys_0.bit_active[4] 0.11794f
C41 oa_sar8_acore18_opt_0.sw_bitcell_opt_term_0.trkb oa_sar8_acore18_opt_0.sw_bitcell_opt_b6_1.bot 1.52713f
C42 sar_ctrl_async_phys_0.sg13g2_a21oi_1$1_0.A2 a_35009_36751# 0.01786f
C43 a_35360_43726# a_35103_43845# 0.34468f
C44 sar_ctrl_async_phys_0.sg13g2_dfrbpq_1$1_0.CLK sar_ctrl_async_phys_0.sg13g2_and2_1$1_6.X 2.41438f
C45 sar_ctrl_async_phys_0.dac_code[0] sar_ctrl_async_phys_0.cmp_n 0.07678f
C46 oa_sar8_acore18_opt_0.sw_bitcell_opt_b7_0.bot VDD 5.14569f
C47 sar_ctrl_async_phys_0.sg13g2_nor2b_1$1_0.A a_31140_42690# 0.07148f
C48 oa_sar8_acore18_opt_0.sw_bitcell_opt_term_0.bot m3_38288_n2380# 0.02173f
C49 a_28392_41214# VDD 0.31323f
C50 sar_ctrl_async_phys_0.sg13g2_buf_1$1_42.A sar_ctrl_async_phys_0.sg13g2_nand2b_1$1_1.B 0.02706f
C51 sar_ctrl_async_phys_0.sg13g2_a22oi_1$1_0.B1 a_30229_33629# 0.05907f
C52 sar_ctrl_async_phys_0.sg13g2_nor2_1$1_14.A sar_ctrl_async_phys_0.sg13g2_and2_1$1_3.X 0.07715f
C53 sar_ctrl_async_phys_0.sg13g2_buf_1$1_6.X a_34268_31826# 0.13787f
C54 a_32696_30664# rst_n 0.27018f
C55 sar_ctrl_async_phys_0.sg13g2_buf_1$1_6.X sar_ctrl_async_phys_0.sg13g2_a22oi_1$1_2.Y 0.21219f
C56 sar_ctrl_async_phys_0.dac_code[2] oa_sar8_acore18_opt_0.sw_bitcell_opt_term_0.vin 1.77777f
C57 sar_ctrl_async_phys_0.sg13g2_a21oi_1$1_5.Y a_31732_35480# 0.02554f
C58 sar_ctrl_async_phys_0.sg13g2_nand2_1$1_5.B sar_ctrl_async_phys_0.sg13g2_nand2_1$1_3.Y 0.38867f
C59 sar_ctrl_async_phys_0.sg13g2_a22oi_1$1_0.B2 a_33080_30664# 0.01367f
C60 sar_ctrl_async_phys_0.sg13g2_a21oi_1$1_5.Y a_31706_35385# 0.01293f
C61 sar_ctrl_async_phys_0.sg13g2_nor2b_1$1_0.A sar_ctrl_async_phys_0.sg13g2_nor2_1$1_2.Y 0.05618f
C62 sar_ctrl_async_phys_0.sg13g2_nand2b_1$1_3.Y a_34459_44356# 0.02726f
C63 sar_ctrl_async_phys_0.sg13g2_nor2b_1$1_0.A a_33973_39677# 0.04161f
C64 sar_ctrl_async_phys_0.dac_code[0] oa_sar8_acore18_opt_0.sw_bitcell_opt_b4_0.bot 0.37225f
C65 sar_ctrl_async_phys_0.sg13g2_a22oi_1$1_3.A2 a_32993_37797# 0.01641f
C66 a_35103_36751# a_35770_36972# 0.0894f
C67 a_34261_36653# a_35009_36751# 0.01058f
C68 a_30650_39921# VDD 0.09561f
C69 sar_ctrl_async_phys_0.bit_active[1] busy 0.0324f
C70 oa_sar8_acore18_opt_0.sw_bitcell_opt_b0_1.bot oa_sar8_acore18_opt_0.sw_bitcell_opt_b7_1.VSS 1.43554f
C71 oa_sar8_acore18_opt_0.sw_bitcell_opt_b7_0.bot oa_sar8_acore18_opt_0.sw_bitcell_opt_b6_0.bot 11.9275f
C72 sar_ctrl_async_phys_0.sg13g2_a22oi_1$1_4.A2 sar_ctrl_async_phys_0.sg13g2_a22oi_1$1_0.B1 0.25109f
C73 sar_ctrl_async_phys_0.sg13g2_nand2b_1$1_3.Y a_34596_40424# 0.04323f
C74 a_30139_43495# a_30879_43845# 0.26905f
C75 sar_ctrl_async_phys_0.sg13g2_nor2b_1$1_4.Y a_31933_43832# 0.01137f
C76 sar_ctrl_async_phys_0.dac_code_n[0] oa_sar8_acore18_opt_0.sw_tg_opt_0.bot 0.19921f
C77 sar_ctrl_async_phys_0.sg13g2_and2_1$1_6.X a_32116_40464# 0.04283f
C78 sar_ctrl_async_phys_0.sg13g2_nor2b_1$1_4.Y a_30879_43845# 0.04202f
C79 sar_ctrl_async_phys_0.sg13g2_inv_1$1_5.A a_30591_32215# 0.02377f
C80 sar_ctrl_async_phys_0.sg13g2_a21oi_1$1_6.B1 a_32580_43448# 0.03224f
C81 sar_ctrl_async_phys_0.sg13g2_buf_1$1_36.A a_35725_45266# 0.04579f
C82 sar_ctrl_async_phys_0.sg13g2_dfrbpq_1$1_0.CLK a_32149_35141# 0.28277f
C83 sar_ctrl_async_phys_0.dac_code[4] oa_sar8_acore18_opt_0.sw_bitcell_opt_b5_0.bot 0.61154f
C84 sar_ctrl_async_phys_0.sg13g2_nor2_1$1_10.B sar_ctrl_async_phys_0.sg13g2_nor2_1$1_7.A 0.01036f
C85 sar_ctrl_async_phys_0.sg13g2_dfrbpq_1$1_0.CLK sar_ctrl_async_phys_0.sg13g2_buf_1$1_6.X 1.64461f
C86 sar_ctrl_async_phys_0.sg13g2_dlygate4sd3_1$1_5.A sar_ctrl_async_phys_0.sg13g2_nor4_1$1_0.Y 0.08906f
C87 sar_ctrl_async_phys_0.sg13g2_buf_1$1_41.X a_34459_44356# 0.42139f
C88 sar_ctrl_async_phys_0.sg13g2_buf_1$1_32.A a_33844_43488# 0.01977f
C89 a_34895_32460# VDD 0.30539f
C90 a_31828_37440# VDD 0.07822f
C91 sar_ctrl_async_phys_0.sg13g2_a22oi_1$1_0.B2 VDD 0.85385f
C92 a_31446_35162# a_32149_35141# 0.02454f
C93 a_28272_37522# VDD 0.09419f
C94 sar_ctrl_async_phys_0.dac_code_n[4] oa_sar8_acore18_opt_0.sw_bitcell_opt_b0_0.bot 0.0829f
C95 sar_ctrl_async_phys_0.sg13g2_dfrbpq_1$1_0.CLK a_30584_44366# 0.01517f
C96 sar_ctrl_async_phys_0.sg13g2_nor2_1$1_10.Y a_30785_43845# 0.01691f
C97 sar_ctrl_async_phys_0.sg13g2_o21ai_1$1_1.B1 a_34911_41287# 0.13293f
C98 sar_ctrl_async_phys_0.sg13g2_buf_1$1_6.X a_31446_35162# 0.08508f
C99 a_31706_35385# a_31732_35480# 0.36952f
C100 a_34520_47296# sar_ctrl_async_phys_0.cmp_fault 0.10039f
C101 sar_ctrl_async_phys_0.sg13g2_a21oi_1$1_0.B1 sar_ctrl_async_phys_0.sg13g2_a21oi_1$1_4.B1 0.02366f
C102 oa_sar8_acore18_opt_0.sw_bitcell_opt_term_1.bot oa_sar8_acore18_opt_0.sw_bitcell_opt_term_0.trkb 1.39215f
C103 a_26728_37416# VDD 0.0182f
C104 a_33626_41433# a_33366_41210# 0.75507f
C105 sar_ctrl_async_phys_0.sg13g2_a21oi_1$1_3.B1 sar_ctrl_async_phys_0.sg13g2_nand2_1$1_5.Y 0.21319f
C106 sar_ctrl_async_phys_0.dac_code_n[7] oa_sar8_acore18_opt_0.sw_tg_opt_0.bot 0.87453f
C107 a_30507_35204# a_30830_35166# 0.43036f
C108 sar_ctrl_async_phys_0.sg13g2_buf_1$1_4.A a_35672_33688# 0.01344f
C109 sar_ctrl_async_phys_0.sg13g2_nand2_1$1_2.Y sar_ctrl_async_phys_0.dac_code[6] 0.02086f
C110 sar_ctrl_async_phys_0.sg13g2_a22oi_1$1_2.A2 sar_ctrl_async_phys_0.sg13g2_buf_1$1_20.A 0.2065f
C111 sar_ctrl_async_phys_0.sg13g2_nand2b_1$1_3.Y sar_ctrl_async_phys_0.sg13g2_buf_1$1_13.A 0.0204f
C112 sar_ctrl_async_phys_0.sg13g2_a21oi_1$1_1.B1 sar_ctrl_async_phys_0.dac_code[1] 0.03225f
C113 sar_ctrl_async_phys_0.sg13g2_a22oi_1$1_2.A2 sar_ctrl_async_phys_0.sg13g2_nor2b_1$1_0.A 0.19746f
C114 sar_ctrl_async_phys_0.sg13g2_dfrbpq_1$1_0.CLK sar_ctrl_async_phys_0.sg13g2_a22oi_1$1_1.B2 0.15795f
C115 sar_ctrl_async_phys_0.hold_req sar_ctrl_async_phys_0.cmp_p 0.26979f
C116 oa_sar8_acore18_opt_0.sw_bitcell_opt_b1_1.bot oa_sar8_acore18_opt_0.bstrap_opt_w2_c1200_1.gb 0.63917f
C117 sar_ctrl_async_phys_0.sg13g2_nand2_1$1_3.A sar_ctrl_async_phys_0.sg13g2_buf_1$1_46.A 0.33559f
C118 sar_ctrl_async_phys_0.sg13g2_a21oi_1$1_0.A2 a_35552_36166# 0.01337f
C119 sar_ctrl_async_phys_0.dac_code_n[3] sar_ctrl_async_phys_0.dac_code_n[6] 0.69545f
C120 a_31060_44552# a_32319_44311# 0.01529f
C121 sar_ctrl_async_phys_0.sg13g2_inv_1$1_0.Y a_36056_32176# 0.08986f
C122 sar_ctrl_async_phys_0.dac_code_n[2] oa_sar8_acore18_opt_0.sw_tg_opt_1.bot 0.07593f
C123 sar_ctrl_async_phys_0.sg13g2_buf_1$1_3.A done 0.1657f
C124 sar_ctrl_async_phys_0.sg13g2_buf_1$1_6.X sar_ctrl_async_phys_0.sg13g2_inv_1$1_5.Y 0.122f
C125 sar_ctrl_async_phys_0.sg13g2_buf_1$1_13.A a_32984_39830# 0.01777f
C126 oa_sar8_acore18_opt_0.sw_bitcell_opt_b0_1.bot oa_sar8_acore18_opt_0.sw_bitcell_opt_b2_1.bot 0.33786f
C127 sar_ctrl_async_phys_0.sg13g2_nand2b_1$1_3.Y sar_ctrl_async_phys_0.sg13g2_nor2_1$1_2.Y 0.01175f
C128 a_31830_40898# a_32635_40471# 0.097f
C129 sar_ctrl_async_phys_0.dac_code[0] m3_57896_n2380# 0.04356f
C130 a_33844_43488# a_34132_43909# 0.43707f
C131 sar_ctrl_async_phys_0.sg13g2_buf_1$1_42.A a_33109_45725# 0.01431f
C132 a_29332_32456# a_30497_32215# 0.43239f
C133 a_30591_32215# a_30848_32358# 0.34468f
C134 a_29851_32260# a_29620_32151# 0.12701f
C135 sar_ctrl_async_phys_0.dac_code[4] sar_ctrl_async_phys_0.dac_code[7] 0.07523f
C136 sar_ctrl_async_phys_0.sg13g2_a21oi_1$1_4.B1 a_31563_43020# 0.02707f
C137 sar_ctrl_async_phys_0.sg13g2_buf_1$1_6.X a_31291_31399# 0.43481f
C138 sar_ctrl_async_phys_0.bit_active[6] sar_ctrl_async_phys_0.sg13g2_buf_1$1_21.A 0.84716f
C139 sar_ctrl_async_phys_0.sg13g2_and2_1$1_0.X sar_ctrl_async_phys_0.sg13g2_buf_1$1_21.A 0.06162f
C140 sar_ctrl_async_phys_0.dac_code[0] oa_sar8_acore18_opt_0.sw_bitcell_opt_b0_0.bot 1.43525f
C141 sar_ctrl_async_phys_0.dac_code_n[0] sar_ctrl_async_phys_0.dac_code_n[3] 0.15089f
C142 sar_ctrl_async_phys_0.sg13g2_a21oi_1$1_0.A1 sar_ctrl_async_phys_0.dac_code[6] 0.16095f
C143 sar_ctrl_async_phys_0.dac_code_n[4] oa_sar8_acore18_opt_0.sw_bitcell_opt_b0_1.bot 0.06598f
C144 sar_ctrl_async_phys_0.sg13g2_inv_1$1_0.A a_33183_32215# 0.0178f
C145 sar_ctrl_async_phys_0.dac_code_n[6] vcm 0.06598f
C146 sar_ctrl_async_phys_0.sg13g2_buf_1$1_41.X sar_ctrl_async_phys_0.sg13g2_nor2_1$1_2.Y 0.09039f
C147 oa_sar8_acore18_opt_0.sw_bitcell_opt_b7_0.bot oa_sar8_acore18_opt_0.sw_bitcell_opt_b2_0.bot 0.96738f
C148 oa_sar8_acore18_opt_0.sw_bitcell_opt_b4_1.bot oa_sar8_acore18_opt_0.sw_bitcell_opt_b7_1.VSS 1.92639f
C149 oa_sar8_acore18_opt_0.sw_bitcell_opt_term_0.vin oa_sar8_acore18_opt_0.sw_bitcell_opt_b3_0.bot 3.98018f
C150 sar_ctrl_async_phys_0.sg13g2_a22oi_1$1_0.B1 sar_ctrl_async_phys_0.sg13g2_inv_1$1_0.A 0.09394f
C151 a_34651_30748# a_34420_30639# 0.12701f
C152 a_34132_30944# a_35297_30703# 0.43239f
C153 a_35391_30703# a_35648_30846# 0.34468f
C154 a_30964_46512# a_31252_46933# 0.43707f
C155 a_28176_39830# VDD 0.08876f
C156 a_29620_43488# a_30785_43845# 0.43239f
C157 a_33818_36897# a_34261_36653# 0.02242f
C158 a_29620_43488# a_29908_43909# 0.43707f
C159 sar_ctrl_async_phys_0.dac_code[4] oa_sar8_acore18_opt_0.sw_bitcell_opt_b1_0.bot 0.1489f
C160 sar_ctrl_async_phys_0.sg13g2_nor2_1$1_10.A a_29232_43570# 0.03037f
C161 result[4] busy 0.02556f
C162 sar_ctrl_async_phys_0.dac_code_n[4] a_35948_n9612# 0.04813f
C163 sar_ctrl_async_phys_0.sg13g2_nand2_1$1_5.B VDD 0.82077f
C164 sar_ctrl_async_phys_0.sg13g2_dlygate4sd3_1$1_7.A a_25608_40501# 0.41651f
C165 sar_ctrl_async_phys_0.sg13g2_nand2b_1$1_3.Y sar_ctrl_async_phys_0.sg13g2_a22oi_1$1_2.A2 0.01442f
C166 sar_ctrl_async_phys_0.dac_code_n[5] sar_ctrl_async_phys_0.dac_code[5] 0.06261f
C167 sar_ctrl_async_phys_0.sg13g2_buf_1$1_37.A sar_ctrl_async_phys_0.sg13g2_buf_1$1_13.A 0.22405f
C168 sar_ctrl_async_phys_0.sg13g2_inv_1$1_6.A a_31247_32876# 0.15819f
C169 sar_ctrl_async_phys_0.dac_code[5] oa_sar8_acore18_opt_0.sw_bitcell_opt_term_0.gb 0.19615f
C170 sar_ctrl_async_phys_0.dac_code_n[3] sar_ctrl_async_phys_0.dac_code_n[7] 0.1317f
C171 sar_ctrl_async_phys_0.sg13g2_nand2b_1$1_3.Y sar_ctrl_async_phys_0.sg13g2_nand2b_1$1_6.A_N 0.02505f
C172 a_34904_47296# sar_ctrl_async_phys_0.dac_code_n[0] 0.24516f
C173 sar_ctrl_async_phys_0.sg13g2_buf_1$1_10.A a_33080_31388# 0.02223f
C174 a_32341_32117# VDD 0.24695f
C175 a_36056_38948# sar_ctrl_async_phys_0.dac_code[5] 0.24516f
C176 sar_ctrl_async_phys_0.dac_code_n[0] vcm 0.07392f
C177 a_31291_31399# a_32031_31749# 0.26905f
C178 sar_ctrl_async_phys_0.sg13g2_a22oi_1$1_2.Y a_30746_31356# 0.03786f
C179 a_28488_35965# VDD 0.31287f
C180 sar_ctrl_async_phys_0.sg13g2_dlygate4sd3_1$1_5.A sar_ctrl_async_phys_0.sg13g2_nor2_1$1_13.A 0.03555f
C181 sar_ctrl_async_phys_0.sg13g2_a21oi_1$1_0.A1 a_34731_37436# 0.03309f
C182 sar_ctrl_async_phys_0.sg13g2_and2_1$1_3.X a_26454_39702# 0.04616f
C183 sar_ctrl_async_phys_0.sg13g2_nor2_1$1_4.Y a_34136_47296# 0.25757f
C184 oa_sar8_acore18_opt_0.sw_bitcell_opt_b5_1.bot oa_sar8_acore18_opt_0.bstrap_opt_w2_c1200_1.gb 0.71955f
C185 sar_ctrl_async_phys_0.sg13g2_buf_1$1_37.A sar_ctrl_async_phys_0.sg13g2_nor2_1$1_2.Y 0.05074f
C186 sar_ctrl_async_phys_0.sg13g2_dfrbpq_1$1_0.CLK sar_ctrl_async_phys_0.sg13g2_dlygate4sd3_1$1_3.A 0.15825f
C187 sar_ctrl_async_phys_0.sg13g2_dfrbpq_1$1_0.CLK a_34651_32911# 0.0441f
C188 sar_ctrl_async_phys_0.sg13g2_inv_1$1_1.Y sar_ctrl_async_phys_0.sg13g2_buf_1$1_0.A 0.10649f
C189 sar_ctrl_async_phys_0.sg13g2_nor2b_1$1_4.Y sar_ctrl_async_phys_0.sg13g2_dfrbpq_1$1_9.D 0.08747f
C190 sar_ctrl_async_phys_0.sg13g2_buf_1$1_41.X sar_ctrl_async_phys_0.sg13g2_a22oi_1$1_2.A2 0.26656f
C191 sar_ctrl_async_phys_0.sample oa_sar8_acore18_opt_0.sw_tg_opt_1.bot 2.09748f
C192 sar_ctrl_async_phys_0.sg13g2_nor2b_1$1_0.A a_31644_36638# 0.01556f
C193 sar_ctrl_async_phys_0.sg13g2_dfrbpq_1$1_0.CLK a_33211_45868# 0.02782f
C194 oa_sar8_acore18_opt_0.sw_bitcell_opt_b2_1.bot oa_sar8_acore18_opt_0.sw_bitcell_opt_b4_1.bot 1.47555f
C195 oa_sar8_acore18_opt_0.sw_bitcell_opt_b1_1.bot oa_sar8_acore18_opt_0.sw_bitcell_opt_b5_1.bot 0.43173f
C196 oa_sar8_acore18_opt_0.sw_bitcell_opt_b0_1.bot oa_sar8_acore18_opt_0.sw_bitcell_opt_b6_1.bot 0.5306f
C197 sar_ctrl_async_phys_0.sg13g2_a22oi_1$1_0.B1 sar_ctrl_async_phys_0.sg13g2_a22oi_1$1_2.B2 0.68192f
C198 sar_ctrl_async_phys_0.sg13g2_buf_1$1_2.A result[5] 0.03446f
C199 a_30331_33772# a_31071_33727# 0.26905f
C200 sar_ctrl_async_phys_0.dac_code_n[7] vcm 0.07208f
C201 sar_ctrl_async_phys_0.sg13g2_buf_1$1_4.A a_34363_36796# 0.01878f
C202 sar_ctrl_async_phys_0.sg13g2_nor2_1$1_14.A a_27249_39888# 0.03258f
C203 sar_ctrl_async_phys_0.dac_code_n[1] oa_sar8_acore18_opt_0.sw_bitcell_opt_term_0.trkb 1.83055f
C204 sar_ctrl_async_phys_0.sg13g2_and2_1$1_6.X sar_ctrl_async_phys_0.sg13g2_nor2_1$1_18.A 0.16045f
C205 sar_ctrl_async_phys_0.dac_code[0] a_35948_n9612# 2.10542f
C206 a_35770_43484# VDD 0.38021f
C207 sar_ctrl_async_phys_0.dac_code_n[6] a_20412_n9612# 0.15855f
C208 sar_ctrl_async_phys_0.sg13g2_buf_1$1_0.A a_34106_32868# 0.03263f
C209 sar_ctrl_async_phys_0.dac_code_n[1] sar_ctrl_async_phys_0.cmp_n 0.05993f
C210 sar_ctrl_async_phys_0.sg13g2_and2_1$1_0.A sar_ctrl_async_phys_0.sg13g2_and2_1$1_3.A 0.36678f
C211 a_31040_40702# a_30783_40821# 0.34468f
C212 a_35391_34773# a_36058_34412# 0.0894f
C213 a_31732_45000# a_32897_45357# 0.43239f
C214 a_32020_45421# a_32251_45007# 0.12701f
C215 a_35463_31435# result[2] 0.03126f
C216 a_29749_32117# a_29851_32260# 0.47622f
C217 sar_ctrl_async_phys_0.sg13g2_a21oi_1$1_0.A2 a_34731_37436# 0.10458f
C218 sar_ctrl_async_phys_0.sg13g2_buf_1$1_6.X a_30486_31826# 0.09881f
C219 sar_ctrl_async_phys_0.dac_code_n[4] oa_sar8_acore18_opt_0.sw_bitcell_opt_b4_1.bot 1.31781f
C220 oa_sar8_acore18_opt_0.sw_bitcell_opt_term_0.vin oa_sar8_acore18_opt_0.sw_bitcell_opt_term_0.bot 3.81939f
C221 a_35391_33261# a_35297_33261# 0.28931f
C222 sar_ctrl_async_phys_0.sg13g2_nor2_1$1_7.A a_28368_36877# 0.13174f
C223 sar_ctrl_async_phys_0.sg13g2_nor2_1$1_12.Y VDD 0.34491f
C224 sar_ctrl_async_phys_0.dac_code[0] a_36152_45082# 0.01701f
C225 a_34549_30605# a_34651_30748# 0.47622f
C226 sar_ctrl_async_phys_0.sg13g2_nor2b_1$1_0.A a_30650_39921# 0.02702f
C227 a_30678_46946# a_30938_46476# 0.75507f
C228 sar_ctrl_async_phys_0.dac_code_n[1] oa_sar8_acore18_opt_0.sw_bitcell_opt_b4_0.bot 0.08549f
C229 sar_ctrl_async_phys_0.sg13g2_nor2_1$1_0.Y a_32251_45007# 0.05769f
C230 sar_ctrl_async_phys_0.sg13g2_nor2_1$1_0.Y sar_ctrl_async_phys_0.sg13g2_a21oi_1$1_2.B1 0.01249f
C231 sar_ctrl_async_phys_0.sg13g2_buf_1$1_2.A sar_ctrl_async_phys_0.sg13g2_buf_1$1_1.A 0.04506f
C232 sar_ctrl_async_phys_0.sg13g2_o21ai_1$1_1.B1 a_30043_40471# 0.46067f
C233 sar_ctrl_async_phys_0.sg13g2_a21oi_1$1_5.Y a_31195_35935# 0.0561f
C234 sar_ctrl_async_phys_0.sg13g2_a22oi_1$1_0.B1 sar_ctrl_async_phys_0.sg13g2_inv_1$1_6.A 1.03483f
C235 sar_ctrl_async_phys_0.sg13g2_a21oi_1$1_6.A2 a_32986_44532# 0.02461f
C236 a_29334_43922# a_29594_43452# 0.75507f
C237 a_30200_35294# VDD 0.1366f
C238 sar_ctrl_async_phys_0.sg13g2_buf_1$1_2.A sar_ctrl_async_phys_0.sg13g2_buf_1$1_7.A 0.02553f
C239 sar_ctrl_async_phys_0.sg13g2_nand2b_1$1_1.B sar_ctrl_async_phys_0.sg13g2_nand2_1$1_5.Y 0.3701f
C240 sar_ctrl_async_phys_0.sg13g2_nor2_1$1_1.Y a_34266_38484# 0.01503f
C241 sar_ctrl_async_phys_0.dac_code_n[0] a_20412_n9612# 0.04166f
C242 a_25596_43448# sar_ctrl_async_phys_0.sg13g2_nor2_1$1_12.Y 0.26353f
C243 oa_sar8_acore18_opt_0.sw_bitcell_opt_term_1.bot oa_sar8_acore18_opt_0.sw_bitcell_opt_b0_1.bot 15.087f
C244 sar_ctrl_async_phys_0.sg13g2_and2_1$1_0.A a_29701_36874# 0.06165f
C245 oa_sar8_acore18_opt_0.sw_bitcell_opt_term_0.vin m3_38288_n2380# 0.05057f
C246 sar_ctrl_async_phys_0.sg13g2_a22oi_1$1_0.A2 sar_ctrl_async_phys_0.sg13g2_a22oi_1$1_0.Y 0.19222f
C247 sar_ctrl_async_phys_0.sg13g2_dfrbpq_1$1_0.CLK a_32192_36166# 0.02172f
C248 a_31258_32436# VDD 0.38058f
C249 sar_ctrl_async_phys_0.sg13g2_inv_1$1_10.Y sar_ctrl_async_phys_0.sg13g2_nand2b_1$1_0.Y 0.01275f
C250 a_26364_45710# a_26160_45878# 0.01048f
C251 sar_ctrl_async_phys_0.sg13g2_and2_1$1_3.X a_27249_39888# 0.02018f
C252 oa_sar8_acore18_opt_0.bstrap_opt_w2_c1200_1.gb vinp 1.71889f
C253 a_30772_31392# a_31060_31813# 0.43707f
C254 oa_sar8_acore18_opt_0.sw_tg_opt_1.bot oa_sar8_acore18_opt_0.sw_tg_opt_0.bot 0.07925f
C255 sar_ctrl_async_phys_0.sg13g2_o21ai_1$1_1.B1 a_30752_39190# 0.10225f
C256 a_36058_30924# VDD 0.37825f
C257 sar_ctrl_async_phys_0.sg13g2_buf_1$1_15.A sar_ctrl_async_phys_0.bit_active[2] 0.10574f
C258 sar_ctrl_async_phys_0.sg13g2_buf_1$1_6.X sar_ctrl_async_phys_0.sg13g2_inv_1$1_1.Y 0.06503f
C259 sar_ctrl_async_phys_0.sg13g2_buf_1$1_6.X a_35384_32176# 0.26639f
C260 sar_ctrl_async_phys_0.sg13g2_and2_1$1_0.A a_30752_39190# 0.01391f
C261 a_32347_37447# a_33087_37797# 0.26905f
C262 a_30495_39309# a_31162_38948# 0.0894f
C263 sar_ctrl_async_phys_0.dac_code_n[7] a_20412_n9612# 0.07137f
C264 sar_ctrl_async_phys_0.sg13g2_dfrbpq_1$1_0.CLK a_34549_32911# 0.26666f
C265 sar_ctrl_async_phys_0.sg13g2_buf_1$1_7.A a_36056_32176# 0.26579f
C266 oa_sar8_acore18_opt_0.sw_bitcell_opt_b4_1.bot oa_sar8_acore18_opt_0.sw_bitcell_opt_b6_1.bot 0.53583f
C267 oa_sar8_acore18_opt_0.sw_bitcell_opt_b3_1.bot oa_sar8_acore18_opt_0.sw_bitcell_opt_b7_1.bot 1.18796f
C268 sar_ctrl_async_phys_0.sg13g2_buf_1$1_19.A VDD 1.46664f
C269 a_33750_36362# a_34010_35892# 0.75507f
C270 sar_ctrl_async_phys_0.bit_active[6] VDD 0.29523f
C271 sar_ctrl_async_phys_0.sg13g2_a22oi_1$1_0.A1 a_30671_33292# 0.01761f
C272 sar_ctrl_async_phys_0.sg13g2_and2_1$1_0.X VDD 0.81675f
C273 VDD result[1] 0.2504f
C274 sar_ctrl_async_phys_0.sg13g2_nor2_1$1_0.Y a_32442_38484# 0.01676f
C275 sar_ctrl_async_phys_0.sg13g2_a22oi_1$1_4.A2 sar_ctrl_async_phys_0.sg13g2_nor2b_1$1_0.Y 0.07778f
C276 sar_ctrl_async_phys_0.dac_code[2] sar_ctrl_async_phys_0.dac_code[5] 0.25122f
C277 sar_ctrl_async_phys_0.cmp_valid sar_ctrl_async_phys_0.dac_code_n[0] 0.08183f
C278 sar_ctrl_async_phys_0.sg13g2_buf_1$1_6.X a_34106_32868# 0.25193f
C279 a_29526_33650# a_29812_33968# 0.41329f
C280 sar_ctrl_async_phys_0.sg13g2_a21oi_1$1_6.A2 a_33179_43832# 0.01048f
C281 a_33818_43452# VDD 0.12337f
C282 sar_ctrl_async_phys_0.sg13g2_a22oi_1$1_2.A2 a_31935_36285# 0.03998f
C283 sar_ctrl_async_phys_0.dac_code_n[4] oa_sar8_acore18_opt_0.sw_bitcell_opt_b7_0.bot 1.49586f
C284 sar_ctrl_async_phys_0.sg13g2_nor4_1$1_0.C a_34171_41332# 0.01132f
C285 a_34549_34423# a_34651_34423# 0.47795f
C286 a_31446_45434# a_32020_45421# 0.31978f
C287 a_31732_45000# a_32149_45007# 0.37583f
C288 a_33948_41936# a_34328_41972# 0.0495f
C289 sar_ctrl_async_phys_0.sg13g2_buf_1$1_15.A a_36056_35200# 0.26354f
C290 oa_sar8_acore18_opt_0.bstrap_opt_w2_c1200_1.out a_21332_n9711# 0.0466f
C291 a_31935_39775# a_31841_39775# 0.28931f
C292 sar_ctrl_async_phys_0.dac_code_n[1] oa_sar8_acore18_opt_0.sw_bitcell_opt_b0_0.bot 0.06248f
C293 sar_ctrl_async_phys_0.sg13g2_and2_1$1_0.A sar_ctrl_async_phys_0.sg13g2_nor2_1$1_8.A 0.16246f
C294 a_32692_46064# a_33857_45823# 0.43239f
C295 a_33211_45868# a_32980_45759# 0.12701f
C296 sar_ctrl_async_phys_0.sg13g2_nand2_1$1_5.Y a_35402_42726# 0.01868f
C297 sar_ctrl_async_phys_0.sg13g2_nand2_1$1_5.B sar_ctrl_async_phys_0.sg13g2_buf_1$1_20.A 0.02057f
C298 sar_ctrl_async_phys_0.sg13g2_nand2b_1$1_1.B a_36336_41342# 0.0175f
C299 sar_ctrl_async_phys_0.sg13g2_a21oi_1$1_3.B1 sar_ctrl_async_phys_0.sg13g2_nand2b_1$1_4.A_N 0.02141f
C300 a_32692_46064# a_33211_45868# 0.34114f
C301 a_34093_42912# a_34175_42726# 0.01117f
C302 oa_sar8_acore18_opt_0.sw_bitcell_opt_term_1.bot oa_sar8_acore18_opt_0.sw_bitcell_opt_b4_1.bot 0.78712f
C303 oa_sar8_acore18_opt_0.bstrap_opt_w2_c1200_1.out oa_sar8_acore18_opt_0.sw_bitcell_opt_b3_1.bot 3.99252f
C304 sar_ctrl_async_phys_0.dac_code_n[3] oa_sar8_acore18_opt_0.sw_tg_opt_1.bot 0.07612f
C305 sar_ctrl_async_phys_0.sg13g2_a22oi_1$1_0.A1 sar_ctrl_async_phys_0.sg13g2_a22oi_1$1_0.Y 0.41728f
C306 sar_ctrl_async_phys_0.sg13g2_buf_1$1_2.A sar_ctrl_async_phys_0.sg13g2_a21oi_1$1_2.B1 0.02628f
C307 VDD track 0.82961f
C308 a_30229_33629# VDD 0.2427f
C309 sar_ctrl_async_phys_0.sg13g2_a21oi_1$1_6.A2 a_32251_45007# 0.01403f
C310 sar_ctrl_async_phys_0.sg13g2_buf_1$1_1.A a_32991_35239# 0.01098f
C311 a_36056_37436# sar_ctrl_async_phys_0.bit_active[5] 0.24654f
C312 a_34651_34423# VDD 0.20875f
C313 sar_ctrl_async_phys_0.sg13g2_nor2_1$1_1.Y a_33654_44234# 0.27239f
C314 a_35772_41936# VDD 0.22089f
C315 a_29046_32138# VDD 0.78242f
C316 a_35664_37695# a_36056_37436# 0.04376f
C317 sar_ctrl_async_phys_0.sg13g2_nor2_1$1_4.Y sar_ctrl_async_phys_0.sg13g2_dlygate4sd3_1$1_11.X 0.11f
C318 sar_ctrl_async_phys_0.sg13g2_nand2b_1$1_1.Y VDD 0.39957f
C319 sar_ctrl_async_phys_0.sg13g2_dfrbpq_1$1_0.CLK a_27504_36010# 0.02762f
C320 sar_ctrl_async_phys_0.sg13g2_buf_1$1_17.A a_30384_35294# 0.01122f
C321 sar_ctrl_async_phys_0.sg13g2_nor2_1$1_0.Y sar_ctrl_async_phys_0.sg13g2_a21oi_1$1_5.A2 0.05251f
C322 sar_ctrl_async_phys_0.sg13g2_buf_1$1_19.A sar_ctrl_async_phys_0.sg13g2_nor2b_1$1_3.Y 0.02456f
C323 a_30486_31826# a_30746_31356# 0.75507f
C324 sar_ctrl_async_phys_0.sg13g2_nor2_1$1_10.B sar_ctrl_async_phys_0.sg13g2_inv_1$1_5.A 0.01832f
C325 sar_ctrl_async_phys_0.sg13g2_o21ai_1$1_1.B1 a_28950_39386# 0.11472f
C326 a_33846_30626# VDD 0.80568f
C327 sar_ctrl_async_phys_0.dac_code[0] oa_sar8_acore18_opt_0.sw_bitcell_opt_b7_0.bot 2.34456f
C328 sar_ctrl_async_phys_0.sg13g2_and2_1$1_0.A a_28950_39386# 0.02583f
C329 sar_ctrl_async_phys_0.sg13g2_buf_1$1_32.A a_34459_44356# 0.03399f
C330 sar_ctrl_async_phys_0.sg13g2_buf_1$1_6.X a_32443_32260# 0.42688f
C331 sar_ctrl_async_phys_0.sg13g2_a21oi_1$1_6.A2 a_32666_45969# 0.03786f
C332 sar_ctrl_async_phys_0.sg13g2_nand2_1$1_3.B sar_ctrl_async_phys_0.sg13g2_nand2_1$1_5.B 0.08919f
C333 sar_ctrl_async_phys_0.sg13g2_a22oi_1$1_4.A2 VDD 1.21549f
C334 a_29258_36642# VDD 0.30674f
C335 a_29653_38959# a_29755_38959# 0.47795f
C336 sar_ctrl_async_phys_0.sg13g2_buf_1$1_19.A sar_ctrl_async_phys_0.sg13g2_buf_1$1_14.A 0.76408f
C337 sar_ctrl_async_phys_0.dac_code_n[3] sar_ctrl_async_phys_0.sg13g2_nand2_1$1_3.A 0.04679f
C338 sar_ctrl_async_phys_0.sg13g2_buf_1$1_14.A sar_ctrl_async_phys_0.bit_active[6] 0.04681f
C339 sar_ctrl_async_phys_0.sg13g2_buf_1$1_5.A sar_ctrl_async_phys_0.bit_active[1] 0.55191f
C340 sar_ctrl_async_phys_0.sg13g2_buf_1$1_14.A sar_ctrl_async_phys_0.sg13g2_and2_1$1_0.X 0.02049f
C341 sar_ctrl_async_phys_0.bit_active[6] sar_ctrl_async_phys_0.bit_active[7] 0.14238f
C342 sar_ctrl_async_phys_0.dac_code_n[1] oa_sar8_acore18_opt_0.sw_bitcell_opt_b0_1.bot 0.11923f
C343 sar_ctrl_async_phys_0.sg13g2_a22oi_1$1_4.A2 a_32897_35239# 0.01759f
C344 sar_ctrl_async_phys_0.sg13g2_buf_1$1_19.A sar_ctrl_async_phys_0.sg13g2_a22oi_1$1_1.A2 0.22045f
C345 oa_sar8_acore18_opt_0.sw_tg_opt_1.bot vcm 3.45898f
C346 sar_ctrl_async_phys_0.sg13g2_nor2_1$1_8.B sar_ctrl_async_phys_0.sg13g2_inv_1$1_7.A 0.3228f
C347 a_29755_38959# VDD 0.20731f
C348 sar_ctrl_async_phys_0.sg13g2_nor2_1$1_3.Y sar_ctrl_async_phys_0.sg13g2_nor2_1$1_8.B 0.0929f
C349 a_27800_41342# VDD 0.13633f
C350 sar_ctrl_async_phys_0.sg13g2_a22oi_1$1_0.B1 sar_ctrl_async_phys_0.sg13g2_inv_1$1_6.Y 0.05218f
C351 sar_ctrl_async_phys_0.sg13g2_buf_1$1_20.A a_35770_43484# 0.01099f
C352 sar_ctrl_async_phys_0.sg13g2_dfrbpq_1$1_0.CLK result[5] 0.01514f
C353 sar_ctrl_async_phys_0.dac_code_n[2] oa_sar8_acore18_opt_0.sw_bitcell_opt_b5_0.bot 0.487f
C354 sar_ctrl_async_phys_0.dac_code[5] oa_sar8_acore18_opt_0.sw_bitcell_opt_b3_0.bot 0.56081f
C355 sar_ctrl_async_phys_0.dac_code_n[1] a_35948_n9612# 0.0499f
C356 a_29238_40898# a_30043_40471# 0.097f
C357 a_33846_34850# a_34132_34416# 0.41329f
C358 a_26954_40424# track 0.01114f
C359 a_33464_31388# result[2] 0.10553f
C360 sar_ctrl_async_phys_0.hold_req sar_ctrl_async_phys_0.dac_code_n[6] 0.05239f
C361 sar_ctrl_async_phys_0.sg13g2_nand2b_1$1_3.Y sar_ctrl_async_phys_0.sg13g2_nand2_1$1_5.B 0.04924f
C362 sar_ctrl_async_phys_0.sg13g2_buf_1$1_7.A sar_ctrl_async_phys_0.sg13g2_a22oi_1$1_2.Y 0.07783f
C363 sar_ctrl_async_phys_0.sg13g2_nor2_1$1_10.B a_30830_35166# 0.05796f
C364 sar_ctrl_async_phys_0.sg13g2_a21oi_1$1_1.B1 sar_ctrl_async_phys_0.dac_code[6] 0.24549f
C365 a_31064_38318# VDD 0.16569f
C366 a_30676_40016# a_30964_39711# 0.43707f
C367 sar_ctrl_async_phys_0.sg13g2_a22oi_1$1_0.B1 sar_ctrl_async_phys_0.sg13g2_buf_1$1_10.A 0.16154f
C368 sar_ctrl_async_phys_0.sg13g2_a22oi_1$1_0.A2 sar_ctrl_async_phys_0.bit_active[0] 0.02729f
C369 a_34132_32904# a_34420_33325# 0.43707f
C370 sar_ctrl_async_phys_0.sg13g2_and2_1$1_0.A sar_ctrl_async_phys_0.sg13g2_nand2_1$1_1.Y 0.01078f
C371 a_26558_40727# a_26673_40726# 0.55452f
C372 oa_sar8_acore18_opt_0.sw_bitcell_opt_term_0.gb m3_60844_n2380# 1.40567f
C373 sar_ctrl_async_phys_0.sg13g2_buf_1$1_2.A sar_ctrl_async_phys_0.sg13g2_inv_1$1_2.Y 0.05523f
C374 sar_ctrl_async_phys_0.cmp_p VDD 6.89721f
C375 sar_ctrl_async_phys_0.sg13g2_buf_1$1_15.A a_34596_40424# 0.26406f
C376 sar_ctrl_async_phys_0.sg13g2_dfrbpq_1$1_0.CLK sar_ctrl_async_phys_0.sg13g2_buf_1$1_1.A 1.01291f
C377 oa_sar8_acore18_opt_0.bstrap_opt_w2_c1200_1.out oa_sar8_acore18_opt_0.sw_bitcell_opt_b7_1.bot 4.61763f
C378 sar_ctrl_async_phys_0.sg13g2_a21oi_1$1_1.B1 sar_ctrl_async_phys_0.sg13g2_nand2b_1$1_2.A_N 0.02239f
C379 sar_ctrl_async_phys_0.sg13g2_buf_1$1_41.X sar_ctrl_async_phys_0.sg13g2_nand2_1$1_5.B 0.02641f
C380 sar_ctrl_async_phys_0.sg13g2_dfrbpq_1$1_0.CLK sar_ctrl_async_phys_0.sg13g2_buf_1$1_7.A 0.31142f
C381 sar_ctrl_async_phys_0.hold_req sar_ctrl_async_phys_0.dac_code_n[0] 0.04991f
C382 sar_ctrl_async_phys_0.sg13g2_nand2b_1$1_5.A_N sar_ctrl_async_phys_0.sg13g2_nand2b_1$1_6.A_N 0.14134f
C383 sar_ctrl_async_phys_0.sg13g2_a22oi_1$1_4.A2 sar_ctrl_async_phys_0.sg13g2_nor2b_1$1_3.Y 0.0122f
C384 a_29941_40471# VDD 0.27195f
C385 a_31640_34498# VDD 0.14174f
C386 sar_ctrl_async_phys_0.sg13g2_a21oi_1$1_6.B1 a_32576_44454# 0.0418f
C387 sar_ctrl_async_phys_0.sg13g2_a21oi_1$1_2.Y sar_ctrl_async_phys_0.sg13g2_inv_1$1_7.A 0.42408f
C388 a_25596_47222# sar_ctrl_async_phys_0.sg13g2_buf_1$1_29.X 0.2591f
C389 sar_ctrl_async_phys_0.dac_code[1] oa_sar8_acore18_opt_0.sw_bitcell_opt_term_0.trkb 1.81503f
C390 sar_ctrl_async_phys_0.sg13g2_inv_1$1_0.A VDD 0.25777f
C391 sar_ctrl_async_phys_0.dac_code_n[2] sar_ctrl_async_phys_0.dac_code[7] 0.13169f
C392 oa_sar8_acore18_opt_0.sw_tg_opt_1.bot a_20412_n9612# 2.5703f
C393 sar_ctrl_async_phys_0.sg13g2_a21oi_1$1_0.B1 a_35245_45266# 0.29061f
C394 sar_ctrl_async_phys_0.sg13g2_nor4_1$1_0.C sar_ctrl_async_phys_0.sg13g2_nor4_1$1_0.Y 0.15405f
C395 sar_ctrl_async_phys_0.sg13g2_nor2_1$1_5.A a_29144_39830# 0.02098f
C396 a_28950_39386# a_29236_38952# 0.41329f
C397 sar_ctrl_async_phys_0.dac_code[1] sar_ctrl_async_phys_0.cmp_n 0.07718f
C398 sar_ctrl_async_phys_0.sg13g2_nor2_1$1_2.Y a_33652_41528# 0.0135f
C399 sar_ctrl_async_phys_0.sg13g2_buf_1$1_20.A sar_ctrl_async_phys_0.bit_active[6] 0.02902f
C400 sar_ctrl_async_phys_0.sg13g2_nor2b_1$1_0.A sar_ctrl_async_phys_0.sg13g2_buf_1$1_19.A 0.49673f
C401 sar_ctrl_async_phys_0.sg13g2_a21oi_1$1_2.B1 sar_ctrl_async_phys_0.sg13g2_nand2_1$1_2.Y 0.06813f
C402 sar_ctrl_async_phys_0.sg13g2_nor2b_1$1_0.A sar_ctrl_async_phys_0.bit_active[6] 0.02461f
C403 sar_ctrl_async_phys_0.hold_req sar_ctrl_async_phys_0.dac_code_n[7] 0.04276f
C404 a_30676_35928# a_31841_36285# 0.43239f
C405 sar_ctrl_async_phys_0.sg13g2_nor2b_1$1_0.A sar_ctrl_async_phys_0.sg13g2_and2_1$1_0.X 3.48228f
C406 sar_ctrl_async_phys_0.sg13g2_buf_1$1_5.A result[4] 0.12175f
C407 sar_ctrl_async_phys_0.sg13g2_nor2_1$1_3.Y sar_ctrl_async_phys_0.sg13g2_inv_1$1_7.A 0.11327f
C408 a_28560_39034# VDD 0.07229f
C409 sar_ctrl_async_phys_0.sg13g2_buf_1$1_37.A sar_ctrl_async_phys_0.sg13g2_nand2_1$1_5.B 1.46328f
C410 sar_ctrl_async_phys_0.sg13g2_nor2_1$1_3.B VDD 0.73902f
C411 sar_ctrl_async_phys_0.dac_code_n[2] oa_sar8_acore18_opt_0.sw_bitcell_opt_b1_0.bot 0.08325f
C412 sar_ctrl_async_phys_0.sg13g2_buf_1$1_3.A sar_ctrl_async_phys_0.bit_active[0] 0.03125f
C413 sar_ctrl_async_phys_0.dac_code[1] oa_sar8_acore18_opt_0.sw_bitcell_opt_b4_0.bot 0.37369f
C414 sar_ctrl_async_phys_0.sg13g2_nor2_1$1_2.Y sar_ctrl_async_phys_0.sg13g2_buf_1$1_15.A 0.24108f
C415 sar_ctrl_async_phys_0.dac_code[5] oa_sar8_acore18_opt_0.sw_bitcell_opt_term_0.bot 0.16277f
C416 a_32580_43448# a_32888_43570# 0.01393f
C417 sar_ctrl_async_phys_0.sg13g2_a21oi_1$1_4.B1 sar_ctrl_async_phys_0.sg13g2_buf_1$1_36.A 0.02754f
C418 a_29498_40428# a_29524_40464# 0.36952f
C419 a_25496_34412# VDD 0.22258f
C420 sar_ctrl_async_phys_0.sg13g2_a22oi_1$1_0.B1 a_32687_32876# 0.06515f
C421 sar_ctrl_async_phys_0.sg13g2_nand2b_1$1_1.B sar_ctrl_async_phys_0.sg13g2_nand2b_1$1_4.A_N 1.59561f
C422 sar_ctrl_async_phys_0.sg13g2_o21ai_1$1_1.B1 a_33375_40821# 0.17377f
C423 a_35672_35200# VDD 0.2631f
C424 sar_ctrl_async_phys_0.sg13g2_dlygate4sd3_1$1_8.X sar_ctrl_async_phys_0.sg13g2_dlygate4sd3_1$1_6.A 0.03498f
C425 a_34228_44247# VDD 0.01236f
C426 sar_ctrl_async_phys_0.sg13g2_nor2_1$1_14.A a_28130_40838# 0.07635f
C427 a_30676_40016# a_31195_39820# 0.34114f
C428 a_30650_39921# a_30390_39698# 0.75507f
C429 a_35280_35365# sar_ctrl_async_phys_0.bit_active[0] 0.01212f
C430 a_34106_32868# a_34549_32911# 0.02242f
C431 sar_ctrl_async_phys_0.sg13g2_nor2_1$1_10.B a_29812_33968# 0.04716f
C432 w_16692_n9960# oa_sar8_acore18_opt_0.sw_bitcell_opt_term_0.trkb 2.16982f
C433 oa_sar8_acore18_opt_0.sw_bitcell_opt_term_0.gb m3_34580_n2380# 1.78701f
C434 a_35557_31435# a_35463_31435# 0.75507f
C435 sar_ctrl_async_phys_0.sg13g2_a21oi_1$1_0.A1 sar_ctrl_async_phys_0.sg13g2_a21oi_1$1_2.B1 0.49221f
C436 sar_ctrl_async_phys_0.sg13g2_and2_1$1_0.B a_30027_39996# 0.07851f
C437 sar_ctrl_async_phys_0.cmp_p a_26184_21025# 2.27077f
C438 sar_ctrl_async_phys_0.sg13g2_a22oi_1$1_2.B2 VDD 0.69738f
C439 a_28651_39740# a_29144_39830# 0.01096f
C440 sar_ctrl_async_phys_0.sg13g2_nand2_1$1_5.Y a_35168_41430# 0.0211f
C441 sar_ctrl_async_phys_0.sg13g2_a21oi_1$1_0.B1 sar_ctrl_async_phys_0.dac_code_n[2] 0.04638f
C442 sar_ctrl_async_phys_0.sg13g2_dfrbpq_1$1_0.CLK a_30774_44234# 0.02691f
C443 sar_ctrl_async_phys_0.sg13g2_buf_1$1_3.A sar_ctrl_async_phys_0.bit_active[4] 0.02867f
C444 sar_ctrl_async_phys_0.sg13g2_nor2b_1$1_4.Y a_30774_44234# 0.0238f
C445 sar_ctrl_async_phys_0.sg13g2_o21ai_1$1_1.B1 sar_ctrl_async_phys_0.sg13g2_buf_1$1_13.A 1.47083f
C446 sar_ctrl_async_phys_0.sg13g2_nor2_1$1_0.Y sar_ctrl_async_phys_0.sg13g2_a21oi_1$1_5.Y 0.08367f
C447 sar_ctrl_async_phys_0.sg13g2_a21oi_1$1_2.B1 a_34075_39820# 0.03067f
C448 sar_ctrl_async_phys_0.sg13g2_and2_1$1_0.A sar_ctrl_async_phys_0.sg13g2_buf_1$1_13.A 0.10104f
C449 sar_ctrl_async_phys_0.sg13g2_a22oi_1$1_2.Y sar_ctrl_async_phys_0.sg13g2_inv_1$1_11.Y 0.16869f
C450 a_27624_35965# VDD 0.34255f
C451 sar_ctrl_async_phys_0.sg13g2_inv_1$1_10.Y sar_ctrl_async_phys_0.sg13g2_nor2_1$1_14.A 0.22839f
C452 sar_ctrl_async_phys_0.sg13g2_dfrbpq_1$1_0.CLK a_32251_45007# 0.02179f
C453 sar_ctrl_async_phys_0.sg13g2_nand2b_1$1_3.Y sar_ctrl_async_phys_0.sg13g2_buf_1$1_19.A 0.01442f
C454 sar_ctrl_async_phys_0.sg13g2_dfrbpq_1$1_0.CLK sar_ctrl_async_phys_0.sg13g2_a21oi_1$1_2.B1 0.36018f
C455 sar_ctrl_async_phys_0.sg13g2_dfrbpq_1$1_0.CLK a_29851_32260# 0.02281f
C456 sar_ctrl_async_phys_0.sg13g2_dfrbpq_1$1_0.CLK a_34651_30748# 0.0391f
C457 sar_ctrl_async_phys_0.sg13g2_buf_1$1_6.X a_30331_33772# 0.42115f
C458 a_32400_41413# sar_ctrl_async_phys_0.sg13g2_buf_1$1_3.A 0.25422f
C459 sar_ctrl_async_phys_0.sg13g2_nor2_1$1_0.Y a_32580_43448# 0.01032f
C460 sar_ctrl_async_phys_0.sg13g2_o21ai_1$1_1.B1 sar_ctrl_async_phys_0.sg13g2_nor2_1$1_2.Y 0.07972f
C461 sar_ctrl_async_phys_0.sg13g2_nor2b_1$1_0.A sar_ctrl_async_phys_0.sg13g2_a22oi_1$1_4.A2 0.18617f
C462 sar_ctrl_async_phys_0.dac_code_n[1] oa_sar8_acore18_opt_0.sw_bitcell_opt_b7_0.bot 0.9807f
C463 sar_ctrl_async_phys_0.sg13g2_a22oi_1$1_1.A2 sar_ctrl_async_phys_0.sg13g2_inv_1$1_0.A 0.01483f
C464 sar_ctrl_async_phys_0.sg13g2_o21ai_1$1_1.B1 a_33973_39677# 0.03432f
C465 sar_ctrl_async_phys_0.sg13g2_buf_1$1_6.X a_29332_32456# 0.45319f
C466 sar_ctrl_async_phys_0.sg13g2_inv_1$1_6.A VDD 0.21204f
C467 a_31542_37874# a_31802_37404# 0.75507f
C468 sar_ctrl_async_phys_0.sg13g2_dfrbpq_1$1_0.CLK a_32666_45969# 0.02276f
C469 a_33183_32215# a_33850_32436# 0.0894f
C470 sar_ctrl_async_phys_0.sg13g2_a22oi_1$1_3.A2 VDD 1.35811f
C471 oa_sar8_acore18_opt_0.sw_tg_opt_0.bot oa_sar8_acore18_opt_0.sw_bitcell_opt_b5_0.bot 15.1026f
C472 sar_ctrl_async_phys_0.sg13g2_buf_1$1_17.A a_33846_34850# 0.2826f
C473 sar_ctrl_async_phys_0.sg13g2_buf_1$1_6.X a_34132_30944# 0.3989f
C474 sar_ctrl_async_phys_0.sg13g2_a22oi_1$1_0.B1 a_34319_32460# 0.04594f
C475 sar_ctrl_async_phys_0.sg13g2_a22oi_1$1_4.A2 a_32251_35284# 0.03059f
C476 a_30650_35892# a_31093_35935# 0.02242f
C477 a_30390_36362# a_30964_36349# 0.31978f
C478 sar_ctrl_async_phys_0.sg13g2_dfrbpq_1$1_0.CLK a_31162_38948# 0.01167f
C479 sar_ctrl_async_phys_0.sg13g2_a22oi_1$1_0.B1 a_33850_32436# 0.01237f
C480 sar_ctrl_async_phys_0.sg13g2_a21oi_1$1_5.Y a_32120_38318# 0.0123f
C481 sar_ctrl_async_phys_0.sg13g2_a21oi_1$1_6.B1 sar_ctrl_async_phys_0.sg13g2_nor2_1$1_0.Y 0.11109f
C482 sar_ctrl_async_phys_0.dac_code[1] oa_sar8_acore18_opt_0.sw_bitcell_opt_b0_0.bot 0.16588f
C483 sar_ctrl_async_phys_0.cmp_fire oa_sar8_acore18_opt_0.sw_tg_opt_1.bot 0.17568f
C484 sar_ctrl_async_phys_0.sg13g2_and2_1$1_0.A a_26544_38389# 0.01016f
C485 a_35952_39901# VDD 0.38985f
C486 sar_ctrl_async_phys_0.dac_code_n[6] oa_sar8_acore18_opt_0.sw_bitcell_opt_term_0.VSS 0.01787f
C487 sar_ctrl_async_phys_0.sg13g2_buf_1$1_19.A a_33754_37436# 0.15746f
C488 sar_ctrl_async_phys_0.sg13g2_buf_1$1_41.X a_33818_43452# 0.24621f
C489 a_34520_38224# VDD 0.22373f
C490 m3_54868_n2380# VDD 0.01997f
C491 sar_ctrl_async_phys_0.sg13g2_buf_1$1_14.A a_35672_35200# 0.26686f
C492 sar_ctrl_async_phys_0.sg13g2_nor2_1$1_2.Y sar_ctrl_async_phys_0.sg13g2_nor2b_1$1_1.Y 0.16374f
C493 sar_ctrl_async_phys_0.sg13g2_nor2_1$1_4.Y sar_ctrl_async_phys_0.sg13g2_dlygate4sd3_1$1_5.X 0.06246f
C494 sar_ctrl_async_phys_0.sg13g2_o21ai_1$1_1.B1 a_32090_40428# 0.2631f
C495 sar_ctrl_async_phys_0.sg13g2_buf_1$1_42.A sar_ctrl_async_phys_0.sg13g2_buf_1$1_2.A 0.17643f
C496 sar_ctrl_async_phys_0.sg13g2_buf_1$1_42.A sar_ctrl_async_phys_0.sg13g2_a21oi_1$1_6.A2 0.25976f
C497 sar_ctrl_async_phys_0.sg13g2_buf_1$1_3.A sar_ctrl_async_phys_0.sg13g2_nand2_1$1_2.B 2.19643f
C498 a_34357_44213# VDD 0.25308f
C499 sar_ctrl_async_phys_0.sg13g2_o21ai_1$1_1.B1 sar_ctrl_async_phys_0.sg13g2_a22oi_1$1_2.A2 0.36565f
C500 a_34520_33688# VDD 0.22062f
C501 a_34615_31475# a_35418_31668# 0.12701f
C502 a_36056_47296# sar_ctrl_async_phys_0.dac_code_n[5] 0.2458f
C503 sar_ctrl_async_phys_0.sg13g2_buf_1$1_37.A sar_ctrl_async_phys_0.sg13g2_buf_1$1_19.A 0.02347f
C504 sar_ctrl_async_phys_0.sg13g2_a22oi_1$1_2.Y a_30872_30758# 0.01607f
C505 sar_ctrl_async_phys_0.sg13g2_nor2_1$1_10.B a_29524_40464# 0.04567f
C506 sar_ctrl_async_phys_0.dac_code_n[0] oa_sar8_acore18_opt_0.sw_bitcell_opt_term_0.VSS 0.06509f
C507 sar_ctrl_async_phys_0.sg13g2_a21oi_1$1_4.B1 sar_ctrl_async_phys_0.dac_code_n[2] 0.05603f
C508 a_33632_40702# VDD 0.17148f
C509 sar_ctrl_async_phys_0.sg13g2_dfrbpq_1$1_0.CLK sar_ctrl_async_phys_0.sg13g2_inv_1$1_2.Y 0.01633f
C510 sar_ctrl_async_phys_0.sg13g2_a21oi_1$1_0.A1 a_33675_43020# 0.03364f
C511 sar_ctrl_async_phys_0.sg13g2_nand2b_1$1_3.Y sar_ctrl_async_phys_0.sg13g2_a22oi_1$1_4.A2 0.01175f
C512 sar_ctrl_async_phys_0.sg13g2_dlygate4sd3_1$1_8.X a_26550_41214# 0.02463f
C513 sar_ctrl_async_phys_0.sg13g2_a22oi_1$1_0.A2 result[4] 0.02829f
C514 a_34615_31475# result[3] 0.0126f
C515 sar_ctrl_async_phys_0.dac_code[7] oa_sar8_acore18_opt_0.sw_tg_opt_0.bot 0.93466f
C516 sar_ctrl_async_phys_0.sg13g2_nand3_1$1_0.Y a_26184_39702# 0.07762f
C517 a_34106_32868# result[5] 0.02095f
C518 a_34136_47296# sar_ctrl_async_phys_0.sg13g2_nor4_1$1_0.C 0.01567f
C519 a_35770_36972# VDD 0.38054f
C520 sar_ctrl_async_phys_0.sg13g2_dlygate4sd3_1$1_6.A VDD 0.52233f
C521 sar_ctrl_async_phys_0.sg13g2_dfrbpq_1$1_0.CLK a_29350_41996# 0.16938f
C522 sar_ctrl_async_phys_0.sg13g2_nor2b_1$1_3.Y sar_ctrl_async_phys_0.sg13g2_a22oi_1$1_3.A2 1.40663f
C523 sar_ctrl_async_phys_0.sg13g2_a21oi_1$1_5.A2 a_32792_41342# 0.02147f
C524 a_27134_39887# track 0.05148f
C525 sar_ctrl_async_phys_0.dac_code_n[3] oa_sar8_acore18_opt_0.sw_bitcell_opt_b5_0.bot 0.5616f
C526 sar_ctrl_async_phys_0.sg13g2_a21oi_1$1_0.A1 sar_ctrl_async_phys_0.sg13g2_a21oi_1$1_5.A2 0.18165f
C527 sar_ctrl_async_phys_0.sg13g2_nand2_1$1_2.B sar_ctrl_async_phys_0.sg13g2_a21oi_1$1_3.A2 0.02252f
C528 a_33936_31675# VDD 0.41414f
C529 sar_ctrl_async_phys_0.dac_code_n[7] oa_sar8_acore18_opt_0.sw_bitcell_opt_term_0.VSS 0.01021f
C530 sar_ctrl_async_phys_0.sg13g2_dlygate4sd3_1$1_5.A sar_ctrl_async_phys_0.sg13g2_dlygate4sd3_1$1_5.X 0.01743f
C531 sar_ctrl_async_phys_0.sg13g2_buf_1$1_4.A a_35391_34773# 0.01247f
C532 a_33276_42686# VDD 0.22555f
C533 sar_ctrl_async_phys_0.sg13g2_a22oi_1$1_3.A2 sar_ctrl_async_phys_0.sg13g2_buf_1$1_14.A 0.01392f
C534 oa_sar8_acore18_opt_0.sw_tg_opt_0.bot oa_sar8_acore18_opt_0.sw_bitcell_opt_b1_0.bot 1.08157f
C535 a_34904_46508# sar_ctrl_async_phys_0.dac_code_n[3] 0.24512f
C536 sar_ctrl_async_phys_0.dac_code[1] a_35948_n9612# 2.40439f
C537 a_30296_42854# VDD 0.13825f
C538 a_32341_32117# a_32212_32151# 0.01562f
C539 sar_ctrl_async_phys_0.hold_req oa_sar8_acore18_opt_0.sw_tg_opt_1.bot 0.09393f
C540 a_31924_32456# a_33183_32215# 0.01529f
C541 sar_ctrl_async_phys_0.sg13g2_nor2_1$1_10.B sar_ctrl_async_phys_0.sg13g2_a22oi_1$1_0.A1 0.33907f
C542 sar_ctrl_async_phys_0.sg13g2_nand2_1$1_5.Y sar_ctrl_async_phys_0.dac_code[5] 0.79595f
C543 sar_ctrl_async_phys_0.sg13g2_nand2_1$1_1.B a_28368_36877# 0.28894f
C544 a_29786_33873# a_29526_33650# 0.75507f
C545 sar_ctrl_async_phys_0.sg13g2_a22oi_1$1_3.A2 sar_ctrl_async_phys_0.sg13g2_a22oi_1$1_1.A2 0.01323f
C546 sar_ctrl_async_phys_0.sg13g2_nand2_1$1_5.Y a_35672_38948# 0.01119f
C547 sar_ctrl_async_phys_0.sg13g2_a22oi_1$1_0.B1 a_31924_32456# 0.0124f
C548 sar_ctrl_async_phys_0.sg13g2_dfrbpq_1$1_0.CLK sar_ctrl_async_phys_0.sg13g2_a21oi_1$1_5.A2 0.01133f
C549 sar_ctrl_async_phys_0.sg13g2_dfrbpq_1$1_0.CLK a_29210_38916# 0.01317f
C550 a_35952_39901# sar_ctrl_async_phys_0.sg13g2_buf_1$1_14.A 0.10413f
C551 a_28488_35965# a_28758_35924# 0.26306f
C552 a_33085_43832# VDD 0.39349f
C553 a_33556_40016# VDD 0.09473f
C554 sar_ctrl_async_phys_0.sg13g2_buf_1$1_14.A a_34520_38224# 0.03599f
C555 a_36152_36806# a_36336_36806# 0.0524f
C556 oa_sar8_acore18_opt_0.sw_bitcell_opt_term_0.trkb m3_41836_n2380# 0.03859f
C557 sar_ctrl_async_phys_0.sg13g2_a22oi_1$1_2.A2 sar_ctrl_async_phys_0.sg13g2_a22oi_1$1_3.B1 0.17768f
C558 sar_ctrl_async_phys_0.sg13g2_nor4_1$1_0.C sar_ctrl_async_phys_0.sg13g2_nor2_1$1_10.B 0.02186f
C559 sar_ctrl_async_phys_0.sg13g2_buf_1$1_37.A a_35772_41936# 0.26249f
C560 sar_ctrl_async_phys_0.sg13g2_nor2_1$1_7.A a_28862_36863# 0.01447f
C561 sar_ctrl_async_phys_0.sg13g2_a21oi_1$1_6.B1 sar_ctrl_async_phys_0.sg13g2_buf_1$1_2.A 0.02819f
C562 a_35028_n9612# VDD 0.8295f
C563 sar_ctrl_async_phys_0.sg13g2_nand2b_1$1_0.Y sar_ctrl_async_phys_0.sg13g2_nor2_1$1_5.A 1.04083f
C564 sar_ctrl_async_phys_0.sg13g2_a22oi_1$1_1.A2 a_34520_38224# 0.01328f
C565 sar_ctrl_async_phys_0.sg13g2_a21oi_1$1_6.B1 sar_ctrl_async_phys_0.sg13g2_a21oi_1$1_6.A2 0.3835f
C566 sar_ctrl_async_phys_0.sg13g2_a21oi_1$1_3.B1 sar_ctrl_async_phys_0.sg13g2_nand2_1$1_2.Y 0.01367f
C567 w_16692_n9960# oa_sar8_acore18_opt_0.sw_bitcell_opt_b0_1.bot 0.13149f
C568 sar_ctrl_async_phys_0.sg13g2_a22oi_1$1_0.B1 sar_ctrl_async_phys_0.sg13g2_inv_1$1_5.A 0.18321f
C569 sar_ctrl_async_phys_0.sg13g2_a21oi_1$1_3.B1 a_35053_40730# 0.02771f
C570 sar_ctrl_async_phys_0.sg13g2_a22oi_1$1_2.A2 a_32715_43020# 0.15709f
C571 a_26954_40424# sar_ctrl_async_phys_0.sg13g2_dlygate4sd3_1$1_6.A 0.01565f
C572 sar_ctrl_async_phys_0.sg13g2_buf_1$1_3.A a_32404_40885# 0.01375f
C573 sar_ctrl_async_phys_0.sg13g2_buf_1$1_37.A sar_ctrl_async_phys_0.sg13g2_a22oi_1$1_4.A2 0.02628f
C574 sar_ctrl_async_phys_0.sg13g2_a21oi_1$1_5.A2 a_32116_40464# 0.01073f
C575 sar_ctrl_async_phys_0.sg13g2_buf_1$1_10.A a_33080_30664# 0.26497f
C576 a_32991_35239# a_33248_35382# 0.34468f
C577 a_31446_35162# a_32020_35175# 0.31978f
C578 a_33648_36010# VDD 0.08533f
C579 sar_ctrl_async_phys_0.dac_code_n[3] sar_ctrl_async_phys_0.dac_code[7] 0.14066f
C580 sar_ctrl_async_phys_0.sg13g2_a22oi_1$1_1.A2 a_34520_33688# 0.04765f
C581 sar_ctrl_async_phys_0.sg13g2_a21oi_1$1_0.A2 sar_ctrl_async_phys_0.bit_active[3] 0.02624f
C582 sar_ctrl_async_phys_0.sg13g2_buf_1$1_3.A a_35103_36751# 0.01729f
C583 sar_ctrl_async_phys_0.sg13g2_o21ai_1$1_1.B1 a_32406_45746# 0.09533f
C584 a_32666_45969# a_32692_46064# 0.36952f
C585 a_34911_41287# a_35578_41508# 0.0894f
C586 a_34069_41189# a_34817_41287# 0.01058f
C587 sar_ctrl_async_phys_0.sg13g2_and2_1$1_0.A a_31644_36638# 0.2575f
C588 sar_ctrl_async_phys_0.sg13g2_nor2_1$1_7.A VDD 0.61638f
C589 sar_ctrl_async_phys_0.sg13g2_a22oi_1$1_0.A1 result[4] 0.07588f
C590 sar_ctrl_async_phys_0.sg13g2_inv_1$1_6.Y VDD 0.43825f
C591 a_34459_44356# a_35199_44311# 0.26905f
C592 sar_ctrl_async_phys_0.sg13g2_nand2b_1$1_0.A_N sar_ctrl_async_phys_0.sg13g2_nand2b_1$1_0.Y 0.02323f
C593 a_34520_47296# sar_ctrl_async_phys_0.sg13g2_buf_1$1_42.A 0.0184f
C594 sar_ctrl_async_phys_0.sg13g2_nor4_1$1_0.C a_33654_44234# 0.01044f
C595 a_29306_32361# VDD 0.09447f
C596 sar_ctrl_async_phys_0.sample oa_sar8_acore18_opt_0.sw_bitcell_opt_b3_1.bot 1.70439f
C597 a_34055_31352# result[3] 0.01332f
C598 sar_ctrl_async_phys_0.dac_code[5] oa_sar8_acore18_opt_0.sw_bitcell_opt_term_0.vin 1.93454f
C599 sar_ctrl_async_phys_0.sg13g2_inv_1$1_11.Y a_30486_31826# 0.28485f
C600 a_33558_36674# VDD 0.8142f
C601 sar_ctrl_async_phys_0.sg13g2_a21oi_1$1_0.B1 sar_ctrl_async_phys_0.sg13g2_nand2_1$1_2.B 0.02283f
C602 sar_ctrl_async_phys_0.dac_code_n[2] sar_ctrl_async_phys_0.dac_code[4] 0.06321f
C603 a_32304_36806# VDD 0.09525f
C604 sar_ctrl_async_phys_0.dac_code_n[3] oa_sar8_acore18_opt_0.sw_bitcell_opt_b1_0.bot 0.10702f
C605 a_34208_45966# VDD 0.18679f
C606 sar_ctrl_async_phys_0.sg13g2_buf_1$1_32.A sar_ctrl_async_phys_0.sg13g2_nand2_1$1_5.B 0.08851f
C607 sar_ctrl_async_phys_0.sg13g2_a21oi_1$1_3.B1 sar_ctrl_async_phys_0.sg13g2_a21oi_1$1_0.A1 0.07178f
C608 sar_ctrl_async_phys_0.sg13g2_buf_1$1_10.A VDD 0.86078f
C609 sar_ctrl_async_phys_0.sg13g2_dfrbpq_1$1_0.CLK a_34767_31359# 0.29165f
C610 sar_ctrl_async_phys_0.sg13g2_nand2b_1$1_0.Y a_28651_39740# 0.29731f
C611 sar_ctrl_async_phys_0.dac_code_n[6] VDD 5.60573f
C612 sar_ctrl_async_phys_0.sg13g2_buf_1$1_7.A a_32443_32260# 0.01956f
C613 oa_sar8_acore18_opt_0.sw_bitcell_opt_term_0.bot m3_60844_n2380# 1.5154f
C614 sar_ctrl_async_phys_0.sg13g2_nor2b_1$1_0.A sar_ctrl_async_phys_0.sg13g2_a22oi_1$1_3.A2 0.07267f
C615 sar_ctrl_async_phys_0.sg13g2_o21ai_1$1_1.B1 a_30650_39921# 0.25874f
C616 VDD busy 0.17562f
C617 sar_ctrl_async_phys_0.sg13g2_nor2_1$1_4.Y sar_ctrl_async_phys_0.sg13g2_dlygate4sd3_1$1_8.X 0.17157f
C618 sar_ctrl_async_phys_0.sg13g2_a21oi_1$1_0.A1 a_35672_38224# 0.04118f
C619 a_31898_32361# a_31924_32456# 0.36952f
C620 sar_ctrl_async_phys_0.sg13g2_buf_1$1_6.X a_34615_31475# 0.43282f
C621 oa_sar8_acore18_opt_0.sw_bitcell_opt_b3_0.bot m3_34580_n2380# 0.01914f
C622 a_26550_41214# VDD 0.22669f
C623 sar_ctrl_async_phys_0.sg13g2_dfrbpq_1$1_0.CLK sar_ctrl_async_phys_0.sg13g2_a21oi_1$1_3.B1 0.01766f
C624 a_35072_39918# a_35482_39996# 0.10373f
C625 a_33973_39677# a_34721_39775# 0.01058f
C626 sar_ctrl_async_phys_0.sg13g2_nor2_1$1_12.Y a_25820_43020# 0.01369f
C627 a_31381_46519# a_32129_46869# 0.01058f
C628 sar_ctrl_async_phys_0.sg13g2_dfrbpq_1$1_0.CLK a_31483_46519# 0.03869f
C629 sar_ctrl_async_phys_0.sg13g2_a22oi_1$1_2.B2 a_32698_31388# 0.12475f
C630 sar_ctrl_async_phys_0.sg13g2_inv_1$1_7.A sar_ctrl_async_phys_0.sg13g2_dlygate4sd3_1$1_0.A 0.11007f
C631 sar_ctrl_async_phys_0.sg13g2_buf_1$1_42.A sar_ctrl_async_phys_0.sg13g2_a21oi_1$1_0.A1 0.06992f
C632 sar_ctrl_async_phys_0.sg13g2_a21oi_1$1_0.B1 sar_ctrl_async_phys_0.dac_code_n[3] 0.03471f
C633 w_39600_n9960# sar_ctrl_async_phys_0.dac_code_n[6] 0.18842f
C634 sar_ctrl_async_phys_0.dac_code_n[6] oa_sar8_acore18_opt_0.sw_bitcell_opt_b6_0.bot 1.20728f
C635 sar_ctrl_async_phys_0.sg13g2_nor2b_1$1_0.A a_34520_38224# 0.26958f
C636 sar_ctrl_async_phys_0.sg13g2_a22oi_1$1_3.B1 a_33168_32986# 0.01039f
C637 sar_ctrl_async_phys_0.dac_code_n[2] oa_sar8_acore18_opt_0.bstrap_opt_w2_c1200_1.out 1.7059f
C638 sar_ctrl_async_phys_0.sg13g2_buf_1$1_2.A sar_ctrl_async_phys_0.sg13g2_buf_1$1_4.A 0.03836f
C639 sar_ctrl_async_phys_0.dac_code_n[0] VDD 3.86728f
C640 sar_ctrl_async_phys_0.dac_code[6] oa_sar8_acore18_opt_0.sw_bitcell_opt_term_0.trkb 2.10643f
C641 m3_48572_n2380# m3_51760_n2380# 0.0157f
C642 sar_ctrl_async_phys_0.sg13g2_dfrbpq_1$1_0.CLK a_33248_35382# 0.01103f
C643 sar_ctrl_async_phys_0.sg13g2_buf_1$1_2.A result[0] 0.01795f
C644 sar_ctrl_async_phys_0.bit_active[5] VDD 0.09413f
C645 oa_sar8_acore18_opt_0.sw_bitcell_opt_term_0.trkb vinn 0.14717f
C646 sar_ctrl_async_phys_0.sg13g2_nand2_1$1_5.B sar_ctrl_async_phys_0.sg13g2_buf_1$1_15.A 0.23426f
C647 a_35664_37695# VDD 0.38799f
C648 sar_ctrl_async_phys_0.sg13g2_buf_1$1_42.A sar_ctrl_async_phys_0.sg13g2_dfrbpq_1$1_0.CLK 0.11572f
C649 sar_ctrl_async_phys_0.sg13g2_nor2b_1$1_2.Y sar_ctrl_async_phys_0.sg13g2_buf_1$1_4.A 0.03592f
C650 a_31732_35480# a_32991_35239# 0.01529f
C651 sar_ctrl_async_phys_0.sg13g2_a22oi_1$1_3.A2 sar_ctrl_async_phys_0.sg13g2_nor2b_1$1_1.B_N 1.04145f
C652 sar_ctrl_async_phys_0.sg13g2_nor2_1$1_5.A a_29210_38916# 0.02407f
C653 sar_ctrl_async_phys_0.sg13g2_dlygate4sd3_1$1_5.A sar_ctrl_async_phys_0.sg13g2_dlygate4sd3_1$1_8.X 0.0562f
C654 sar_ctrl_async_phys_0.dac_code_n[0] oa_sar8_acore18_opt_0.sw_bitcell_opt_b6_0.bot 0.66916f
C655 a_34904_47296# sar_ctrl_async_phys_0.sg13g2_a21oi_1$1_0.B1 0.01537f
C656 a_33654_44234# a_33940_44552# 0.41329f
C657 sar_ctrl_async_phys_0.dac_code[1] oa_sar8_acore18_opt_0.sw_bitcell_opt_b7_0.bot 2.35385f
C658 sar_ctrl_async_phys_0.sg13g2_buf_1$1_13.A sar_ctrl_async_phys_0.sg13g2_nor2_1$1_15.Y 0.11967f
C659 sar_ctrl_async_phys_0.sg13g2_nor2b_1$1_0.Y a_31802_37404# 0.02833f
C660 sar_ctrl_async_phys_0.sample oa_sar8_acore18_opt_0.sw_bitcell_opt_b7_1.bot 2.35718f
C661 sar_ctrl_async_phys_0.dac_code[6] oa_sar8_acore18_opt_0.sw_bitcell_opt_b4_0.bot 0.57019f
C662 sar_ctrl_async_phys_0.dac_code_n[7] VDD 6.1058f
C663 sar_ctrl_async_phys_0.sg13g2_and2_1$1_6.X sar_ctrl_async_phys_0.sg13g2_buf_1$1_13.A 0.08351f
C664 sar_ctrl_async_phys_0.sg13g2_buf_1$1_14.A a_33558_36674# 0.01632f
C665 sar_ctrl_async_phys_0.dac_code[3] oa_sar8_acore18_opt_0.sw_bitcell_opt_term_0.trkb 1.83157f
C666 sar_ctrl_async_phys_0.sg13g2_a21oi_1$1_0.A2 a_36336_36010# 0.01383f
C667 sar_ctrl_async_phys_0.sg13g2_nor2_1$1_10.B a_31563_43020# 0.15657f
C668 a_31140_42690# sar_ctrl_async_phys_0.sg13g2_and2_1$1_6.X 0.27188f
C669 a_32687_32876# VDD 0.30484f
C670 sar_ctrl_async_phys_0.sg13g2_nand2b_1$1_3.Y sar_ctrl_async_phys_0.sg13g2_a22oi_1$1_3.A2 0.02088f
C671 sar_ctrl_async_phys_0.sg13g2_a21oi_1$1_0.A1 sar_ctrl_async_phys_0.sg13g2_a21oi_1$1_5.Y 0.18188f
C672 sar_ctrl_async_phys_0.sg13g2_a21oi_1$1_6.A2 a_33109_45725# 0.01174f
C673 a_31477_44213# a_32225_44311# 0.01058f
C674 a_32319_44311# a_32986_44532# 0.0894f
C675 sar_ctrl_async_phys_0.dac_code[3] sar_ctrl_async_phys_0.cmp_n 0.07708f
C676 sar_ctrl_async_phys_0.sg13g2_inv_1$1_2.Y sar_ctrl_async_phys_0.sg13g2_inv_1$1_1.Y 0.01757f
C677 sar_ctrl_async_phys_0.sg13g2_a22oi_1$1_1.Y sar_ctrl_async_phys_0.sg13g2_a22oi_1$1_2.B2 0.07514f
C678 a_34136_33688# result[4] 0.09102f
C679 sar_ctrl_async_phys_0.sg13g2_nor2_1$1_2.Y sar_ctrl_async_phys_0.sg13g2_nor2_1$1_15.Y 0.18891f
C680 sar_ctrl_async_phys_0.sg13g2_dfrbpq_1$1_0.CLK a_34636_31749# 0.11269f
C681 sar_ctrl_async_phys_0.sg13g2_nor2_1$1_2.Y sar_ctrl_async_phys_0.sg13g2_and2_1$1_6.X 0.01875f
C682 sar_ctrl_async_phys_0.sg13g2_nand2_1$1_3.A a_34363_43495# 0.03284f
C683 a_32404_40885# a_32635_40471# 0.12701f
C684 a_32116_40464# a_33281_40821# 0.43239f
C685 sar_ctrl_async_phys_0.sg13g2_nor2b_1$1_2.Y a_34266_37436# 0.01475f
C686 sar_ctrl_async_phys_0.dac_code_n[7] oa_sar8_acore18_opt_0.sw_bitcell_opt_b6_0.bot 0.87364f
C687 w_39600_n9960# sar_ctrl_async_phys_0.dac_code_n[7] 0.1684f
C688 a_34363_43495# a_35103_43845# 0.26905f
C689 sar_ctrl_async_phys_0.sg13g2_a21oi_1$1_4.A2 a_31563_43020# 0.10443f
C690 sar_ctrl_async_phys_0.sg13g2_a22oi_1$1_2.A2 sar_ctrl_async_phys_0.sg13g2_buf_1$1_17.A 0.65089f
C691 sar_ctrl_async_phys_0.sg13g2_dfrbpq_1$1_0.CLK sar_ctrl_async_phys_0.sg13g2_a21oi_1$1_5.Y 0.17941f
C692 sar_ctrl_async_phys_0.sg13g2_nand2b_1$1_4.A_N a_34224_45082# 0.01791f
C693 sar_ctrl_async_phys_0.sg13g2_buf_1$1_42.A a_35245_45936# 0.28699f
C694 sar_ctrl_async_phys_0.dac_code[3] oa_sar8_acore18_opt_0.sw_bitcell_opt_b4_0.bot 0.43407f
C695 sar_ctrl_async_phys_0.sg13g2_a22oi_1$1_0.B1 a_29812_33968# 0.02525f
C696 sar_ctrl_async_phys_0.sg13g2_buf_1$1_6.X a_34055_31352# 0.17199f
C697 sar_ctrl_async_phys_0.sg13g2_nor4_1$1_0.C sar_ctrl_async_phys_0.cmp_valid 0.03883f
C698 sar_ctrl_async_phys_0.sg13g2_nor2_1$1_10.A sar_ctrl_async_phys_0.sg13g2_nor2_1$1_10.B 0.22459f
C699 sar_ctrl_async_phys_0.bit_active[0] done 0.01107f
C700 sar_ctrl_async_phys_0.sg13g2_a21oi_1$1_5.Y a_31446_35162# 0.05873f
C701 sar_ctrl_async_phys_0.sg13g2_nand2_1$1_5.B a_34520_42760# 0.02891f
C702 a_33556_40016# a_34815_39775# 0.01529f
C703 sar_ctrl_async_phys_0.sg13g2_a21oi_1$1_6.B1 sar_ctrl_async_phys_0.sg13g2_a21oi_1$1_0.A1 0.10768f
C704 sar_ctrl_async_phys_0.sg13g2_a21oi_1$1_4.B1 sar_ctrl_async_phys_0.sg13g2_nor2_1$1_10.B 0.28164f
C705 sar_ctrl_async_phys_0.sg13g2_nand2b_1$1_3.Y a_34357_44213# 0.02911f
C706 sar_ctrl_async_phys_0.sg13g2_nor2b_1$1_0.A a_33556_40016# 0.01578f
C707 sar_ctrl_async_phys_0.dac_code_n[6] oa_sar8_acore18_opt_0.sw_bitcell_opt_b2_0.bot 0.08472f
C708 sar_ctrl_async_phys_0.sg13g2_a21oi_1$1_4.B1 sar_ctrl_async_phys_0.dac_code_n[3] 0.03222f
C709 a_30678_46946# a_31483_46519# 0.097f
C710 sar_ctrl_async_phys_0.sg13g2_nor2_1$1_11.Y a_29524_40464# 0.0109f
C711 sar_ctrl_async_phys_0.sg13g2_buf_1$1_3.A a_36056_37436# 0.01804f
C712 a_31195_39820# VDD 0.20623f
C713 a_33844_36992# a_35009_36751# 0.43239f
C714 a_35103_36751# a_35360_36894# 0.34468f
C715 a_34363_36796# a_34132_36687# 0.12701f
C716 a_30027_39996# VDD 0.2948f
C717 sar_ctrl_async_phys_0.sg13g2_nor2b_1$1_4.Y a_32580_43448# 0.24634f
C718 a_30879_43845# a_30785_43845# 0.28931f
C719 sar_ctrl_async_phys_0.sg13g2_a22oi_1$1_3.A2 sar_ctrl_async_phys_0.sg13g2_a22oi_1$1_1.Y 0.05577f
C720 sar_ctrl_async_phys_0.sample oa_sar8_acore18_opt_0.bstrap_opt_w2_c1200_1.out 0.83538f
C721 a_30139_43495# a_31136_43726# 0.03061f
C722 sar_ctrl_async_phys_0.sg13g2_and2_1$1_6.X a_32090_40428# 0.01799f
C723 sar_ctrl_async_phys_0.sg13g2_a21oi_1$1_2.B1 a_34911_41287# 0.0147f
C724 sar_ctrl_async_phys_0.sg13g2_nor2b_1$1_4.Y a_31136_43726# 0.02588f
C725 sar_ctrl_async_phys_0.sg13g2_a21oi_1$1_5.Y a_32116_40464# 0.05054f
C726 sar_ctrl_async_phys_0.dac_code_n[3] oa_sar8_acore18_opt_0.sw_bitcell_opt_b3_1.bot 1.31061f
C727 m3_34580_n2380# m3_38288_n2380# 0.0157f
C728 sar_ctrl_async_phys_0.sg13g2_dfrbpq_1$1_0.CLK a_31732_35480# 0.0833f
C729 sar_ctrl_async_phys_0.sg13g2_a21oi_1$1_4.B1 sar_ctrl_async_phys_0.sg13g2_a21oi_1$1_4.A2 0.07587f
C730 sar_ctrl_async_phys_0.sg13g2_a21oi_1$1_6.B1 sar_ctrl_async_phys_0.sg13g2_dfrbpq_1$1_0.CLK 1.01038f
C731 sar_ctrl_async_phys_0.sg13g2_nor2_1$1_4.Y VDD 2.70005f
C732 sar_ctrl_async_phys_0.sg13g2_nand2_1$1_3.A a_34765_45266# 0.03395f
C733 sar_ctrl_async_phys_0.sg13g2_a22oi_1$1_2.A2 sar_ctrl_async_phys_0.sg13g2_and2_1$1_6.X 0.01837f
C734 sar_ctrl_async_phys_0.sg13g2_buf_1$1_41.X a_34357_44213# 0.03582f
C735 a_34319_32460# VDD 0.31085f
C736 a_31802_37404# VDD 0.09647f
C737 sar_ctrl_async_phys_0.sg13g2_dfrbpq_1$1_0.CLK a_34555_35935# 0.0455f
C738 a_33850_32436# VDD 0.39173f
C739 sar_ctrl_async_phys_0.sg13g2_a22oi_1$1_1.B2 result[6] 0.17364f
C740 a_31446_35162# a_31732_35480# 0.41329f
C741 sar_ctrl_async_phys_0.sg13g2_dfrbpq_1$1_0.CLK a_31034_44457# 0.0151f
C742 a_31093_35935# VDD 0.25066f
C743 a_31706_35385# a_31446_35162# 0.75507f
C744 sar_ctrl_async_phys_0.dac_code_n[0] oa_sar8_acore18_opt_0.sw_bitcell_opt_b2_0.bot 0.12572f
C745 a_35288_47296# sar_ctrl_async_phys_0.sg13g2_a21oi_1$1_6.B1 0.0117f
C746 sar_ctrl_async_phys_0.dac_code[4] oa_sar8_acore18_opt_0.sw_tg_opt_0.bot 0.88445f
C747 sar_ctrl_async_phys_0.sg13g2_dfrbpq_1$1_0.CLK a_32533_40471# 0.24827f
C748 sar_ctrl_async_phys_0.sg13g2_buf_1$1_19.A a_33652_41528# 0.04665f
C749 sar_ctrl_async_phys_0.sg13g2_and2_1$1_3.X sar_ctrl_async_phys_0.sg13g2_buf_1$1_26.X 0.01539f
C750 sar_ctrl_async_phys_0.sg13g2_nor2b_1$1_4.Y a_31034_44457# 0.02669f
C751 sar_ctrl_async_phys_0.dac_code[6] oa_sar8_acore18_opt_0.sw_bitcell_opt_b0_0.bot 0.37274f
C752 sar_ctrl_async_phys_0.sg13g2_a21oi_1$1_1.B1 sar_ctrl_async_phys_0.dac_code[2] 0.01168f
C753 sar_ctrl_async_phys_0.cmp_n a_30632_22281# 1.92064f
C754 sar_ctrl_async_phys_0.sg13g2_nand2_1$1_3.A sar_ctrl_async_phys_0.sg13g2_nand2_1$1_3.Y 0.31357f
C755 sar_ctrl_async_phys_0.sg13g2_buf_1$1_36.A sar_ctrl_async_phys_0.sg13g2_buf_1$1_46.A 0.11042f
C756 sar_ctrl_async_phys_0.sg13g2_buf_1$1_29.X sar_ctrl_async_phys_0.hold_req 0.03319f
C757 sar_ctrl_async_phys_0.sg13g2_a21oi_1$1_0.A2 a_34555_35935# 0.03075f
C758 a_33846_33338# VDD 0.80732f
C759 sar_ctrl_async_phys_0.sg13g2_a22oi_1$1_1.Y a_34520_33688# 0.01148f
C760 sar_ctrl_async_phys_0.sg13g2_nor2b_1$1_0.A a_32304_36806# 0.01904f
C761 a_34324_36349# a_34555_35935# 0.12701f
C762 a_34453_35935# a_35201_36285# 0.01058f
C763 sar_ctrl_async_phys_0.sg13g2_dfrbpq_1$1_0.CLK sar_ctrl_async_phys_0.sg13g2_nand2b_1$1_1.B 0.13508f
C764 sar_ctrl_async_phys_0.sg13g2_nand3_1$1_0.C track 0.14129f
C765 sar_ctrl_async_phys_0.sg13g2_buf_1$1_15.A sar_ctrl_async_phys_0.bit_active[6] 0.02739f
C766 sar_ctrl_async_phys_0.sg13g2_inv_1$1_2.Y a_32443_32260# 0.0287f
C767 sar_ctrl_async_phys_0.sg13g2_a22oi_1$1_2.A2 sar_ctrl_async_phys_0.sg13g2_buf_1$1_6.X 0.10589f
C768 sar_ctrl_async_phys_0.dac_code_n[7] oa_sar8_acore18_opt_0.sw_bitcell_opt_b2_0.bot 0.12526f
C769 sar_ctrl_async_phys_0.dac_code_n[6] sar_ctrl_async_phys_0.sg13g2_buf_1$1_20.A 0.36521f
C770 sar_ctrl_async_phys_0.sg13g2_nor4_1$1_0.C sar_ctrl_async_phys_0.sg13g2_nor2_1$1_11.Y 0.01817f
C771 sar_ctrl_async_phys_0.sg13g2_and2_1$1_1.B a_35770_36972# 0.12463f
C772 a_32116_40464# a_32533_40471# 0.37583f
C773 sar_ctrl_async_phys_0.sg13g2_a21oi_1$1_5.Y a_31841_39775# 0.01379f
C774 a_31830_40898# a_32404_40885# 0.31978f
C775 sar_ctrl_async_phys_0.sg13g2_a21oi_1$1_0.A2 a_34363_36796# 0.04528f
C776 sar_ctrl_async_phys_0.dac_code[3] oa_sar8_acore18_opt_0.sw_bitcell_opt_b0_0.bot 0.15675f
C777 sar_ctrl_async_phys_0.sg13g2_dlygate4sd3_1$1_5.A VDD 1.03022f
C778 sar_ctrl_async_phys_0.sg13g2_and2_1$1_0.A sar_ctrl_async_phys_0.sg13g2_nor2_1$1_12.Y 0.27036f
C779 a_33558_43922# a_34363_43495# 0.097f
C780 sar_ctrl_async_phys_0.sg13g2_buf_1$1_15.A a_33818_43452# 0.01409f
C781 sar_ctrl_async_phys_0.sg13g2_a21oi_1$1_0.B1 sar_ctrl_async_phys_0.cmp_valid 0.28683f
C782 sar_ctrl_async_phys_0.sg13g2_nor2_1$1_4.Y a_26954_40424# 0.01057f
C783 sar_ctrl_async_phys_0.sg13g2_buf_1$1_42.A a_32692_46064# 0.03513f
C784 a_32991_45357# a_32897_45357# 0.28931f
C785 a_29749_32117# a_29620_32151# 0.01562f
C786 a_36058_32900# result[4] 0.02147f
C787 sar_ctrl_async_phys_0.sg13g2_a22oi_1$1_0.B1 a_31832_34412# 0.26791f
C788 sar_ctrl_async_phys_0.sg13g2_nor2_1$1_0.Y a_32576_44454# 0.01109f
C789 sar_ctrl_async_phys_0.dac_code_n[6] oa_sar8_acore18_opt_0.sw_bitcell_opt_b7_1.VSS 1.419f
C790 sar_ctrl_async_phys_0.sg13g2_a21oi_1$1_0.A1 sar_ctrl_async_phys_0.sg13g2_buf_1$1_4.A 0.02052f
C791 sar_ctrl_async_phys_0.hold_req oa_sar8_acore18_opt_0.sw_bitcell_opt_b5_0.bot 0.08873f
C792 sar_ctrl_async_phys_0.sg13g2_nor2b_1$1_0.A a_30964_39711# 0.02043f
C793 a_34549_30605# a_34420_30639# 0.01562f
C794 sar_ctrl_async_phys_0.bit_active[1] done 0.02797f
C795 a_34261_36653# a_34363_36796# 0.47622f
C796 a_33818_36897# a_33844_36992# 0.36952f
C797 sar_ctrl_async_phys_0.sg13g2_nor2b_1$1_1.B_N a_33558_36674# 0.01288f
C798 sar_ctrl_async_phys_0.sg13g2_a22oi_1$1_0.B2 result[3] 0.03099f
C799 sar_ctrl_async_phys_0.sg13g2_buf_1$1_20.A sar_ctrl_async_phys_0.bit_active[5] 0.09357f
C800 sar_ctrl_async_phys_0.sg13g2_nor2_1$1_1.Y VDD 0.60913f
C801 sar_ctrl_async_phys_0.sg13g2_dfrbpq_1$1_11.D a_31716_38912# 0.04916f
C802 sar_ctrl_async_phys_0.sg13g2_buf_1$1_20.A a_35664_37695# 0.02377f
C803 a_20412_n9612# a_21332_n9711# 0.23797f
C804 a_35245_45936# sar_ctrl_async_phys_0.sg13g2_nand2b_1$1_1.B 0.26568f
C805 sar_ctrl_async_phys_0.sg13g2_dfrbpq_1$1_0.CLK sar_ctrl_async_phys_0.sg13g2_buf_1$1_4.A 0.24558f
C806 sar_ctrl_async_phys_0.dac_code_n[3] sar_ctrl_async_phys_0.dac_code[4] 0.72379f
C807 sar_ctrl_async_phys_0.dac_code[6] a_35948_n9612# 1.03492f
C808 sar_ctrl_async_phys_0.sg13g2_buf_1$1_37.A a_33276_42686# 0.25863f
C809 a_35948_n9612# vinn 0.98838f
C810 sar_ctrl_async_phys_0.sg13g2_a22oi_1$1_2.Y sar_ctrl_async_phys_0.sg13g2_inv_1$1_3.Y 0.06853f
C811 sar_ctrl_async_phys_0.sg13g2_a22oi_1$1_4.A2 a_33652_41528# 0.05041f
C812 oa_sar8_acore18_opt_0.sw_bitcell_opt_term_0.vin m3_60844_n2380# 0.05057f
C813 sar_ctrl_async_phys_0.dac_code_n[0] oa_sar8_acore18_opt_0.sw_bitcell_opt_b7_1.VSS 0.91217f
C814 a_35672_47296# sar_ctrl_async_phys_0.sg13g2_a21oi_1$1_4.B1 0.01001f
C815 sar_ctrl_async_phys_0.sg13g2_buf_1$1_10.A a_32698_31388# 0.0141f
C816 a_31924_32456# VDD 0.07402f
C817 sar_ctrl_async_phys_0.sg13g2_nor2_1$1_6.B VDD 0.28705f
C818 sar_ctrl_async_phys_0.sg13g2_o21ai_1$1_1.B1 sar_ctrl_async_phys_0.sg13g2_buf_1$1_19.A 1.17581f
C819 sar_ctrl_async_phys_0.sg13g2_a21oi_1$1_0.A1 sar_ctrl_async_phys_0.sg13g2_nand2_1$1_5.Y 0.04887f
C820 a_31291_31399# a_32288_31630# 0.03061f
C821 sar_ctrl_async_phys_0.sg13g2_dfrbpq_1$1_0.CLK sar_ctrl_async_phys_0.sg13g2_nor2_1$1_8.B 0.02874f
C822 sar_ctrl_async_phys_0.sg13g2_buf_1$1_15.A sar_ctrl_async_phys_0.sg13g2_nand2b_1$1_1.Y 0.0111f
C823 sar_ctrl_async_phys_0.sg13g2_nand2b_1$1_0.A_N sar_ctrl_async_phys_0.sg13g2_nor2_1$1_14.A 0.72338f
C824 sar_ctrl_async_phys_0.sg13g2_a22oi_1$1_0.A1 sar_ctrl_async_phys_0.sg13g2_a22oi_1$1_0.B1 1.79446f
C825 oa_sar8_acore18_opt_0.sw_bitcell_opt_b3_1.bot a_20412_n9612# 0.02079f
C826 oa_sar8_acore18_opt_0.sw_tg_opt_1.bot VDD 1.11363f
C827 sar_ctrl_async_phys_0.sg13g2_buf_1$1_20.A sar_ctrl_async_phys_0.dac_code_n[7] 0.2149f
C828 sar_ctrl_async_phys_0.sg13g2_and2_1$1_3.X a_26184_39702# 0.02461f
C829 sar_ctrl_async_phys_0.sg13g2_a21oi_1$1_0.A2 sar_ctrl_async_phys_0.sg13g2_buf_1$1_4.A 0.15233f
C830 sar_ctrl_async_phys_0.dac_code[4] m3_48572_n2380# 0.02484f
C831 sar_ctrl_async_phys_0.sg13g2_buf_1$1_37.A a_33085_43832# 0.14551f
C832 sar_ctrl_async_phys_0.sg13g2_dfrbpq_1$1_0.CLK a_34420_33325# 0.01513f
C833 sar_ctrl_async_phys_0.sg13g2_inv_1$1_1.Y a_33752_33688# 0.06918f
C834 sar_ctrl_async_phys_0.dac_code_n[6] oa_sar8_acore18_opt_0.sw_bitcell_opt_b2_1.bot 0.06598f
C835 sar_ctrl_async_phys_0.sg13g2_dfrbpq_1$1_0.CLK sar_ctrl_async_phys_0.sg13g2_nand2_1$1_5.Y 0.09108f
C836 sar_ctrl_async_phys_0.sg13g2_a22oi_1$1_1.A2 a_33846_33338# 0.04486f
C837 a_33750_36362# a_34555_35935# 0.097f
C838 sar_ctrl_async_phys_0.dac_code[3] a_35948_n9612# 2.19972f
C839 sar_ctrl_async_phys_0.sg13g2_dfrbpq_1$1_0.CLK a_33109_45725# 0.25909f
C840 sar_ctrl_async_phys_0.sg13g2_inv_1$1_5.A VDD 0.30534f
C841 sar_ctrl_async_phys_0.sg13g2_dfrbpq_1$1_0.CLK sar_ctrl_async_phys_0.sg13g2_inv_1$1_3.Y 0.028f
C842 sar_ctrl_async_phys_0.dac_code_n[7] oa_sar8_acore18_opt_0.sw_bitcell_opt_b7_1.VSS 1.51874f
C843 sar_ctrl_async_phys_0.sg13g2_a21oi_1$1_1.B1 sar_ctrl_async_phys_0.sg13g2_a21oi_1$1_3.B1 0.42352f
C844 sar_ctrl_async_phys_0.hold_req sar_ctrl_async_phys_0.dac_code[7] 0.13327f
C845 sar_ctrl_async_phys_0.sg13g2_nand2_1$1_3.A VDD 1.0854f
C846 sar_ctrl_async_phys_0.sg13g2_buf_1$1_4.A a_34261_36653# 0.01725f
C847 sar_ctrl_async_phys_0.sg13g2_buf_1$1_19.A sar_ctrl_async_phys_0.sg13g2_nor2b_1$1_1.Y 0.08269f
C848 sar_ctrl_async_phys_0.dac_code_n[3] oa_sar8_acore18_opt_0.bstrap_opt_w2_c1200_1.out 1.74774f
C849 sar_ctrl_async_phys_0.sg13g2_buf_1$1_4.A a_32888_36806# 0.02286f
C850 sar_ctrl_async_phys_0.sg13g2_a21oi_1$1_4.B1 sar_ctrl_async_phys_0.cmp_valid 0.05818f
C851 a_35103_43845# VDD 0.1734f
C852 sar_ctrl_async_phys_0.sg13g2_a21oi_1$1_6.B1 a_32692_46064# 0.01146f
C853 sar_ctrl_async_phys_0.sg13g2_nand2_1$1_3.B sar_ctrl_async_phys_0.dac_code_n[7] 0.02399f
C854 sar_ctrl_async_phys_0.sg13g2_a21oi_1$1_5.Y sar_ctrl_async_phys_0.sg13g2_nor2_1$1_18.A 0.12785f
C855 sar_ctrl_async_phys_0.sg13g2_and2_1$1_0.X a_31261_38232# 0.1052f
C856 sar_ctrl_async_phys_0.dac_code_n[4] sar_ctrl_async_phys_0.dac_code_n[6] 0.38985f
C857 a_30043_40471# a_30783_40821# 0.26905f
C858 a_35648_34654# a_36058_34412# 0.10373f
C859 sar_ctrl_async_phys_0.dac_code_n[0] sar_ctrl_async_phys_0.sg13g2_nand2b_1$1_3.Y 0.05798f
C860 a_35557_31435# result[2] 0.01431f
C861 sar_ctrl_async_phys_0.sg13g2_dlygate4sd3_1$1_1.A a_27894_35924# 0.01144f
C862 a_29332_32456# a_29851_32260# 0.34114f
C863 sar_ctrl_async_phys_0.sg13g2_a21oi_1$1_0.A1 sar_ctrl_async_phys_0.sg13g2_a21oi_1$1_2.Y 0.61649f
C864 sar_ctrl_async_phys_0.hold_req oa_sar8_acore18_opt_0.sw_bitcell_opt_b1_0.bot 0.11752f
C865 sar_ctrl_async_phys_0.sg13g2_nor2_1$1_1.Y sar_ctrl_async_phys_0.sg13g2_nor2b_1$1_3.Y 0.03063f
C866 sar_ctrl_async_phys_0.sg13g2_a22oi_1$1_2.A2 sar_ctrl_async_phys_0.sg13g2_dfrbpq_1$1_9.D 0.23059f
C867 sar_ctrl_async_phys_0.sg13g2_nor2_1$1_4.Y a_26570_42690# 0.0612f
C868 a_35391_33261# a_36058_32900# 0.0894f
C869 sar_ctrl_async_phys_0.sg13g2_buf_1$1_42.A sar_ctrl_async_phys_0.sg13g2_a21oi_1$1_1.B1 0.50816f
C870 sar_ctrl_async_phys_0.sg13g2_nand2b_1$1_0.A_N sar_ctrl_async_phys_0.sg13g2_and2_1$1_3.X 0.01256f
C871 sar_ctrl_async_phys_0.sg13g2_and2_1$1_0.A track 0.203f
C872 a_34132_30944# a_34651_30748# 0.34114f
C873 sar_ctrl_async_phys_0.sg13g2_a21oi_1$1_0.A1 sar_ctrl_async_phys_0.sg13g2_inv_1$1_7.A 0.0887f
C874 sar_ctrl_async_phys_0.sg13g2_dfrbpq_1$1_0.CLK sar_ctrl_async_phys_0.sg13g2_a21oi_1$1_2.Y 0.09893f
C875 sar_ctrl_async_phys_0.sg13g2_nor2_1$1_10.B a_30676_35928# 0.04215f
C876 a_30830_35166# VDD 0.1059f
C877 sar_ctrl_async_phys_0.dac_code_n[0] sar_ctrl_async_phys_0.dac_code_n[4] 0.16381f
C878 sar_ctrl_async_phys_0.sg13g2_nand2b_1$1_3.Y sar_ctrl_async_phys_0.dac_code_n[7] 1.12215f
C879 sar_ctrl_async_phys_0.sg13g2_nor2_1$1_1.Y sar_ctrl_async_phys_0.sg13g2_a22oi_1$1_1.A2 0.19134f
C880 sar_ctrl_async_phys_0.sg13g2_o21ai_1$1_1.B1 sar_ctrl_async_phys_0.sg13g2_a22oi_1$1_4.A2 0.9518f
C881 sar_ctrl_async_phys_0.dac_code_n[6] sar_ctrl_async_phys_0.sg13g2_buf_1$1_37.A 0.14451f
C882 sar_ctrl_async_phys_0.dac_code_n[7] oa_sar8_acore18_opt_0.sw_bitcell_opt_b2_1.bot 0.15756f
C883 a_28368_36877# sar_ctrl_async_phys_0.sg13g2_dlygate4sd3_1$1_0.X 0.18369f
C884 a_35725_45266# VDD 0.24701f
C885 sar_ctrl_async_phys_0.sg13g2_buf_1$1_5.A VDD 0.39356f
C886 oa_sar8_acore18_opt_0.sw_bitcell_opt_term_0.vin m3_34580_n2380# 0.05057f
C887 sar_ctrl_async_phys_0.sg13g2_dfrbpq_1$1_0.CLK a_31195_35935# 0.01835f
C888 a_30848_32358# VDD 0.16874f
C889 sar_ctrl_async_phys_0.sg13g2_inv_1$1_10.Y a_28130_40838# 0.11562f
C890 a_26184_39702# a_26454_39702# 0.26306f
C891 sar_ctrl_async_phys_0.sg13g2_dfrbpq_1$1_0.CLK sar_ctrl_async_phys_0.sg13g2_nor2_1$1_3.Y 0.24651f
C892 a_28008_23477# oa_sar8_acore18_opt_0.sw_tg_opt_0.bot 0.84269f
C893 oa_sar8_acore18_opt_0.sw_tg_opt_1.bot a_26184_21025# 0.8014f
C894 sar_ctrl_async_phys_0.sg13g2_and2_1$1_1.B a_35664_37695# 0.28054f
C895 sar_ctrl_async_phys_0.sg13g2_o21ai_1$1_1.B1 a_29755_38959# 0.43068f
C896 a_35648_30846# VDD 0.16813f
C897 sar_ctrl_async_phys_0.dac_code_n[6] sar_ctrl_async_phys_0.dac_code[0] 0.0797f
C898 sar_ctrl_async_phys_0.sg13g2_and2_1$1_0.A a_29755_38959# 0.01515f
C899 sar_ctrl_async_phys_0.sg13g2_buf_1$1_32.A a_34228_44247# 0.02683f
C900 sar_ctrl_async_phys_0.sg13g2_buf_1$1_6.X sar_ctrl_async_phys_0.sg13g2_a22oi_1$1_0.B2 0.16407f
C901 sar_ctrl_async_phys_0.sg13g2_buf_1$1_41.X sar_ctrl_async_phys_0.dac_code_n[7] 0.01055f
C902 sar_ctrl_async_phys_0.sg13g2_dlygate4sd3_1$1_6.X track 1.36804f
C903 a_30752_39190# a_31162_38948# 0.10373f
C904 a_32347_37447# a_33344_37678# 0.03061f
C905 sar_ctrl_async_phys_0.dac_code_n[6] oa_sar8_acore18_opt_0.sw_bitcell_opt_b6_1.bot 1.4314f
C906 sar_ctrl_async_phys_0.sg13g2_buf_1$1_1.A result[7] 0.04778f
C907 sar_ctrl_async_phys_0.sg13g2_buf_1$1_26.X sar_ctrl_async_phys_0.sg13g2_nor2_1$1_3.Y 0.03053f
C908 sar_ctrl_async_phys_0.dac_code_n[4] sar_ctrl_async_phys_0.dac_code_n[7] 0.12955f
C909 sar_ctrl_async_phys_0.sg13g2_dfrbpq_1$1_0.CLK a_34132_32904# 0.08571f
C910 sar_ctrl_async_phys_0.sg13g2_dlygate4sd3_1$1_5.A a_26570_42690# 0.41f
C911 a_34800_39034# VDD 0.09245f
C912 sar_ctrl_async_phys_0.sg13g2_a22oi_1$1_4.A2 sar_ctrl_async_phys_0.sg13g2_nor2b_1$1_1.Y 0.04609f
C913 a_31716_38912# VDD 0.19209f
C914 sar_ctrl_async_phys_0.sg13g2_and2_1$1_0.A a_31064_38318# 0.02675f
C915 sar_ctrl_async_phys_0.sg13g2_buf_1$1_4.A a_32580_36642# 0.27767f
C916 sar_ctrl_async_phys_0.sg13g2_a21oi_1$1_6.A2 a_32888_43570# 0.01964f
C917 sar_ctrl_async_phys_0.dac_code_n[0] sar_ctrl_async_phys_0.dac_code[0] 0.07052f
C918 sar_ctrl_async_phys_0.sg13g2_a22oi_1$1_2.A2 a_32192_36166# 0.02708f
C919 a_33558_43922# VDD 0.80918f
C920 oa_sar8_acore18_opt_0.sw_bitcell_opt_b5_0.bot oa_sar8_acore18_opt_0.sw_bitcell_opt_term_0.VSS 2.09854f
C921 a_34549_34423# a_34420_34837# 0.01562f
C922 a_34132_34416# a_34651_34423# 0.34102f
C923 sar_ctrl_async_phys_0.sg13g2_buf_1$1_36.A a_35866_44532# 0.05521f
C924 a_31706_44964# a_32149_45007# 0.02242f
C925 sar_ctrl_async_phys_0.dac_code[6] oa_sar8_acore18_opt_0.sw_bitcell_opt_b7_0.bot 2.37893f
C926 sar_ctrl_async_phys_0.sg13g2_buf_1$1_3.A sar_ctrl_async_phys_0.sg13g2_buf_1$1_21.A 0.62827f
C927 sar_ctrl_async_phys_0.dac_code_n[5] oa_sar8_acore18_opt_0.sw_bitcell_opt_term_0.trkb 2.03605f
C928 sar_ctrl_async_phys_0.sg13g2_a21oi_1$1_6.B1 sar_ctrl_async_phys_0.sg13g2_a21oi_1$1_1.B1 0.14122f
C929 sar_ctrl_async_phys_0.sg13g2_buf_1$1_37.A sar_ctrl_async_phys_0.dac_code_n[7] 0.04981f
C930 sar_ctrl_async_phys_0.dac_code[2] a_36056_41972# 0.02826f
C931 oa_sar8_acore18_opt_0.sw_bitcell_opt_term_0.trkb oa_sar8_acore18_opt_0.sw_bitcell_opt_term_0.gb 9.49663f
C932 oa_sar8_acore18_opt_0.bstrap_opt_w2_c1200_1.out a_20412_n9612# 0.06429f
C933 sar_ctrl_async_phys_0.sg13g2_nand2_1$1_1.B VDD 0.62215f
C934 sar_ctrl_async_phys_0.dac_code[1] sar_ctrl_async_phys_0.sg13g2_nand2b_1$1_1.Y 0.02508f
C935 sar_ctrl_async_phys_0.dac_code_n[5] sar_ctrl_async_phys_0.cmp_n 0.0675f
C936 sar_ctrl_async_phys_0.sg13g2_a22oi_1$1_4.A2 sar_ctrl_async_phys_0.sg13g2_a22oi_1$1_3.B1 0.02782f
C937 sar_ctrl_async_phys_0.sg13g2_nor2_1$1_13.B sar_ctrl_async_phys_0.sg13g2_dlygate4sd3_1$1_6.A 0.03968f
C938 sar_ctrl_async_phys_0.sg13g2_o21ai_1$1_1.B1 a_29941_40471# 0.05147f
C939 sar_ctrl_async_phys_0.sg13g2_nor2_1$1_1.Y sar_ctrl_async_phys_0.sg13g2_buf_1$1_20.A 0.04233f
C940 a_33109_45725# a_32980_45759# 0.01562f
C941 a_31261_38232# a_31064_38318# 0.01798f
C942 sar_ctrl_async_phys_0.sg13g2_and2_1$1_0.A a_31640_34498# 0.01966f
C943 sar_ctrl_async_phys_0.dac_code_n[6] oa_sar8_acore18_opt_0.sw_bitcell_opt_term_1.bot 0.06773f
C944 sar_ctrl_async_phys_0.dac_code[0] sar_ctrl_async_phys_0.dac_code_n[7] 3.04581f
C945 sar_ctrl_async_phys_0.sg13g2_nor2_1$1_1.Y sar_ctrl_async_phys_0.sg13g2_nor2b_1$1_0.A 0.70781f
C946 sar_ctrl_async_phys_0.dac_code_n[2] sar_ctrl_async_phys_0.sample 0.04458f
C947 a_26280_41214# a_26550_41214# 0.26306f
C948 sar_ctrl_async_phys_0.sg13g2_nor2_1$1_4.Y a_30964_46512# 0.01122f
C949 a_32692_46064# a_33109_45725# 0.3749f
C950 a_32406_45746# a_33211_45868# 0.097f
C951 sar_ctrl_async_phys_0.dac_code_n[7] oa_sar8_acore18_opt_0.sw_bitcell_opt_b6_1.bot 0.13944f
C952 a_28862_36863# a_28977_36864# 0.55452f
C953 sar_ctrl_async_phys_0.sg13g2_nor2_1$1_4.Y sar_ctrl_async_phys_0.sg13g2_buf_1$1_41.X 0.01284f
C954 sar_ctrl_async_phys_0.dac_code_n[5] oa_sar8_acore18_opt_0.sw_bitcell_opt_b4_0.bot 0.25145f
C955 a_29812_33968# VDD 0.07436f
C956 sar_ctrl_async_phys_0.dac_code[3] oa_sar8_acore18_opt_0.sw_bitcell_opt_b7_0.bot 2.35239f
C957 oa_sar8_acore18_opt_0.sw_bitcell_opt_b4_0.bot oa_sar8_acore18_opt_0.sw_bitcell_opt_term_0.gb 0.62633f
C958 a_35245_42242# VDD 0.24013f
C959 a_32149_45007# VDD 0.25734f
C960 sar_ctrl_async_phys_0.sg13g2_a21oi_1$1_1.B1 sar_ctrl_async_phys_0.sg13g2_nand2b_1$1_1.B 0.94518f
C961 a_34328_41972# VDD 0.24002f
C962 sar_ctrl_async_phys_0.sg13g2_buf_1$1_1.A a_34904_33688# 0.2642f
C963 a_34106_30849# VDD 0.11582f
C964 sar_ctrl_async_phys_0.sg13g2_nand2_1$1_2.Y a_35595_40460# 0.02171f
C965 sar_ctrl_async_phys_0.sg13g2_and2_1$1_0.A a_28560_39034# 0.01649f
C966 rst_n result[0] 0.38687f
C967 sar_ctrl_async_phys_0.sg13g2_buf_1$1_6.X a_32341_32117# 0.04031f
C968 sar_ctrl_async_phys_0.sg13g2_and2_1$1_0.A sar_ctrl_async_phys_0.sg13g2_nor2_1$1_3.B 0.29161f
C969 sar_ctrl_async_phys_0.dac_code_n[0] oa_sar8_acore18_opt_0.sw_bitcell_opt_term_1.bot 0.12842f
C970 sar_ctrl_async_phys_0.dac_code_n[3] sar_ctrl_async_phys_0.sg13g2_buf_1$1_36.A 0.39225f
C971 a_33072_42854# VDD 0.07697f
C972 a_28977_36864# VDD 0.22865f
C973 a_29653_38959# a_29524_39373# 0.01562f
C974 a_29236_38952# a_29755_38959# 0.34102f
C975 a_31828_37440# a_33087_37797# 0.01529f
C976 a_31256_37522# a_31440_37522# 0.0524f
C977 sar_ctrl_async_phys_0.dac_code[7] oa_sar8_acore18_opt_0.sw_bitcell_opt_term_0.VSS 1.54742f
C978 sar_ctrl_async_phys_0.sg13g2_a22oi_1$1_1.Y a_34319_32460# 0.1757f
C979 sar_ctrl_async_phys_0.sg13g2_nor4_1$1_0.C sar_ctrl_async_phys_0.sg13g2_dfrbpq_1$1_11.D 0.3696f
C980 result[5] result[6] 0.14489f
C981 sar_ctrl_async_phys_0.sg13g2_nor2_1$1_5.A sar_ctrl_async_phys_0.sg13g2_a21oi_1$1_2.Y 0.12254f
C982 oa_sar8_acore18_opt_0.sw_tg_opt_1.bot oa_sar8_acore18_opt_0.sw_bitcell_opt_b7_1.VSS 0.03121f
C983 sar_ctrl_async_phys_0.sg13g2_buf_1$1_0.A a_31258_32436# 0.12564f
C984 sar_ctrl_async_phys_0.bit_active[6] a_36056_38224# 0.0134f
C985 sar_ctrl_async_phys_0.sg13g2_nand2_1$1_3.A sar_ctrl_async_phys_0.sg13g2_buf_1$1_20.A 0.05953f
C986 sar_ctrl_async_phys_0.sg13g2_buf_1$1_20.A a_35103_43845# 0.01267f
C987 oa_sar8_acore18_opt_0.sw_bitcell_opt_b1_0.bot oa_sar8_acore18_opt_0.sw_bitcell_opt_term_0.VSS 1.49696f
C988 sar_ctrl_async_phys_0.sg13g2_a22oi_1$1_1.B2 a_32341_32117# 0.01042f
C989 sar_ctrl_async_phys_0.sg13g2_a22oi_1$1_1.Y a_33846_33338# 0.03441f
C990 sar_ctrl_async_phys_0.dac_code_n[7] oa_sar8_acore18_opt_0.sw_bitcell_opt_term_1.bot 0.72747f
C991 a_29238_40898# a_29812_40885# 0.31978f
C992 a_33846_34850# a_34106_34380# 0.75507f
C993 sar_ctrl_async_phys_0.sg13g2_nand2b_1$1_3.Y sar_ctrl_async_phys_0.sg13g2_nor2_1$1_1.Y 0.01999f
C994 a_33080_31388# result[2] 0.24606f
C995 sar_ctrl_async_phys_0.sg13g2_a22oi_1$1_3.B1 a_31640_34498# 0.03019f
C996 sar_ctrl_async_phys_0.sg13g2_nor4_1$1_0.Y sar_ctrl_async_phys_0.sg13g2_nor2_1$1_13.A 0.01387f
C997 sar_ctrl_async_phys_0.sg13g2_a22oi_1$1_0.A2 VDD 0.64196f
C998 sar_ctrl_async_phys_0.sg13g2_nor2_1$1_10.B a_30507_35204# 0.03185f
C999 sar_ctrl_async_phys_0.sg13g2_a21oi_1$1_0.A1 a_35595_40460# 0.06813f
C1000 sar_ctrl_async_phys_0.sg13g2_dlygate4sd3_1$1_6.X sar_ctrl_async_phys_0.sg13g2_nor2_1$1_3.B 0.01052f
C1001 sar_ctrl_async_phys_0.sg13g2_a21oi_1$1_1.B1 sar_ctrl_async_phys_0.sg13g2_buf_1$1_4.A 0.02466f
C1002 a_32341_32117# a_32031_31749# 0.01182f
C1003 sar_ctrl_async_phys_0.dac_code_n[2] oa_sar8_acore18_opt_0.sw_tg_opt_0.bot 0.23301f
C1004 a_30390_39698# a_30964_39711# 0.31978f
C1005 a_31195_39820# a_32192_39918# 0.02979f
C1006 sar_ctrl_async_phys_0.sg13g2_a22oi_1$1_3.B1 sar_ctrl_async_phys_0.sg13g2_inv_1$1_0.A 0.11457f
C1007 sar_ctrl_async_phys_0.sg13g2_buf_1$1_7.A result[6] 0.02823f
C1008 sar_ctrl_async_phys_0.sg13g2_nand2_1$1_3.A sar_ctrl_async_phys_0.sg13g2_nand2_1$1_3.B 0.06915f
C1009 oa_sar8_acore18_opt_0.sw_bitcell_opt_term_0.gb m3_57896_n2380# 1.40567f
C1010 sar_ctrl_async_phys_0.sg13g2_buf_1$1_29.X VDD 0.58698f
C1011 sar_ctrl_async_phys_0.sg13g2_nand2_1$1_3.B a_35103_43845# 0.02817f
C1012 a_25496_31388# VDD 0.22258f
C1013 sar_ctrl_async_phys_0.sg13g2_nor2b_1$1_0.A a_30830_35166# 0.03607f
C1014 sar_ctrl_async_phys_0.sg13g2_buf_1$1_8.A sar_ctrl_async_phys_0.sg13g2_inv_1$1_0.A 0.80564f
C1015 a_26666_38912# track 0.01198f
C1016 sar_ctrl_async_phys_0.sg13g2_nand2b_1$1_1.B a_34911_41287# 0.01204f
C1017 sar_ctrl_async_phys_0.sg13g2_buf_1$1_41.X sar_ctrl_async_phys_0.sg13g2_nor2_1$1_1.Y 0.12941f
C1018 sar_ctrl_async_phys_0.sg13g2_dfrbpq_1$1_0.CLK a_32576_44454# 0.02764f
C1019 sar_ctrl_async_phys_0.dac_code_n[5] oa_sar8_acore18_opt_0.sw_bitcell_opt_b0_0.bot 0.08014f
C1020 oa_sar8_acore18_opt_0.sw_tg_opt_1.bot oa_sar8_acore18_opt_0.sw_bitcell_opt_b2_1.bot 1.77926f
C1021 oa_sar8_acore18_opt_0.sw_bitcell_opt_b0_0.bot oa_sar8_acore18_opt_0.sw_bitcell_opt_term_0.gb 0.60585f
C1022 sar_ctrl_async_phys_0.sg13g2_and2_1$1_6.X sar_ctrl_async_phys_0.sg13g2_buf_1$1_19.A 0.157f
C1023 sar_ctrl_async_phys_0.sg13g2_o21ai_1$1_1.B1 sar_ctrl_async_phys_0.sg13g2_a22oi_1$1_3.A2 0.62479f
C1024 a_29524_40464# VDD 0.07706f
C1025 a_31832_34412# VDD 0.24461f
C1026 sar_ctrl_async_phys_0.sg13g2_nand2_1$1_2.Y sar_ctrl_async_phys_0.dac_code[5] 0.05315f
C1027 sar_ctrl_async_phys_0.sg13g2_a21oi_1$1_6.B1 a_32319_44311# 0.01784f
C1028 sar_ctrl_async_phys_0.sg13g2_a21oi_1$1_1.B1 sar_ctrl_async_phys_0.sg13g2_nand2_1$1_5.Y 0.04387f
C1029 sar_ctrl_async_phys_0.sg13g2_and2_1$1_6.X sar_ctrl_async_phys_0.sg13g2_and2_1$1_0.X 0.01652f
C1030 sar_ctrl_async_phys_0.sg13g2_nand2_1$1_2.Y a_35672_38948# 0.25949f
C1031 sar_ctrl_async_phys_0.sg13g2_a22oi_1$1_1.A2 a_34420_34837# 0.0187f
C1032 sar_ctrl_async_phys_0.dac_code[2] oa_sar8_acore18_opt_0.sw_bitcell_opt_term_0.trkb 1.87273f
C1033 sar_ctrl_async_phys_0.sg13g2_a21oi_1$1_2.Y a_30964_36349# 0.01327f
C1034 a_35463_31435# VDD 0.77441f
C1035 sar_ctrl_async_phys_0.hold_req oa_sar8_acore18_opt_0.sw_bitcell_opt_b7_1.bot 2.98608f
C1036 sar_ctrl_async_phys_0.dac_code_n[3] sar_ctrl_async_phys_0.sg13g2_buf_1$1_46.A 0.28967f
C1037 sar_ctrl_async_phys_0.sg13g2_nand2_1$1_3.A sar_ctrl_async_phys_0.sg13g2_nand2b_1$1_3.Y 0.66134f
C1038 sar_ctrl_async_phys_0.dac_code_n[4] oa_sar8_acore18_opt_0.sw_tg_opt_1.bot 0.07641f
C1039 sar_ctrl_async_phys_0.sg13g2_a21oi_1$1_0.B1 a_34765_45266# 0.10896f
C1040 sar_ctrl_async_phys_0.dac_code_n[1] sar_ctrl_async_phys_0.dac_code_n[6] 0.3393f
C1041 sar_ctrl_async_phys_0.bit_active[0] sar_ctrl_async_phys_0.bit_active[4] 0.01616f
C1042 sar_ctrl_async_phys_0.bit_active[2] sar_ctrl_async_phys_0.bit_active[3] 0.08343f
C1043 sar_ctrl_async_phys_0.dac_code[2] sar_ctrl_async_phys_0.cmp_n 0.07726f
C1044 sar_ctrl_async_phys_0.sg13g2_nor2_1$1_4.Y a_26280_41214# 0.03149f
C1045 a_28950_39386# a_29210_38916# 0.75507f
C1046 sar_ctrl_async_phys_0.sg13g2_nor2_1$1_2.Y a_33366_41210# 0.04854f
C1047 sar_ctrl_async_phys_0.hold_req sar_ctrl_async_phys_0.dac_code[4] 0.10808f
C1048 sar_ctrl_async_phys_0.sg13g2_a22oi_1$1_0.Y result[4] 1.1844f
C1049 oa_sar8_acore18_opt_0.sw_bitcell_opt_b5_0.bot VDD 3.8844f
C1050 a_35725_45266# sar_ctrl_async_phys_0.sg13g2_nand2_1$1_3.B 0.01285f
C1051 sar_ctrl_async_phys_0.sg13g2_a22oi_1$1_2.A2 sar_ctrl_async_phys_0.sg13g2_buf_1$1_1.A 0.02328f
C1052 a_30964_36349# a_31195_35935# 0.12701f
C1053 sar_ctrl_async_phys_0.sg13g2_buf_1$1_3.A VDD 1.47969f
C1054 sar_ctrl_async_phys_0.sg13g2_a21oi_1$1_2.B1 a_34596_40424# 0.01838f
C1055 sar_ctrl_async_phys_0.sg13g2_nor2b_1$1_0.A a_31716_38912# 0.06245f
C1056 sar_ctrl_async_phys_0.sg13g2_buf_1$1_37.A sar_ctrl_async_phys_0.sg13g2_nor2_1$1_1.Y 0.03135f
C1057 sar_ctrl_async_phys_0.sg13g2_a22oi_1$1_3.B1 sar_ctrl_async_phys_0.sg13g2_a22oi_1$1_2.B2 0.01118f
C1058 a_28376_39034# VDD 0.13754f
C1059 a_26385_39214# VDD 0.2274f
C1060 sar_ctrl_async_phys_0.sg13g2_a22oi_1$1_2.A2 sar_ctrl_async_phys_0.sg13g2_buf_1$1_7.A 0.10726f
C1061 sar_ctrl_async_phys_0.sg13g2_a22oi_1$1_3.A2 sar_ctrl_async_phys_0.sg13g2_nor2b_1$1_1.Y 0.41528f
C1062 sar_ctrl_async_phys_0.dac_code[2] oa_sar8_acore18_opt_0.sw_bitcell_opt_b4_0.bot 0.38521f
C1063 a_34904_46508# VDD 0.22224f
C1064 sar_ctrl_async_phys_0.sg13g2_buf_1$1_41.X sar_ctrl_async_phys_0.sg13g2_nand2_1$1_3.A 0.05267f
C1065 a_33085_43832# sar_ctrl_async_phys_0.sg13g2_buf_1$1_15.A 0.10507f
C1066 sar_ctrl_async_phys_0.sg13g2_a22oi_1$1_4.A2 sar_ctrl_async_phys_0.sg13g2_buf_1$1_17.A 0.0616f
C1067 sar_ctrl_async_phys_0.dac_code_n[4] sar_ctrl_async_phys_0.sg13g2_nand2_1$1_3.A 0.37121f
C1068 sar_ctrl_async_phys_0.sg13g2_dfrbpq_1$1_0.CLK a_34261_43495# 0.26948f
C1069 sar_ctrl_async_phys_0.sg13g2_buf_1$1_20.A a_33558_43922# 0.01268f
C1070 sar_ctrl_async_phys_0.sg13g2_a22oi_1$1_2.B2 sar_ctrl_async_phys_0.sg13g2_buf_1$1_8.A 0.11371f
C1071 sar_ctrl_async_phys_0.sg13g2_buf_1$1_2.A sar_ctrl_async_phys_0.sg13g2_nor2b_1$1_2.Y 0.06059f
C1072 sar_ctrl_async_phys_0.dac_code_n[0] sar_ctrl_async_phys_0.sg13g2_nand2b_1$1_5.A_N 0.0174f
C1073 sar_ctrl_async_phys_0.dac_code_n[2] sar_ctrl_async_phys_0.dac_code_n[3] 7.84342f
C1074 sar_ctrl_async_phys_0.sg13g2_buf_1$1_41.X a_35103_43845# 0.13457f
C1075 sar_ctrl_async_phys_0.sg13g2_a22oi_1$1_0.A1 VDD 2.25319f
C1076 sar_ctrl_async_phys_0.dac_code_n[5] oa_sar8_acore18_opt_0.sw_bitcell_opt_b0_1.bot 0.06598f
C1077 sar_ctrl_async_phys_0.sg13g2_buf_1$1_6.X result[1] 0.04672f
C1078 sar_ctrl_async_phys_0.sg13g2_buf_1$1_14.A sar_ctrl_async_phys_0.sg13g2_a22oi_1$1_0.A2 0.06967f
C1079 sar_ctrl_async_phys_0.dac_code_n[0] sar_ctrl_async_phys_0.dac_code_n[1] 29.4112f
C1080 a_29238_40898# a_29941_40471# 0.02432f
C1081 sar_ctrl_async_phys_0.sg13g2_a21oi_1$1_0.A1 a_35672_38948# 0.04238f
C1082 sar_ctrl_async_phys_0.sg13g2_a22oi_1$1_0.B1 a_31823_32876# 0.05299f
C1083 oa_sar8_acore18_opt_0.sw_bitcell_opt_b6_0.bot oa_sar8_acore18_opt_0.sw_bitcell_opt_b5_0.bot 13.8916f
C1084 w_39600_n9960# oa_sar8_acore18_opt_0.sw_bitcell_opt_b5_0.bot 0.01116f
C1085 sar_ctrl_async_phys_0.sg13g2_o21ai_1$1_1.B1 a_33632_40702# 0.14559f
C1086 a_35280_35365# VDD 0.38681f
C1087 sar_ctrl_async_phys_0.sg13g2_a22oi_1$1_0.A2 sar_ctrl_async_phys_0.sg13g2_a22oi_1$1_1.A2 0.51021f
C1088 sar_ctrl_async_phys_0.sample oa_sar8_acore18_opt_0.sw_tg_opt_0.bot 2.11094f
C1089 a_30676_40016# a_31093_39677# 0.3749f
C1090 a_30390_39698# a_31195_39820# 0.097f
C1091 a_36056_35200# sar_ctrl_async_phys_0.bit_active[3] 0.08833f
C1092 sar_ctrl_async_phys_0.sg13g2_buf_1$1_13.A sar_ctrl_async_phys_0.sg13g2_a21oi_1$1_2.B1 0.02707f
C1093 a_34106_32868# a_34132_32904# 0.36952f
C1094 a_34808_35200# sar_ctrl_async_phys_0.bit_active[0] 0.09577f
C1095 sar_ctrl_async_phys_0.dac_code_n[5] a_35948_n9612# 0.0476f
C1096 sar_ctrl_async_phys_0.sg13g2_nor4_1$1_0.C VDD 1.56489f
C1097 sar_ctrl_async_phys_0.hold_req oa_sar8_acore18_opt_0.bstrap_opt_w2_c1200_1.out 0.06588f
C1098 oa_sar8_acore18_opt_0.sw_bitcell_opt_term_0.gb a_35948_n9612# 3.45673f
C1099 sar_ctrl_async_phys_0.sg13g2_a21oi_1$1_3.A2 VDD 0.45666f
C1100 sar_ctrl_async_phys_0.sg13g2_a22oi_1$1_3.A2 sar_ctrl_async_phys_0.sg13g2_a22oi_1$1_3.B1 0.06074f
C1101 a_28651_39740# a_28853_39702# 0.01117f
C1102 sar_ctrl_async_phys_0.sg13g2_and2_1$1_0.A sar_ctrl_async_phys_0.sg13g2_dlygate4sd3_1$1_6.A 0.02318f
C1103 sar_ctrl_async_phys_0.sg13g2_a22oi_1$1_0.A1 a_34895_32120# 0.01722f
C1104 sar_ctrl_async_phys_0.sg13g2_nand2_1$1_5.Y a_34911_41287# 0.05492f
C1105 sar_ctrl_async_phys_0.bit_active[0] sar_ctrl_async_phys_0.bit_active[1] 0.11588f
C1106 oa_sar8_acore18_opt_0.sw_tg_opt_1.bot oa_sar8_acore18_opt_0.sw_bitcell_opt_b6_1.bot 29.8359f
C1107 sar_ctrl_async_phys_0.dac_code_n[1] sar_ctrl_async_phys_0.dac_code_n[7] 0.12099f
C1108 sar_ctrl_async_phys_0.sg13g2_and2_1$1_6.X sar_ctrl_async_phys_0.sg13g2_a22oi_1$1_4.A2 0.16468f
C1109 sar_ctrl_async_phys_0.dac_code_n[2] vcm 0.06598f
C1110 sar_ctrl_async_phys_0.sg13g2_a22oi_1$1_3.A2 sar_ctrl_async_phys_0.sg13g2_buf_1$1_8.A 0.11462f
C1111 sar_ctrl_async_phys_0.sg13g2_nor2_1$1_2.Y sar_ctrl_async_phys_0.sg13g2_a21oi_1$1_2.B1 0.01871f
C1112 sar_ctrl_async_phys_0.sg13g2_inv_1$1_0.A result[3] 0.01176f
C1113 sar_ctrl_async_phys_0.dac_code[7] VDD 6.12423f
C1114 sar_ctrl_async_phys_0.sg13g2_a21oi_1$1_2.B1 a_33973_39677# 0.01204f
C1115 sar_ctrl_async_phys_0.sg13g2_nor2_1$1_0.Y sar_ctrl_async_phys_0.sg13g2_a21oi_1$1_0.A1 0.05948f
C1116 a_36336_36806# VDD 0.05605f
C1117 sar_ctrl_async_phys_0.sg13g2_dfrbpq_1$1_0.CLK a_29749_32117# 0.25519f
C1118 sar_ctrl_async_phys_0.dac_code_n[4] a_35725_45266# 0.03264f
C1119 sar_ctrl_async_phys_0.sg13g2_nand2_1$1_3.A sar_ctrl_async_phys_0.dac_code[0] 0.20448f
C1120 a_36056_46508# sar_ctrl_async_phys_0.dac_code_n[6] 0.08882f
C1121 sar_ctrl_async_phys_0.sg13g2_dfrbpq_1$1_0.CLK a_34549_30605# 0.26558f
C1122 sar_ctrl_async_phys_0.sg13g2_buf_1$1_6.X a_30229_33629# 0.0356f
C1123 sar_ctrl_async_phys_0.sg13g2_buf_1$1_3.A sar_ctrl_async_phys_0.sg13g2_nor2b_1$1_3.Y 0.04742f
C1124 sar_ctrl_async_phys_0.sg13g2_o21ai_1$1_1.B1 a_33085_43832# 0.01228f
C1125 sar_ctrl_async_phys_0.sg13g2_dfrbpq_1$1_0.CLK sar_ctrl_async_phys_0.sg13g2_dlygate4sd3_1$1_0.A 0.01075f
C1126 sar_ctrl_async_phys_0.sg13g2_o21ai_1$1_1.B1 a_33556_40016# 0.37272f
C1127 sar_ctrl_async_phys_0.sg13g2_buf_1$1_6.X a_29046_32138# 0.12868f
C1128 oa_sar8_acore18_opt_0.sw_bitcell_opt_term_0.trkb oa_sar8_acore18_opt_0.sw_bitcell_opt_b3_0.bot 1.40269f
C1129 sar_ctrl_async_phys_0.dac_code[1] m3_54868_n2380# 0.04365f
C1130 sar_ctrl_async_phys_0.sg13g2_dfrbpq_1$1_0.CLK sar_ctrl_async_phys_0.sg13g2_nor2_1$1_0.Y 0.24963f
C1131 oa_sar8_acore18_opt_0.sw_bitcell_opt_b1_0.bot VDD 2.50993f
C1132 a_33183_32215# a_33089_32215# 0.28931f
C1133 sar_ctrl_async_phys_0.sg13g2_buf_1$1_3.A sar_ctrl_async_phys_0.sg13g2_buf_1$1_14.A 0.23351f
C1134 a_33183_32215# a_33440_32358# 0.34468f
C1135 w_39600_n9960# sar_ctrl_async_phys_0.dac_code[7] 0.02244f
C1136 sar_ctrl_async_phys_0.dac_code[7] oa_sar8_acore18_opt_0.sw_bitcell_opt_b6_0.bot 1.24101f
C1137 sar_ctrl_async_phys_0.sg13g2_nor2b_1$1_4.Y sar_ctrl_async_phys_0.sg13g2_nor2_1$1_0.Y 0.16378f
C1138 sar_ctrl_async_phys_0.sg13g2_buf_1$1_6.X a_33846_30626# 0.12144f
C1139 sar_ctrl_async_phys_0.bit_active[4] sar_ctrl_async_phys_0.bit_active[1] 0.35983f
C1140 sar_ctrl_async_phys_0.sg13g2_buf_1$1_3.A sar_ctrl_async_phys_0.bit_active[7] 0.07658f
C1141 sar_ctrl_async_phys_0.sg13g2_a22oi_1$1_4.A2 a_32149_35141# 0.01314f
C1142 a_30650_35892# a_30676_35928# 0.36952f
C1143 sar_ctrl_async_phys_0.sg13g2_dfrbpq_1$1_0.CLK a_30495_39309# 0.03245f
C1144 sar_ctrl_async_phys_0.dac_code[2] oa_sar8_acore18_opt_0.sw_bitcell_opt_b0_0.bot 0.15607f
C1145 sar_ctrl_async_phys_0.sg13g2_dfrbpq_1$1_11.D a_31830_40898# 0.28123f
C1146 sar_ctrl_async_phys_0.sg13g2_a22oi_1$1_4.A2 sar_ctrl_async_phys_0.sg13g2_buf_1$1_6.X 0.0186f
C1147 sar_ctrl_async_phys_0.sg13g2_a21oi_1$1_4.B1 sar_ctrl_async_phys_0.sg13g2_nand2_1$1_3.Y 0.12941f
C1148 a_32223_46869# a_32129_46869# 0.28931f
C1149 sar_ctrl_async_phys_0.sg13g2_dfrbpq_1$1_0.CLK sar_ctrl_async_phys_0.sg13g2_inv_1$1_10.Y 0.09425f
C1150 sar_ctrl_async_phys_0.cmp_fire a_28008_23477# 0.83464f
C1151 sar_ctrl_async_phys_0.sg13g2_buf_1$1_0.A sar_ctrl_async_phys_0.sg13g2_inv_1$1_0.A 0.01703f
C1152 a_35482_39996# VDD 0.38099f
C1153 sar_ctrl_async_phys_0.sg13g2_buf_1$1_14.A sar_ctrl_async_phys_0.sg13g2_a22oi_1$1_0.A1 0.11171f
C1154 sar_ctrl_async_phys_0.dac_code_n[5] oa_sar8_acore18_opt_0.sw_bitcell_opt_b4_1.bot 0.10447f
C1155 oa_sar8_acore18_opt_0.sw_tg_opt_1.bot oa_sar8_acore18_opt_0.sw_bitcell_opt_term_1.bot 3.91174f
C1156 sar_ctrl_async_phys_0.dac_code_n[3] sar_ctrl_async_phys_0.sample 0.04462f
C1157 sar_ctrl_async_phys_0.sg13g2_a22oi_1$1_2.A2 a_32251_45007# 0.02359f
C1158 sar_ctrl_async_phys_0.sg13g2_a22oi_1$1_2.A2 sar_ctrl_async_phys_0.sg13g2_a21oi_1$1_2.B1 0.01446f
C1159 oa_sar8_acore18_opt_0.sw_bitcell_opt_b4_0.bot oa_sar8_acore18_opt_0.sw_bitcell_opt_b3_0.bot 16.6641f
C1160 oa_sar8_acore18_opt_0.sw_bitcell_opt_b5_0.bot oa_sar8_acore18_opt_0.sw_bitcell_opt_b2_0.bot 0.56024f
C1161 oa_sar8_acore18_opt_0.sw_bitcell_opt_b6_0.bot oa_sar8_acore18_opt_0.sw_bitcell_opt_b1_0.bot 0.51889f
C1162 sar_ctrl_async_phys_0.sg13g2_nor4_1$1_0.C sar_ctrl_async_phys_0.sg13g2_nor2b_1$1_3.Y 1.30091f
C1163 m3_51760_n2380# VDD 0.02113f
C1164 a_36152_36806# sar_ctrl_async_phys_0.bit_active[4] 0.01103f
C1165 sar_ctrl_async_phys_0.sg13g2_buf_1$1_41.X a_33558_43922# 0.09478f
C1166 sar_ctrl_async_phys_0.sg13g2_buf_1$1_14.A a_35280_35365# 0.02709f
C1167 sar_ctrl_async_phys_0.sg13g2_a22oi_1$1_1.A2 sar_ctrl_async_phys_0.sg13g2_a22oi_1$1_0.A1 0.38839f
C1168 sar_ctrl_async_phys_0.sg13g2_nor2_1$1_0.Y a_32116_40464# 0.02267f
C1169 sar_ctrl_async_phys_0.sg13g2_buf_1$1_15.A sar_ctrl_async_phys_0.bit_active[5] 0.03053f
C1170 sar_ctrl_async_phys_0.sg13g2_and2_1$1_0.A sar_ctrl_async_phys_0.sg13g2_nor2_1$1_7.A 0.22605f
C1171 sar_ctrl_async_phys_0.sg13g2_a21oi_1$1_0.B1 VDD 0.86467f
C1172 a_33940_44552# VDD 0.10726f
C1173 sar_ctrl_async_phys_0.sg13g2_a21oi_1$1_3.A2 sar_ctrl_async_phys_0.sg13g2_buf_1$1_14.A 0.31424f
C1174 a_34136_33688# VDD 0.25669f
C1175 sar_ctrl_async_phys_0.dac_code_n[2] a_20412_n9612# 1.21641f
C1176 sar_ctrl_async_phys_0.sg13g2_inv_1$1_5.Y a_29912_31474# 0.02791f
C1177 a_34615_31475# a_34767_31359# 0.47622f
C1178 sar_ctrl_async_phys_0.sg13g2_buf_1$1_26.X a_26681_38232# 0.01002f
C1179 sar_ctrl_async_phys_0.sg13g2_inv_1$1_5.A a_30671_32876# 0.17706f
C1180 a_35672_47296# sar_ctrl_async_phys_0.dac_code_n[2] 0.09852f
C1181 sar_ctrl_async_phys_0.sg13g2_o21ai_1$1_1.B1 a_34208_45966# 0.10165f
C1182 sar_ctrl_async_phys_0.sg13g2_buf_1$1_8.A a_33936_31675# 0.12f
C1183 sar_ctrl_async_phys_0.sg13g2_a22oi_1$1_4.Y sar_ctrl_async_phys_0.sg13g2_inv_1$1_3.Y 0.08471f
C1184 a_32635_40471# VDD 0.20992f
C1185 sar_ctrl_async_phys_0.sample vcm 1.92707f
C1186 sar_ctrl_async_phys_0.sg13g2_buf_1$1_15.A sar_ctrl_async_phys_0.dac_code_n[7] 0.16985f
C1187 sar_ctrl_async_phys_0.bit_active[7] sar_ctrl_async_phys_0.dac_code[7] 0.18317f
C1188 a_35360_36894# VDD 0.16912f
C1189 sar_ctrl_async_phys_0.sg13g2_buf_1$1_13.A sar_ctrl_async_phys_0.sg13g2_a21oi_1$1_5.A2 0.16541f
C1190 a_25488_40546# VDD 0.06694f
C1191 sar_ctrl_async_phys_0.sg13g2_dfrbpq_1$1_0.CLK a_28968_42013# 0.01565f
C1192 sar_ctrl_async_phys_0.sg13g2_buf_1$1_41.X a_32149_45007# 0.03668f
C1193 sar_ctrl_async_phys_0.sg13g2_a22oi_1$1_2.B2 sar_ctrl_async_phys_0.sg13g2_buf_1$1_0.A 0.67541f
C1194 sar_ctrl_async_phys_0.sg13g2_nor2b_1$1_4.Y a_30872_45082# 0.03647f
C1195 sar_ctrl_async_phys_0.dac_code[4] oa_sar8_acore18_opt_0.sw_bitcell_opt_term_0.VSS 1.21829f
C1196 sar_ctrl_async_phys_0.sg13g2_a22oi_1$1_0.A2 sar_ctrl_async_phys_0.sg13g2_nor2b_1$1_1.B_N 0.02776f
C1197 sar_ctrl_async_phys_0.sg13g2_nor2b_1$1_1.Y a_33558_36674# 0.28009f
C1198 oa_sar8_acore18_opt_0.sw_bitcell_opt_term_0.trkb oa_sar8_acore18_opt_0.sw_bitcell_opt_term_0.bot 1.34511f
C1199 a_33464_31388# VDD 0.22292f
C1200 sar_ctrl_async_phys_0.sg13g2_buf_1$1_2.A sar_ctrl_async_phys_0.sg13g2_a21oi_1$1_0.A1 0.03341f
C1201 sar_ctrl_async_phys_0.sg13g2_buf_1$1_7.A a_34895_32460# 0.01136f
C1202 sar_ctrl_async_phys_0.sg13g2_buf_1$1_4.A a_35648_34654# 0.01485f
C1203 sar_ctrl_async_phys_0.sg13g2_buf_1$1_6.X a_31640_34498# 0.02143f
C1204 sar_ctrl_async_phys_0.dac_code[2] a_35948_n9612# 2.16982f
C1205 sar_ctrl_async_phys_0.sg13g2_a21oi_1$1_6.A2 sar_ctrl_async_phys_0.sg13g2_a21oi_1$1_0.A1 0.19123f
C1206 a_31563_43020# VDD 0.3033f
C1207 a_36152_43570# a_36336_43570# 0.0524f
C1208 sar_ctrl_async_phys_0.dac_code[7] oa_sar8_acore18_opt_0.sw_bitcell_opt_b2_0.bot 0.2817f
C1209 a_31947_41508# VDD 0.23289f
C1210 a_31924_32456# a_32212_32151# 0.43707f
C1211 sar_ctrl_async_phys_0.sg13g2_and2_1$1_0.A a_30964_39711# 0.01364f
C1212 sar_ctrl_async_phys_0.cmp_valid sar_ctrl_async_phys_0.dac_code_n[2] 0.19988f
C1213 sar_ctrl_async_phys_0.sg13g2_buf_1$1_20.A sar_ctrl_async_phys_0.sg13g2_buf_1$1_3.A 0.06811f
C1214 sar_ctrl_async_phys_0.dac_code_n[3] oa_sar8_acore18_opt_0.sw_tg_opt_0.bot 0.97237f
C1215 sar_ctrl_async_phys_0.sg13g2_buf_1$1_6.X sar_ctrl_async_phys_0.sg13g2_inv_1$1_0.A 0.27897f
C1216 sar_ctrl_async_phys_0.sg13g2_nor2b_1$1_0.A sar_ctrl_async_phys_0.sg13g2_buf_1$1_3.A 0.01841f
C1217 sar_ctrl_async_phys_0.sg13g2_a21oi_1$1_0.A1 sar_ctrl_async_phys_0.sg13g2_nor2b_1$1_2.Y 0.02222f
C1218 a_34132_30944# result[0] 0.01341f
C1219 sar_ctrl_async_phys_0.sg13g2_dfrbpq_1$1_0.CLK a_28774_41278# 0.06384f
C1220 a_34555_35935# sar_ctrl_async_phys_0.bit_active[2] 0.02578f
C1221 sar_ctrl_async_phys_0.sg13g2_a22oi_1$1_3.A2 a_33658_35460# 0.0106f
C1222 sar_ctrl_async_phys_0.sg13g2_dfrbpq_1$1_0.CLK sar_ctrl_async_phys_0.sg13g2_buf_1$1_2.A 0.10474f
C1223 a_35772_41936# sar_ctrl_async_phys_0.sg13g2_nand2b_1$1_2.A_N 0.05153f
C1224 sar_ctrl_async_phys_0.dac_code_n[5] oa_sar8_acore18_opt_0.sw_bitcell_opt_b7_0.bot 1.76276f
C1225 sar_ctrl_async_phys_0.sg13g2_a22oi_1$1_4.A2 a_33087_37797# 0.01437f
C1226 sar_ctrl_async_phys_0.sg13g2_dfrbpq_1$1_0.CLK sar_ctrl_async_phys_0.sg13g2_a21oi_1$1_6.A2 0.0633f
C1227 oa_sar8_acore18_opt_0.sw_bitcell_opt_b7_0.bot oa_sar8_acore18_opt_0.sw_bitcell_opt_term_0.gb 0.94077f
C1228 a_33270_39698# VDD 0.81094f
C1229 sar_ctrl_async_phys_0.sg13g2_dfrbpq_1$1_9.D a_31194_44996# 0.01284f
C1230 oa_sar8_acore18_opt_0.sw_bitcell_opt_b2_0.bot oa_sar8_acore18_opt_0.sw_bitcell_opt_b1_0.bot 17.5779f
C1231 oa_sar8_acore18_opt_0.sw_bitcell_opt_b4_0.bot oa_sar8_acore18_opt_0.sw_bitcell_opt_term_0.bot 0.76981f
C1232 oa_sar8_acore18_opt_0.sw_bitcell_opt_b3_0.bot oa_sar8_acore18_opt_0.sw_bitcell_opt_b0_0.bot 0.40744f
C1233 a_30576_46594# VDD 0.09878f
C1234 sar_ctrl_async_phys_0.sg13g2_a22oi_1$1_2.A2 a_31446_45434# 0.0249f
C1235 oa_sar8_acore18_opt_0.sw_bitcell_opt_term_0.trkb m3_38288_n2380# 0.03859f
C1236 sar_ctrl_async_phys_0.sg13g2_nor2b_1$1_0.A sar_ctrl_async_phys_0.sg13g2_a22oi_1$1_0.A1 0.0883f
C1237 sar_ctrl_async_phys_0.sg13g2_a22oi_1$1_3.A2 sar_ctrl_async_phys_0.sg13g2_buf_1$1_17.A 0.04539f
C1238 a_29232_43570# VDD 0.08647f
C1239 a_21332_n9711# VDD 0.8295f
C1240 sar_ctrl_async_phys_0.sg13g2_nor2_1$1_10.A VDD 0.65389f
C1241 sar_ctrl_async_phys_0.sg13g2_buf_1$1_3.A a_35295_36285# 0.04751f
C1242 oa_sar8_acore18_opt_0.sw_bitcell_opt_term_0.trkb oa_sar8_acore18_opt_0.bstrap_opt_w2_c1200_1.gb 7.21267f
C1243 sar_ctrl_async_phys_0.sg13g2_a21oi_1$1_0.B1 sar_ctrl_async_phys_0.sg13g2_buf_1$1_14.A 0.25399f
C1244 sar_ctrl_async_phys_0.sg13g2_inv_1$1_0.A sar_ctrl_async_phys_0.sg13g2_a22oi_1$1_1.B2 1.19137f
C1245 sar_ctrl_async_phys_0.sg13g2_a21oi_1$1_4.B1 VDD 0.88557f
C1246 sar_ctrl_async_phys_0.sg13g2_nor2b_1$1_3.Y a_32635_40471# 0.02204f
C1247 a_26558_40727# sar_ctrl_async_phys_0.sg13g2_dlygate4sd3_1$1_6.A 0.01247f
C1248 sar_ctrl_async_phys_0.sg13g2_buf_1$1_37.A a_33072_42854# 0.01202f
C1249 sar_ctrl_async_phys_0.sg13g2_nor4_1$1_0.C sar_ctrl_async_phys_0.sg13g2_buf_1$1_20.A 0.02944f
C1250 oa_sar8_acore18_opt_0.sw_tg_opt_0.bot vcm 3.53635f
C1251 sar_ctrl_async_phys_0.sg13g2_nor4_1$1_0.C sar_ctrl_async_phys_0.sg13g2_nor2b_1$1_0.A 0.03327f
C1252 sar_ctrl_async_phys_0.sg13g2_buf_1$1_10.A a_32696_30664# 0.01199f
C1253 sar_ctrl_async_phys_0.sg13g2_a21oi_1$1_0.B1 sar_ctrl_async_phys_0.sg13g2_a22oi_1$1_1.A2 0.33609f
C1254 sar_ctrl_async_phys_0.sg13g2_a21oi_1$1_1.B1 sar_ctrl_async_phys_0.sg13g2_nand2b_1$1_4.A_N 0.04245f
C1255 oa_sar8_acore18_opt_0.sw_bitcell_opt_term_0.trkb oa_sar8_acore18_opt_0.sw_bitcell_opt_b1_1.bot 1.3958f
C1256 a_34636_31749# a_34615_31475# 0.34114f
C1257 sar_ctrl_async_phys_0.sg13g2_buf_1$1_10.A sar_ctrl_async_phys_0.sg13g2_buf_1$1_8.A 0.03144f
C1258 oa_sar8_acore18_opt_0.sw_bitcell_opt_b3_1.bot VDD 3.01881f
C1259 oa_sar8_acore18_opt_0.sw_bitcell_opt_b2_0.bot m3_51760_n2380# 1.59913f
C1260 sar_ctrl_async_phys_0.sg13g2_a22oi_1$1_0.A2 sar_ctrl_async_phys_0.sg13g2_and2_1$1_1.B 0.02266f
C1261 sar_ctrl_async_phys_0.sg13g2_dlygate4sd3_1$1_0.X a_28862_36863# 0.16603f
C1262 sar_ctrl_async_phys_0.sg13g2_a22oi_1$1_2.A2 sar_ctrl_async_phys_0.sg13g2_a21oi_1$1_5.A2 1.12569f
C1263 sar_ctrl_async_phys_0.dac_code_n[1] oa_sar8_acore18_opt_0.sw_tg_opt_1.bot 0.35671f
C1264 a_32666_45969# a_32406_45746# 0.75507f
C1265 a_34911_41287# a_35168_41430# 0.34468f
C1266 a_33652_41528# a_34817_41287# 0.43239f
C1267 a_34171_41332# a_33940_41223# 0.12701f
C1268 a_31830_40898# VDD 0.77566f
C1269 a_29786_33873# VDD 0.09788f
C1270 sar_ctrl_async_phys_0.dac_code_n[6] sar_ctrl_async_phys_0.dac_code[1] 0.06253f
C1271 sar_ctrl_async_phys_0.sg13g2_nand2b_1$1_0.A_N a_28130_40838# 0.01231f
C1272 sar_ctrl_async_phys_0.sg13g2_nor2b_1$1_0.Y a_31440_37522# 0.02958f
C1273 sar_ctrl_async_phys_0.sg13g2_buf_1$1_20.A sar_ctrl_async_phys_0.dac_code[7] 0.22394f
C1274 a_33368_44366# a_33552_44366# 0.0524f
C1275 a_33936_31675# result[3] 0.01309f
C1276 sar_ctrl_async_phys_0.sg13g2_buf_1$1_6.X sar_ctrl_async_phys_0.sg13g2_a22oi_1$1_2.B2 0.07473f
C1277 sar_ctrl_async_phys_0.sg13g2_a22oi_1$1_3.A2 sar_ctrl_async_phys_0.sg13g2_nor2_1$1_15.Y 0.18043f
C1278 a_36058_32900# VDD 0.37733f
C1279 sar_ctrl_async_phys_0.sg13g2_and2_1$1_6.X sar_ctrl_async_phys_0.sg13g2_a22oi_1$1_3.A2 0.02132f
C1280 a_32986_44532# sar_ctrl_async_phys_0.sg13g2_nand2_1$1_5.B 0.11497f
C1281 a_31352_36806# VDD 0.16122f
C1282 sar_ctrl_async_phys_0.sg13g2_a22oi_1$1_0.A1 sar_ctrl_async_phys_0.sg13g2_nor2b_1$1_1.B_N 0.03321f
C1283 sar_ctrl_async_phys_0.sg13g2_nand2b_1$1_3.Y sar_ctrl_async_phys_0.sg13g2_buf_1$1_3.A 0.12263f
C1284 sar_ctrl_async_phys_0.sg13g2_and2_1$1_3.A sar_ctrl_async_phys_0.sg13g2_nor2_1$1_3.Y 0.09199f
C1285 a_33951_45823# VDD 0.20909f
C1286 sar_ctrl_async_phys_0.sg13g2_a22oi_1$1_2.A2 a_32020_35175# 0.01181f
C1287 sar_ctrl_async_phys_0.sg13g2_nand2b_1$1_5.A_N sar_ctrl_async_phys_0.sg13g2_nand2_1$1_3.A 0.12626f
C1288 sar_ctrl_async_phys_0.sg13g2_dlygate4sd3_1$1_0.X VDD 0.27939f
C1289 sar_ctrl_async_phys_0.dac_code_n[1] sar_ctrl_async_phys_0.sg13g2_nand2_1$1_3.A 0.01381f
C1290 sar_ctrl_async_phys_0.sg13g2_a22oi_1$1_0.B1 a_30507_35204# 0.03066f
C1291 sar_ctrl_async_phys_0.sg13g2_nor2b_1$1_1.B_N a_35280_35365# 0.10493f
C1292 a_30384_31474# VDD 0.08211f
C1293 sar_ctrl_async_phys_0.sg13g2_inv_1$1_10.Y sar_ctrl_async_phys_0.sg13g2_nand2b_1$1_0.A_N 0.51609f
C1294 a_33375_40821# a_33281_40821# 0.28931f
C1295 sar_ctrl_async_phys_0.sg13g2_buf_1$1_7.A a_32341_32117# 0.01045f
C1296 sar_ctrl_async_phys_0.sg13g2_a22oi_1$1_0.A2 a_35211_37436# 0.16224f
C1297 sar_ctrl_async_phys_0.sg13g2_o21ai_1$1_1.B1 a_31195_39820# 0.42223f
C1298 sar_ctrl_async_phys_0.sg13g2_a22oi_1$1_0.B1 sar_ctrl_async_phys_0.sg13g2_a22oi_1$1_0.Y 0.11448f
C1299 sar_ctrl_async_phys_0.dac_code_n[0] sar_ctrl_async_phys_0.dac_code[1] 0.06405f
C1300 sar_ctrl_async_phys_0.sg13g2_nor2b_1$1_3.Y a_33270_39698# 0.27448f
C1301 sar_ctrl_async_phys_0.sg13g2_nor2_1$1_8.B sar_ctrl_async_phys_0.sg13g2_nor2_1$1_8.A 0.08458f
C1302 sar_ctrl_async_phys_0.sg13g2_buf_1$1_4.A sar_ctrl_async_phys_0.bit_active[2] 0.08179f
C1303 sar_ctrl_async_phys_0.sg13g2_and2_1$1_0.A a_31195_39820# 0.056f
C1304 sar_ctrl_async_phys_0.sg13g2_nor2_1$1_4.Y a_26454_41972# 0.05178f
C1305 sar_ctrl_async_phys_0.sg13g2_a22oi_1$1_2.B2 sar_ctrl_async_phys_0.sg13g2_a22oi_1$1_1.B2 0.02782f
C1306 a_31898_32361# a_31638_32138# 0.75507f
C1307 oa_sar8_acore18_opt_0.sw_bitcell_opt_b3_0.bot a_35948_n9612# 0.03603f
C1308 sar_ctrl_async_phys_0.dac_code_n[4] oa_sar8_acore18_opt_0.sw_bitcell_opt_b5_0.bot 0.44073f
C1309 sar_ctrl_async_phys_0.sg13g2_a22oi_1$1_0.B2 a_34651_30748# 0.01806f
C1310 a_34815_39775# a_35482_39996# 0.0894f
C1311 a_29941_40471# a_30689_40821# 0.01058f
C1312 a_33556_40016# a_34721_39775# 0.43239f
C1313 a_34075_39820# a_33844_39711# 0.12701f
C1314 sar_ctrl_async_phys_0.sg13g2_buf_1$1_6.X sar_ctrl_async_phys_0.sg13g2_inv_1$1_6.A 0.02344f
C1315 sar_ctrl_async_phys_0.sg13g2_nor2_1$1_12.Y a_25496_42854# 0.01072f
C1316 sar_ctrl_async_phys_0.sg13g2_buf_1$1_42.A sar_ctrl_async_phys_0.sg13g2_buf_1$1_13.A 0.0133f
C1317 oa_sar8_acore18_opt_0.sw_bitcell_opt_b0_0.bot oa_sar8_acore18_opt_0.sw_bitcell_opt_term_0.bot 19.5908f
C1318 a_30964_46512# a_32129_46869# 0.43239f
C1319 sar_ctrl_async_phys_0.sg13g2_a22oi_1$1_3.A2 sar_ctrl_async_phys_0.sg13g2_buf_1$1_6.X 0.02267f
C1320 sar_ctrl_async_phys_0.sg13g2_nor2_1$1_4.Y sar_ctrl_async_phys_0.sg13g2_and2_1$1_0.A 0.44478f
C1321 a_31252_46933# a_31483_46519# 0.12701f
C1322 sar_ctrl_async_phys_0.sg13g2_nor2_1$1_11.Y a_29048_40546# 0.03153f
C1323 sar_ctrl_async_phys_0.sg13g2_nor4_1$1_0.C sar_ctrl_async_phys_0.sg13g2_nand2b_1$1_3.Y 0.47264f
C1324 sar_ctrl_async_phys_0.sg13g2_dlygate4sd3_1$1_7.A track 0.47342f
C1325 w_16692_n9960# sar_ctrl_async_phys_0.dac_code_n[6] 0.28176f
C1326 sar_ctrl_async_phys_0.sg13g2_buf_1$1_3.A sar_ctrl_async_phys_0.sg13g2_and2_1$1_1.B 0.2455f
C1327 sar_ctrl_async_phys_0.sg13g2_a21oi_1$1_0.A1 sar_ctrl_async_phys_0.sg13g2_nand2_1$1_2.Y 0.88075f
C1328 sar_ctrl_async_phys_0.dac_code_n[3] vcm 0.06598f
C1329 sar_ctrl_async_phys_0.dac_code[1] sar_ctrl_async_phys_0.dac_code_n[7] 0.10246f
C1330 sar_ctrl_async_phys_0.sg13g2_and2_1$1_0.A a_31093_35935# 0.0387f
C1331 sar_ctrl_async_phys_0.sg13g2_nor2_1$1_6.Y VDD 0.66229f
C1332 sar_ctrl_async_phys_0.sg13g2_nor2_1$1_1.Y sar_ctrl_async_phys_0.sg13g2_buf_1$1_15.A 0.02963f
C1333 sar_ctrl_async_phys_0.sg13g2_dfrbpq_1$1_0.CLK a_32991_35239# 0.01648f
C1334 sar_ctrl_async_phys_0.sg13g2_a21oi_1$1_0.B1 sar_ctrl_async_phys_0.sg13g2_buf_1$1_20.A 0.02859f
C1335 sar_ctrl_async_phys_0.sg13g2_buf_1$1_42.A sar_ctrl_async_phys_0.sg13g2_nor2_1$1_2.Y 0.76804f
C1336 sar_ctrl_async_phys_0.sg13g2_nand2_1$1_3.A sar_ctrl_async_phys_0.sg13g2_buf_1$1_32.A 0.63532f
C1337 a_33940_44552# sar_ctrl_async_phys_0.sg13g2_buf_1$1_20.A 0.0121f
C1338 sar_ctrl_async_phys_0.sg13g2_a21oi_1$1_0.B1 sar_ctrl_async_phys_0.sg13g2_nor2b_1$1_0.A 0.04803f
C1339 sar_ctrl_async_phys_0.sg13g2_buf_1$1_2.A a_33750_36362# 0.01083f
C1340 oa_sar8_acore18_opt_0.sw_bitcell_opt_term_0.trkb oa_sar8_acore18_opt_0.sw_bitcell_opt_b5_1.bot 1.51334f
C1341 a_31440_37522# VDD 0.06906f
C1342 sar_ctrl_async_phys_0.sg13g2_dfrbpq_1$1_0.CLK a_35288_33688# 0.029f
C1343 oa_sar8_acore18_opt_0.sw_bitcell_opt_b7_1.bot VDD 8.98218f
C1344 sar_ctrl_async_phys_0.sg13g2_a22oi_1$1_0.A1 a_33754_37436# 0.01169f
C1345 sar_ctrl_async_phys_0.sg13g2_nor2_1$1_2.Y a_33281_40821# 0.01098f
C1346 sar_ctrl_async_phys_0.sg13g2_nor4_1$1_0.C sar_ctrl_async_phys_0.sg13g2_buf_1$1_41.X 0.02197f
C1347 sar_ctrl_async_phys_0.sg13g2_a22oi_1$1_0.A1 sar_ctrl_async_phys_0.sg13g2_a22oi_1$1_1.Y 0.42377f
C1348 sar_ctrl_async_phys_0.sg13g2_buf_1$1_4.A a_36056_35200# 0.02428f
C1349 a_34055_31352# a_34636_31749# 0.01529f
C1350 sar_ctrl_async_phys_0.hold_req sar_ctrl_async_phys_0.dac_code_n[2] 0.05309f
C1351 sar_ctrl_async_phys_0.dac_code[4] VDD 4.92002f
C1352 a_34069_41189# a_34171_41332# 0.47622f
C1353 sar_ctrl_async_phys_0.sg13g2_nor2b_1$1_2.Y a_33750_36362# 0.27283f
C1354 sar_ctrl_async_phys_0.dac_code[2] oa_sar8_acore18_opt_0.sw_bitcell_opt_b7_0.bot 2.35818f
C1355 sar_ctrl_async_phys_0.sg13g2_a21oi_1$1_3.B1 sar_ctrl_async_phys_0.sg13g2_nand2b_1$1_6.A_N 0.02291f
C1356 w_16692_n9960# sar_ctrl_async_phys_0.dac_code_n[0] 0.03874f
C1357 sar_ctrl_async_phys_0.sg13g2_nor2_1$1_4.Y sar_ctrl_async_phys_0.sg13g2_dlygate4sd3_1$1_6.X 0.01622f
C1358 a_30830_35166# sar_ctrl_async_phys_0.sg13g2_dfrbpq_1$1_5.D 0.21607f
C1359 sar_ctrl_async_phys_0.sg13g2_a21oi_1$1_6.A2 a_32980_45759# 0.01554f
C1360 a_34224_42058# VDD 0.07747f
C1361 sar_ctrl_async_phys_0.sg13g2_buf_1$1_13.A sar_ctrl_async_phys_0.sg13g2_a21oi_1$1_5.Y 0.05188f
C1362 sar_ctrl_async_phys_0.dac_code[0] oa_sar8_acore18_opt_0.sw_bitcell_opt_b5_0.bot 0.7413f
C1363 sar_ctrl_async_phys_0.sg13g2_buf_1$1_2.A a_32692_46064# 0.01246f
C1364 sar_ctrl_async_phys_0.sample sar_ctrl_async_phys_0.cmp_fire 10.0366f
C1365 a_31823_32876# VDD 0.30319f
C1366 sar_ctrl_async_phys_0.sg13g2_a21oi_1$1_2.Y sar_ctrl_async_phys_0.sg13g2_nor2_1$1_8.A 0.01613f
C1367 sar_ctrl_async_phys_0.sg13g2_a21oi_1$1_6.A2 a_32692_46064# 0.01807f
C1368 a_35402_46878# sar_ctrl_async_phys_0.sg13g2_buf_1$1_36.A 0.01535f
C1369 a_31579_44356# a_31348_44247# 0.12701f
C1370 sar_ctrl_async_phys_0.sg13g2_nand2_1$1_3.B a_33940_44552# 0.02443f
C1371 sar_ctrl_async_phys_0.sg13g2_and2_1$1_0.A sar_ctrl_async_phys_0.sg13g2_dlygate4sd3_1$1_5.A 0.13939f
C1372 a_32319_44311# a_32576_44454# 0.34468f
C1373 a_31060_44552# a_32225_44311# 0.43239f
C1374 sar_ctrl_async_phys_0.sg13g2_buf_1$1_4.A result[7] 0.02627f
C1375 a_35295_36285# a_35201_36285# 0.28931f
C1376 sar_ctrl_async_phys_0.dac_code_n[4] sar_ctrl_async_phys_0.dac_code[7] 0.13169f
C1377 sar_ctrl_async_phys_0.sg13g2_inv_1$1_2.Y sar_ctrl_async_phys_0.sg13g2_a22oi_1$1_0.B2 0.06664f
C1378 sar_ctrl_async_phys_0.dac_code[4] oa_sar8_acore18_opt_0.sw_bitcell_opt_b6_0.bot 1.17468f
C1379 w_39600_n9960# sar_ctrl_async_phys_0.dac_code[4] 0.04487f
C1380 sar_ctrl_async_phys_0.sg13g2_dfrbpq_1$1_0.CLK sar_ctrl_async_phys_0.sg13g2_a22oi_1$1_2.Y 0.1514f
C1381 sar_ctrl_async_phys_0.sg13g2_nand2_1$1_3.A sar_ctrl_async_phys_0.sg13g2_buf_1$1_15.A 0.07319f
C1382 sar_ctrl_async_phys_0.cmp_p a_30632_22281# 1.10635f
C1383 sar_ctrl_async_phys_0.sg13g2_nor2_1$1_8.A sar_ctrl_async_phys_0.sg13g2_inv_1$1_7.A 0.29877f
C1384 a_34040_45082# a_34224_45082# 0.0524f
C1385 w_16692_n9960# sar_ctrl_async_phys_0.dac_code_n[7] 0.01571f
C1386 a_34363_43495# a_35360_43726# 0.03061f
C1387 a_34261_43495# a_35009_43845# 0.01058f
C1388 sar_ctrl_async_phys_0.sg13g2_buf_1$1_42.A sar_ctrl_async_phys_0.sg13g2_nand2b_1$1_6.A_N 0.45822f
C1389 sar_ctrl_async_phys_0.sg13g2_nor4_1$1_0.C sar_ctrl_async_phys_0.sg13g2_buf_1$1_37.A 0.02706f
C1390 VDD done 0.21964f
C1391 sar_ctrl_async_phys_0.sg13g2_dfrbpq_1$1_0.CLK sar_ctrl_async_phys_0.sg13g2_a21oi_1$1_0.A1 0.74815f
C1392 sar_ctrl_async_phys_0.sg13g2_nand2_1$1_1.Y sar_ctrl_async_phys_0.sg13g2_nor2_1$1_8.B 0.54266f
C1393 sar_ctrl_async_phys_0.sg13g2_buf_1$1_42.A a_34618_46044# 0.01736f
C1394 sar_ctrl_async_phys_0.dac_code_n[4] oa_sar8_acore18_opt_0.sw_bitcell_opt_b1_0.bot 0.09671f
C1395 sar_ctrl_async_phys_0.sg13g2_o21ai_1$1_1.B1 sar_ctrl_async_phys_0.sg13g2_nor2_1$1_1.Y 0.10447f
C1396 oa_sar8_acore18_opt_0.bstrap_opt_w2_c1200_1.out VDD 4.07597f
C1397 sar_ctrl_async_phys_0.sg13g2_inv_1$1_0.A sar_ctrl_async_phys_0.sg13g2_inv_1$1_0.Y 0.08093f
C1398 sar_ctrl_async_phys_0.dac_code_n[3] a_20412_n9612# 1.21221f
C1399 sar_ctrl_async_phys_0.sg13g2_nand2_1$1_5.B a_34093_42912# 0.19357f
C1400 sar_ctrl_async_phys_0.sg13g2_buf_1$1_0.A sar_ctrl_async_phys_0.sg13g2_buf_1$1_10.A 1.08234f
C1401 sar_ctrl_async_phys_0.sg13g2_a21oi_1$1_0.B1 sar_ctrl_async_phys_0.sg13g2_nand2b_1$1_3.Y 0.22794f
C1402 sar_ctrl_async_phys_0.sg13g2_nand2b_1$1_3.Y a_33940_44552# 0.04692f
C1403 sar_ctrl_async_phys_0.sg13g2_dfrbpq_1$1_0.CLK a_34075_39820# 0.02636f
C1404 sar_ctrl_async_phys_0.sg13g2_buf_1$1_8.A a_33850_32436# 0.01981f
C1405 a_31093_39677# VDD 0.24806f
C1406 sar_ctrl_async_phys_0.sg13g2_a21oi_1$1_0.A1 sar_ctrl_async_phys_0.sg13g2_a21oi_1$1_0.A2 0.1797f
C1407 oa_sar8_acore18_opt_0.sw_bitcell_opt_b0_1.bot oa_sar8_acore18_opt_0.bstrap_opt_w2_c1200_1.gb 0.64235f
C1408 sar_ctrl_async_phys_0.sg13g2_a22oi_1$1_3.A2 a_33087_37797# 0.04232f
C1409 a_34261_36653# a_34132_36687# 0.01562f
C1410 a_29808_39830# VDD 0.07536f
C1411 a_36056_33688# busy 0.08833f
C1412 sar_ctrl_async_phys_0.sg13g2_dfrbpq_1$1_0.CLK a_30139_43495# 0.0441f
C1413 sar_ctrl_async_phys_0.sg13g2_dlygate4sd3_1$1_0.A a_28870_35948# 0.16535f
C1414 sar_ctrl_async_phys_0.sg13g2_buf_1$1_13.A a_32533_40471# 0.05046f
C1415 sar_ctrl_async_phys_0.sg13g2_nor2b_1$1_4.Y sar_ctrl_async_phys_0.sg13g2_dfrbpq_1$1_0.CLK 0.03815f
C1416 sar_ctrl_async_phys_0.sg13g2_nor2_1$1_10.A sar_ctrl_async_phys_0.sg13g2_nor2b_1$1_0.A 0.46f
C1417 a_35952_39901# sar_ctrl_async_phys_0.dac_code[6] 0.0182f
C1418 sar_ctrl_async_phys_0.sg13g2_a21oi_1$1_4.B1 sar_ctrl_async_phys_0.sg13g2_buf_1$1_20.A 0.23087f
C1419 sar_ctrl_async_phys_0.sg13g2_nor2b_1$1_4.Y a_30139_43495# 0.01003f
C1420 sar_ctrl_async_phys_0.sg13g2_a21oi_1$1_5.Y a_32090_40428# 0.01427f
C1421 sar_ctrl_async_phys_0.sg13g2_buf_1$1_2.A rst_n 0.02582f
C1422 sar_ctrl_async_phys_0.sg13g2_buf_1$1_2.A sar_ctrl_async_phys_0.sg13g2_inv_1$1_1.Y 0.05839f
C1423 sar_ctrl_async_phys_0.sg13g2_a21oi_1$1_4.B1 sar_ctrl_async_phys_0.sg13g2_nor2b_1$1_0.A 0.05836f
C1424 oa_sar8_acore18_opt_0.sw_bitcell_opt_term_0.trkb vinp 0.14725f
C1425 sar_ctrl_async_phys_0.sg13g2_dfrbpq_1$1_0.CLK sar_ctrl_async_phys_0.sg13g2_buf_1$1_26.X 0.02884f
C1426 sar_ctrl_async_phys_0.dac_code[0] sar_ctrl_async_phys_0.dac_code[7] 0.14614f
C1427 oa_sar8_acore18_opt_0.sw_bitcell_opt_term_0.trkb oa_sar8_acore18_opt_0.sw_bitcell_opt_term_0.vin 13.1742f
C1428 oa_sar8_acore18_opt_0.sw_bitcell_opt_b0_1.bot oa_sar8_acore18_opt_0.sw_bitcell_opt_b1_1.bot 14.7298f
C1429 sar_ctrl_async_phys_0.sg13g2_a22oi_1$1_2.A2 sar_ctrl_async_phys_0.sg13g2_a21oi_1$1_5.Y 0.65471f
C1430 sar_ctrl_async_phys_0.sg13g2_dfrbpq_1$1_0.CLK sar_ctrl_async_phys_0.sg13g2_a21oi_1$1_0.A2 0.3851f
C1431 sar_ctrl_async_phys_0.sg13g2_buf_1$1_41.X a_33940_44552# 0.44462f
C1432 sar_ctrl_async_phys_0.sg13g2_nor2_1$1_1.Y sar_ctrl_async_phys_0.sg13g2_nor2b_1$1_1.Y 0.01391f
C1433 sar_ctrl_async_phys_0.sg13g2_buf_1$1_32.A a_33558_43922# 0.01693f
C1434 a_33440_32358# VDD 0.17174f
C1435 a_30676_35928# VDD 0.07488f
C1436 sar_ctrl_async_phys_0.cmp_fire oa_sar8_acore18_opt_0.sw_tg_opt_0.bot 0.17887f
C1437 sar_ctrl_async_phys_0.hold_req sar_ctrl_async_phys_0.sample 28.7208f
C1438 sar_ctrl_async_phys_0.sg13g2_a22oi_1$1_2.Y a_31291_31399# 0.01018f
C1439 sar_ctrl_async_phys_0.sg13g2_dfrbpq_1$1_0.CLK a_32116_40464# 0.0624f
C1440 sar_ctrl_async_phys_0.sg13g2_buf_1$1_19.A a_33366_41210# 0.04041f
C1441 a_26630_37814# VDD 0.01149f
C1442 sar_ctrl_async_phys_0.sg13g2_and2_1$1_3.X a_26544_38389# 0.10857f
C1443 sar_ctrl_async_phys_0.sg13g2_nor2_1$1_10.Y sar_ctrl_async_phys_0.sg13g2_nor2_1$1_10.A 0.25848f
C1444 sar_ctrl_async_phys_0.sg13g2_buf_1$1_36.A sar_ctrl_async_phys_0.sg13g2_nand2_1$1_3.Y 0.04391f
C1445 sar_ctrl_async_phys_0.dac_code[0] oa_sar8_acore18_opt_0.sw_bitcell_opt_b1_0.bot 0.15556f
C1446 sar_ctrl_async_phys_0.sg13g2_nand2_1$1_3.A a_34520_42760# 0.01063f
C1447 sar_ctrl_async_phys_0.sg13g2_a22oi_1$1_2.A2 a_32580_43448# 0.03994f
C1448 a_25596_47222# sar_ctrl_async_phys_0.hold_req 0.24585f
C1449 sar_ctrl_async_phys_0.sg13g2_a21oi_1$1_4.B1 sar_ctrl_async_phys_0.sg13g2_nand2_1$1_3.B 0.02571f
C1450 oa_sar8_acore18_opt_0.sw_bitcell_opt_b3_1.bot oa_sar8_acore18_opt_0.sw_bitcell_opt_b7_1.VSS 1.7475f
C1451 oa_sar8_acore18_opt_0.sw_bitcell_opt_term_0.vin oa_sar8_acore18_opt_0.sw_bitcell_opt_b4_0.bot 4.0259f
C1452 oa_sar8_acore18_opt_0.sw_bitcell_opt_b7_0.bot oa_sar8_acore18_opt_0.sw_bitcell_opt_b3_0.bot 0.96639f
C1453 sar_ctrl_async_phys_0.sg13g2_dfrbpq_1$1_0.CLK a_34261_36653# 0.25191f
C1454 sar_ctrl_async_phys_0.sg13g2_a22oi_1$1_1.Y a_34136_33688# 0.01022f
C1455 a_31477_44213# a_31579_44356# 0.47622f
C1456 sar_ctrl_async_phys_0.sg13g2_buf_1$1_6.X sar_ctrl_async_phys_0.sg13g2_inv_1$1_6.Y 0.22137f
C1457 sar_ctrl_async_phys_0.sg13g2_nor2b_1$1_0.A a_31352_36806# 0.01267f
C1458 a_34036_35928# a_35201_36285# 0.43239f
C1459 sar_ctrl_async_phys_0.dac_code[4] oa_sar8_acore18_opt_0.sw_bitcell_opt_b2_0.bot 0.1489f
C1460 sar_ctrl_async_phys_0.sg13g2_a22oi_1$1_2.A2 a_31732_35480# 0.02594f
C1461 sar_ctrl_async_phys_0.sg13g2_buf_1$1_6.X a_29306_32361# 0.25814f
C1462 sar_ctrl_async_phys_0.sg13g2_a21oi_1$1_6.B1 sar_ctrl_async_phys_0.sg13g2_a22oi_1$1_2.A2 0.77381f
C1463 sar_ctrl_async_phys_0.sg13g2_buf_1$1_1.A a_34651_34423# 0.06287f
C1464 sar_ctrl_async_phys_0.sg13g2_a22oi_1$1_2.A2 a_31706_35385# 0.03871f
C1465 a_31328_33870# a_31738_33948# 0.10373f
C1466 sar_ctrl_async_phys_0.sg13g2_dfrbpq_1$1_0.CLK a_31291_31399# 0.05733f
C1467 sar_ctrl_async_phys_0.sg13g2_buf_1$1_2.A sar_ctrl_async_phys_0.sg13g2_a21oi_1$1_1.B1 0.03724f
C1468 sar_ctrl_async_phys_0.sg13g2_a21oi_1$1_0.B1 sar_ctrl_async_phys_0.sg13g2_buf_1$1_37.A 0.01845f
C1469 sar_ctrl_async_phys_0.sg13g2_a21oi_1$1_6.B1 sar_ctrl_async_phys_0.sg13g2_nand2b_1$1_6.A_N 0.16067f
C1470 a_32090_40428# a_32533_40471# 0.02242f
C1471 sar_ctrl_async_phys_0.sg13g2_a21oi_1$1_6.B1 a_34618_46044# 0.03713f
C1472 sar_ctrl_async_phys_0.sg13g2_a21oi_1$1_0.A2 a_34261_36653# 0.02206f
C1473 a_36336_43570# VDD 0.05617f
C1474 a_33844_43488# a_34261_43495# 0.37583f
C1475 a_33558_43922# a_34132_43909# 0.31978f
C1476 a_34904_47296# sar_ctrl_async_phys_0.cmp_valid 0.10582f
C1477 sar_ctrl_async_phys_0.sg13g2_nor2_1$1_4.Y a_26558_40727# 0.04601f
C1478 sar_ctrl_async_phys_0.sg13g2_buf_1$1_6.X sar_ctrl_async_phys_0.sg13g2_buf_1$1_10.A 0.05033f
C1479 a_32991_45357# a_33658_44996# 0.0894f
C1480 a_33558_43922# sar_ctrl_async_phys_0.sg13g2_buf_1$1_15.A 0.06242f
C1481 sar_ctrl_async_phys_0.sg13g2_a22oi_1$1_4.A2 sar_ctrl_async_phys_0.sg13g2_buf_1$1_1.A 0.02662f
C1482 a_29332_32456# a_29620_32151# 0.43707f
C1483 a_35391_33261# result[4] 0.02387f
C1484 sar_ctrl_async_phys_0.sg13g2_buf_1$1_13.A sar_ctrl_async_phys_0.sg13g2_buf_1$1_4.A 0.01395f
C1485 sar_ctrl_async_phys_0.sg13g2_a21oi_1$1_4.B1 sar_ctrl_async_phys_0.sg13g2_nand2b_1$1_3.Y 0.28477f
C1486 sar_ctrl_async_phys_0.sg13g2_nor2_1$1_0.Y a_32319_44311# 0.03604f
C1487 sar_ctrl_async_phys_0.sg13g2_nor2_1$1_2.Y a_33530_39921# 0.01455f
C1488 sar_ctrl_async_phys_0.sg13g2_a22oi_1$1_0.B2 a_34767_31359# 0.04999f
C1489 a_33530_39921# a_33973_39677# 0.02242f
C1490 sar_ctrl_async_phys_0.sg13g2_a21oi_1$1_0.A1 a_35313_37784# 0.0135f
C1491 oa_sar8_acore18_opt_0.sw_bitcell_opt_b4_1.bot oa_sar8_acore18_opt_0.bstrap_opt_w2_c1200_1.gb 0.67477f
C1492 a_34132_30944# a_34420_30639# 0.43707f
C1493 a_33844_36992# a_34363_36796# 0.34114f
C1494 sar_ctrl_async_phys_0.sg13g2_o21ai_1$1_1.B1 a_32897_45357# 0.01422f
C1495 a_33818_36897# a_33558_36674# 0.75507f
C1496 sar_ctrl_async_phys_0.sg13g2_nor2_1$1_4.Y a_26666_38912# 0.03011f
C1497 sar_ctrl_async_phys_0.sg13g2_nor2b_1$1_4.Y a_30678_46946# 0.27757f
C1498 a_29334_43922# a_30139_43495# 0.097f
C1499 sar_ctrl_async_phys_0.sg13g2_buf_1$1_19.A sar_ctrl_async_phys_0.sg13g2_a21oi_1$1_2.B1 0.02205f
C1500 sar_ctrl_async_phys_0.sg13g2_dfrbpq_1$1_11.D a_32156_38948# 0.01398f
C1501 sar_ctrl_async_phys_0.sg13g2_buf_1$1_10.A sar_ctrl_async_phys_0.sg13g2_a22oi_1$1_1.B2 0.75634f
C1502 sar_ctrl_async_phys_0.sg13g2_a21oi_1$1_2.B1 sar_ctrl_async_phys_0.bit_active[6] 0.05936f
C1503 a_33552_44366# VDD 0.0696f
C1504 sar_ctrl_async_phys_0.sg13g2_nand2b_1$1_1.B sar_ctrl_async_phys_0.sg13g2_nand2b_1$1_6.A_N 0.31726f
C1505 sar_ctrl_async_phys_0.sg13g2_buf_1$1_41.X sar_ctrl_async_phys_0.sg13g2_nor2_1$1_10.A 0.25038f
C1506 sar_ctrl_async_phys_0.sg13g2_nor2_1$1_10.A a_29620_43488# 0.01654f
C1507 oa_sar8_acore18_opt_0.sw_bitcell_opt_b0_1.bot oa_sar8_acore18_opt_0.sw_bitcell_opt_b5_1.bot 0.36922f
C1508 oa_sar8_acore18_opt_0.sw_bitcell_opt_b1_1.bot oa_sar8_acore18_opt_0.sw_bitcell_opt_b4_1.bot 1.13359f
C1509 oa_sar8_acore18_opt_0.sw_bitcell_opt_b2_1.bot oa_sar8_acore18_opt_0.sw_bitcell_opt_b3_1.bot 14.0637f
C1510 sar_ctrl_async_phys_0.hold_req oa_sar8_acore18_opt_0.sw_tg_opt_0.bot 9.37779f
C1511 sar_ctrl_async_phys_0.sg13g2_a21oi_1$1_4.B1 sar_ctrl_async_phys_0.sg13g2_buf_1$1_41.X 0.03448f
C1512 VDD result[2] 0.46855f
C1513 sar_ctrl_async_phys_0.dac_code_n[2] oa_sar8_acore18_opt_0.sw_bitcell_opt_term_0.VSS 0.0453f
C1514 sar_ctrl_async_phys_0.sg13g2_a21oi_1$1_4.B1 sar_ctrl_async_phys_0.dac_code_n[4] 0.05254f
C1515 sar_ctrl_async_phys_0.sg13g2_dfrbpq_1$1_0.CLK a_32347_37447# 0.02911f
C1516 a_34651_30748# result[1] 0.02546f
C1517 a_35028_n9612# vinn 0.80795f
C1518 sar_ctrl_async_phys_0.sg13g2_a22oi_1$1_4.A2 a_33366_41210# 0.01385f
C1519 oa_sar8_acore18_opt_0.sw_bitcell_opt_term_0.vin m3_57896_n2380# 0.05057f
C1520 a_31638_32138# VDD 0.77518f
C1521 sar_ctrl_async_phys_0.sg13g2_buf_1$1_20.A sar_ctrl_async_phys_0.dac_code[4] 0.12396f
C1522 sar_ctrl_async_phys_0.sg13g2_buf_1$1_19.A a_34093_42912# 0.0105f
C1523 sar_ctrl_async_phys_0.sg13g2_nand2_1$1_3.A sar_ctrl_async_phys_0.dac_code[1] 0.02774f
C1524 sar_ctrl_async_phys_0.sg13g2_a22oi_1$1_2.Y a_30486_31826# 0.05306f
C1525 sar_ctrl_async_phys_0.dac_code_n[4] oa_sar8_acore18_opt_0.sw_bitcell_opt_b3_1.bot 0.10478f
C1526 a_34904_38948# sar_ctrl_async_phys_0.bit_active[6] 0.2475f
C1527 sar_ctrl_async_phys_0.dac_code[4] m3_45264_n2380# 0.0553f
C1528 oa_sar8_acore18_opt_0.sw_bitcell_opt_b7_0.bot oa_sar8_acore18_opt_0.sw_bitcell_opt_term_0.bot 1.12023f
C1529 oa_sar8_acore18_opt_0.sw_bitcell_opt_term_0.vin oa_sar8_acore18_opt_0.sw_bitcell_opt_b0_0.bot 3.83256f
C1530 oa_sar8_acore18_opt_0.sw_bitcell_opt_b7_1.bot oa_sar8_acore18_opt_0.sw_bitcell_opt_b7_1.VSS 2.53864f
C1531 sar_ctrl_async_phys_0.sg13g2_dfrbpq_1$1_0.CLK sar_ctrl_async_phys_0.sg13g2_nor2_1$1_5.A 1.04974f
C1532 sar_ctrl_async_phys_0.sg13g2_nand3_1$1_0.Y track 0.47239f
C1533 sar_ctrl_async_phys_0.dac_code_n[1] oa_sar8_acore18_opt_0.sw_bitcell_opt_b5_0.bot 0.30346f
C1534 sar_ctrl_async_phys_0.sg13g2_dfrbpq_1$1_0.CLK a_32580_36642# 0.03319f
C1535 a_33750_36362# a_34324_36349# 0.31978f
C1536 a_34171_41332# VDD 0.22691f
C1537 sar_ctrl_async_phys_0.sg13g2_dfrbpq_1$1_0.CLK a_32692_46064# 0.11868f
C1538 a_34904_46508# sar_ctrl_async_phys_0.sg13g2_nand2b_1$1_5.A_N 0.04847f
C1539 sar_ctrl_async_phys_0.sg13g2_buf_1$1_41.X a_33951_45823# 0.01145f
C1540 sar_ctrl_async_phys_0.sg13g2_a22oi_1$1_2.A2 sar_ctrl_async_phys_0.sg13g2_buf_1$1_4.A 0.06958f
C1541 sar_ctrl_async_phys_0.sg13g2_a21oi_1$1_4.B1 sar_ctrl_async_phys_0.sg13g2_buf_1$1_37.A 0.38957f
C1542 a_34904_46508# sar_ctrl_async_phys_0.dac_code_n[1] 0.09811f
C1543 sar_ctrl_async_phys_0.sg13g2_buf_1$1_36.A VDD 0.80775f
C1544 sar_ctrl_async_phys_0.sg13g2_dlygate4sd3_1$1_6.A a_27530_39666# 0.41275f
C1545 a_29812_33968# a_31071_33727# 0.01529f
C1546 w_16692_n9960# oa_sar8_acore18_opt_0.sw_tg_opt_1.bot 0.09929f
C1547 sar_ctrl_async_phys_0.sg13g2_buf_1$1_4.A a_33844_36992# 0.03374f
C1548 a_35672_47296# sar_ctrl_async_phys_0.cmp_valid 0.0101f
C1549 sar_ctrl_async_phys_0.sg13g2_nor4_1$1_0.C sar_ctrl_async_phys_0.sg13g2_nor2_1$1_13.B 0.06434f
C1550 sar_ctrl_async_phys_0.sg13g2_a21oi_1$1_0.A1 a_30129_39724# 0.0137f
C1551 a_35360_43726# VDD 0.16938f
C1552 sar_ctrl_async_phys_0.sg13g2_and2_1$1_0.A sar_ctrl_async_phys_0.sg13g2_nand2_1$1_1.B 0.12615f
C1553 sar_ctrl_async_phys_0.sg13g2_dfrbpq_1$1_0.CLK sar_ctrl_async_phys_0.sg13g2_nand2b_1$1_0.A_N 0.0609f
C1554 sar_ctrl_async_phys_0.sg13g2_nor2_1$1_10.B a_30676_40016# 0.04902f
C1555 sar_ctrl_async_phys_0.sg13g2_a21oi_1$1_0.A1 sar_ctrl_async_phys_0.sg13g2_nor2_1$1_18.A 0.03777f
C1556 sar_ctrl_async_phys_0.sg13g2_buf_1$1_0.A a_33846_33338# 0.02759f
C1557 a_30043_40471# a_31040_40702# 0.03061f
C1558 a_35648_34654# a_35391_34773# 0.34468f
C1559 sar_ctrl_async_phys_0.sg13g2_a21oi_1$1_2.B1 a_29812_40885# 0.02102f
C1560 a_31732_45000# a_32991_45357# 0.01529f
C1561 sar_ctrl_async_phys_0.sg13g2_a21oi_1$1_4.B1 sar_ctrl_async_phys_0.dac_code[0] 0.15745f
C1562 a_28006_35948# a_27894_35924# 0.55452f
C1563 a_29046_32138# a_29851_32260# 0.097f
C1564 a_29332_32456# a_29749_32117# 0.3749f
C1565 sar_ctrl_async_phys_0.sg13g2_nor2_1$1_10.B sar_ctrl_async_phys_0.sg13g2_and2_1$1_0.B 0.02459f
C1566 sar_ctrl_async_phys_0.dac_code_n[6] sar_ctrl_async_phys_0.dac_code[6] 0.17593f
C1567 sar_ctrl_async_phys_0.sg13g2_dlygate4sd3_1$1_8.X sar_ctrl_async_phys_0.sg13g2_nor4_1$1_0.Y 0.69655f
C1568 sar_ctrl_async_phys_0.sg13g2_buf_1$1_7.A sar_ctrl_async_phys_0.sg13g2_inv_1$1_0.A 0.41884f
C1569 sar_ctrl_async_phys_0.sg13g2_a22oi_1$1_0.B2 a_34636_31749# 0.02689f
C1570 sar_ctrl_async_phys_0.sg13g2_nor4_1$1_0.C sar_ctrl_async_phys_0.sg13g2_nand2b_1$1_5.A_N 0.02611f
C1571 sar_ctrl_async_phys_0.sg13g2_nor2_1$1_4.Y a_26289_42912# 0.04525f
C1572 a_35648_33142# a_36058_32900# 0.10373f
C1573 sar_ctrl_async_phys_0.hold_req sar_ctrl_async_phys_0.dac_code_n[3] 0.06169f
C1574 sar_ctrl_async_phys_0.sg13g2_inv_1$1_2.Y result[1] 0.13696f
C1575 sar_ctrl_async_phys_0.sg13g2_a21oi_1$1_3.B1 sar_ctrl_async_phys_0.sg13g2_nand2_1$1_5.B 0.01672f
C1576 sar_ctrl_async_phys_0.sg13g2_a22oi_1$1_4.A2 sar_ctrl_async_phys_0.sg13g2_a21oi_1$1_2.B1 0.01871f
C1577 sar_ctrl_async_phys_0.sg13g2_a21oi_1$1_5.Y a_31828_37440# 0.04681f
C1578 sar_ctrl_async_phys_0.sg13g2_dfrbpq_1$1_0.CLK sar_ctrl_async_phys_0.sg13g2_nor2_1$1_18.A 1.21232f
C1579 a_34132_30944# a_34549_30605# 0.3749f
C1580 a_33846_30626# a_34651_30748# 0.097f
C1581 sar_ctrl_async_phys_0.sg13g2_a21oi_1$1_1.B1 sar_ctrl_async_phys_0.sg13g2_nand2_1$1_2.Y 0.05932f
C1582 sar_ctrl_async_phys_0.sg13g2_o21ai_1$1_1.B1 a_32149_45007# 0.01489f
C1583 oa_sar8_acore18_opt_0.bstrap_opt_w2_c1200_1.out oa_sar8_acore18_opt_0.sw_bitcell_opt_b7_1.VSS 0.11679f
C1584 oa_sar8_acore18_opt_0.sw_bitcell_opt_b2_1.bot oa_sar8_acore18_opt_0.sw_bitcell_opt_b7_1.bot 1.15895f
C1585 sar_ctrl_async_phys_0.sg13g2_a22oi_1$1_2.A2 sar_ctrl_async_phys_0.sg13g2_inv_1$1_3.Y 0.07104f
C1586 oa_sar8_acore18_opt_0.sw_bitcell_opt_b3_1.bot oa_sar8_acore18_opt_0.sw_bitcell_opt_b6_1.bot 0.52491f
C1587 oa_sar8_acore18_opt_0.sw_bitcell_opt_b4_1.bot oa_sar8_acore18_opt_0.sw_bitcell_opt_b5_1.bot 8.59552f
C1588 a_30507_35204# VDD 0.85801f
C1589 sar_ctrl_async_phys_0.sg13g2_nor2_1$1_10.B a_30650_35892# 0.03238f
C1590 a_32580_36642# a_32888_36806# 0.01393f
C1591 sar_ctrl_async_phys_0.sg13g2_nor2_1$1_10.B sar_ctrl_async_phys_0.sg13g2_a22oi_1$1_0.B1 0.49047f
C1592 a_31579_44356# VDD 0.20645f
C1593 a_33211_45868# a_34208_45966# 0.02979f
C1594 a_26168_38318# a_26352_38318# 0.0524f
C1595 a_29701_36874# sar_ctrl_async_phys_0.sg13g2_dlygate4sd3_1$1_0.A 0.01033f
C1596 sar_ctrl_async_phys_0.sg13g2_a22oi_1$1_0.Y VDD 0.2783f
C1597 sar_ctrl_async_phys_0.dac_code_n[1] sar_ctrl_async_phys_0.dac_code[7] 0.12342f
C1598 a_31738_33948# VDD 0.38139f
C1599 sar_ctrl_async_phys_0.dac_code_n[6] sar_ctrl_async_phys_0.dac_code[3] 0.06252f
C1600 sar_ctrl_async_phys_0.sg13g2_buf_1$1_19.A a_33675_43020# 0.07857f
C1601 sar_ctrl_async_phys_0.dac_code_n[0] sar_ctrl_async_phys_0.dac_code[6] 1.39363f
C1602 sar_ctrl_async_phys_0.sg13g2_dfrbpq_1$1_0.CLK a_32245_37447# 0.27424f
C1603 a_35245_45266# VDD 0.24057f
C1604 sar_ctrl_async_phys_0.dac_code_n[0] vinn 0.03781f
C1605 oa_sar8_acore18_opt_0.sw_bitcell_opt_term_0.vin a_35948_n9612# 0.0636f
C1606 a_33658_44996# VDD 0.38416f
C1607 sar_ctrl_async_phys_0.sg13g2_nor2b_1$1_0.A a_30676_35928# 0.0194f
C1608 a_30591_32215# VDD 0.17242f
C1609 a_30486_31826# a_31291_31399# 0.097f
C1610 sar_ctrl_async_phys_0.sg13g2_buf_1$1_42.A sar_ctrl_async_phys_0.sg13g2_nand2_1$1_5.B 0.58064f
C1611 a_28008_23477# a_26184_21025# 0.69491f
C1612 sar_ctrl_async_phys_0.sg13g2_o21ai_1$1_1.B1 a_29524_39373# 0.02369f
C1613 a_35391_30703# VDD 0.17142f
C1614 sar_ctrl_async_phys_0.sg13g2_dlygate4sd3_1$1_9.X VDD 0.45957f
C1615 sar_ctrl_async_phys_0.dac_code_n[4] sar_ctrl_async_phys_0.dac_code[4] 0.06321f
C1616 sar_ctrl_async_phys_0.dac_code_n[1] oa_sar8_acore18_opt_0.sw_bitcell_opt_b1_0.bot 0.06187f
C1617 a_30752_39190# a_30495_39309# 0.34468f
C1618 sar_ctrl_async_phys_0.sg13g2_nor4_1$1_0.C sar_ctrl_async_phys_0.sg13g2_buf_1$1_32.A 0.04779f
C1619 sar_ctrl_async_phys_0.sg13g2_buf_1$1_7.A sar_ctrl_async_phys_0.sg13g2_a22oi_1$1_2.B2 0.0219f
C1620 sar_ctrl_async_phys_0.sg13g2_a21oi_1$1_1.B1 sar_ctrl_async_phys_0.sg13g2_a21oi_1$1_0.A1 0.28042f
C1621 sar_ctrl_async_phys_0.sg13g2_dlygate4sd3_1$1_5.A a_26289_42912# 0.01976f
C1622 sar_ctrl_async_phys_0.dac_code_n[7] sar_ctrl_async_phys_0.dac_code[6] 0.16858f
C1623 sar_ctrl_async_phys_0.sg13g2_buf_1$1_46.A VDD 0.52517f
C1624 sar_ctrl_async_phys_0.dac_code_n[0] sar_ctrl_async_phys_0.dac_code[3] 0.06405f
C1625 sar_ctrl_async_phys_0.sg13g2_nor2_1$1_14.A a_28176_39830# 0.01714f
C1626 sar_ctrl_async_phys_0.sg13g2_buf_1$1_15.A sar_ctrl_async_phys_0.sg13g2_buf_1$1_3.A 0.02342f
C1627 sar_ctrl_async_phys_0.sg13g2_buf_1$1_6.X a_33846_33338# 0.0866f
C1628 oa_sar8_acore18_opt_0.sw_bitcell_opt_term_1.bot oa_sar8_acore18_opt_0.sw_bitcell_opt_b3_1.bot 0.49221f
C1629 oa_sar8_acore18_opt_0.bstrap_opt_w2_c1200_1.out oa_sar8_acore18_opt_0.sw_bitcell_opt_b2_1.bot 3.94653f
C1630 a_25596_41174# sar_ctrl_async_phys_0.sg13g2_nor4_1$1_0.Y 0.25757f
C1631 sar_ctrl_async_phys_0.sg13g2_a22oi_1$1_1.B2 a_34319_32460# 0.0841f
C1632 sar_ctrl_async_phys_0.sg13g2_inv_1$1_2.Y a_33846_30626# 0.27769f
C1633 a_34132_34416# a_34420_34837# 0.43707f
C1634 sar_ctrl_async_phys_0.sg13g2_a22oi_1$1_4.A2 sar_ctrl_async_phys_0.sg13g2_inv_1$1_2.Y 0.18069f
C1635 a_31706_44964# a_31732_45000# 0.36952f
C1636 sar_ctrl_async_phys_0.sg13g2_nor2_1$1_1.Y sar_ctrl_async_phys_0.sg13g2_and2_1$1_6.X 0.02789f
C1637 sar_ctrl_async_phys_0.sg13g2_buf_1$1_29.X sar_ctrl_async_phys_0.sg13g2_and2_1$1_0.A 0.04677f
C1638 sar_ctrl_async_phys_0.sg13g2_buf_1$1_0.A sar_ctrl_async_phys_0.sg13g2_inv_1$1_5.A 0.51295f
C1639 sar_ctrl_async_phys_0.sg13g2_a21oi_1$1_0.B1 sar_ctrl_async_phys_0.sg13g2_nand2b_1$1_5.A_N 0.52382f
C1640 sar_ctrl_async_phys_0.sg13g2_nor2_1$1_8.A sar_ctrl_async_phys_0.sg13g2_dlygate4sd3_1$1_0.A 0.04773f
C1641 sar_ctrl_async_phys_0.sg13g2_a22oi_1$1_3.A2 sar_ctrl_async_phys_0.sg13g2_buf_1$1_1.A 0.04257f
C1642 sar_ctrl_async_phys_0.sg13g2_a21oi_1$1_0.B1 sar_ctrl_async_phys_0.dac_code_n[1] 0.02356f
C1643 sar_ctrl_async_phys_0.sg13g2_buf_1$1_7.A sar_ctrl_async_phys_0.sg13g2_inv_1$1_6.A 0.3896f
C1644 sar_ctrl_async_phys_0.dac_code[2] a_35772_41936# 0.02152f
C1645 sar_ctrl_async_phys_0.dac_code[3] sar_ctrl_async_phys_0.dac_code_n[7] 0.06328f
C1646 sar_ctrl_async_phys_0.dac_code_n[4] oa_sar8_acore18_opt_0.bstrap_opt_w2_c1200_1.out 1.81036f
C1647 sar_ctrl_async_phys_0.dac_code_n[2] VDD 4.28501f
C1648 a_26352_38318# VDD 0.06779f
C1649 sar_ctrl_async_phys_0.sg13g2_buf_1$1_35.A sar_ctrl_async_phys_0.dac_code[4] 0.34596f
C1650 sar_ctrl_async_phys_0.sg13g2_nand3_1$1_0.Y sar_ctrl_async_phys_0.sg13g2_nor2_1$1_3.B 0.194f
C1651 sar_ctrl_async_phys_0.dac_code[5] oa_sar8_acore18_opt_0.sw_bitcell_opt_term_0.trkb 2.01172f
C1652 a_34549_32911# a_35297_33261# 0.01058f
C1653 sar_ctrl_async_phys_0.sg13g2_a21oi_1$1_1.B1 sar_ctrl_async_phys_0.sg13g2_a21oi_1$1_0.A2 0.08575f
C1654 a_33846_33338# sar_ctrl_async_phys_0.sg13g2_a22oi_1$1_1.B2 0.01854f
C1655 a_34520_33688# result[5] 0.0884f
C1656 oa_sar8_acore18_opt_0.sw_bitcell_opt_b6_1.bot oa_sar8_acore18_opt_0.sw_bitcell_opt_b7_1.bot 11.0588f
C1657 oa_sar8_acore18_opt_0.sw_tg_opt_0.bot oa_sar8_acore18_opt_0.sw_bitcell_opt_term_0.VSS 0.03903f
C1658 sar_ctrl_async_phys_0.sg13g2_nor2b_1$1_1.Y sar_ctrl_async_phys_0.sg13g2_a22oi_1$1_0.A2 0.1122f
C1659 sar_ctrl_async_phys_0.sg13g2_nor4_1$1_0.C sar_ctrl_async_phys_0.sg13g2_buf_1$1_15.A 0.02833f
C1660 sar_ctrl_async_phys_0.dac_code[0] sar_ctrl_async_phys_0.dac_code[4] 0.19839f
C1661 sar_ctrl_async_phys_0.sg13g2_o21ai_1$1_1.B1 a_29524_40464# 0.42887f
C1662 a_32692_46064# a_32980_45759# 0.43707f
C1663 sar_ctrl_async_phys_0.dac_code[5] sar_ctrl_async_phys_0.cmp_n 0.07134f
C1664 sar_ctrl_async_phys_0.sg13g2_buf_1$1_3.A a_35297_34773# 0.0108f
C1665 sar_ctrl_async_phys_0.sg13g2_a22oi_1$1_4.A2 a_33675_43020# 0.15869f
C1666 a_32406_45746# a_33109_45725# 0.02454f
C1667 a_29526_33650# VDD 0.78273f
C1668 sar_ctrl_async_phys_0.sg13g2_nor4_1$1_0.Y VDD 0.65388f
C1669 sar_ctrl_async_phys_0.sg13g2_a22oi_1$1_1.A2 sar_ctrl_async_phys_0.sg13g2_a22oi_1$1_0.Y 0.07649f
C1670 sar_ctrl_async_phys_0.sg13g2_nand2b_1$1_0.A_N sar_ctrl_async_phys_0.sg13g2_nor2_1$1_5.A 0.02697f
C1671 sar_ctrl_async_phys_0.sg13g2_and2_1$1_3.X a_28176_39830# 0.01198f
C1672 sar_ctrl_async_phys_0.dac_code_n[2] oa_sar8_acore18_opt_0.sw_bitcell_opt_b6_0.bot 1.01149f
C1673 sar_ctrl_async_phys_0.sg13g2_buf_1$1_15.A sar_ctrl_async_phys_0.dac_code[7] 0.03013f
C1674 w_39600_n9960# sar_ctrl_async_phys_0.dac_code_n[2] 0.04379f
C1675 sar_ctrl_async_phys_0.sg13g2_dfrbpq_1$1_0.CLK a_32443_32260# 0.02026f
C1676 a_29048_40546# VDD 0.15189f
C1677 a_31732_45000# VDD 0.07655f
C1678 sar_ctrl_async_phys_0.dac_code[5] oa_sar8_acore18_opt_0.sw_bitcell_opt_b4_0.bot 0.56281f
C1679 a_34765_42242# VDD 0.24438f
C1680 a_33914_44457# a_34357_44213# 0.02242f
C1681 sar_ctrl_async_phys_0.sg13g2_nor2_1$1_4.Y a_26566_39766# 0.05084f
C1682 a_33948_41936# VDD 0.25911f
C1683 sar_ctrl_async_phys_0.sg13g2_a21oi_1$1_1.B1 a_35245_45936# 0.01043f
C1684 sar_ctrl_async_phys_0.sg13g2_o21ai_1$1_1.B1 sar_ctrl_async_phys_0.sg13g2_buf_1$1_3.A 1.30157f
C1685 sar_ctrl_async_phys_0.sg13g2_buf_1$1_17.A a_30830_35166# 0.12585f
C1686 sar_ctrl_async_phys_0.sg13g2_buf_1$1_1.A a_34520_33688# 0.01037f
C1687 a_33464_30664# VDD 0.22384f
C1688 sar_ctrl_async_phys_0.sg13g2_nand2_1$1_2.Y a_36074_40830# 0.01536f
C1689 sar_ctrl_async_phys_0.sg13g2_a21oi_1$1_0.B1 sar_ctrl_async_phys_0.sg13g2_buf_1$1_32.A 0.03684f
C1690 sar_ctrl_async_phys_0.sg13g2_buf_1$1_32.A a_33940_44552# 0.02036f
C1691 sar_ctrl_async_phys_0.sg13g2_buf_1$1_6.X a_31924_32456# 0.4434f
C1692 a_28026_36972# VDD 0.01405f
C1693 a_29236_38952# a_29524_39373# 0.43707f
C1694 a_32245_37447# a_32347_37447# 0.47795f
C1695 sar_ctrl_async_phys_0.sg13g2_a22oi_1$1_0.B2 result[0] 0.04686f
C1696 sar_ctrl_async_phys_0.sg13g2_buf_1$1_5.A a_36056_33688# 0.02044f
C1697 sar_ctrl_async_phys_0.sg13g2_nor4_1$1_0.C a_31450_40460# 0.01175f
C1698 sar_ctrl_async_phys_0.sg13g2_nor2_1$1_5.A a_28651_39740# 0.0458f
C1699 a_31935_36285# a_31841_36285# 0.28931f
C1700 sar_ctrl_async_phys_0.sg13g2_buf_1$1_36.A sar_ctrl_async_phys_0.sg13g2_buf_1$1_20.A 0.02277f
C1701 oa_sar8_acore18_opt_0.sw_bitcell_opt_term_1.bot oa_sar8_acore18_opt_0.sw_bitcell_opt_b7_1.bot 1.34622f
C1702 oa_sar8_acore18_opt_0.bstrap_opt_w2_c1200_1.out oa_sar8_acore18_opt_0.sw_bitcell_opt_b6_1.bot 4.26916f
C1703 sar_ctrl_async_phys_0.sg13g2_and2_1$1_0.X a_35672_38224# 0.25799f
C1704 sar_ctrl_async_phys_0.sg13g2_nand2b_1$1_1.B sar_ctrl_async_phys_0.sg13g2_nand2_1$1_5.B 0.07447f
C1705 sar_ctrl_async_phys_0.sg13g2_buf_1$1_6.X sar_ctrl_async_phys_0.sg13g2_inv_1$1_5.A 0.21092f
C1706 sar_ctrl_async_phys_0.sg13g2_a22oi_1$1_1.B2 a_31924_32456# 0.03154f
C1707 sar_ctrl_async_phys_0.sg13g2_nor4_1$1_0.C sar_ctrl_async_phys_0.sg13g2_o21ai_1$1_1.B1 1.63617f
C1708 sar_ctrl_async_phys_0.sg13g2_inv_1$1_2.Y sar_ctrl_async_phys_0.sg13g2_inv_1$1_0.A 0.12558f
C1709 sar_ctrl_async_phys_0.sg13g2_nor4_1$1_0.C sar_ctrl_async_phys_0.sg13g2_and2_1$1_0.A 0.02378f
C1710 sar_ctrl_async_phys_0.dac_code_n[3] oa_sar8_acore18_opt_0.sw_bitcell_opt_term_0.VSS 0.07008f
C1711 sar_ctrl_async_phys_0.sg13g2_nand2b_1$1_0.A_N a_28651_39740# 0.17348f
C1712 sar_ctrl_async_phys_0.sg13g2_a22oi_1$1_3.B1 a_31832_34412# 0.27632f
C1713 sar_ctrl_async_phys_0.sg13g2_a21oi_1$1_4.B1 sar_ctrl_async_phys_0.dac_code_n[1] 0.03003f
C1714 sar_ctrl_async_phys_0.bit_active[0] VDD 0.16919f
C1715 sar_ctrl_async_phys_0.sample VDD 4.33512f
C1716 oa_sar8_acore18_opt_0.sw_bitcell_opt_b7_0.bot oa_sar8_acore18_opt_0.sw_bitcell_opt_term_0.vin 4.23458f
C1717 a_31195_39820# a_31935_39775# 0.26905f
C1718 sar_ctrl_async_phys_0.sg13g2_a21oi_1$1_0.B1 sar_ctrl_async_phys_0.sg13g2_buf_1$1_15.A 1.59151f
C1719 sar_ctrl_async_phys_0.sg13g2_buf_1$1_36.A sar_ctrl_async_phys_0.sg13g2_nand2_1$1_3.B 0.04014f
C1720 a_33846_33338# a_34651_32911# 0.097f
C1721 oa_sar8_acore18_opt_0.sw_bitcell_opt_term_0.gb m3_54868_n2380# 1.44533f
C1722 sar_ctrl_async_phys_0.sg13g2_a21oi_1$1_2.B1 sar_ctrl_async_phys_0.sg13g2_a22oi_1$1_3.A2 0.03975f
C1723 a_25596_47222# VDD 0.2853f
C1724 a_27206_39326# track 0.02234f
C1725 sar_ctrl_async_phys_0.sg13g2_nor2b_1$1_0.A a_30507_35204# 0.02126f
C1726 a_25596_43448# sar_ctrl_async_phys_0.sample 0.25174f
C1727 sar_ctrl_async_phys_0.sg13g2_dfrbpq_1$1_0.CLK a_32319_44311# 0.01998f
C1728 sar_ctrl_async_phys_0.dac_code_n[2] oa_sar8_acore18_opt_0.sw_bitcell_opt_b2_0.bot 0.0829f
C1729 sar_ctrl_async_phys_0.dac_code[1] oa_sar8_acore18_opt_0.sw_bitcell_opt_b5_0.bot 0.7608f
C1730 sar_ctrl_async_phys_0.dac_code[5] oa_sar8_acore18_opt_0.sw_bitcell_opt_b0_0.bot 0.15267f
C1731 oa_sar8_acore18_opt_0.sw_bitcell_opt_term_1.bot oa_sar8_acore18_opt_0.bstrap_opt_w2_c1200_1.out 3.86071f
C1732 sar_ctrl_async_phys_0.sg13g2_nand2b_1$1_3.Y a_34171_41332# 0.02997f
C1733 a_29498_40428# VDD 0.09696f
C1734 sar_ctrl_async_phys_0.sg13g2_and2_1$1_6.X a_34800_39034# 0.02495f
C1735 sar_ctrl_async_phys_0.sg13g2_nand2b_1$1_1.B a_35770_43484# 0.02171f
C1736 sar_ctrl_async_phys_0.bit_active[4] VDD 0.25589f
C1737 sar_ctrl_async_phys_0.sg13g2_a22oi_1$1_0.A1 sar_ctrl_async_phys_0.sg13g2_a22oi_1$1_3.B1 0.82943f
C1738 sar_ctrl_async_phys_0.sg13g2_a21oi_1$1_5.Y sar_ctrl_async_phys_0.sg13g2_and2_1$1_0.X 0.2464f
C1739 sar_ctrl_async_phys_0.sg13g2_a21oi_1$1_4.B1 sar_ctrl_async_phys_0.sg13g2_buf_1$1_32.A 0.03626f
C1740 sar_ctrl_async_phys_0.sg13g2_buf_1$1_36.A sar_ctrl_async_phys_0.sg13g2_nand2b_1$1_3.Y 0.11732f
C1741 sar_ctrl_async_phys_0.sg13g2_nor2_1$1_13.A VDD 0.43732f
C1742 a_35557_31435# VDD 0.09574f
C1743 sar_ctrl_async_phys_0.sg13g2_inv_1$1_2.Y sar_ctrl_async_phys_0.sg13g2_a22oi_1$1_2.B2 0.02487f
C1744 sar_ctrl_async_phys_0.sg13g2_nor2_1$1_11.Y a_29562_39996# 0.01635f
C1745 sar_ctrl_async_phys_0.sg13g2_a22oi_1$1_0.A1 sar_ctrl_async_phys_0.sg13g2_buf_1$1_8.A 0.13963f
C1746 sar_ctrl_async_phys_0.sg13g2_buf_1$1_6.X a_30848_32358# 0.11038f
C1747 sar_ctrl_async_phys_0.hold_req sar_ctrl_async_phys_0.cmp_fire 0.06648f
C1748 a_28662_41214# a_28774_41278# 0.55452f
C1749 sar_ctrl_async_phys_0.sg13g2_nor4_1$1_0.C a_28680_40460# 0.02021f
C1750 sar_ctrl_async_phys_0.sg13g2_buf_1$1_17.A a_34420_34837# 0.01416f
C1751 sar_ctrl_async_phys_0.sg13g2_buf_1$1_6.X a_35648_30846# 0.10528f
C1752 a_33944_46594# sar_ctrl_async_phys_0.sg13g2_buf_1$1_2.A 0.01094f
C1753 sar_ctrl_async_phys_0.sg13g2_nand2b_1$1_4.A_N a_36152_45082# 0.02034f
C1754 a_35245_45266# sar_ctrl_async_phys_0.sg13g2_nand2_1$1_3.B 0.18197f
C1755 a_30676_35928# a_31935_36285# 0.01529f
C1756 a_32400_41413# VDD 0.39748f
C1757 sar_ctrl_async_phys_0.sg13g2_a22oi_1$1_2.A2 a_32576_44454# 0.02236f
C1758 a_27304_38928# VDD 0.01839f
C1759 a_25680_39034# VDD 0.06935f
C1760 a_34520_46508# VDD 0.22208f
C1761 sar_ctrl_async_phys_0.sg13g2_nand2_1$1_5.B sar_ctrl_async_phys_0.sg13g2_nand2_1$1_5.Y 0.12815f
C1762 sar_ctrl_async_phys_0.sg13g2_buf_1$1_42.A sar_ctrl_async_phys_0.sg13g2_a22oi_1$1_4.A2 0.21987f
C1763 a_32890_46508# VDD 0.3871f
C1764 sar_ctrl_async_phys_0.dac_code_n[4] sar_ctrl_async_phys_0.sg13g2_buf_1$1_36.A 0.18163f
C1765 sar_ctrl_async_phys_0.sg13g2_dfrbpq_1$1_0.CLK a_33844_43488# 0.09074f
C1766 oa_sar8_acore18_opt_0.sw_tg_opt_0.bot VDD 0.75123f
C1767 sar_ctrl_async_phys_0.sg13g2_buf_1$1_41.X a_35360_43726# 0.09892f
C1768 sar_ctrl_async_phys_0.sg13g2_nor2_1$1_14.A track 0.29415f
C1769 a_34266_38484# VDD 0.01119f
C1770 sar_ctrl_async_phys_0.sg13g2_a22oi_1$1_4.A2 a_33281_40821# 0.01268f
C1771 sar_ctrl_async_phys_0.sg13g2_buf_1$1_14.A sar_ctrl_async_phys_0.bit_active[0] 0.11153f
C1772 sar_ctrl_async_phys_0.sg13g2_buf_1$1_7.A sar_ctrl_async_phys_0.sg13g2_buf_1$1_10.A 1.30588f
C1773 a_29238_40898# a_29524_40464# 0.41329f
C1774 sar_ctrl_async_phys_0.sg13g2_a22oi_1$1_0.B1 a_31247_32876# 0.05312f
C1775 sar_ctrl_async_phys_0.sg13g2_nor2b_1$1_4.Y a_32538_43484# 0.01296f
C1776 sar_ctrl_async_phys_0.sg13g2_o21ai_1$1_1.B1 a_32635_40471# 0.4656f
C1777 a_34808_35200# VDD 0.22335f
C1778 sar_ctrl_async_phys_0.sg13g2_a22oi_1$1_3.A2 sar_ctrl_async_phys_0.sg13g2_inv_1$1_2.Y 0.08161f
C1779 sar_ctrl_async_phys_0.dac_code[1] sar_ctrl_async_phys_0.dac_code[7] 0.57898f
C1780 sar_ctrl_async_phys_0.sg13g2_a21oi_1$1_4.B1 sar_ctrl_async_phys_0.sg13g2_buf_1$1_15.A 0.0892f
C1781 sar_ctrl_async_phys_0.sg13g2_a22oi_1$1_1.A2 sar_ctrl_async_phys_0.bit_active[0] 0.1941f
C1782 a_35866_44532# VDD 0.38055f
C1783 a_30390_39698# a_31093_39677# 0.02454f
C1784 a_35672_35200# sar_ctrl_async_phys_0.bit_active[3] 0.24512f
C1785 sar_ctrl_async_phys_0.sg13g2_dfrbpq_1$1_0.CLK sar_ctrl_async_phys_0.sg13g2_and2_1$1_3.A 0.01204f
C1786 a_33846_33338# a_34549_32911# 0.02432f
C1787 a_34424_35200# sar_ctrl_async_phys_0.bit_active[0] 0.25545f
C1788 sar_ctrl_async_phys_0.bit_active[1] VDD 0.19376f
C1789 a_34136_47296# VDD 0.29348f
C1790 oa_sar8_acore18_opt_0.sw_bitcell_opt_term_0.gb a_35028_n9612# 0.84767f
C1791 sar_ctrl_async_phys_0.sg13g2_a21oi_1$1_0.A1 a_30043_40471# 0.05707f
C1792 a_35418_31668# a_35463_31435# 0.31978f
C1793 oa_sar8_acore18_opt_0.sw_tg_opt_0.bot oa_sar8_acore18_opt_0.sw_bitcell_opt_b6_0.bot 29.8992f
C1794 sar_ctrl_async_phys_0.dac_code_n[1] sar_ctrl_async_phys_0.dac_code[4] 0.05494f
C1795 sar_ctrl_async_phys_0.dac_code[5] a_35948_n9612# 1.25638f
C1796 sar_ctrl_async_phys_0.sg13g2_nand2_1$1_2.B VDD 0.54501f
C1797 sar_ctrl_async_phys_0.sg13g2_buf_1$1_26.X sar_ctrl_async_phys_0.sg13g2_and2_1$1_3.A 1.07405f
C1798 sar_ctrl_async_phys_0.dac_code_n[2] oa_sar8_acore18_opt_0.sw_bitcell_opt_b7_1.VSS 1.045f
C1799 sar_ctrl_async_phys_0.sg13g2_buf_1$1_36.A sar_ctrl_async_phys_0.sg13g2_buf_1$1_37.A 0.10503f
C1800 sar_ctrl_async_phys_0.dac_code[1] oa_sar8_acore18_opt_0.sw_bitcell_opt_b1_0.bot 1.44578f
C1801 sar_ctrl_async_phys_0.sg13g2_buf_1$1_41.X a_31579_44356# 0.44302f
C1802 sar_ctrl_async_phys_0.sg13g2_nand2_1$1_3.A a_36156_45710# 0.26064f
C1803 sar_ctrl_async_phys_0.sg13g2_dfrbpq_1$1_0.CLK a_30331_33772# 0.01464f
C1804 a_35463_31435# result[3] 0.01151f
C1805 sar_ctrl_async_phys_0.sg13g2_a21oi_1$1_2.B1 a_33556_40016# 0.03305f
C1806 sar_ctrl_async_phys_0.sg13g2_buf_1$1_36.A sar_ctrl_async_phys_0.sg13g2_buf_1$1_35.A 0.67096f
C1807 a_36152_36806# VDD 0.12573f
C1808 sar_ctrl_async_phys_0.sg13g2_and2_1$1_0.A a_31947_41508# 0.01611f
C1809 sar_ctrl_async_phys_0.sg13g2_dfrbpq_1$1_0.CLK a_30043_40471# 0.03138f
C1810 sar_ctrl_async_phys_0.sg13g2_dfrbpq_1$1_0.CLK a_29332_32456# 0.08437f
C1811 sar_ctrl_async_phys_0.sg13g2_buf_1$1_36.A sar_ctrl_async_phys_0.dac_code[0] 0.13107f
C1812 sar_ctrl_async_phys_0.sg13g2_buf_1$1_41.X a_33658_44996# 0.04709f
C1813 a_35672_46508# sar_ctrl_async_phys_0.dac_code_n[6] 0.24512f
C1814 sar_ctrl_async_phys_0.sg13g2_dfrbpq_1$1_0.CLK a_34132_30944# 0.06904f
C1815 sar_ctrl_async_phys_0.sg13g2_buf_1$1_6.X a_29812_33968# 0.40065f
C1816 sar_ctrl_async_phys_0.sg13g2_and2_1$1_3.X track 0.11415f
C1817 sar_ctrl_async_phys_0.sg13g2_a22oi_1$1_0.Y sar_ctrl_async_phys_0.sg13g2_a22oi_1$1_1.Y 0.99552f
C1818 sar_ctrl_async_phys_0.sg13g2_o21ai_1$1_1.B1 a_33270_39698# 0.09797f
C1819 sar_ctrl_async_phys_0.sg13g2_buf_1$1_19.A a_33530_39921# 0.02703f
C1820 sar_ctrl_async_phys_0.sg13g2_nor2_1$1_6.B a_29276_37436# 0.01451f
C1821 sar_ctrl_async_phys_0.sg13g2_nor2_1$1_3.B a_27206_39326# 0.07484f
C1822 sar_ctrl_async_phys_0.sg13g2_nor4_1$1_0.C a_29238_40898# 0.01841f
C1823 sar_ctrl_async_phys_0.sg13g2_nor2_1$1_10.B VDD 1.46308f
C1824 sar_ctrl_async_phys_0.sg13g2_buf_1$1_6.X a_34106_30849# 0.27272f
C1825 a_26666_38912# a_26385_39214# 0.26306f
C1826 a_25496_39034# a_25680_39034# 0.0524f
C1827 sar_ctrl_async_phys_0.dac_code_n[3] VDD 4.71881f
C1828 a_34236_46472# a_34520_46508# 0.09867f
C1829 sar_ctrl_async_phys_0.sg13g2_a22oi_1$1_4.A2 a_31732_35480# 0.03317f
C1830 sar_ctrl_async_phys_0.dac_code_n[1] oa_sar8_acore18_opt_0.bstrap_opt_w2_c1200_1.out 1.66192f
C1831 a_30390_36362# a_31093_35935# 0.02432f
C1832 sar_ctrl_async_phys_0.sg13g2_dfrbpq_1$1_0.CLK a_30752_39190# 0.0124f
C1833 sar_ctrl_async_phys_0.sg13g2_a21oi_1$1_4.B1 sar_ctrl_async_phys_0.sg13g2_o21ai_1$1_1.B1 0.02335f
C1834 a_32223_46869# a_32890_46508# 0.0894f
C1835 sar_ctrl_async_phys_0.dac_code_n[4] sar_ctrl_async_phys_0.sg13g2_buf_1$1_46.A 0.54384f
C1836 sar_ctrl_async_phys_0.dac_code_n[5] sar_ctrl_async_phys_0.dac_code_n[6] 11.5165f
C1837 sar_ctrl_async_phys_0.sg13g2_dfrbpq_1$1_0.CLK a_27984_41342# 0.01788f
C1838 sar_ctrl_async_phys_0.dac_code_n[6] oa_sar8_acore18_opt_0.sw_bitcell_opt_term_0.gb 0.15158f
C1839 sar_ctrl_async_phys_0.sg13g2_a21oi_1$1_4.B1 sar_ctrl_async_phys_0.sg13g2_and2_1$1_0.A 0.02546f
C1840 a_35072_39918# VDD 0.1706f
C1841 a_28006_35948# sar_ctrl_async_phys_0.sg13g2_dlygate4sd3_1$1_1.A 0.18762f
C1842 sar_ctrl_async_phys_0.sg13g2_inv_1$1_5.Y a_29332_32456# 0.01272f
C1843 oa_sar8_acore18_opt_0.sw_bitcell_opt_term_0.trkb m3_60844_n2380# 0.03859f
C1844 sar_ctrl_async_phys_0.dac_code_n[2] oa_sar8_acore18_opt_0.sw_bitcell_opt_b2_1.bot 1.30837f
C1845 sar_ctrl_async_phys_0.sg13g2_a21oi_1$1_4.A2 VDD 0.56469f
C1846 m3_48572_n2380# VDD 0.02229f
C1847 sar_ctrl_async_phys_0.sg13g2_nor2_1$1_0.Y a_32090_40428# 0.02157f
C1848 result[0] result[1] 0.30366f
C1849 sar_ctrl_async_phys_0.sg13g2_nand2b_1$1_1.B a_35772_41936# 0.25445f
C1850 sar_ctrl_async_phys_0.sg13g2_o21ai_1$1_1.B1 a_31830_40898# 0.09791f
C1851 sar_ctrl_async_phys_0.sg13g2_inv_1$1_3.Y a_31258_32436# 0.0146f
C1852 sar_ctrl_async_phys_0.dac_code_n[3] oa_sar8_acore18_opt_0.sw_bitcell_opt_b6_0.bot 1.1155f
C1853 w_39600_n9960# sar_ctrl_async_phys_0.dac_code_n[3] 0.02244f
C1854 sar_ctrl_async_phys_0.sg13g2_nor2b_1$1_3.Y sar_ctrl_async_phys_0.sg13g2_nand2_1$1_2.B 0.07712f
C1855 sar_ctrl_async_phys_0.sg13g2_a22oi_1$1_1.A2 a_34808_35200# 0.02348f
C1856 a_34904_47296# VDD 0.22112f
C1857 a_33654_44234# VDD 0.81377f
C1858 sar_ctrl_async_phys_0.sg13g2_nor2_1$1_0.Y sar_ctrl_async_phys_0.sg13g2_a22oi_1$1_2.A2 2.46667f
C1859 oa_sar8_acore18_opt_0.sw_tg_opt_0.bot oa_sar8_acore18_opt_0.sw_bitcell_opt_b2_0.bot 1.82508f
C1860 VDD vcm 0.5117f
C1861 sar_ctrl_async_phys_0.dac_code_n[0] sar_ctrl_async_phys_0.dac_code_n[5] 0.16371f
C1862 sar_ctrl_async_phys_0.dac_code_n[2] sar_ctrl_async_phys_0.dac_code_n[4] 3.20331f
C1863 a_35962_35924# VDD 0.37823f
C1864 sar_ctrl_async_phys_0.sg13g2_a22oi_1$1_0.A1 sar_ctrl_async_phys_0.sg13g2_buf_1$1_17.A 0.03852f
C1865 sar_ctrl_async_phys_0.sg13g2_a22oi_1$1_0.A2 sar_ctrl_async_phys_0.sg13g2_buf_1$1_6.X 0.07752f
C1866 a_34526_31826# a_34767_31359# 0.01058f
C1867 a_36058_34412# busy 0.01097f
C1868 sar_ctrl_async_phys_0.dac_code_n[0] oa_sar8_acore18_opt_0.sw_bitcell_opt_term_0.gb 0.12845f
C1869 sar_ctrl_async_phys_0.sg13g2_a22oi_1$1_0.A1 sar_ctrl_async_phys_0.sg13g2_buf_1$1_0.A 0.22712f
C1870 sar_ctrl_async_phys_0.sg13g2_o21ai_1$1_1.B1 a_33951_45823# 0.13292f
C1871 sar_ctrl_async_phys_0.sg13g2_buf_1$1_8.A a_33464_31388# 0.28142f
C1872 sar_ctrl_async_phys_0.sg13g2_and2_1$1_0.A a_31352_36806# 0.04142f
C1873 VDD result[4] 0.30893f
C1874 sar_ctrl_async_phys_0.sample oa_sar8_acore18_opt_0.sw_bitcell_opt_b7_1.VSS 0.17303f
C1875 sar_ctrl_async_phys_0.sg13g2_buf_1$1_15.A sar_ctrl_async_phys_0.dac_code[4] 0.27276f
C1876 a_35456_44454# a_35866_44532# 0.10373f
C1877 sar_ctrl_async_phys_0.sg13g2_nor2_1$1_14.A sar_ctrl_async_phys_0.sg13g2_nor2_1$1_3.B 0.03003f
C1878 a_33846_33338# result[5] 0.0119f
C1879 a_36056_38224# sar_ctrl_async_phys_0.dac_code[7] 0.2475f
C1880 sar_ctrl_async_phys_0.sg13g2_buf_1$1_46.A sar_ctrl_async_phys_0.dac_code[0] 0.32842f
C1881 a_35103_36751# VDD 0.17425f
C1882 sar_ctrl_async_phys_0.sg13g2_buf_1$1_20.A sar_ctrl_async_phys_0.bit_active[4] 0.03073f
C1883 sar_ctrl_async_phys_0.sg13g2_and2_1$1_6.X sar_ctrl_async_phys_0.sg13g2_buf_1$1_3.A 0.02145f
C1884 a_25878_40460# VDD 0.23028f
C1885 sar_ctrl_async_phys_0.sg13g2_buf_1$1_41.X a_31732_45000# 0.38811f
C1886 sar_ctrl_async_phys_0.sg13g2_a22oi_1$1_0.A2 sar_ctrl_async_phys_0.sg13g2_a22oi_1$1_1.B2 0.0222f
C1887 a_35770_36972# sar_ctrl_async_phys_0.bit_active[3] 0.03562f
C1888 sar_ctrl_async_phys_0.sg13g2_a22oi_1$1_2.B2 a_33752_33688# 0.25755f
C1889 sar_ctrl_async_phys_0.sg13g2_dfrbpq_1$1_0.CLK sar_ctrl_async_phys_0.bit_active[2] 0.50016f
C1890 sar_ctrl_async_phys_0.sg13g2_buf_1$1_2.A sar_ctrl_async_phys_0.sg13g2_buf_1$1_13.A 0.02746f
C1891 sar_ctrl_async_phys_0.dac_code_n[5] sar_ctrl_async_phys_0.dac_code_n[7] 0.12926f
C1892 a_35288_33688# result[7] 0.09723f
C1893 sar_ctrl_async_phys_0.sg13g2_a21oi_1$1_3.B1 sar_ctrl_async_phys_0.sg13g2_a22oi_1$1_3.A2 0.83097f
C1894 sar_ctrl_async_phys_0.dac_code_n[7] oa_sar8_acore18_opt_0.sw_bitcell_opt_term_0.gb 0.11198f
C1895 sar_ctrl_async_phys_0.sg13g2_nor2b_1$1_1.B_N sar_ctrl_async_phys_0.bit_active[0] 0.30188f
C1896 sar_ctrl_async_phys_0.sg13g2_a22oi_1$1_4.A2 a_33530_39921# 0.02452f
C1897 a_33080_31388# VDD 0.22118f
C1898 sar_ctrl_async_phys_0.sg13g2_dlygate4sd3_1$1_5.A a_25496_42854# 0.02058f
C1899 sar_ctrl_async_phys_0.sg13g2_buf_1$1_6.X a_31832_34412# 0.01662f
C1900 a_31640_41342# VDD 0.16037f
C1901 a_31638_32138# a_32212_32151# 0.31978f
C1902 sar_ctrl_async_phys_0.sg13g2_a21oi_1$1_4.B1 sar_ctrl_async_phys_0.dac_code[1] 0.01122f
C1903 sar_ctrl_async_phys_0.sg13g2_buf_1$1_6.X a_35463_31435# 0.09272f
C1904 sar_ctrl_async_phys_0.sg13g2_a21oi_1$1_0.A2 sar_ctrl_async_phys_0.bit_active[2] 0.19437f
C1905 sar_ctrl_async_phys_0.sg13g2_buf_1$1_2.A sar_ctrl_async_phys_0.sg13g2_nor2_1$1_2.Y 0.01177f
C1906 oa_sar8_acore18_opt_0.sw_bitcell_opt_b5_0.bot m3_41836_n2380# 1.76659f
C1907 sar_ctrl_async_phys_0.sg13g2_dfrbpq_1$1_0.CLK a_28662_41214# 0.06872f
C1908 sar_ctrl_async_phys_0.sg13g2_dfrbpq_1$1_0.CLK a_28950_39386# 0.04601f
C1909 sar_ctrl_async_phys_0.sg13g2_a22oi_1$1_4.A2 sar_ctrl_async_phys_0.sg13g2_buf_1$1_4.A 0.01645f
C1910 sar_ctrl_async_phys_0.dac_code_n[2] sar_ctrl_async_phys_0.dac_code[0] 0.07017f
C1911 sar_ctrl_async_phys_0.sg13g2_and2_1$1_0.A sar_ctrl_async_phys_0.sg13g2_nor2_1$1_6.Y 0.9116f
C1912 sar_ctrl_async_phys_0.sg13g2_a22oi_1$1_3.A2 a_33248_35382# 0.04007f
C1913 a_35245_42242# sar_ctrl_async_phys_0.sg13g2_nand2b_1$1_2.A_N 0.16549f
C1914 a_33168_39830# VDD 0.06984f
C1915 sar_ctrl_async_phys_0.sg13g2_nor4_1$1_0.C sar_ctrl_async_phys_0.sg13g2_and2_1$1_6.X 0.03796f
C1916 sar_ctrl_async_phys_0.sg13g2_inv_1$1_2.Y sar_ctrl_async_phys_0.sg13g2_buf_1$1_10.A 0.2457f
C1917 sar_ctrl_async_phys_0.sample oa_sar8_acore18_opt_0.sw_bitcell_opt_b2_1.bot 1.66251f
C1918 sar_ctrl_async_phys_0.dac_code[5] oa_sar8_acore18_opt_0.sw_bitcell_opt_b7_0.bot 2.3546f
C1919 a_31381_46519# VDD 0.26496f
C1920 oa_sar8_acore18_opt_0.sw_bitcell_opt_term_0.trkb m3_34580_n2380# 0.03859f
C1921 a_30037_43495# VDD 0.26385f
C1922 sar_ctrl_async_phys_0.dac_code_n[3] oa_sar8_acore18_opt_0.sw_bitcell_opt_b2_0.bot 0.10702f
C1923 a_20412_n9612# VDD 1.41542f
C1924 m3_57896_n2380# m3_60844_n2380# 0.0157f
C1925 sar_ctrl_async_phys_0.sg13g2_buf_1$1_3.A a_35552_36166# 0.03331f
C1926 sar_ctrl_async_phys_0.sg13g2_and2_1$1_3.X sar_ctrl_async_phys_0.sg13g2_nor2_1$1_3.B 0.29369f
C1927 a_36056_32176# result[6] 0.24535f
C1928 a_35672_47296# VDD 0.21798f
C1929 sar_ctrl_async_phys_0.sg13g2_dlygate4sd3_1$1_11.X VDD 0.2482f
C1930 a_25990_40484# sar_ctrl_async_phys_0.sg13g2_dlygate4sd3_1$1_6.A 0.15773f
C1931 sar_ctrl_async_phys_0.sg13g2_a22oi_1$1_0.A1 sar_ctrl_async_phys_0.sg13g2_buf_1$1_6.X 0.50718f
C1932 sar_ctrl_async_phys_0.sg13g2_buf_1$1_26.X sar_ctrl_async_phys_0.cmp_n 0.02125f
C1933 sar_ctrl_async_phys_0.dac_code_n[4] sar_ctrl_async_phys_0.sample 0.04464f
C1934 a_34453_35935# VDD 0.24748f
C1935 a_34636_31749# a_34526_31826# 0.43239f
C1936 a_34268_31826# a_34615_31475# 0.02979f
C1937 sar_ctrl_async_phys_0.sg13g2_nor2b_1$1_2.Y a_34308_37400# 0.25221f
C1938 sar_ctrl_async_phys_0.sg13g2_nor2_1$1_0.Y a_32406_45746# 0.2868f
C1939 sar_ctrl_async_phys_0.sg13g2_nor2b_1$1_0.A sar_ctrl_async_phys_0.sg13g2_nand2_1$1_2.B 0.08645f
C1940 oa_sar8_acore18_opt_0.sw_bitcell_opt_b4_0.bot m3_34580_n2380# 0.02484f
C1941 sar_ctrl_async_phys_0.dac_code_n[6] sar_ctrl_async_phys_0.dac_code[2] 0.06252f
C1942 a_34069_41189# a_33940_41223# 0.01562f
C1943 sar_ctrl_async_phys_0.sg13g2_dfrbpq_1$1_0.CLK result[7] 0.21526f
C1944 a_33940_44552# a_35199_44311# 0.01529f
C1945 sar_ctrl_async_phys_0.hold_req oa_sar8_acore18_opt_0.sw_bitcell_opt_term_0.VSS 1.93568f
C1946 sar_ctrl_async_phys_0.sg13g2_a22oi_1$1_1.A2 result[4] 0.01907f
C1947 sar_ctrl_async_phys_0.sg13g2_buf_1$1_2.A a_33844_36992# 0.01013f
C1948 sar_ctrl_async_phys_0.sg13g2_nor2_1$1_4.Y sar_ctrl_async_phys_0.sg13g2_nand3_1$1_0.Y 0.02126f
C1949 a_33464_31388# result[3] 0.24645f
C1950 sar_ctrl_async_phys_0.sg13g2_a21oi_1$1_5.Y sar_ctrl_async_phys_0.sg13g2_inv_1$1_6.A 0.0107f
C1951 a_35000_45878# VDD 0.13924f
C1952 a_35391_33261# VDD 0.17444f
C1953 sar_ctrl_async_phys_0.sg13g2_a22oi_1$1_0.A1 sar_ctrl_async_phys_0.sg13g2_a22oi_1$1_1.B2 0.21653f
C1954 sar_ctrl_async_phys_0.sg13g2_nand2_1$1_3.B a_35866_44532# 0.12339f
C1955 sar_ctrl_async_phys_0.sg13g2_buf_1$1_0.A a_34136_33688# 0.26774f
C1956 sar_ctrl_async_phys_0.sg13g2_a21oi_1$1_2.B1 a_30027_39996# 0.01253f
C1957 a_27249_39888# track 0.0497f
C1958 sar_ctrl_async_phys_0.dac_code_n[2] oa_sar8_acore18_opt_0.sw_bitcell_opt_term_1.bot 0.06773f
C1959 sar_ctrl_async_phys_0.sg13g2_and2_1$1_3.A a_27120_37522# 0.01861f
C1960 sar_ctrl_async_phys_0.sg13g2_nand2b_1$1_5.A_N sar_ctrl_async_phys_0.sg13g2_buf_1$1_36.A 0.10109f
C1961 sar_ctrl_async_phys_0.cmp_valid VDD 0.20889f
C1962 sar_ctrl_async_phys_0.sg13g2_nor2b_1$1_2.Y a_33844_36992# 0.05004f
C1963 sar_ctrl_async_phys_0.sg13g2_a22oi_1$1_0.A2 a_34651_32911# 0.02305f
C1964 w_16692_n9960# oa_sar8_acore18_opt_0.sw_bitcell_opt_b3_1.bot 0.02733f
C1965 sar_ctrl_async_phys_0.dac_code_n[1] sar_ctrl_async_phys_0.sg13g2_buf_1$1_36.A 0.0133f
C1966 a_28368_36877# VDD 0.39164f
C1967 sar_ctrl_async_phys_0.sg13g2_dfrbpq_1$1_0.CLK a_34615_31475# 0.04307f
C1968 sar_ctrl_async_phys_0.sg13g2_nor2b_1$1_1.B_N a_34808_35200# 0.26818f
C1969 a_31189_31399# VDD 0.24903f
C1970 sar_ctrl_async_phys_0.sg13g2_inv_1$1_10.Y a_28392_41214# 0.06515f
C1971 a_33375_40821# a_34042_40460# 0.0894f
C1972 sar_ctrl_async_phys_0.dac_code_n[0] sar_ctrl_async_phys_0.dac_code[2] 0.06405f
C1973 sar_ctrl_async_phys_0.sg13g2_buf_1$1_7.A a_31924_32456# 0.01219f
C1974 sar_ctrl_async_phys_0.sg13g2_buf_1$1_13.A a_35288_38224# 0.25838f
C1975 sar_ctrl_async_phys_0.sg13g2_a22oi_1$1_0.A2 a_34731_37436# 0.06162f
C1976 sar_ctrl_async_phys_0.sg13g2_o21ai_1$1_1.B1 a_31093_39677# 0.03524f
C1977 sar_ctrl_async_phys_0.sg13g2_nor2b_1$1_3.Y a_33168_39830# 0.02821f
C1978 sar_ctrl_async_phys_0.sg13g2_and2_1$1_1.B sar_ctrl_async_phys_0.bit_active[4] 0.03433f
C1979 sar_ctrl_async_phys_0.sg13g2_and2_1$1_0.A a_31093_39677# 0.01767f
C1980 sar_ctrl_async_phys_0.sg13g2_nor2_1$1_4.Y a_26566_41996# 0.05084f
C1981 sar_ctrl_async_phys_0.sg13g2_nor2b_1$1_0.A sar_ctrl_async_phys_0.sg13g2_nor2_1$1_10.B 0.80698f
C1982 a_25596_41174# sar_ctrl_async_phys_0.cmp_fire 0.24585f
C1983 sar_ctrl_async_phys_0.sg13g2_nor4_1$1_0.Y a_26280_41214# 0.0121f
C1984 sar_ctrl_async_phys_0.dac_code_n[3] m3_45264_n2380# 0.05682f
C1985 sar_ctrl_async_phys_0.sg13g2_a22oi_1$1_0.B2 a_34549_30605# 0.01042f
C1986 a_33973_39677# a_33844_39711# 0.01562f
C1987 a_34815_39775# a_35072_39918# 0.34468f
C1988 a_29524_40464# a_30689_40821# 0.43239f
C1989 sar_ctrl_async_phys_0.sg13g2_a21oi_1$1_0.B1 sar_ctrl_async_phys_0.sg13g2_and2_1$1_6.X 0.03194f
C1990 sar_ctrl_async_phys_0.sg13g2_buf_1$1_42.A a_33276_42686# 0.01861f
C1991 sar_ctrl_async_phys_0.sg13g2_a21oi_1$1_2.Y a_29755_38959# 0.06214f
C1992 sar_ctrl_async_phys_0.sample oa_sar8_acore18_opt_0.sw_bitcell_opt_b6_1.bot 1.89979f
C1993 sar_ctrl_async_phys_0.dac_code[6] oa_sar8_acore18_opt_0.sw_bitcell_opt_b5_0.bot 0.65555f
C1994 sar_ctrl_async_phys_0.sg13g2_nor2_1$1_4.Y a_26364_45710# 0.03206f
C1995 a_32602_39996# VDD 0.38463f
C1996 sar_ctrl_async_phys_0.sg13g2_buf_1$1_3.A sar_ctrl_async_phys_0.dac_code[6] 0.21769f
C1997 sar_ctrl_async_phys_0.sg13g2_inv_1$1_7.A a_29258_36642# 0.02103f
C1998 sar_ctrl_async_phys_0.sg13g2_a21oi_1$1_4.A2 sar_ctrl_async_phys_0.sg13g2_buf_1$1_20.A 0.01467f
C1999 sar_ctrl_async_phys_0.dac_code_n[3] oa_sar8_acore18_opt_0.sw_bitcell_opt_b7_1.VSS 1.11123f
C2000 sar_ctrl_async_phys_0.dac_code[1] sar_ctrl_async_phys_0.dac_code[4] 0.1931f
C2001 sar_ctrl_async_phys_0.sg13g2_dlygate4sd3_1$1_11.X a_27032_39034# 0.0312f
C2002 a_31546_43484# sar_ctrl_async_phys_0.sg13g2_a21oi_1$1_4.A2 0.13046f
C2003 sar_ctrl_async_phys_0.dac_code[2] sar_ctrl_async_phys_0.dac_code_n[7] 0.06322f
C2004 sar_ctrl_async_phys_0.dac_code_n[4] oa_sar8_acore18_opt_0.sw_tg_opt_0.bot 0.84386f
C2005 sar_ctrl_async_phys_0.sg13g2_a21oi_1$1_2.B1 a_34817_41287# 0.01466f
C2006 sar_ctrl_async_phys_0.sg13g2_nor2_1$1_10.Y sar_ctrl_async_phys_0.sg13g2_nor2_1$1_10.B 0.16338f
C2007 sar_ctrl_async_phys_0.sg13g2_and2_1$1_0.A a_30676_35928# 0.02102f
C2008 m3_45264_n2380# m3_48572_n2380# 0.0157f
C2009 sar_ctrl_async_phys_0.sg13g2_a22oi_1$1_3.A2 a_32533_40471# 0.02609f
C2010 sar_ctrl_async_phys_0.sg13g2_nor2_1$1_14.A sar_ctrl_async_phys_0.sg13g2_dlygate4sd3_1$1_6.A 0.25757f
C2011 sar_ctrl_async_phys_0.sg13g2_and2_1$1_0.A a_26630_37814# 0.05388f
C2012 a_36056_37436# VDD 0.25958f
C2013 sar_ctrl_async_phys_0.sg13g2_buf_1$1_42.A a_33085_43832# 0.01094f
C2014 sar_ctrl_async_phys_0.sg13g2_nand2b_1$1_5.A_N a_33658_44996# 0.11615f
C2015 a_31256_37522# VDD 0.13725f
C2016 sar_ctrl_async_phys_0.sg13g2_buf_1$1_5.A result[5] 0.01653f
C2017 sar_ctrl_async_phys_0.sg13g2_nand2b_1$1_4.A_N a_35770_43484# 0.11503f
C2018 sar_ctrl_async_phys_0.sg13g2_buf_1$1_4.A a_35672_35200# 0.01226f
C2019 a_32602_35924# VDD 0.38551f
C2020 sar_ctrl_async_phys_0.sg13g2_nand2b_1$1_0.A_N a_27738_40460# 0.01502f
C2021 sar_ctrl_async_phys_0.dac_code[3] oa_sar8_acore18_opt_0.sw_bitcell_opt_b5_0.bot 0.58748f
C2022 sar_ctrl_async_phys_0.sg13g2_dfrbpq_1$1_0.CLK a_34596_40424# 0.05058f
C2023 a_34055_31352# a_34268_31826# 0.34468f
C2024 sar_ctrl_async_phys_0.sg13g2_nor2_1$1_10.Y sar_ctrl_async_phys_0.sg13g2_a21oi_1$1_4.A2 0.01805f
C2025 sar_ctrl_async_phys_0.cmp_fire VDD 8.48843f
C2026 sar_ctrl_async_phys_0.sg13g2_nor2_1$1_5.A a_28950_39386# 0.34958f
C2027 sar_ctrl_async_phys_0.sg13g2_nor4_1$1_0.C sar_ctrl_async_phys_0.cmp_fault 0.05439f
C2028 a_33652_41528# a_34171_41332# 0.34114f
C2029 a_30830_35166# a_31007_35460# 0.01057f
C2030 sar_ctrl_async_phys_0.sg13g2_nor2b_1$1_0.Y a_31542_37874# 0.33212f
C2031 sar_ctrl_async_phys_0.sg13g2_buf_1$1_1.A a_30830_35166# 0.09326f
C2032 sar_ctrl_async_phys_0.sg13g2_nor2_1$1_11.Y VDD 0.40452f
C2033 sar_ctrl_async_phys_0.sg13g2_and2_1$1_6.X a_31947_41508# 0.08698f
C2034 sar_ctrl_async_phys_0.sg13g2_a21oi_1$1_3.A2 sar_ctrl_async_phys_0.dac_code[6] 0.06323f
C2035 sar_ctrl_async_phys_0.sg13g2_a21oi_1$1_0.A1 sar_ctrl_async_phys_0.sg13g2_buf_1$1_13.A 0.11367f
C2036 sar_ctrl_async_phys_0.dac_code_n[6] oa_sar8_acore18_opt_0.sw_bitcell_opt_b3_0.bot 0.08014f
C2037 a_31247_32876# VDD 0.30319f
C2038 sar_ctrl_async_phys_0.sg13g2_a21oi_1$1_6.A2 a_32406_45746# 0.05168f
C2039 a_31477_44213# a_31348_44247# 0.01562f
C2040 a_35295_36285# a_35962_35924# 0.0894f
C2041 sar_ctrl_async_phys_0.dac_code_n[5] oa_sar8_acore18_opt_0.sw_tg_opt_1.bot 0.0767f
C2042 sar_ctrl_async_phys_0.dac_code_n[1] sar_ctrl_async_phys_0.sg13g2_buf_1$1_46.A 0.01853f
C2043 sar_ctrl_async_phys_0.sample oa_sar8_acore18_opt_0.sw_bitcell_opt_term_1.bot 1.5824f
C2044 sar_ctrl_async_phys_0.sg13g2_nand2_1$1_3.A a_35672_46508# 0.01781f
C2045 sar_ctrl_async_phys_0.dac_code_n[3] sar_ctrl_async_phys_0.sg13g2_nand2b_1$1_3.Y 0.29076f
C2046 sar_ctrl_async_phys_0.sg13g2_buf_1$1_15.A a_34171_41332# 0.01483f
C2047 sar_ctrl_async_phys_0.sg13g2_a22oi_1$1_0.A2 a_34549_32911# 0.02806f
C2048 sar_ctrl_async_phys_0.dac_code[6] sar_ctrl_async_phys_0.dac_code[7] 4.15647f
C2049 sar_ctrl_async_phys_0.sg13g2_nor2_1$1_1.Y sar_ctrl_async_phys_0.sg13g2_a21oi_1$1_2.B1 0.02559f
C2050 sar_ctrl_async_phys_0.dac_code_n[3] oa_sar8_acore18_opt_0.sw_bitcell_opt_b2_1.bot 0.11977f
C2051 sar_ctrl_async_phys_0.sg13g2_dfrbpq_1$1_0.CLK a_34055_31352# 0.02002f
C2052 sar_ctrl_async_phys_0.dac_code[0] oa_sar8_acore18_opt_0.sw_tg_opt_0.bot 0.94493f
C2053 sar_ctrl_async_phys_0.sg13g2_and2_1$1_1.B a_36152_36806# 0.0243f
C2054 sar_ctrl_async_phys_0.sg13g2_dfrbpq_1$1_0.CLK sar_ctrl_async_phys_0.sg13g2_buf_1$1_13.A 3.36369f
C2055 sar_ctrl_async_phys_0.sg13g2_nor2_1$1_2.Y sar_ctrl_async_phys_0.sg13g2_a21oi_1$1_0.A1 0.02541f
C2056 a_32116_40464# a_33375_40821# 0.01529f
C2057 a_33844_43488# a_35009_43845# 0.43239f
C2058 sar_ctrl_async_phys_0.sg13g2_dlygate4sd3_1$1_6.A sar_ctrl_async_phys_0.sg13g2_and2_1$1_3.X 0.18251f
C2059 sar_ctrl_async_phys_0.sg13g2_buf_1$1_42.A a_34208_45966# 0.0569f
C2060 sar_ctrl_async_phys_0.sg13g2_nor2_1$1_10.A sar_ctrl_async_phys_0.sg13g2_and2_1$1_6.X 0.04685f
C2061 a_30591_32215# a_30497_32215# 0.28931f
C2062 sar_ctrl_async_phys_0.dac_code_n[0] oa_sar8_acore18_opt_0.sw_bitcell_opt_b3_0.bot 0.06958f
C2063 sar_ctrl_async_phys_0.sg13g2_a21oi_1$1_4.B1 sar_ctrl_async_phys_0.sg13g2_and2_1$1_6.X 0.05187f
C2064 sar_ctrl_async_phys_0.sg13g2_inv_1$1_0.Y a_35463_31435# 0.28638f
C2065 sar_ctrl_async_phys_0.dac_code[6] oa_sar8_acore18_opt_0.sw_bitcell_opt_b1_0.bot 0.17902f
C2066 sar_ctrl_async_phys_0.dac_code_n[4] sar_ctrl_async_phys_0.dac_code_n[3] 7.38812f
C2067 sar_ctrl_async_phys_0.sg13g2_a22oi_1$1_2.B2 sar_ctrl_async_phys_0.sg13g2_inv_1$1_3.Y 0.07375f
C2068 a_32580_43448# a_33085_43832# 0.01771f
C2069 sar_ctrl_async_phys_0.sg13g2_and2_1$1_0.B a_29653_38959# 0.0105f
C2070 a_33973_39677# a_34075_39820# 0.47622f
C2071 sar_ctrl_async_phys_0.dac_code_n[2] sar_ctrl_async_phys_0.dac_code_n[1] 28.6759f
C2072 sar_ctrl_async_phys_0.sg13g2_dfrbpq_1$1_0.CLK sar_ctrl_async_phys_0.sg13g2_nor2_1$1_2.Y 0.02078f
C2073 sar_ctrl_async_phys_0.sg13g2_a22oi_1$1_3.A2 sar_ctrl_async_phys_0.sg13g2_buf_1$1_4.A 0.01714f
C2074 sar_ctrl_async_phys_0.sg13g2_buf_1$1_8.A a_33440_32358# 0.04188f
C2075 sar_ctrl_async_phys_0.sg13g2_dfrbpq_1$1_0.CLK a_33973_39677# 0.27341f
C2076 sar_ctrl_async_phys_0.sg13g2_nor4_1$1_0.Y sar_ctrl_async_phys_0.sg13g2_nor2_1$1_13.B 0.01424f
C2077 a_30676_40016# VDD 0.07223f
C2078 a_35391_30703# a_35297_30703# 0.28931f
C2079 sar_ctrl_async_phys_0.dac_code[3] sar_ctrl_async_phys_0.dac_code[7] 0.07489f
C2080 sar_ctrl_async_phys_0.sg13g2_a22oi_1$1_3.A2 a_33344_37678# 0.01808f
C2081 a_33844_36992# a_34132_36687# 0.43707f
C2082 a_35672_33688# busy 0.24512f
C2083 sar_ctrl_async_phys_0.sg13g2_and2_1$1_0.B VDD 0.44677f
C2084 sar_ctrl_async_phys_0.sg13g2_buf_1$1_13.A a_32116_40464# 0.01986f
C2085 sar_ctrl_async_phys_0.sg13g2_buf_1$1_41.X sar_ctrl_async_phys_0.sg13g2_a21oi_1$1_4.A2 0.04118f
C2086 sar_ctrl_async_phys_0.sg13g2_nor2b_1$1_4.Y a_30785_43845# 0.01626f
C2087 a_29908_43909# a_30139_43495# 0.12701f
C2088 sar_ctrl_async_phys_0.sg13g2_and2_1$1_6.X a_31830_40898# 0.02908f
C2089 sar_ctrl_async_phys_0.sg13g2_inv_1$1_5.A a_29851_32260# 0.07233f
C2090 sar_ctrl_async_phys_0.sg13g2_a22oi_1$1_2.A2 sar_ctrl_async_phys_0.sg13g2_a22oi_1$1_2.Y 0.01805f
C2091 sar_ctrl_async_phys_0.hold_req VDD 0.93949f
C2092 w_16692_n9960# oa_sar8_acore18_opt_0.bstrap_opt_w2_c1200_1.out 0.03635f
C2093 sar_ctrl_async_phys_0.sg13g2_buf_1$1_2.A sar_ctrl_async_phys_0.sg13g2_a22oi_1$1_0.B2 0.01975f
C2094 sar_ctrl_async_phys_0.dac_code_n[7] oa_sar8_acore18_opt_0.sw_bitcell_opt_b3_0.bot 0.0722f
C2095 sar_ctrl_async_phys_0.sg13g2_a22oi_1$1_2.A2 a_32792_41342# 0.01103f
C2096 sar_ctrl_async_phys_0.sg13g2_buf_1$1_41.X a_33654_44234# 0.13045f
C2097 sar_ctrl_async_phys_0.sg13g2_a22oi_1$1_2.A2 sar_ctrl_async_phys_0.sg13g2_a21oi_1$1_0.A1 0.14915f
C2098 sar_ctrl_async_phys_0.sg13g2_nor2_1$1_3.B sar_ctrl_async_phys_0.sg13g2_nor2_1$1_3.Y 0.18464f
C2099 sar_ctrl_async_phys_0.sg13g2_buf_1$1_13.A a_32888_36806# 0.01776f
C2100 sar_ctrl_async_phys_0.dac_code[3] oa_sar8_acore18_opt_0.sw_bitcell_opt_b1_0.bot 0.15675f
C2101 a_31542_37874# VDD 0.77997f
C2102 sar_ctrl_async_phys_0.sg13g2_a21oi_1$1_3.B1 sar_ctrl_async_phys_0.dac_code_n[7] 1.34287f
C2103 a_26544_38389# sar_ctrl_async_phys_0.sg13g2_buf_1$1_26.X 0.25477f
C2104 a_33183_32215# VDD 0.17909f
C2105 sar_ctrl_async_phys_0.sg13g2_nor2_1$1_2.Y a_32116_40464# 0.01729f
C2106 sar_ctrl_async_phys_0.sg13g2_buf_1$1_42.A sar_ctrl_async_phys_0.dac_code_n[0] 0.09666f
C2107 a_30650_35892# VDD 0.09663f
C2108 sar_ctrl_async_phys_0.cmp_fire a_26184_21025# 0.84644f
C2109 sar_ctrl_async_phys_0.dac_code_n[4] vcm 0.06598f
C2110 sar_ctrl_async_phys_0.sg13g2_o21ai_1$1_1.B1 a_34171_41332# 0.4205f
C2111 sar_ctrl_async_phys_0.sg13g2_a22oi_1$1_3.A2 a_33252_36642# 0.05757f
C2112 sar_ctrl_async_phys_0.dac_code_n[3] sar_ctrl_async_phys_0.sg13g2_buf_1$1_37.A 0.04743f
C2113 sar_ctrl_async_phys_0.sg13g2_nor2_1$1_10.Y a_30037_43495# 0.02191f
C2114 sar_ctrl_async_phys_0.sg13g2_a22oi_1$1_2.Y a_31060_31813# 0.01834f
C2115 sar_ctrl_async_phys_0.sg13g2_a22oi_1$1_0.B1 VDD 1.9443f
C2116 sar_ctrl_async_phys_0.sg13g2_buf_1$1_19.A a_33626_41433# 0.0415f
C2117 a_26160_37522# VDD 0.08637f
C2118 sar_ctrl_async_phys_0.sg13g2_inv_1$1_5.A sar_ctrl_async_phys_0.sg13g2_inv_1$1_11.Y 0.03661f
C2119 sar_ctrl_async_phys_0.dac_code_n[6] oa_sar8_acore18_opt_0.sw_bitcell_opt_term_0.bot 0.08786f
C2120 sar_ctrl_async_phys_0.sg13g2_nand2b_1$1_3.Y a_31640_41342# 0.02086f
C2121 sar_ctrl_async_phys_0.hold_req oa_sar8_acore18_opt_0.sw_bitcell_opt_b6_0.bot 0.13089f
C2122 a_36056_46508# sar_ctrl_async_phys_0.sg13g2_buf_1$1_46.A 0.26281f
C2123 sar_ctrl_async_phys_0.sg13g2_dfrbpq_1$1_0.CLK sar_ctrl_async_phys_0.sg13g2_a22oi_1$1_2.A2 2.16429f
C2124 sar_ctrl_async_phys_0.dac_code_n[3] sar_ctrl_async_phys_0.dac_code[0] 0.22592f
C2125 sar_ctrl_async_phys_0.sg13g2_dfrbpq_1$1_0.CLK a_33844_36992# 0.08735f
C2126 sar_ctrl_async_phys_0.sg13g2_nor2b_1$1_4.Y sar_ctrl_async_phys_0.sg13g2_a22oi_1$1_2.A2 0.06288f
C2127 sar_ctrl_async_phys_0.sg13g2_buf_1$1_6.X a_29786_33873# 0.23918f
C2128 a_31060_44552# a_31579_44356# 0.34114f
C2129 a_33940_41223# VDD 0.02354f
C2130 a_36152_45082# a_36336_45082# 0.0524f
C2131 sar_ctrl_async_phys_0.sg13g2_a22oi_1$1_2.A2 a_31446_35162# 0.04863f
C2132 sar_ctrl_async_phys_0.sg13g2_a22oi_1$1_1.Y result[4] 0.02188f
C2133 sar_ctrl_async_phys_0.sg13g2_inv_1$1_2.Y a_31924_32456# 0.02165f
C2134 a_31071_33727# a_31738_33948# 0.0894f
C2135 a_30229_33629# a_30977_33727# 0.01058f
C2136 sar_ctrl_async_phys_0.sg13g2_dfrbpq_1$1_0.CLK a_31060_31813# 0.01049f
C2137 sar_ctrl_async_phys_0.sg13g2_buf_1$1_4.A a_35770_36972# 0.01851f
C2138 sar_ctrl_async_phys_0.sg13g2_dlygate4sd3_1$1_5.X VDD 0.31855f
C2139 a_32090_40428# a_32116_40464# 0.36952f
C2140 sar_ctrl_async_phys_0.sg13g2_nand2_1$1_1.Y a_28874_37806# 0.01574f
C2141 a_36152_43570# VDD 0.12572f
C2142 sar_ctrl_async_phys_0.sg13g2_a21oi_1$1_0.A2 a_33844_36992# 0.03904f
C2143 a_33818_43452# a_34261_43495# 0.02242f
C2144 sar_ctrl_async_phys_0.dac_code_n[6] m3_38288_n2380# 0.04765f
C2145 sar_ctrl_async_phys_0.dac_code_n[0] oa_sar8_acore18_opt_0.sw_bitcell_opt_term_0.bot 4.37448f
C2146 a_36058_34412# sar_ctrl_async_phys_0.sg13g2_buf_1$1_5.A 0.11729f
C2147 a_33248_45238# a_33658_44996# 0.10373f
C2148 a_29851_32260# a_30848_32358# 0.02979f
C2149 sar_ctrl_async_phys_0.sg13g2_a22oi_1$1_2.A2 a_32116_40464# 0.01055f
C2150 a_29046_32138# a_29620_32151# 0.31978f
C2151 a_35648_33142# result[4] 0.05159f
C2152 sar_ctrl_async_phys_0.sg13g2_a22oi_1$1_0.A2 result[5] 0.01559f
C2153 sar_ctrl_async_phys_0.dac_code_n[6] oa_sar8_acore18_opt_0.bstrap_opt_w2_c1200_1.gb 0.14954f
C2154 sar_ctrl_async_phys_0.sg13g2_buf_1$1_8.A result[2] 0.05142f
C2155 sar_ctrl_async_phys_0.sg13g2_a21oi_1$1_6.B1 sar_ctrl_async_phys_0.dac_code_n[6] 0.14338f
C2156 oa_sar8_acore18_opt_0.sw_bitcell_opt_b2_1.bot a_20412_n9612# 0.04144f
C2157 a_28856_32270# sar_ctrl_async_phys_0.sg13g2_inv_1$1_5.Y 0.03202f
C2158 sar_ctrl_async_phys_0.dac_code_n[1] sar_ctrl_async_phys_0.sample 0.04488f
C2159 a_32984_39830# a_33168_39830# 0.0524f
C2160 a_33530_39921# a_33556_40016# 0.36952f
C2161 sar_ctrl_async_phys_0.sg13g2_a21oi_1$1_0.A1 a_34833_37784# 0.01296f
C2162 sar_ctrl_async_phys_0.sg13g2_buf_1$1_13.A a_32347_37447# 0.02349f
C2163 a_36058_32900# sar_ctrl_async_phys_0.sg13g2_a22oi_1$1_1.B2 0.12131f
C2164 a_34651_30748# a_35648_30846# 0.02979f
C2165 a_33846_30626# a_34420_30639# 0.31978f
C2166 a_30678_46946# a_31252_46933# 0.31978f
C2167 a_30964_46512# a_31381_46519# 0.37583f
C2168 a_33558_36674# a_34363_36796# 0.097f
C2169 a_33844_36992# a_34261_36653# 0.3749f
C2170 sar_ctrl_async_phys_0.dac_code_n[6] oa_sar8_acore18_opt_0.sw_bitcell_opt_b1_1.bot 0.06598f
C2171 sar_ctrl_async_phys_0.sg13g2_buf_1$1_41.X a_31381_46519# 0.03797f
C2172 sar_ctrl_async_phys_0.sg13g2_buf_1$1_2.A sar_ctrl_async_phys_0.sg13g2_nand2_1$1_5.B 0.02716f
C2173 sar_ctrl_async_phys_0.sg13g2_buf_1$1_41.X a_30037_43495# 0.05321f
C2174 sar_ctrl_async_phys_0.sg13g2_a21oi_1$1_6.A2 sar_ctrl_async_phys_0.sg13g2_nand2_1$1_5.B 0.52747f
C2175 a_29620_43488# a_30037_43495# 0.37583f
C2176 a_29334_43922# a_29908_43909# 0.31978f
C2177 sar_ctrl_async_phys_0.sg13g2_buf_1$1_20.A a_36056_37436# 0.26785f
C2178 a_35245_45936# sar_ctrl_async_phys_0.sg13g2_nand2b_1$1_6.A_N 0.18475f
C2179 a_33368_44366# VDD 0.12894f
C2180 sar_ctrl_async_phys_0.sg13g2_nor2_1$1_10.A a_29594_43452# 0.01658f
C2181 sar_ctrl_async_phys_0.sg13g2_nor2_1$1_13.A sar_ctrl_async_phys_0.sg13g2_nor2_1$1_13.B 0.18581f
C2182 sar_ctrl_async_phys_0.dac_code_n[7] oa_sar8_acore18_opt_0.sw_bitcell_opt_term_0.bot 0.07989f
C2183 sar_ctrl_async_phys_0.dac_code_n[0] m3_38288_n2380# 0.04726f
C2184 sar_ctrl_async_phys_0.dac_code_n[4] a_20412_n9612# 1.21641f
C2185 sar_ctrl_async_phys_0.sg13g2_and2_1$1_0.A sar_ctrl_async_phys_0.sg13g2_dlygate4sd3_1$1_9.X 0.11432f
C2186 a_35672_47296# sar_ctrl_async_phys_0.dac_code_n[4] 0.24511f
C2187 sar_ctrl_async_phys_0.sg13g2_a21oi_1$1_2.Y a_30944_35166# 0.0166f
C2188 sar_ctrl_async_phys_0.dac_code_n[3] oa_sar8_acore18_opt_0.sw_bitcell_opt_term_1.bot 0.06773f
C2189 sar_ctrl_async_phys_0.sg13g2_a22oi_1$1_0.A2 sar_ctrl_async_phys_0.sg13g2_buf_1$1_1.A 0.02066f
C2190 sar_ctrl_async_phys_0.sg13g2_a21oi_1$1_6.B1 sar_ctrl_async_phys_0.dac_code_n[0] 0.04003f
C2191 a_34549_30605# result[1] 0.01936f
C2192 sar_ctrl_async_phys_0.dac_code_n[0] oa_sar8_acore18_opt_0.bstrap_opt_w2_c1200_1.gb 0.13844f
C2193 sar_ctrl_async_phys_0.sg13g2_a22oi_1$1_4.A2 a_33626_41433# 0.01946f
C2194 oa_sar8_acore18_opt_0.sw_bitcell_opt_term_0.vin m3_54868_n2380# 0.05057f
C2195 a_31898_32361# VDD 0.09607f
C2196 sar_ctrl_async_phys_0.sg13g2_a22oi_1$1_0.A2 sar_ctrl_async_phys_0.sg13g2_buf_1$1_7.A 0.02489f
C2197 sar_ctrl_async_phys_0.sg13g2_buf_1$1_36.A sar_ctrl_async_phys_0.dac_code[1] 0.01696f
C2198 sar_ctrl_async_phys_0.sg13g2_nor2_1$1_0.Y sar_ctrl_async_phys_0.sg13g2_and2_1$1_0.X 0.02202f
C2199 a_31060_31813# a_31291_31399# 0.12701f
C2200 sar_ctrl_async_phys_0.sg13g2_a22oi_1$1_1.A2 sar_ctrl_async_phys_0.sg13g2_a22oi_1$1_0.B1 0.01366f
C2201 sar_ctrl_async_phys_0.hold_req oa_sar8_acore18_opt_0.sw_bitcell_opt_b2_0.bot 0.10875f
C2202 sar_ctrl_async_phys_0.dac_code_n[7] m3_38288_n2380# 0.03354f
C2203 a_34036_35928# a_34453_35935# 0.37583f
C2204 a_34069_41189# VDD 0.26243f
C2205 sar_ctrl_async_phys_0.dac_code_n[7] oa_sar8_acore18_opt_0.bstrap_opt_w2_c1200_1.gb 0.22148f
C2206 sar_ctrl_async_phys_0.sg13g2_dfrbpq_1$1_0.CLK a_32406_45746# 0.02551f
C2207 a_34520_46508# sar_ctrl_async_phys_0.dac_code_n[1] 0.24558f
C2208 a_26662_41278# sar_ctrl_async_phys_0.sg13g2_dlygate4sd3_1$1_9.A 0.15627f
C2209 sar_ctrl_async_phys_0.cmp_valid sar_ctrl_async_phys_0.dac_code_n[4] 0.01013f
C2210 sar_ctrl_async_phys_0.sg13g2_buf_1$1_6.X a_31823_32876# 0.01311f
C2211 sar_ctrl_async_phys_0.sg13g2_buf_1$1_4.A a_33558_36674# 0.02348f
C2212 sar_ctrl_async_phys_0.sg13g2_nor2_1$1_7.A sar_ctrl_async_phys_0.sg13g2_nor2_1$1_8.B 0.24977f
C2213 sar_ctrl_async_phys_0.sg13g2_a22oi_1$1_2.A2 a_32347_37447# 0.0582f
C2214 sar_ctrl_async_phys_0.sg13g2_a21oi_1$1_5.Y a_31195_39820# 0.02798f
C2215 sar_ctrl_async_phys_0.dac_code_n[1] oa_sar8_acore18_opt_0.sw_tg_opt_0.bot 0.15719f
C2216 sar_ctrl_async_phys_0.sg13g2_a22oi_1$1_3.B1 sar_ctrl_async_phys_0.sg13g2_a22oi_1$1_0.Y 0.01924f
C2217 a_34363_43495# VDD 0.21026f
C2218 sar_ctrl_async_phys_0.dac_code_n[7] oa_sar8_acore18_opt_0.sw_bitcell_opt_b1_1.bot 0.16095f
C2219 sar_ctrl_async_phys_0.sg13g2_a22oi_1$1_0.A1 result[5] 0.06792f
C2220 sar_ctrl_async_phys_0.sg13g2_a22oi_1$1_3.B1 a_31738_33948# 0.04524f
C2221 sar_ctrl_async_phys_0.sg13g2_dfrbpq_1$1_0.CLK a_28392_41214# 0.03469f
C2222 sar_ctrl_async_phys_0.sg13g2_nor2_1$1_10.B a_30390_39698# 0.01298f
C2223 oa_sar8_acore18_opt_0.sw_bitcell_opt_b7_0.bot m3_34580_n2380# 1.93437f
C2224 a_34651_34423# a_35391_34773# 0.26905f
C2225 a_32149_45007# a_32251_45007# 0.47795f
C2226 sar_ctrl_async_phys_0.sg13g2_dlygate4sd3_1$1_1.A a_28488_35965# 0.45808f
C2227 a_27624_35965# a_27894_35924# 0.26306f
C2228 a_29046_32138# a_29749_32117# 0.02454f
C2229 sar_ctrl_async_phys_0.sg13g2_buf_1$1_15.A sar_ctrl_async_phys_0.bit_active[0] 0.02163f
C2230 a_32602_39996# a_32984_39830# 0.01012f
C2231 sar_ctrl_async_phys_0.sg13g2_buf_1$1_13.A a_32245_37447# 0.03598f
C2232 sar_ctrl_async_phys_0.sg13g2_buf_1$1_4.A busy 0.79992f
C2233 a_35648_33142# a_35391_33261# 0.34468f
C2234 sar_ctrl_async_phys_0.sg13g2_nor2b_1$1_0.A a_30676_40016# 0.04116f
C2235 sar_ctrl_async_phys_0.dac_code_n[6] oa_sar8_acore18_opt_0.sw_bitcell_opt_b5_1.bot 0.07638f
C2236 sar_ctrl_async_phys_0.sg13g2_o21ai_1$1_1.B1 sar_ctrl_async_phys_0.sg13g2_nor4_1$1_0.Y 0.0379f
C2237 sar_ctrl_async_phys_0.sg13g2_nand2b_1$1_1.B sar_ctrl_async_phys_0.dac_code_n[7] 0.11697f
C2238 sar_ctrl_async_phys_0.sg13g2_a21oi_1$1_5.Y a_31802_37404# 0.02192f
C2239 result[2] result[3] 0.34171f
C2240 a_33846_30626# a_34549_30605# 0.02454f
C2241 sar_ctrl_async_phys_0.sg13g2_a21oi_1$1_0.A1 a_31828_37440# 0.01464f
C2242 oa_sar8_acore18_opt_0.sw_bitcell_opt_term_0.VSS VDD 1.10249f
C2243 sar_ctrl_async_phys_0.sg13g2_and2_1$1_0.A sar_ctrl_async_phys_0.sg13g2_nor4_1$1_0.Y 0.07566f
C2244 sar_ctrl_async_phys_0.sg13g2_a22oi_1$1_2.A2 a_32580_36642# 0.02477f
C2245 sar_ctrl_async_phys_0.sg13g2_nor2b_1$1_0.A sar_ctrl_async_phys_0.sg13g2_and2_1$1_0.B 0.52584f
C2246 sar_ctrl_async_phys_0.sg13g2_a21oi_1$1_5.Y a_31093_35935# 0.02675f
C2247 a_33951_45823# a_33857_45823# 0.28931f
C2248 sar_ctrl_async_phys_0.sg13g2_o21ai_1$1_1.B1 a_31732_45000# 0.02921f
C2249 sar_ctrl_async_phys_0.sg13g2_buf_1$1_21.A VDD 0.53711f
C2250 a_33252_36642# a_33558_36674# 0.01036f
C2251 sar_ctrl_async_phys_0.sg13g2_o21ai_1$1_1.B1 a_33948_41936# 0.25214f
C2252 sar_ctrl_async_phys_0.sg13g2_dlygate4sd3_1$1_7.A a_25488_40546# 0.02661f
C2253 sar_ctrl_async_phys_0.sg13g2_nand2_1$1_1.B a_29084_38484# 0.01297f
C2254 sar_ctrl_async_phys_0.sg13g2_a22oi_1$1_0.A1 sar_ctrl_async_phys_0.sg13g2_buf_1$1_1.A 0.03692f
C2255 a_31477_44213# VDD 0.24288f
C2256 a_33211_45868# a_33951_45823# 0.26905f
C2257 a_29258_36642# sar_ctrl_async_phys_0.sg13g2_dlygate4sd3_1$1_0.A 0.4338f
C2258 sar_ctrl_async_phys_0.sg13g2_nor2_1$1_0.Y sar_ctrl_async_phys_0.sg13g2_a22oi_1$1_4.A2 0.48052f
C2259 a_31328_33870# VDD 0.16903f
C2260 sar_ctrl_async_phys_0.sg13g2_a22oi_1$1_0.A1 sar_ctrl_async_phys_0.sg13g2_buf_1$1_7.A 1.01239f
C2261 sar_ctrl_async_phys_0.sg13g2_dfrbpq_1$1_0.CLK a_31828_37440# 0.07726f
C2262 a_34765_45266# VDD 0.24393f
C2263 sar_ctrl_async_phys_0.sg13g2_dfrbpq_1$1_0.CLK sar_ctrl_async_phys_0.sg13g2_a22oi_1$1_0.B2 0.65858f
C2264 sar_ctrl_async_phys_0.sg13g2_dfrbpq_1$1_11.D VDD 0.32155f
C2265 oa_sar8_acore18_opt_0.sw_bitcell_opt_term_0.vin a_35028_n9612# 0.04547f
C2266 a_32991_45357# VDD 0.17865f
C2267 sar_ctrl_async_phys_0.sg13g2_nor2b_1$1_0.A a_30650_35892# 0.01875f
C2268 sar_ctrl_async_phys_0.sg13g2_dlygate4sd3_1$1_5.A sar_ctrl_async_phys_0.sg13g2_nor2_1$1_14.A 0.02219f
C2269 oa_sar8_acore18_opt_0.sw_bitcell_opt_b6_0.bot oa_sar8_acore18_opt_0.sw_bitcell_opt_term_0.VSS 2.28853f
C2270 sar_ctrl_async_phys_0.sg13g2_buf_1$1_42.A sar_ctrl_async_phys_0.sg13g2_nor2_1$1_1.Y 0.05613f
C2271 sar_ctrl_async_phys_0.sg13g2_nor2b_1$1_0.A sar_ctrl_async_phys_0.sg13g2_a22oi_1$1_0.B1 0.01335f
C2272 a_35664_37695# sar_ctrl_async_phys_0.sg13g2_buf_1$1_4.A 0.1043f
C2273 a_30772_31392# a_31189_31399# 0.37583f
C2274 a_30486_31826# a_31060_31813# 0.31978f
C2275 sar_ctrl_async_phys_0.hold_req oa_sar8_acore18_opt_0.sw_bitcell_opt_b7_1.VSS 1.96992f
C2276 sar_ctrl_async_phys_0.sg13g2_buf_1$1_15.A sar_ctrl_async_phys_0.bit_active[4] 0.45709f
C2277 sar_ctrl_async_phys_0.sg13g2_nor2_1$1_4.Y sar_ctrl_async_phys_0.sg13g2_and2_1$1_3.X 1.16614f
C2278 sar_ctrl_async_phys_0.sg13g2_dlygate4sd3_1$1_8.X VDD 0.49542f
C2279 sar_ctrl_async_phys_0.sg13g2_buf_1$1_6.X a_33440_32358# 0.10345f
C2280 oa_sar8_acore18_opt_0.sw_bitcell_opt_term_1.bot a_20412_n9612# 0.36795f
C2281 sar_ctrl_async_phys_0.sg13g2_buf_1$1_2.A sar_ctrl_async_phys_0.sg13g2_buf_1$1_19.A 0.20298f
C2282 a_29755_38959# a_30495_39309# 0.26905f
C2283 a_32116_37861# a_32347_37447# 0.12701f
C2284 sar_ctrl_async_phys_0.sg13g2_buf_1$1_26.X a_26728_37416# 0.0162f
C2285 sar_ctrl_async_phys_0.dac_code[4] sar_ctrl_async_phys_0.dac_code[6] 0.07342f
C2286 sar_ctrl_async_phys_0.sg13g2_buf_1$1_2.A sar_ctrl_async_phys_0.sg13g2_and2_1$1_0.X 0.01928f
C2287 sar_ctrl_async_phys_0.dac_code_n[3] sar_ctrl_async_phys_0.sg13g2_nand2b_1$1_5.A_N 0.32535f
C2288 sar_ctrl_async_phys_0.sg13g2_a21oi_1$1_3.B1 sar_ctrl_async_phys_0.sg13g2_nand2_1$1_3.A 0.04924f
C2289 sar_ctrl_async_phys_0.sg13g2_nand2_1$1_3.Y VDD 0.49329f
C2290 sar_ctrl_async_phys_0.dac_code_n[1] sar_ctrl_async_phys_0.dac_code_n[3] 0.14431f
C2291 sar_ctrl_async_phys_0.sg13g2_buf_1$1_0.A a_31638_32138# 0.04844f
C2292 sar_ctrl_async_phys_0.dac_code_n[2] sar_ctrl_async_phys_0.dac_code[1] 0.06321f
C2293 sar_ctrl_async_phys_0.sg13g2_buf_1$1_19.A sar_ctrl_async_phys_0.sg13g2_nor2b_1$1_2.Y 0.22026f
C2294 sar_ctrl_async_phys_0.sg13g2_nor2_1$1_7.A sar_ctrl_async_phys_0.sg13g2_inv_1$1_7.A 1.62894f
C2295 sar_ctrl_async_phys_0.dac_code_n[7] oa_sar8_acore18_opt_0.sw_bitcell_opt_b5_1.bot 0.11261f
C2296 sar_ctrl_async_phys_0.sg13g2_a22oi_1$1_1.B2 a_33089_32215# 0.01356f
C2297 sar_ctrl_async_phys_0.sg13g2_a22oi_1$1_2.A2 a_32245_37447# 0.01865f
C2298 sar_ctrl_async_phys_0.sg13g2_nand2b_1$1_2.A_N sar_ctrl_async_phys_0.dac_code[4] 0.01589f
C2299 sar_ctrl_async_phys_0.dac_code_n[5] oa_sar8_acore18_opt_0.sw_bitcell_opt_b5_0.bot 0.50895f
C2300 oa_sar8_acore18_opt_0.sw_bitcell_opt_b5_0.bot oa_sar8_acore18_opt_0.sw_bitcell_opt_term_0.gb 0.78567f
C2301 a_29524_40464# a_30783_40821# 0.01529f
C2302 sar_ctrl_async_phys_0.sg13g2_a21oi_1$1_2.B1 a_29524_40464# 0.04206f
C2303 a_31446_45434# a_32149_45007# 0.02432f
C2304 sar_ctrl_async_phys_0.sg13g2_buf_1$1_29.X a_26364_45710# 0.2475f
C2305 sar_ctrl_async_phys_0.dac_code[3] sar_ctrl_async_phys_0.dac_code[4] 8.04574f
C2306 sar_ctrl_async_phys_0.sg13g2_buf_1$1_3.A a_36056_38948# 0.03233f
C2307 sar_ctrl_async_phys_0.sg13g2_nor2_1$1_8.A a_29701_36874# 0.20328f
C2308 sar_ctrl_async_phys_0.sg13g2_buf_1$1_42.A sar_ctrl_async_phys_0.sg13g2_nand2_1$1_3.A 0.30844f
C2309 sar_ctrl_async_phys_0.sg13g2_a22oi_1$1_3.A2 a_35595_40460# 0.16191f
C2310 sar_ctrl_async_phys_0.dac_code_n[6] oa_sar8_acore18_opt_0.sw_bitcell_opt_term_0.vin 0.07198f
C2311 sar_ctrl_async_phys_0.sg13g2_nor2b_1$1_0.Y VDD 0.45952f
C2312 a_32192_39918# a_32602_39996# 0.10373f
C2313 a_26168_38318# VDD 0.13506f
C2314 sar_ctrl_async_phys_0.dac_code_n[1] vcm 0.06635f
C2315 a_34132_32904# a_35297_33261# 0.43239f
C2316 a_34136_33688# result[5] 0.24516f
C2317 sar_ctrl_async_phys_0.sg13g2_buf_1$1_15.A sar_ctrl_async_phys_0.bit_active[1] 0.03108f
C2318 a_26558_40727# sar_ctrl_async_phys_0.sg13g2_dlygate4sd3_1$1_9.X 0.15609f
C2319 sar_ctrl_async_phys_0.sg13g2_and2_1$1_3.A sar_ctrl_async_phys_0.cmp_n 0.04869f
C2320 sar_ctrl_async_phys_0.sg13g2_buf_1$1_21.A sar_ctrl_async_phys_0.bit_active[7] 0.0354f
C2321 sar_ctrl_async_phys_0.sg13g2_o21ai_1$1_1.B1 a_29498_40428# 0.27141f
C2322 a_32406_45746# a_32980_45759# 0.31978f
C2323 sar_ctrl_async_phys_0.sg13g2_a21oi_1$1_2.B1 sar_ctrl_async_phys_0.sg13g2_buf_1$1_3.A 0.11465f
C2324 sar_ctrl_async_phys_0.sg13g2_dfrbpq_1$1_0.CLK sar_ctrl_async_phys_0.sg13g2_nand2_1$1_5.B 0.03517f
C2325 sar_ctrl_async_phys_0.sg13g2_o21ai_1$1_1.B1 sar_ctrl_async_phys_0.sg13g2_nor2_1$1_13.A 0.22854f
C2326 a_32406_45746# a_32692_46064# 0.41329f
C2327 sar_ctrl_async_phys_0.hold_req sar_ctrl_async_phys_0.dac_code_n[4] 0.05309f
C2328 a_25596_41174# VDD 0.29289f
C2329 sar_ctrl_async_phys_0.sg13g2_buf_1$1_2.A sar_ctrl_async_phys_0.sg13g2_nand2b_1$1_1.Y 0.02832f
C2330 oa_sar8_acore18_opt_0.sw_bitcell_opt_b2_0.bot oa_sar8_acore18_opt_0.sw_bitcell_opt_term_0.VSS 1.61769f
C2331 w_16692_n9960# sar_ctrl_async_phys_0.dac_code_n[2] 0.02245f
C2332 sar_ctrl_async_phys_0.sg13g2_nor2_1$1_4.Y a_33944_47390# 0.0334f
C2333 sar_ctrl_async_phys_0.sg13g2_dfrbpq_1$1_0.CLK a_32341_32117# 0.25394f
C2334 a_28782_40460# VDD 0.01793f
C2335 a_34549_34423# VDD 0.25102f
C2336 sar_ctrl_async_phys_0.dac_code_n[0] oa_sar8_acore18_opt_0.sw_bitcell_opt_term_0.vin 0.39545f
C2337 a_31706_44964# VDD 0.09412f
C2338 a_33914_44457# a_33940_44552# 0.36952f
C2339 sar_ctrl_async_phys_0.sg13g2_a21oi_1$1_1.B1 sar_ctrl_async_phys_0.sg13g2_nand2b_1$1_6.A_N 0.02862f
C2340 sar_ctrl_async_phys_0.sg13g2_nor2_1$1_4.Y a_26454_39702# 0.04228f
C2341 sar_ctrl_async_phys_0.sg13g2_a21oi_1$1_1.B1 a_34618_46044# 0.01356f
C2342 a_28760_42058# VDD 0.1655f
C2343 sar_ctrl_async_phys_0.sg13g2_buf_1$1_17.A a_30507_35204# 0.15868f
C2344 sar_ctrl_async_phys_0.sg13g2_buf_1$1_6.X result[2] 0.10076f
C2345 sar_ctrl_async_phys_0.sg13g2_buf_1$1_2.A sar_ctrl_async_phys_0.sg13g2_a22oi_1$1_4.A2 0.02029f
C2346 a_33080_30664# VDD 0.22174f
C2347 sar_ctrl_async_phys_0.dac_code_n[5] sar_ctrl_async_phys_0.dac_code[7] 0.13099f
C2348 sar_ctrl_async_phys_0.sg13g2_buf_1$1_32.A a_33654_44234# 0.03453f
C2349 sar_ctrl_async_phys_0.dac_code[7] oa_sar8_acore18_opt_0.sw_bitcell_opt_term_0.gb 0.41252f
C2350 sar_ctrl_async_phys_0.sg13g2_buf_1$1_6.X a_31638_32138# 0.12111f
C2351 sar_ctrl_async_phys_0.sg13g2_a22oi_1$1_0.Y sar_ctrl_async_phys_0.sg13g2_buf_1$1_0.A 0.01657f
C2352 a_28862_36863# VDD 0.18807f
C2353 a_32245_37447# a_32116_37861# 0.01562f
C2354 a_31828_37440# a_32347_37447# 0.34102f
C2355 sar_ctrl_async_phys_0.sg13g2_buf_1$1_19.A a_33844_39711# 0.01729f
C2356 sar_ctrl_async_phys_0.sg13g2_nor4_1$1_0.C a_30783_40821# 0.01684f
C2357 oa_sar8_acore18_opt_0.sw_tg_opt_1.bot oa_sar8_acore18_opt_0.bstrap_opt_w2_c1200_1.gb 0.22022f
C2358 a_36056_38948# sar_ctrl_async_phys_0.dac_code[7] 0.01757f
C2359 sar_ctrl_async_phys_0.sg13g2_nor4_1$1_0.C sar_ctrl_async_phys_0.sg13g2_a21oi_1$1_2.B1 0.64642f
C2360 a_28392_41214# sar_ctrl_async_phys_0.sg13g2_nand2b_1$1_0.A_N 0.3992f
C2361 a_31935_36285# a_32602_35924# 0.0894f
C2362 sar_ctrl_async_phys_0.dac_code_n[7] vinp 0.10141f
C2363 sar_ctrl_async_phys_0.sg13g2_a22oi_1$1_0.B1 sar_ctrl_async_phys_0.sg13g2_a22oi_1$1_1.Y 0.11847f
C2364 sar_ctrl_async_phys_0.sg13g2_nor4_1$1_0.C sar_ctrl_async_phys_0.sg13g2_nand2b_1$1_0.Y 0.41519f
C2365 a_29653_38959# VDD 0.24331f
C2366 sar_ctrl_async_phys_0.sg13g2_and2_1$1_0.X a_35288_38224# 0.01368f
C2367 sar_ctrl_async_phys_0.dac_code_n[7] oa_sar8_acore18_opt_0.sw_bitcell_opt_term_0.vin 0.049f
C2368 sar_ctrl_async_phys_0.dac_code_n[5] oa_sar8_acore18_opt_0.sw_bitcell_opt_b1_0.bot 0.22653f
C2369 oa_sar8_acore18_opt_0.sw_tg_opt_1.bot oa_sar8_acore18_opt_0.sw_bitcell_opt_b1_1.bot 1.04735f
C2370 sar_ctrl_async_phys_0.sg13g2_buf_1$1_20.A a_34363_43495# 0.0114f
C2371 oa_sar8_acore18_opt_0.sw_bitcell_opt_b1_0.bot oa_sar8_acore18_opt_0.sw_bitcell_opt_term_0.gb 0.61173f
C2372 sar_ctrl_async_phys_0.dac_code_n[1] a_20412_n9612# 1.18204f
C2373 sar_ctrl_async_phys_0.sg13g2_a21oi_1$1_6.B1 sar_ctrl_async_phys_0.sg13g2_nand2_1$1_3.A 0.66276f
C2374 sar_ctrl_async_phys_0.hold_req sar_ctrl_async_phys_0.dac_code[0] 0.12424f
C2375 sar_ctrl_async_phys_0.sg13g2_buf_1$1_19.A a_34042_40460# 0.02128f
C2376 sar_ctrl_async_phys_0.hold_req oa_sar8_acore18_opt_0.sw_bitcell_opt_b6_1.bot 0.29336f
C2377 a_25596_43448# VDD 0.2875f
C2378 a_34357_44213# a_34261_43495# 0.02581f
C2379 sar_ctrl_async_phys_0.sg13g2_a22oi_1$1_2.Y a_31258_32436# 0.04643f
C2380 a_35952_39901# sar_ctrl_async_phys_0.dac_code[5] 0.0158f
C2381 a_33846_33338# a_34420_33325# 0.31978f
C2382 sar_ctrl_async_phys_0.sg13g2_nor2_1$1_10.B a_31071_33727# 0.01523f
C2383 sar_ctrl_async_phys_0.sg13g2_buf_1$1_42.A a_33558_43922# 0.02169f
C2384 sar_ctrl_async_phys_0.sg13g2_buf_1$1_20.A sar_ctrl_async_phys_0.sg13g2_buf_1$1_21.A 0.02095f
C2385 oa_sar8_acore18_opt_0.sw_bitcell_opt_term_0.gb m3_51760_n2380# 1.48499f
C2386 sar_ctrl_async_phys_0.sg13g2_buf_1$1_15.A a_35962_35924# 0.02332f
C2387 oa_sar8_acore18_opt_0.sw_bitcell_opt_b6_0.bot VDD 4.11698f
C2388 w_39600_n9960# VDD 1.20689f
C2389 sar_ctrl_async_phys_0.sg13g2_nand2_1$1_3.B a_34363_43495# 0.02643f
C2390 sar_ctrl_async_phys_0.sg13g2_a21oi_1$1_2.Y a_30027_39996# 0.16255f
C2391 sar_ctrl_async_phys_0.sg13g2_nand2_1$1_5.Y a_34817_41287# 0.01609f
C2392 sar_ctrl_async_phys_0.sg13g2_a22oi_1$1_0.A1 sar_ctrl_async_phys_0.sg13g2_inv_1$1_2.Y 0.15698f
C2393 sar_ctrl_async_phys_0.sg13g2_a21oi_1$1_3.B1 a_35245_42242# 0.29552f
C2394 sar_ctrl_async_phys_0.sg13g2_nand2b_1$1_5.A_N a_35000_45878# 0.01848f
C2395 sar_ctrl_async_phys_0.dac_code[2] oa_sar8_acore18_opt_0.sw_bitcell_opt_b5_0.bot 0.78403f
C2396 a_36058_32900# result[5] 0.01255f
C2397 sar_ctrl_async_phys_0.sg13g2_nand2_1$1_3.A sar_ctrl_async_phys_0.sg13g2_nand2b_1$1_1.B 0.55048f
C2398 sar_ctrl_async_phys_0.sg13g2_dfrbpq_1$1_0.CLK a_31258_32436# 0.02413f
C2399 sar_ctrl_async_phys_0.sg13g2_a21oi_1$1_0.A1 sar_ctrl_async_phys_0.sg13g2_buf_1$1_19.A 1.02824f
C2400 sar_ctrl_async_phys_0.sg13g2_o21ai_1$1_1.B1 sar_ctrl_async_phys_0.sg13g2_nor2_1$1_10.B 0.67002f
C2401 sar_ctrl_async_phys_0.sg13g2_nand2b_1$1_1.B a_35103_43845# 0.02688f
C2402 sar_ctrl_async_phys_0.sg13g2_buf_1$1_2.A sar_ctrl_async_phys_0.sg13g2_inv_1$1_0.A 0.0162f
C2403 sar_ctrl_async_phys_0.cmp_valid sar_ctrl_async_phys_0.dac_code_n[1] 0.01231f
C2404 sar_ctrl_async_phys_0.sg13g2_a21oi_1$1_0.A1 sar_ctrl_async_phys_0.bit_active[6] 0.02345f
C2405 sar_ctrl_async_phys_0.sg13g2_buf_1$1_6.X sar_ctrl_async_phys_0.sg13g2_a22oi_1$1_0.Y 0.03218f
C2406 sar_ctrl_async_phys_0.sg13g2_and2_1$1_0.A sar_ctrl_async_phys_0.sg13g2_nor2_1$1_10.B 0.23074f
C2407 sar_ctrl_async_phys_0.sg13g2_a21oi_1$1_5.Y a_31716_38912# 0.01302f
C2408 sar_ctrl_async_phys_0.sg13g2_a21oi_1$1_0.A1 sar_ctrl_async_phys_0.sg13g2_and2_1$1_0.X 0.20028f
C2409 sar_ctrl_async_phys_0.sg13g2_buf_1$1_6.X a_31738_33948# 0.04257f
C2410 a_26954_40424# VDD 0.34508f
C2411 sar_ctrl_async_phys_0.sg13g2_nor2_1$1_10.B a_30401_39309# 0.01488f
C2412 sar_ctrl_async_phys_0.dac_code[0] a_36152_43570# 0.01665f
C2413 sar_ctrl_async_phys_0.dac_code[1] oa_sar8_acore18_opt_0.sw_tg_opt_0.bot 0.90081f
C2414 sar_ctrl_async_phys_0.sg13g2_a21oi_1$1_6.B1 a_32897_45357# 0.01081f
C2415 sar_ctrl_async_phys_0.sg13g2_a21oi_1$1_5.A2 sar_ctrl_async_phys_0.sg13g2_buf_1$1_3.A 0.21411f
C2416 sar_ctrl_async_phys_0.sg13g2_buf_1$1_6.X a_30591_32215# 0.13984f
C2417 sar_ctrl_async_phys_0.sg13g2_o21ai_1$1_1.B1 a_35072_39918# 0.10165f
C2418 sar_ctrl_async_phys_0.sg13g2_a21oi_1$1_0.B1 sar_ctrl_async_phys_0.sg13g2_a21oi_1$1_2.B1 0.05321f
C2419 sar_ctrl_async_phys_0.sg13g2_nand2b_1$1_3.Y a_34363_43495# 0.01184f
C2420 a_31828_37440# a_32245_37447# 0.37583f
C2421 sar_ctrl_async_phys_0.sg13g2_dfrbpq_1$1_0.CLK sar_ctrl_async_phys_0.sg13g2_buf_1$1_19.A 0.08552f
C2422 sar_ctrl_async_phys_0.sg13g2_buf_1$1_6.X a_35391_30703# 0.13785f
C2423 sar_ctrl_async_phys_0.sg13g2_nor2b_1$1_3.Y VDD 0.4318f
C2424 a_35245_45266# a_35327_45366# 0.01117f
C2425 sar_ctrl_async_phys_0.sg13g2_and2_1$1_0.A sar_ctrl_async_phys_0.sg13g2_a21oi_1$1_4.A2 0.17841f
C2426 sar_ctrl_async_phys_0.sg13g2_a22oi_1$1_4.A2 a_32991_35239# 0.0257f
C2427 a_31093_35935# a_31195_35935# 0.47795f
C2428 sar_ctrl_async_phys_0.sg13g2_dfrbpq_1$1_0.CLK sar_ctrl_async_phys_0.sg13g2_and2_1$1_0.X 0.10688f
C2429 sar_ctrl_async_phys_0.sg13g2_dfrbpq_1$1_0.CLK result[1] 0.0266f
C2430 sar_ctrl_async_phys_0.sg13g2_a22oi_1$1_2.A2 a_32319_44311# 0.01849f
C2431 sar_ctrl_async_phys_0.sg13g2_nor2_1$1_6.B sar_ctrl_async_phys_0.sg13g2_nor2_1$1_8.B 0.15635f
C2432 sar_ctrl_async_phys_0.sg13g2_nor2_1$1_3.Y a_27354_37436# 0.01369f
C2433 a_27032_39034# VDD 0.13717f
C2434 oa_sar8_acore18_opt_0.sw_tg_opt_1.bot oa_sar8_acore18_opt_0.sw_bitcell_opt_b5_1.bot 15.0257f
C2435 sar_ctrl_async_phys_0.sg13g2_a22oi_1$1_0.Y sar_ctrl_async_phys_0.sg13g2_a22oi_1$1_1.B2 0.02198f
C2436 a_25496_39034# VDD 0.11649f
C2437 sar_ctrl_async_phys_0.sg13g2_buf_1$1_3.A sar_ctrl_async_phys_0.bit_active[3] 0.26273f
C2438 a_34236_46472# VDD 0.24667f
C2439 sar_ctrl_async_phys_0.sg13g2_buf_1$1_14.A VDD 0.82494f
C2440 a_32223_46869# VDD 0.18398f
C2441 a_33085_43832# a_32888_43570# 0.01798f
C2442 sar_ctrl_async_phys_0.bit_active[7] VDD 0.21249f
C2443 a_26184_21025# VDD 0.75713f
C2444 sar_ctrl_async_phys_0.sg13g2_buf_1$1_41.X a_34363_43495# 0.42137f
C2445 sar_ctrl_async_phys_0.sg13g2_nand2b_1$1_1.B a_35725_45266# 0.27107f
C2446 sar_ctrl_async_phys_0.sg13g2_a22oi_1$1_1.A2 VDD 0.63934f
C2447 a_29238_40898# a_29498_40428# 0.75507f
C2448 sar_ctrl_async_phys_0.sg13g2_a22oi_1$1_0.B1 a_30671_32876# 0.05825f
C2449 sar_ctrl_async_phys_0.sg13g2_nand2_1$1_3.B sar_ctrl_async_phys_0.sg13g2_nand2_1$1_3.Y 0.24056f
C2450 sar_ctrl_async_phys_0.sg13g2_inv_1$1_3.Y a_31924_32456# 0.02893f
C2451 sar_ctrl_async_phys_0.sg13g2_nor4_1$1_0.C sar_ctrl_async_phys_0.sg13g2_a21oi_1$1_5.A2 0.0128f
C2452 sar_ctrl_async_phys_0.dac_code[2] sar_ctrl_async_phys_0.dac_code[7] 0.18941f
C2453 a_34424_35200# VDD 0.30775f
C2454 sar_ctrl_async_phys_0.sg13g2_nor2b_1$1_0.A sar_ctrl_async_phys_0.sg13g2_nor2b_1$1_0.Y 0.20441f
C2455 a_35456_44454# VDD 0.17023f
C2456 a_30390_39698# a_30676_40016# 0.41329f
C2457 sar_ctrl_async_phys_0.sg13g2_buf_1$1_2.A sar_ctrl_async_phys_0.sg13g2_a22oi_1$1_2.B2 0.07068f
C2458 sar_ctrl_async_phys_0.sg13g2_nand2b_1$1_3.Y a_34765_45266# 0.02419f
C2459 oa_sar8_acore18_opt_0.sw_bitcell_opt_term_0.trkb oa_sar8_acore18_opt_0.sw_bitcell_opt_b4_0.bot 1.42453f
C2460 sar_ctrl_async_phys_0.sg13g2_a22oi_1$1_2.A2 sar_ctrl_async_phys_0.sg13g2_a22oi_1$1_4.Y 0.02614f
C2461 a_33846_33338# a_34132_32904# 0.41329f
C2462 sar_ctrl_async_phys_0.sg13g2_nand2b_1$1_3.Y sar_ctrl_async_phys_0.sg13g2_dfrbpq_1$1_11.D 0.01542f
C2463 oa_sar8_acore18_opt_0.sw_bitcell_opt_b2_0.bot VDD 2.76646f
C2464 sar_ctrl_async_phys_0.sg13g2_a21oi_1$1_0.A1 a_29812_40885# 0.01098f
C2465 a_34767_31359# a_35463_31435# 0.02454f
C2466 a_34896_40546# VDD 0.07677f
C2467 sar_ctrl_async_phys_0.dac_code_n[4] oa_sar8_acore18_opt_0.sw_bitcell_opt_term_0.VSS 0.01969f
C2468 sar_ctrl_async_phys_0.sg13g2_a21oi_1$1_4.B1 sar_ctrl_async_phys_0.dac_code_n[5] 0.34686f
C2469 sar_ctrl_async_phys_0.sg13g2_a22oi_1$1_0.A1 a_34319_32120# 0.01722f
C2470 sar_ctrl_async_phys_0.sg13g2_and2_1$1_0.A a_25878_40460# 0.0651f
C2471 sar_ctrl_async_phys_0.sg13g2_nor2_1$1_10.B sar_ctrl_async_phys_0.sg13g2_a22oi_1$1_3.B1 0.01307f
C2472 a_35866_44532# a_36248_44366# 0.01012f
C2473 a_26544_38389# sar_ctrl_async_phys_0.sg13g2_and2_1$1_3.A 0.10846f
C2474 sar_ctrl_async_phys_0.sg13g2_buf_1$1_17.A sar_ctrl_async_phys_0.bit_active[0] 0.02418f
C2475 sar_ctrl_async_phys_0.dac_code[2] oa_sar8_acore18_opt_0.sw_bitcell_opt_b1_0.bot 0.15621f
C2476 sar_ctrl_async_phys_0.sg13g2_buf_1$1_41.X a_31477_44213# 0.0562f
C2477 sar_ctrl_async_phys_0.sg13g2_dfrbpq_1$1_0.CLK a_30229_33629# 0.25052f
C2478 sar_ctrl_async_phys_0.sg13g2_a21oi_1$1_0.A1 sar_ctrl_async_phys_0.sg13g2_a22oi_1$1_4.A2 0.19426f
C2479 sar_ctrl_async_phys_0.dac_code_n[5] oa_sar8_acore18_opt_0.sw_bitcell_opt_b3_1.bot 0.06598f
C2480 sar_ctrl_async_phys_0.sg13g2_buf_1$1_36.A a_35672_42760# 0.01825f
C2481 sar_ctrl_async_phys_0.dac_code_n[3] sar_ctrl_async_phys_0.dac_code[1] 0.07695f
C2482 sar_ctrl_async_phys_0.sg13g2_nand2b_1$1_3.Y sar_ctrl_async_phys_0.sg13g2_nand2_1$1_3.Y 0.05324f
C2483 sar_ctrl_async_phys_0.sg13g2_dfrbpq_1$1_0.CLK a_34651_34423# 0.0314f
C2484 oa_sar8_acore18_opt_0.sw_bitcell_opt_b6_0.bot oa_sar8_acore18_opt_0.sw_bitcell_opt_b2_0.bot 0.51681f
C2485 oa_sar8_acore18_opt_0.sw_bitcell_opt_b5_0.bot oa_sar8_acore18_opt_0.sw_bitcell_opt_b3_0.bot 0.83214f
C2486 w_39600_n9960# oa_sar8_acore18_opt_0.sw_bitcell_opt_b2_0.bot 0.01162f
C2487 sar_ctrl_async_phys_0.sg13g2_buf_1$1_41.X a_32991_45357# 0.14149f
C2488 sar_ctrl_async_phys_0.sg13g2_dfrbpq_1$1_0.CLK sar_ctrl_async_phys_0.sg13g2_nand2b_1$1_1.Y 0.12866f
C2489 sar_ctrl_async_phys_0.sg13g2_buf_1$1_26.X track 0.02666f
C2490 sar_ctrl_async_phys_0.sg13g2_a21oi_1$1_0.A1 a_29755_38959# 0.02209f
C2491 sar_ctrl_async_phys_0.sg13g2_buf_1$1_6.X a_29526_33650# 0.0872f
C2492 sar_ctrl_async_phys_0.sg13g2_buf_1$1_4.A sar_ctrl_async_phys_0.sg13g2_buf_1$1_5.A 0.13529f
C2493 sar_ctrl_async_phys_0.sg13g2_a21oi_1$1_3.B1 sar_ctrl_async_phys_0.sg13g2_buf_1$1_3.A 0.04208f
C2494 sar_ctrl_async_phys_0.sg13g2_buf_1$1_2.A sar_ctrl_async_phys_0.sg13g2_a22oi_1$1_3.A2 0.08778f
C2495 sar_ctrl_async_phys_0.sg13g2_a21oi_1$1_6.B1 a_32149_45007# 0.02432f
C2496 sar_ctrl_async_phys_0.dac_code[2] m3_51760_n2380# 0.04372f
C2497 sar_ctrl_async_phys_0.sg13g2_dfrbpq_1$1_0.CLK sar_ctrl_async_phys_0.sg13g2_a22oi_1$1_4.A2 0.25908f
C2498 a_34904_46508# sar_ctrl_async_phys_0.sg13g2_a21oi_1$1_3.B1 0.25496f
C2499 oa_sar8_acore18_opt_0.sw_tg_opt_1.bot vinp 0.12658f
C2500 a_26570_42690# VDD 0.35f
C2501 sar_ctrl_async_phys_0.sg13g2_nor2_1$1_6.B sar_ctrl_async_phys_0.sg13g2_inv_1$1_7.A 0.01318f
C2502 a_26270_39215# a_26385_39214# 0.55452f
C2503 a_30390_36362# a_30676_35928# 0.41329f
C2504 sar_ctrl_async_phys_0.sg13g2_dfrbpq_1$1_0.CLK a_29755_38959# 0.04236f
C2505 sar_ctrl_async_phys_0.sg13g2_buf_1$1_3.A a_35672_38224# 0.10357f
C2506 sar_ctrl_async_phys_0.sg13g2_a21oi_1$1_2.B1 a_31830_40898# 0.04105f
C2507 a_32480_46750# a_32890_46508# 0.10373f
C2508 sar_ctrl_async_phys_0.sg13g2_a21oi_1$1_4.B1 a_34093_42912# 0.31618f
C2509 sar_ctrl_async_phys_0.sg13g2_a22oi_1$1_0.Y a_34651_32911# 0.03499f
C2510 sar_ctrl_async_phys_0.dac_code[0] oa_sar8_acore18_opt_0.sw_bitcell_opt_term_0.VSS 0.99386f
C2511 sar_ctrl_async_phys_0.sg13g2_nand2b_1$1_4.A_N sar_ctrl_async_phys_0.dac_code_n[7] 0.01176f
C2512 a_34815_39775# VDD 0.17696f
C2513 sar_ctrl_async_phys_0.sg13g2_buf_1$1_20.A VDD 0.55005f
C2514 sar_ctrl_async_phys_0.dac_code_n[6] sar_ctrl_async_phys_0.dac_code[5] 0.06345f
C2515 a_29306_32361# a_29749_32117# 0.02242f
C2516 sar_ctrl_async_phys_0.sg13g2_inv_1$1_5.Y a_29046_32138# 0.27899f
C2517 a_28008_23477# a_30632_22281# 0.69494f
C2518 sar_ctrl_async_phys_0.sg13g2_buf_1$1_14.A sar_ctrl_async_phys_0.sg13g2_a22oi_1$1_1.A2 0.77834f
C2519 sar_ctrl_async_phys_0.sg13g2_nor2b_1$1_0.A VDD 2.19806f
C2520 oa_sar8_acore18_opt_0.sw_bitcell_opt_term_0.trkb m3_57896_n2380# 0.03859f
C2521 sar_ctrl_async_phys_0.sg13g2_inv_1$1_2.Y a_33464_31388# 0.01307f
C2522 a_31546_43484# VDD 0.38081f
C2523 m3_45264_n2380# VDD 0.02402f
C2524 sar_ctrl_async_phys_0.sg13g2_nor2_1$1_7.A sar_ctrl_async_phys_0.sg13g2_dlygate4sd3_1$1_0.A 0.0408f
C2525 sar_ctrl_async_phys_0.sg13g2_buf_1$1_3.A a_35672_33688# 0.26375f
C2526 sar_ctrl_async_phys_0.sg13g2_nor2_1$1_4.Y a_26174_42911# 0.01469f
C2527 sar_ctrl_async_phys_0.sg13g2_nor4_1$1_0.C sar_ctrl_async_phys_0.sg13g2_a21oi_1$1_3.B1 0.12622f
C2528 sar_ctrl_async_phys_0.sg13g2_nand2b_1$1_1.B a_35245_42242# 0.38854f
C2529 w_16692_n9960# sar_ctrl_async_phys_0.dac_code_n[3] 0.02423f
C2530 sar_ctrl_async_phys_0.sg13g2_buf_1$1_42.A a_34904_46508# 0.02271f
C2531 sar_ctrl_async_phys_0.hold_req sar_ctrl_async_phys_0.dac_code_n[1] 0.04482f
C2532 a_32251_35284# VDD 0.20928f
C2533 sar_ctrl_async_phys_0.sg13g2_buf_1$1_2.A a_34520_33688# 0.24957f
C2534 oa_sar8_acore18_opt_0.sw_bitcell_opt_term_0.trkb oa_sar8_acore18_opt_0.sw_bitcell_opt_b0_0.bot 1.35188f
C2535 oa_sar8_acore18_opt_0.sw_bitcell_opt_b7_1.VSS VDD 1.10471f
C2536 sar_ctrl_async_phys_0.sg13g2_a21oi_1$1_5.A2 a_32635_40471# 0.04871f
C2537 sar_ctrl_async_phys_0.dac_code[7] oa_sar8_acore18_opt_0.sw_bitcell_opt_b3_0.bot 0.30504f
C2538 sar_ctrl_async_phys_0.sg13g2_dlygate4sd3_1$1_9.A track 0.05323f
C2539 sar_ctrl_async_phys_0.sg13g2_buf_1$1_37.A sar_ctrl_async_phys_0.sg13g2_nand2_1$1_3.Y 0.13168f
C2540 a_35295_36285# VDD 0.175f
C2541 a_34636_31749# a_35463_31435# 0.41329f
C2542 sar_ctrl_async_phys_0.sg13g2_a21oi_1$1_0.A1 a_29941_40471# 0.01441f
C2543 a_35391_34773# busy 0.01881f
C2544 sar_ctrl_async_phys_0.sg13g2_nor2_1$1_10.Y VDD 0.35098f
C2545 sar_ctrl_async_phys_0.sg13g2_nand2_1$1_3.B VDD 0.67637f
C2546 sar_ctrl_async_phys_0.dac_code_n[0] sar_ctrl_async_phys_0.dac_code[5] 0.06405f
C2547 sar_ctrl_async_phys_0.dac_code_n[2] sar_ctrl_async_phys_0.dac_code[6] 0.2392f
C2548 sar_ctrl_async_phys_0.sg13g2_buf_1$1_8.A a_33080_31388# 0.01119f
C2549 a_34357_44213# a_35105_44311# 0.01058f
C2550 a_35199_44311# a_35866_44532# 0.0894f
C2551 sar_ctrl_async_phys_0.sg13g2_a21oi_1$1_2.Y a_30830_35166# 0.49639f
C2552 sar_ctrl_async_phys_0.sg13g2_dlygate4sd3_1$1_11.X sar_ctrl_async_phys_0.sg13g2_dlygate4sd3_1$1_6.X 0.3148f
C2553 sar_ctrl_async_phys_0.sg13g2_buf_1$1_26.X sar_ctrl_async_phys_0.cmp_p 0.01044f
C2554 sar_ctrl_async_phys_0.sg13g2_nor4_1$1_0.C sar_ctrl_async_phys_0.sg13g2_buf_1$1_42.A 0.08914f
C2555 sar_ctrl_async_phys_0.sg13g2_dfrbpq_1$1_11.D a_32192_39918# 0.01327f
C2556 sar_ctrl_async_phys_0.sg13g2_inv_1$1_11.Y a_30384_31474# 0.03037f
C2557 a_36056_33688# sar_ctrl_async_phys_0.bit_active[1] 0.25232f
C2558 oa_sar8_acore18_opt_0.sw_bitcell_opt_b5_0.bot oa_sar8_acore18_opt_0.sw_bitcell_opt_term_0.bot 0.43021f
C2559 oa_sar8_acore18_opt_0.sw_bitcell_opt_b3_0.bot oa_sar8_acore18_opt_0.sw_bitcell_opt_b1_0.bot 0.42289f
C2560 oa_sar8_acore18_opt_0.sw_bitcell_opt_b4_0.bot oa_sar8_acore18_opt_0.sw_bitcell_opt_b0_0.bot 1.25188f
C2561 sar_ctrl_async_phys_0.sg13g2_dfrbpq_1$1_0.CLK a_29941_40471# 0.27812f
C2562 sar_ctrl_async_phys_0.sg13g2_nand2_1$1_1.B sar_ctrl_async_phys_0.sg13g2_nor2_1$1_8.B 0.19665f
C2563 sar_ctrl_async_phys_0.dac_code_n[5] sar_ctrl_async_phys_0.dac_code[4] 0.06252f
C2564 sar_ctrl_async_phys_0.sg13g2_nor2b_1$1_1.B_N VDD 0.77993f
C2565 sar_ctrl_async_phys_0.sg13g2_and2_1$1_6.X a_32400_41413# 0.10413f
C2566 sar_ctrl_async_phys_0.sg13g2_buf_1$1_41.X a_31706_44964# 0.2726f
C2567 sar_ctrl_async_phys_0.dac_code[4] oa_sar8_acore18_opt_0.sw_bitcell_opt_term_0.gb 0.2044f
C2568 sar_ctrl_async_phys_0.sg13g2_a21oi_1$1_5.A2 a_31947_41508# 0.08185f
C2569 a_34904_33688# result[7] 0.25229f
C2570 sar_ctrl_async_phys_0.sg13g2_dfrbpq_1$1_0.CLK sar_ctrl_async_phys_0.sg13g2_inv_1$1_0.A 1.38181f
C2571 a_32698_31388# VDD 0.38247f
C2572 sar_ctrl_async_phys_0.sg13g2_dlygate4sd3_1$1_5.A a_26174_42911# 0.01407f
C2573 sar_ctrl_async_phys_0.dac_code_n[7] sar_ctrl_async_phys_0.dac_code[5] 5.26948f
C2574 sar_ctrl_async_phys_0.dac_code_n[2] sar_ctrl_async_phys_0.dac_code[3] 0.06321f
C2575 sar_ctrl_async_phys_0.sg13g2_nand2b_1$1_3.Y VDD 0.86954f
C2576 sar_ctrl_async_phys_0.sg13g2_a21oi_1$1_5.Y sar_ctrl_async_phys_0.sg13g2_a22oi_1$1_0.A1 0.19678f
C2577 a_32341_32117# a_32443_32260# 0.47622f
C2578 sar_ctrl_async_phys_0.sg13g2_nor2b_1$1_0.A sar_ctrl_async_phys_0.sg13g2_nor2b_1$1_3.Y 0.16955f
C2579 oa_sar8_acore18_opt_0.sw_bitcell_opt_term_0.trkb oa_sar8_acore18_opt_0.sw_bitcell_opt_b0_1.bot 1.3864f
C2580 sar_ctrl_async_phys_0.sg13g2_a21oi_1$1_4.B1 a_33675_43020# 0.05925f
C2581 sar_ctrl_async_phys_0.sg13g2_buf_1$1_6.X a_35557_31435# 0.2441f
C2582 sar_ctrl_async_phys_0.sg13g2_a21oi_1$1_5.A2 a_33270_39698# 0.0111f
C2583 oa_sar8_acore18_opt_0.sw_bitcell_opt_b2_1.bot VDD 2.81891f
C2584 sar_ctrl_async_phys_0.sg13g2_nor4_1$1_0.C sar_ctrl_async_phys_0.sg13g2_nor2_1$1_14.A 0.02769f
C2585 sar_ctrl_async_phys_0.sg13g2_nor2_1$1_18.A sar_ctrl_async_phys_0.sg13g2_and2_1$1_0.X 0.04536f
C2586 sar_ctrl_async_phys_0.sg13g2_a21oi_1$1_6.A2 a_33085_43832# 0.26858f
C2587 sar_ctrl_async_phys_0.sg13g2_dfrbpq_1$1_0.CLK sar_ctrl_async_phys_0.sg13g2_nor2_1$1_3.B 0.13495f
C2588 sar_ctrl_async_phys_0.sg13g2_a22oi_1$1_3.A2 a_32991_35239# 0.0309f
C2589 sar_ctrl_async_phys_0.sg13g2_a22oi_1$1_0.Y a_34549_32911# 0.04331f
C2590 a_35245_42242# a_35327_42342# 0.01117f
C2591 sar_ctrl_async_phys_0.sg13g2_nor2b_1$1_0.A sar_ctrl_async_phys_0.sg13g2_buf_1$1_14.A 0.23877f
C2592 sar_ctrl_async_phys_0.sg13g2_a22oi_1$1_4.A2 a_32347_37447# 0.02314f
C2593 sar_ctrl_async_phys_0.sg13g2_dlygate4sd3_1$1_8.X a_26280_41214# 0.40903f
C2594 sar_ctrl_async_phys_0.sg13g2_buf_1$1_20.A sar_ctrl_async_phys_0.bit_active[7] 0.0263f
C2595 a_32984_39830# VDD 0.13109f
C2596 sar_ctrl_async_phys_0.sg13g2_a22oi_1$1_2.B2 sar_ctrl_async_phys_0.sg13g2_a22oi_1$1_2.Y 0.19697f
C2597 sar_ctrl_async_phys_0.sg13g2_nor4_1$1_0.C sar_ctrl_async_phys_0.sg13g2_a21oi_1$1_5.Y 0.0205f
C2598 a_30964_46512# VDD 0.0772f
C2599 oa_sar8_acore18_opt_0.sw_bitcell_opt_term_0.trkb a_35948_n9612# 0.80047f
C2600 sar_ctrl_async_phys_0.sg13g2_and2_1$1_0.A a_31256_37522# 0.026f
C2601 sar_ctrl_async_phys_0.sg13g2_a21oi_1$1_0.B1 sar_ctrl_async_phys_0.sg13g2_a21oi_1$1_3.B1 1.72006f
C2602 sar_ctrl_async_phys_0.sg13g2_nor2_1$1_3.B sar_ctrl_async_phys_0.sg13g2_buf_1$1_26.X 0.04232f
C2603 sar_ctrl_async_phys_0.sg13g2_buf_1$1_41.X VDD 8.3941f
C2604 a_29620_43488# VDD 0.07706f
C2605 sar_ctrl_async_phys_0.dac_code_n[5] oa_sar8_acore18_opt_0.bstrap_opt_w2_c1200_1.out 1.87319f
C2606 sar_ctrl_async_phys_0.sg13g2_a22oi_1$1_3.A2 sar_ctrl_async_phys_0.sg13g2_nand2_1$1_2.Y 0.05967f
C2607 sar_ctrl_async_phys_0.sg13g2_nor2b_1$1_0.A sar_ctrl_async_phys_0.sg13g2_a22oi_1$1_1.A2 0.0122f
C2608 sar_ctrl_async_phys_0.sg13g2_nor2_1$1_10.B sar_ctrl_async_phys_0.sg13g2_buf_1$1_17.A 0.1529f
C2609 sar_ctrl_async_phys_0.dac_code_n[4] VDD 4.93184f
C2610 sar_ctrl_async_phys_0.sg13g2_nor2_1$1_10.B sar_ctrl_async_phys_0.sg13g2_buf_1$1_0.A 0.1044f
C2611 sar_ctrl_async_phys_0.sg13g2_a22oi_1$1_3.A2 a_35053_40730# 0.07242f
C2612 sar_ctrl_async_phys_0.sg13g2_and2_1$1_0.A sar_ctrl_async_phys_0.cmp_fire 0.06573f
C2613 sar_ctrl_async_phys_0.sg13g2_and2_1$1_3.X a_26385_39214# 0.03641f
C2614 sar_ctrl_async_phys_0.sg13g2_inv_1$1_0.A a_33359_32876# 0.17571f
C2615 result[7] result[6] 0.10732f
C2616 result[4] result[3] 0.1471f
C2617 a_27134_39887# VDD 0.18836f
C2618 sar_ctrl_async_phys_0.dac_code[7] oa_sar8_acore18_opt_0.sw_bitcell_opt_term_0.bot 0.11923f
C2619 sar_ctrl_async_phys_0.sg13g2_buf_1$1_3.A a_32533_40471# 0.01086f
C2620 sar_ctrl_async_phys_0.sg13g2_and2_1$1_1.B VDD 0.5614f
C2621 sar_ctrl_async_phys_0.sg13g2_o21ai_1$1_1.B1 sar_ctrl_async_phys_0.sg13g2_nor2_1$1_11.Y 0.1995f
C2622 a_33754_37436# VDD 0.38504f
C2623 a_36058_34412# done 0.01216f
C2624 sar_ctrl_async_phys_0.sg13g2_a22oi_1$1_1.Y VDD 0.28032f
C2625 oa_sar8_acore18_opt_0.sw_bitcell_opt_b0_0.bot m3_57896_n2380# 1.5154f
C2626 sar_ctrl_async_phys_0.sg13g2_a21oi_1$1_2.Y sar_ctrl_async_phys_0.sg13g2_nand2_1$1_1.B 0.01047f
C2627 sar_ctrl_async_phys_0.sg13g2_a22oi_1$1_0.A2 sar_ctrl_async_phys_0.sg13g2_buf_1$1_4.A 0.06609f
C2628 a_34036_35928# VDD 0.11596f
C2629 a_34055_31352# a_34615_31475# 0.26905f
C2630 sar_ctrl_async_phys_0.sg13g2_dfrbpq_1$1_0.CLK sar_ctrl_async_phys_0.sg13g2_a22oi_1$1_2.B2 0.15494f
C2631 oa_sar8_acore18_opt_0.sw_bitcell_opt_b4_0.bot a_35948_n9612# 0.04172f
C2632 a_33652_41528# a_33940_41223# 0.43707f
C2633 sar_ctrl_async_phys_0.sg13g2_nor2b_1$1_2.Y a_33648_36010# 0.02826f
C2634 w_16692_n9960# a_20412_n9612# 5.07759f
C2635 sar_ctrl_async_phys_0.dac_code_n[4] oa_sar8_acore18_opt_0.sw_bitcell_opt_b6_0.bot 0.90747f
C2636 w_39600_n9960# sar_ctrl_async_phys_0.dac_code_n[4] 0.11956f
C2637 sar_ctrl_async_phys_0.sg13g2_inv_1$1_6.A sar_ctrl_async_phys_0.sg13g2_a22oi_1$1_2.Y 0.01423f
C2638 sar_ctrl_async_phys_0.sg13g2_buf_1$1_42.A sar_ctrl_async_phys_0.sg13g2_a21oi_1$1_0.B1 0.05147f
C2639 sar_ctrl_async_phys_0.sg13g2_nor4_1$1_0.C sar_ctrl_async_phys_0.sg13g2_a21oi_1$1_6.B1 0.03325f
C2640 oa_sar8_acore18_opt_0.sw_bitcell_opt_b1_0.bot oa_sar8_acore18_opt_0.sw_bitcell_opt_term_0.bot 0.38018f
C2641 sar_ctrl_async_phys_0.sg13g2_nor4_1$1_0.C sar_ctrl_async_phys_0.sg13g2_and2_1$1_3.X 0.08119f
C2642 sar_ctrl_async_phys_0.sg13g2_nand2_1$1_1.B sar_ctrl_async_phys_0.sg13g2_inv_1$1_7.A 0.036f
C2643 sar_ctrl_async_phys_0.sg13g2_buf_1$1_14.A sar_ctrl_async_phys_0.sg13g2_nor2b_1$1_1.B_N 0.77092f
C2644 sar_ctrl_async_phys_0.sg13g2_dfrbpq_1$1_0.CLK a_27624_35965# 0.41101f
C2645 a_35648_33142# VDD 0.17045f
C2646 sar_ctrl_async_phys_0.sg13g2_buf_1$1_37.A VDD 0.7312f
C2647 sar_ctrl_async_phys_0.sg13g2_nand2_1$1_3.B a_35456_44454# 0.03801f
C2648 sar_ctrl_async_phys_0.sg13g2_nor2_1$1_10.B sar_ctrl_async_phys_0.sg13g2_and2_1$1_6.X 0.02351f
C2649 sar_ctrl_async_phys_0.sg13g2_buf_1$1_2.A sar_ctrl_async_phys_0.sg13g2_buf_1$1_10.A 0.22157f
C2650 sar_ctrl_async_phys_0.sg13g2_nand2b_1$1_3.Y sar_ctrl_async_phys_0.sg13g2_nor2b_1$1_3.Y 1.39546f
C2651 sar_ctrl_async_phys_0.sg13g2_a21oi_1$1_0.A1 sar_ctrl_async_phys_0.sg13g2_a22oi_1$1_3.A2 0.16207f
C2652 sar_ctrl_async_phys_0.sg13g2_a21oi_1$1_2.B1 a_29808_39830# 0.01816f
C2653 sar_ctrl_async_phys_0.sg13g2_a21oi_1$1_1.B1 sar_ctrl_async_phys_0.bit_active[6] 0.02784f
C2654 sar_ctrl_async_phys_0.sg13g2_nor2b_1$1_2.Y a_33558_36674# 0.03547f
C2655 sar_ctrl_async_phys_0.sg13g2_a22oi_1$1_1.A2 sar_ctrl_async_phys_0.sg13g2_nor2b_1$1_1.B_N 0.19937f
C2656 sar_ctrl_async_phys_0.sg13g2_a21oi_1$1_1.B1 sar_ctrl_async_phys_0.sg13g2_and2_1$1_0.X 0.02945f
C2657 sar_ctrl_async_phys_0.sg13g2_buf_1$1_35.A VDD 0.5502f
C2658 a_35211_37436# VDD 0.23284f
C2659 sar_ctrl_async_phys_0.sg13g2_buf_1$1_0.A result[4] 0.09146f
C2660 sar_ctrl_async_phys_0.sg13g2_dfrbpq_1$1_0.CLK a_34526_31826# 0.02267f
C2661 sar_ctrl_async_phys_0.sg13g2_nor2b_1$1_1.B_N a_34424_35200# 0.01536f
C2662 a_30772_31392# VDD 0.07224f
C2663 sar_ctrl_async_phys_0.dac_code[0] VDD 4.09982f
C2664 a_33632_40702# a_34042_40460# 0.10373f
C2665 sar_ctrl_async_phys_0.sg13g2_buf_1$1_7.A a_31638_32138# 0.02416f
C2666 sar_ctrl_async_phys_0.sg13g2_buf_1$1_13.A a_34904_38224# 0.0122f
C2667 sar_ctrl_async_phys_0.sg13g2_dfrbpq_1$1_0.CLK sar_ctrl_async_phys_0.sg13g2_inv_1$1_6.A 0.04574f
C2668 oa_sar8_acore18_opt_0.sw_bitcell_opt_term_0.trkb oa_sar8_acore18_opt_0.sw_bitcell_opt_b4_1.bot 1.46626f
C2669 sar_ctrl_async_phys_0.sg13g2_o21ai_1$1_1.B1 a_30676_40016# 0.37533f
C2670 oa_sar8_acore18_opt_0.sw_bitcell_opt_b6_1.bot VDD 4.42027f
C2671 sar_ctrl_async_phys_0.sg13g2_dfrbpq_1$1_0.CLK sar_ctrl_async_phys_0.sg13g2_a22oi_1$1_3.A2 1.4015f
C2672 sar_ctrl_async_phys_0.sg13g2_and2_1$1_0.A a_30676_40016# 0.01709f
C2673 sar_ctrl_async_phys_0.sg13g2_a22oi_1$1_2.B2 a_33359_32876# 0.01169f
C2674 sar_ctrl_async_phys_0.sg13g2_nor2_1$1_4.Y a_26184_42013# 0.02185f
C2675 sar_ctrl_async_phys_0.sg13g2_and2_1$1_0.A sar_ctrl_async_phys_0.sg13g2_and2_1$1_0.B 0.77743f
C2676 a_33556_40016# a_33844_39711# 0.43707f
C2677 sar_ctrl_async_phys_0.sg13g2_a22oi_1$1_4.A2 a_32245_37447# 0.01483f
C2678 sar_ctrl_async_phys_0.sg13g2_buf_1$1_41.X a_34236_46472# 0.24679f
C2679 a_30964_46512# a_32223_46869# 0.01529f
C2680 sar_ctrl_async_phys_0.sg13g2_nor2b_1$1_0.A sar_ctrl_async_phys_0.sg13g2_buf_1$1_20.A 0.06737f
C2681 sar_ctrl_async_phys_0.sg13g2_nor2_1$1_10.B sar_ctrl_async_phys_0.sg13g2_buf_1$1_6.X 0.0221f
C2682 a_32192_39918# VDD 0.17064f
C2683 sar_ctrl_async_phys_0.dac_code[0] oa_sar8_acore18_opt_0.sw_bitcell_opt_b6_0.bot 1.1725f
C2684 sar_ctrl_async_phys_0.dac_code_n[1] oa_sar8_acore18_opt_0.sw_bitcell_opt_term_0.VSS 0.04328f
C2685 sar_ctrl_async_phys_0.sg13g2_a21oi_1$1_4.B1 sar_ctrl_async_phys_0.sg13g2_a21oi_1$1_3.B1 0.02005f
C2686 w_39600_n9960# sar_ctrl_async_phys_0.dac_code[0] 0.10836f
C2687 sar_ctrl_async_phys_0.sg13g2_buf_1$1_41.X a_32223_46869# 0.13297f
C2688 sar_ctrl_async_phys_0.sg13g2_inv_1$1_7.A a_28977_36864# 0.01066f
C2689 sar_ctrl_async_phys_0.dac_code[2] sar_ctrl_async_phys_0.dac_code[4] 4.19871f
C2690 sar_ctrl_async_phys_0.sg13g2_buf_1$1_3.A sar_ctrl_async_phys_0.sg13g2_buf_1$1_4.A 0.65894f
C2691 a_35103_36751# a_35009_36751# 0.28931f
C2692 sar_ctrl_async_phys_0.sg13g2_a21oi_1$1_4.A2 a_31933_43832# 0.19533f
C2693 sar_ctrl_async_phys_0.sg13g2_nand2b_1$1_3.Y a_34896_40546# 0.01215f
C2694 sar_ctrl_async_phys_0.sg13g2_dlygate4sd3_1$1_11.X a_26666_38912# 0.41101f
C2695 sar_ctrl_async_phys_0.sg13g2_a22oi_1$1_3.A2 a_32116_40464# 0.02868f
C2696 sar_ctrl_async_phys_0.dac_code[6] oa_sar8_acore18_opt_0.sw_tg_opt_0.bot 0.92346f
C2697 sar_ctrl_async_phys_0.sg13g2_a22oi_1$1_0.Y result[5] 0.01998f
C2698 sar_ctrl_async_phys_0.sg13g2_a22oi_1$1_0.A1 sar_ctrl_async_phys_0.sg13g2_buf_1$1_4.A 0.0341f
C2699 sar_ctrl_async_phys_0.sg13g2_dfrbpq_1$1_0.CLK a_34357_44213# 0.25591f
C2700 sar_ctrl_async_phys_0.sg13g2_nand2_1$1_3.A sar_ctrl_async_phys_0.sg13g2_nand2b_1$1_4.A_N 0.11152f
C2701 sar_ctrl_async_phys_0.sg13g2_nand2b_1$1_5.A_N a_34765_45266# 0.1784f
C2702 sar_ctrl_async_phys_0.sg13g2_and2_1$1_0.B a_31261_38232# 0.27841f
C2703 sar_ctrl_async_phys_0.sg13g2_buf_1$1_14.A a_34036_35928# 0.02412f
C2704 sar_ctrl_async_phys_0.sg13g2_buf_1$1_32.A a_34363_43495# 0.05598f
C2705 sar_ctrl_async_phys_0.sg13g2_buf_1$1_41.X a_35456_44454# 0.10322f
C2706 sar_ctrl_async_phys_0.sg13g2_nor2_1$1_2.Y a_33375_40821# 0.03852f
C2707 sar_ctrl_async_phys_0.sg13g2_nand2_1$1_3.B sar_ctrl_async_phys_0.sg13g2_buf_1$1_20.A 0.11018f
C2708 a_31935_36285# VDD 0.17651f
C2709 a_33936_31675# a_34268_31826# 0.10373f
C2710 sar_ctrl_async_phys_0.dac_code_n[4] oa_sar8_acore18_opt_0.sw_bitcell_opt_b2_0.bot 0.0829f
C2711 sar_ctrl_async_phys_0.sg13g2_a22oi_1$1_1.A2 sar_ctrl_async_phys_0.sg13g2_a22oi_1$1_1.Y 0.25466f
C2712 a_26280_41214# VDD 0.36118f
C2713 sar_ctrl_async_phys_0.sg13g2_a22oi_1$1_1.A2 a_34036_35928# 0.01132f
C2714 a_34136_47296# sar_ctrl_async_phys_0.cmp_fault 0.24726f
C2715 sar_ctrl_async_phys_0.sg13g2_buf_1$1_42.A sar_ctrl_async_phys_0.sg13g2_a21oi_1$1_4.B1 0.03564f
C2716 sar_ctrl_async_phys_0.sg13g2_a21oi_1$1_0.B1 sar_ctrl_async_phys_0.sg13g2_a21oi_1$1_6.B1 0.0497f
C2717 a_33652_41528# a_34069_41189# 0.3749f
C2718 a_33366_41210# a_34171_41332# 0.097f
C2719 sar_ctrl_async_phys_0.sg13g2_nand2_1$1_5.Y sar_ctrl_async_phys_0.sg13g2_buf_1$1_3.A 0.56177f
C2720 oa_sar8_acore18_opt_0.sw_bitcell_opt_term_1.bot VDD 3.79006f
C2721 a_30507_35204# a_31007_35460# 0.03308f
C2722 a_30830_35166# a_30733_35460# 0.02903f
C2723 a_30200_35294# a_30384_35294# 0.0524f
C2724 sar_ctrl_async_phys_0.sg13g2_buf_1$1_1.A a_30507_35204# 0.01716f
C2725 sar_ctrl_async_phys_0.sg13g2_a21oi_1$1_5.Y a_31947_41508# 0.15867f
C2726 sar_ctrl_async_phys_0.sg13g2_and2_1$1_0.A sar_ctrl_async_phys_0.sg13g2_dlygate4sd3_1$1_5.X 0.19472f
C2727 a_30671_32876# VDD 0.30337f
C2728 sar_ctrl_async_phys_0.dac_code[3] oa_sar8_acore18_opt_0.sw_tg_opt_0.bot 0.88659f
C2729 sar_ctrl_async_phys_0.sg13g2_buf_1$1_6.X result[4] 0.15769f
C2730 a_35672_46508# sar_ctrl_async_phys_0.sg13g2_buf_1$1_36.A 0.02597f
C2731 a_31060_44552# a_31348_44247# 0.43707f
C2732 sar_ctrl_async_phys_0.sg13g2_buf_1$1_1.A sar_ctrl_async_phys_0.sg13g2_a22oi_1$1_0.Y 0.014f
C2733 a_35552_36166# a_35962_35924# 0.10373f
C2734 sar_ctrl_async_phys_0.sg13g2_buf_1$1_15.A a_34069_41189# 0.02605f
C2735 sar_ctrl_async_phys_0.sg13g2_inv_1$1_2.Y a_33089_32215# 0.01351f
C2736 sar_ctrl_async_phys_0.sg13g2_a22oi_1$1_0.A1 sar_ctrl_async_phys_0.sg13g2_inv_1$1_3.Y 0.0391f
C2737 sar_ctrl_async_phys_0.sg13g2_a22oi_1$1_0.A2 a_34132_32904# 0.03244f
C2738 sar_ctrl_async_phys_0.sg13g2_buf_1$1_7.A sar_ctrl_async_phys_0.sg13g2_a22oi_1$1_0.Y 0.02268f
C2739 sar_ctrl_async_phys_0.sg13g2_nor2_1$1_2.Y sar_ctrl_async_phys_0.sg13g2_buf_1$1_13.A 0.23045f
C2740 a_28392_41214# a_28662_41214# 0.26306f
C2741 a_31738_33948# sar_ctrl_async_phys_0.sg13g2_buf_1$1_7.A 0.12191f
C2742 sar_ctrl_async_phys_0.sg13g2_dlygate4sd3_1$1_5.A sar_ctrl_async_phys_0.sg13g2_inv_1$1_10.Y 0.01833f
C2743 sar_ctrl_async_phys_0.sg13g2_nand2_1$1_3.A a_34261_43495# 0.05841f
C2744 oa_sar8_acore18_opt_0.sw_bitcell_opt_term_0.trkb oa_sar8_acore18_opt_0.sw_bitcell_opt_b7_0.bot 1.5146f
C2745 sar_ctrl_async_phys_0.sg13g2_nand2b_1$1_3.Y sar_ctrl_async_phys_0.sg13g2_buf_1$1_20.A 0.02214f
C2746 a_32533_40471# a_32635_40471# 0.47795f
C2747 sar_ctrl_async_phys_0.sg13g2_dfrbpq_1$1_0.CLK a_30296_42854# 0.01027f
C2748 a_34132_43909# a_34363_43495# 0.12701f
C2749 sar_ctrl_async_phys_0.sg13g2_a21oi_1$1_0.B1 sar_ctrl_async_phys_0.sg13g2_nand2b_1$1_1.B 0.07041f
C2750 sar_ctrl_async_phys_0.sg13g2_buf_1$1_15.A a_34363_43495# 0.01114f
C2751 sar_ctrl_async_phys_0.sg13g2_nand2b_1$1_4.A_N a_35725_45266# 0.18859f
C2752 sar_ctrl_async_phys_0.sg13g2_buf_1$1_42.A a_33951_45823# 0.03709f
C2753 sar_ctrl_async_phys_0.sg13g2_nor2_1$1_10.A a_31098_43020# 0.01486f
C2754 sar_ctrl_async_phys_0.sg13g2_a22oi_1$1_1.B2 result[4] 0.06314f
C2755 sar_ctrl_async_phys_0.hold_req sar_ctrl_async_phys_0.dac_code[1] 0.12491f
C2756 sar_ctrl_async_phys_0.sg13g2_nand2_1$1_5.Y sar_ctrl_async_phys_0.sg13g2_a21oi_1$1_3.A2 0.0154f
C2757 sar_ctrl_async_phys_0.sg13g2_nor2_1$1_0.Y a_32225_44311# 0.0177f
C2758 sar_ctrl_async_phys_0.sg13g2_inv_1$1_0.A a_35384_32176# 0.01953f
C2759 sar_ctrl_async_phys_0.sg13g2_a22oi_1$1_0.B1 sar_ctrl_async_phys_0.sg13g2_a22oi_1$1_3.B1 0.70674f
C2760 a_33556_40016# a_34075_39820# 0.34114f
C2761 sar_ctrl_async_phys_0.sg13g2_and2_1$1_0.B a_29236_38952# 0.02578f
C2762 sar_ctrl_async_phys_0.dac_code[0] oa_sar8_acore18_opt_0.sw_bitcell_opt_b2_0.bot 0.50054f
C2763 sar_ctrl_async_phys_0.sg13g2_buf_1$1_8.A a_33183_32215# 0.03304f
C2764 sar_ctrl_async_phys_0.sg13g2_dfrbpq_1$1_0.CLK a_33556_40016# 0.09624f
C2765 sar_ctrl_async_phys_0.sg13g2_nor2_1$1_11.Y a_29238_40898# 0.27995f
C2766 sar_ctrl_async_phys_0.dac_code_n[3] sar_ctrl_async_phys_0.dac_code[6] 0.13816f
C2767 a_30390_39698# VDD 0.77573f
C2768 sar_ctrl_async_phys_0.sg13g2_buf_1$1_41.X sar_ctrl_async_phys_0.sg13g2_buf_1$1_20.A 1.95432f
C2769 oa_sar8_acore18_opt_0.sw_bitcell_opt_term_0.vin oa_sar8_acore18_opt_0.sw_bitcell_opt_b5_0.bot 4.11337f
C2770 oa_sar8_acore18_opt_0.sw_bitcell_opt_b2_1.bot oa_sar8_acore18_opt_0.sw_bitcell_opt_b7_1.VSS 1.62509f
C2771 oa_sar8_acore18_opt_0.sw_bitcell_opt_b7_0.bot oa_sar8_acore18_opt_0.sw_bitcell_opt_b4_0.bot 1.23226f
C2772 sar_ctrl_async_phys_0.sg13g2_a22oi_1$1_3.A2 a_32347_37447# 0.01035f
C2773 a_33558_36674# a_34132_36687# 0.31978f
C2774 a_34363_36796# a_35360_36894# 0.02979f
C2775 sar_ctrl_async_phys_0.sg13g2_a22oi_1$1_0.B1 sar_ctrl_async_phys_0.sg13g2_buf_1$1_8.A 0.03307f
C2776 a_29328_39830# VDD 0.06995f
C2777 sar_ctrl_async_phys_0.sg13g2_nand2_1$1_5.Y sar_ctrl_async_phys_0.dac_code[7] 0.06281f
C2778 sar_ctrl_async_phys_0.sg13g2_buf_1$1_41.X sar_ctrl_async_phys_0.sg13g2_nor2b_1$1_0.A 0.01724f
C2779 sar_ctrl_async_phys_0.sg13g2_nand2b_1$1_3.Y sar_ctrl_async_phys_0.sg13g2_nand2_1$1_3.B 1.07083f
C2780 sar_ctrl_async_phys_0.sg13g2_nor2_1$1_4.Y sar_ctrl_async_phys_0.sg13g2_buf_1$1_2.A 0.01734f
C2781 sar_ctrl_async_phys_0.sg13g2_buf_1$1_41.X a_31546_43484# 0.01858f
C2782 sar_ctrl_async_phys_0.sg13g2_a21oi_1$1_2.B1 a_34171_41332# 0.02435f
C2783 sar_ctrl_async_phys_0.sg13g2_a21oi_1$1_5.Y a_31830_40898# 0.03136f
C2784 sar_ctrl_async_phys_0.dac_code[4] oa_sar8_acore18_opt_0.sw_bitcell_opt_b3_0.bot 0.64086f
C2785 sar_ctrl_async_phys_0.sg13g2_inv_1$1_5.A a_29749_32117# 0.07793f
C2786 sar_ctrl_async_phys_0.sg13g2_a22oi_1$1_1.B2 a_33080_31388# 0.25858f
C2787 sar_ctrl_async_phys_0.sg13g2_nor2_1$1_10.B a_30689_40821# 0.01678f
C2788 sar_ctrl_async_phys_0.sg13g2_a22oi_1$1_2.A2 sar_ctrl_async_phys_0.sg13g2_buf_1$1_13.A 0.17516f
C2789 sar_ctrl_async_phys_0.dac_code[6] m3_48572_n2380# 0.05582f
C2790 oa_sar8_acore18_opt_0.bstrap_opt_w2_c1200_1.gb a_21332_n9711# 0.85251f
C2791 sar_ctrl_async_phys_0.sg13g2_nor2_1$1_3.B a_27120_37522# 0.01275f
C2792 sar_ctrl_async_phys_0.dac_code_n[4] oa_sar8_acore18_opt_0.sw_bitcell_opt_b7_1.VSS 1.21041f
C2793 sar_ctrl_async_phys_0.sg13g2_a21oi_1$1_6.B1 sar_ctrl_async_phys_0.sg13g2_a21oi_1$1_4.B1 0.04896f
C2794 sar_ctrl_async_phys_0.sg13g2_o21ai_1$1_1.B1 a_34069_41189# 0.03518f
C2795 a_31189_31399# a_31937_31749# 0.01058f
C2796 sar_ctrl_async_phys_0.dac_code_n[3] a_36156_45710# 0.01347f
C2797 sar_ctrl_async_phys_0.sg13g2_buf_1$1_41.X sar_ctrl_async_phys_0.sg13g2_nor2_1$1_10.Y 0.11284f
C2798 sar_ctrl_async_phys_0.dac_code_n[3] sar_ctrl_async_phys_0.dac_code[3] 2.56117f
C2799 sar_ctrl_async_phys_0.sg13g2_nor2_1$1_10.Y a_29620_43488# 0.04571f
C2800 a_28758_35924# VDD 0.22626f
C2801 a_35402_39318# sar_ctrl_async_phys_0.sg13g2_buf_1$1_21.A 0.01535f
C2802 sar_ctrl_async_phys_0.sg13g2_buf_1$1_41.X sar_ctrl_async_phys_0.sg13g2_nand2_1$1_3.B 0.04312f
C2803 oa_sar8_acore18_opt_0.sw_tg_opt_0.bot a_30632_22281# 0.8059f
C2804 sar_ctrl_async_phys_0.dac_code_n[4] sar_ctrl_async_phys_0.sg13g2_nand2_1$1_3.B 0.01282f
C2805 sar_ctrl_async_phys_0.sg13g2_inv_1$1_5.A a_29912_31474# 0.01318f
C2806 oa_sar8_acore18_opt_0.sw_bitcell_opt_b3_1.bot oa_sar8_acore18_opt_0.bstrap_opt_w2_c1200_1.gb 0.65061f
C2807 a_35672_46508# sar_ctrl_async_phys_0.sg13g2_buf_1$1_46.A 0.01145f
C2808 sar_ctrl_async_phys_0.sg13g2_buf_1$1_37.A sar_ctrl_async_phys_0.sg13g2_buf_1$1_20.A 0.07609f
C2809 sar_ctrl_async_phys_0.sg13g2_nor2_1$1_13.B VDD 0.65606f
C2810 sar_ctrl_async_phys_0.sg13g2_a22oi_1$1_0.A1 a_34132_32904# 0.02026f
C2811 sar_ctrl_async_phys_0.sg13g2_inv_1$1_1.Y sar_ctrl_async_phys_0.sg13g2_a22oi_1$1_2.B2 0.6463f
C2812 a_31060_44552# a_31477_44213# 0.3749f
C2813 a_30774_44234# a_31579_44356# 0.097f
C2814 sar_ctrl_async_phys_0.sg13g2_inv_1$1_2.Y result[2] 0.18446f
C2815 a_34036_35928# a_35295_36285# 0.01529f
C2816 sar_ctrl_async_phys_0.dac_code[3] m3_48572_n2380# 0.04448f
C2817 sar_ctrl_async_phys_0.sg13g2_buf_1$1_20.A sar_ctrl_async_phys_0.sg13g2_buf_1$1_35.A 0.01079f
C2818 sar_ctrl_async_phys_0.sg13g2_dfrbpq_1$1_0.CLK sar_ctrl_async_phys_0.sg13g2_buf_1$1_10.A 0.16283f
C2819 oa_sar8_acore18_opt_0.sw_bitcell_opt_b1_1.bot oa_sar8_acore18_opt_0.sw_bitcell_opt_b3_1.bot 0.43751f
C2820 oa_sar8_acore18_opt_0.sw_bitcell_opt_b0_1.bot oa_sar8_acore18_opt_0.sw_bitcell_opt_b4_1.bot 1.26779f
C2821 sar_ctrl_async_phys_0.dac_code[0] sar_ctrl_async_phys_0.sg13g2_buf_1$1_20.A 0.05769f
C2822 a_30331_33772# a_30100_33663# 0.12701f
C2823 a_29812_33968# a_30977_33727# 0.43239f
C2824 a_31071_33727# a_31328_33870# 0.34468f
C2825 sar_ctrl_async_phys_0.sg13g2_buf_1$1_6.X a_35391_33261# 0.15222f
C2826 sar_ctrl_async_phys_0.sg13g2_buf_1$1_4.A a_35360_36894# 0.04394f
C2827 sar_ctrl_async_phys_0.sg13g2_nor2_1$1_14.A sar_ctrl_async_phys_0.sg13g2_nor2_1$1_6.Y 0.05181f
C2828 sar_ctrl_async_phys_0.dac_code[7] oa_sar8_acore18_opt_0.sw_bitcell_opt_term_0.vin 2.6753f
C2829 sar_ctrl_async_phys_0.sg13g2_nand2b_1$1_5.A_N VDD 0.63661f
C2830 sar_ctrl_async_phys_0.sg13g2_a21oi_1$1_4.B1 sar_ctrl_async_phys_0.sg13g2_nand2b_1$1_1.B 0.02871f
C2831 sar_ctrl_async_phys_0.sg13g2_dlygate4sd3_1$1_9.X sar_ctrl_async_phys_0.sg13g2_nand3_1$1_0.Y 0.24509f
C2832 a_31830_40898# a_32533_40471# 0.02432f
C2833 sar_ctrl_async_phys_0.sg13g2_nand2_1$1_1.Y a_28272_37522# 0.01646f
C2834 sar_ctrl_async_phys_0.dac_code_n[1] VDD 4.04044f
C2835 a_33818_43452# a_33844_43488# 0.36952f
C2836 sar_ctrl_async_phys_0.sg13g2_buf_1$1_41.X sar_ctrl_async_phys_0.sg13g2_nand2b_1$1_3.Y 0.02709f
C2837 sar_ctrl_async_phys_0.dac_code_n[5] sar_ctrl_async_phys_0.sg13g2_buf_1$1_46.A 0.03097f
C2838 a_33558_43922# a_34261_43495# 0.02432f
C2839 a_31450_40460# sar_ctrl_async_phys_0.sg13g2_dfrbpq_1$1_11.D 0.015f
C2840 a_33248_45238# a_32991_45357# 0.34468f
C2841 a_29851_32260# a_30591_32215# 0.26905f
C2842 sar_ctrl_async_phys_0.sg13g2_buf_1$1_37.A sar_ctrl_async_phys_0.sg13g2_nand2_1$1_3.B 0.01114f
C2843 sar_ctrl_async_phys_0.sg13g2_buf_1$1_6.X a_31189_31399# 0.04966f
C2844 sar_ctrl_async_phys_0.dac_code_n[4] oa_sar8_acore18_opt_0.sw_bitcell_opt_b2_1.bot 0.06598f
C2845 sar_ctrl_async_phys_0.sg13g2_a22oi_1$1_0.B2 a_34615_31475# 0.05422f
C2846 a_33530_39921# a_33270_39698# 0.75507f
C2847 oa_sar8_acore18_opt_0.sw_bitcell_opt_term_0.vin oa_sar8_acore18_opt_0.sw_bitcell_opt_b1_0.bot 3.87886f
C2848 oa_sar8_acore18_opt_0.sw_bitcell_opt_b7_0.bot oa_sar8_acore18_opt_0.sw_bitcell_opt_b0_0.bot 0.96897f
C2849 oa_sar8_acore18_opt_0.sw_bitcell_opt_b6_1.bot oa_sar8_acore18_opt_0.sw_bitcell_opt_b7_1.VSS 2.29885f
C2850 sar_ctrl_async_phys_0.sg13g2_a22oi_1$1_3.A2 sar_ctrl_async_phys_0.sg13g2_inv_1$1_1.Y 0.17403f
C2851 a_34651_30748# a_35391_30703# 0.26905f
C2852 a_35672_33688# done 0.09118f
C2853 sar_ctrl_async_phys_0.sg13g2_buf_1$1_2.A sar_ctrl_async_phys_0.sg13g2_nor2_1$1_1.Y 1.96448f
C2854 a_30938_46476# a_31381_46519# 0.02242f
C2855 sar_ctrl_async_phys_0.dac_code[0] sar_ctrl_async_phys_0.sg13g2_nand2_1$1_3.B 0.16082f
C2856 a_33558_36674# a_34261_36653# 0.02454f
C2857 sar_ctrl_async_phys_0.sg13g2_o21ai_1$1_1.B1 sar_ctrl_async_phys_0.sg13g2_dfrbpq_1$1_11.D 0.40997f
C2858 sar_ctrl_async_phys_0.sg13g2_a21oi_1$1_5.Y a_31841_36285# 0.01543f
C2859 sar_ctrl_async_phys_0.dac_code_n[1] oa_sar8_acore18_opt_0.sw_bitcell_opt_b6_0.bot 0.59859f
C2860 sar_ctrl_async_phys_0.sg13g2_buf_1$1_41.X a_30964_46512# 0.39153f
C2861 sar_ctrl_async_phys_0.sg13g2_o21ai_1$1_1.B1 a_32991_45357# 0.01443f
C2862 sar_ctrl_async_phys_0.dac_code[4] oa_sar8_acore18_opt_0.sw_bitcell_opt_term_0.bot 0.159f
C2863 sar_ctrl_async_phys_0.sg13g2_and2_1$1_0.A sar_ctrl_async_phys_0.sg13g2_dfrbpq_1$1_11.D 0.01522f
C2864 sar_ctrl_async_phys_0.sg13g2_buf_1$1_41.X a_29620_43488# 0.3994f
C2865 a_29594_43452# a_30037_43495# 0.02242f
C2866 sar_ctrl_async_phys_0.sg13g2_dfrbpq_1$1_5.D VDD 0.40262f
C2867 a_34618_46044# sar_ctrl_async_phys_0.sg13g2_nand2b_1$1_6.A_N 0.11568f
C2868 sar_ctrl_async_phys_0.sg13g2_nand3_1$1_0.C VDD 0.27453f
C2869 sar_ctrl_async_phys_0.dac_code_n[2] sar_ctrl_async_phys_0.dac_code_n[5] 0.17908f
C2870 sar_ctrl_async_phys_0.dac_code_n[2] oa_sar8_acore18_opt_0.sw_bitcell_opt_term_0.gb 0.10773f
C2871 sar_ctrl_async_phys_0.sg13g2_and2_1$1_0.A sar_ctrl_async_phys_0.sg13g2_dlygate4sd3_1$1_8.X 0.01998f
C2872 sar_ctrl_async_phys_0.sg13g2_nor2_1$1_1.Y sar_ctrl_async_phys_0.sg13g2_nor2b_1$1_2.Y 0.15601f
C2873 sar_ctrl_async_phys_0.sg13g2_a22oi_1$1_4.A2 sar_ctrl_async_phys_0.sg13g2_a22oi_1$1_4.Y 0.01851f
C2874 a_34132_30944# result[1] 0.02959f
C2875 a_35288_47296# sar_ctrl_async_phys_0.dac_code_n[0] 0.08978f
C2876 sar_ctrl_async_phys_0.sg13g2_nand2b_1$1_3.Y sar_ctrl_async_phys_0.sg13g2_buf_1$1_37.A 0.01447f
C2877 sar_ctrl_async_phys_0.sg13g2_buf_1$1_32.A VDD 0.71632f
C2878 sar_ctrl_async_phys_0.sg13g2_buf_1$1_13.A a_31644_36638# 0.26386f
C2879 oa_sar8_acore18_opt_0.sw_bitcell_opt_term_0.vin m3_51760_n2380# 0.05057f
C2880 sar_ctrl_async_phys_0.sg13g2_buf_1$1_36.A sar_ctrl_async_phys_0.dac_code[2] 0.66005f
C2881 sar_ctrl_async_phys_0.sg13g2_nand2b_1$1_0.A_N sar_ctrl_async_phys_0.sg13g2_dlygate4sd3_1$1_6.A 0.05053f
C2882 a_26566_39766# sar_ctrl_async_phys_0.sg13g2_dlygate4sd3_1$1_11.X 0.15762f
C2883 sar_ctrl_async_phys_0.sg13g2_buf_1$1_36.A a_36056_42760# 0.03026f
C2884 oa_sar8_acore18_opt_0.sw_bitcell_opt_b7_1.bot oa_sar8_acore18_opt_0.bstrap_opt_w2_c1200_1.gb 0.98095f
C2885 sar_ctrl_async_phys_0.sg13g2_dfrbpq_1$1_0.CLK sar_ctrl_async_phys_0.dac_code_n[7] 0.07501f
C2886 sar_ctrl_async_phys_0.sg13g2_and2_1$1_3.A track 0.48508f
C2887 a_33087_37797# a_32993_37797# 0.28931f
C2888 sar_ctrl_async_phys_0.sg13g2_a22oi_1$1_0.Y sar_ctrl_async_phys_0.sg13g2_inv_1$1_2.Y 0.0815f
C2889 sar_ctrl_async_phys_0.sg13g2_buf_1$1_41.X sar_ctrl_async_phys_0.sg13g2_buf_1$1_37.A 0.01422f
C2890 a_34010_35892# a_34453_35935# 0.02242f
C2891 a_33652_41528# VDD 0.09096f
C2892 oa_sar8_acore18_opt_0.sw_bitcell_opt_b2_1.bot oa_sar8_acore18_opt_0.sw_bitcell_opt_b6_1.bot 0.51912f
C2893 oa_sar8_acore18_opt_0.sw_bitcell_opt_b1_1.bot oa_sar8_acore18_opt_0.sw_bitcell_opt_b7_1.bot 1.15779f
C2894 oa_sar8_acore18_opt_0.sw_bitcell_opt_b3_1.bot oa_sar8_acore18_opt_0.sw_bitcell_opt_b5_1.bot 0.83733f
C2895 oa_sar8_acore18_opt_0.sw_bitcell_opt_term_1.bot oa_sar8_acore18_opt_0.sw_bitcell_opt_b7_1.VSS 1.40447f
C2896 sar_ctrl_async_phys_0.sg13g2_inv_1$1_0.Y result[4] 0.0453f
C2897 sar_ctrl_async_phys_0.dac_code_n[4] sar_ctrl_async_phys_0.sg13g2_buf_1$1_37.A 0.02332f
C2898 sar_ctrl_async_phys_0.sg13g2_a22oi_1$1_2.B2 a_32443_32260# 0.01339f
C2899 sar_ctrl_async_phys_0.sg13g2_a22oi_1$1_0.B1 sar_ctrl_async_phys_0.sg13g2_buf_1$1_17.A 0.43327f
C2900 sar_ctrl_async_phys_0.sg13g2_a22oi_1$1_0.B1 sar_ctrl_async_phys_0.sg13g2_buf_1$1_0.A 0.18949f
C2901 a_36056_46508# VDD 0.21878f
C2902 a_30229_33629# a_30331_33772# 0.47622f
C2903 sar_ctrl_async_phys_0.dac_code[1] oa_sar8_acore18_opt_0.sw_bitcell_opt_term_0.VSS 1.00987f
C2904 sar_ctrl_async_phys_0.cmp_fault sar_ctrl_async_phys_0.cmp_valid 0.22679f
C2905 sar_ctrl_async_phys_0.sg13g2_and2_1$1_0.A sar_ctrl_async_phys_0.sg13g2_nor2b_1$1_0.Y 0.03565f
C2906 a_34132_43909# VDD 0.01026f
C2907 sar_ctrl_async_phys_0.dac_code_n[4] sar_ctrl_async_phys_0.dac_code[0] 0.61177f
C2908 sar_ctrl_async_phys_0.sg13g2_and2_1$1_0.A a_26168_38318# 0.01557f
C2909 sar_ctrl_async_phys_0.sg13g2_a21oi_1$1_0.A1 a_30027_39996# 0.07327f
C2910 sar_ctrl_async_phys_0.sg13g2_buf_1$1_15.A VDD 0.8924f
C2911 a_29812_40885# a_30043_40471# 0.12701f
C2912 a_34549_34423# a_35297_34773# 0.01058f
C2913 a_34651_34423# a_35648_34654# 0.03061f
C2914 sar_ctrl_async_phys_0.sg13g2_and2_1$1_1.B a_35211_37436# 0.11101f
C2915 a_32149_45007# a_32020_45421# 0.01562f
C2916 a_31732_45000# a_32251_45007# 0.34102f
C2917 a_34765_42242# sar_ctrl_async_phys_0.sg13g2_a21oi_1$1_2.B1 0.17988f
C2918 a_35772_41936# a_36056_41972# 0.09867f
C2919 a_34767_31359# result[2] 0.01378f
C2920 a_29046_32138# a_29332_32456# 0.41329f
C2921 sar_ctrl_async_phys_0.sg13g2_nor4_1$1_0.Y sar_ctrl_async_phys_0.sg13g2_nand2b_1$1_0.Y 0.37802f
C2922 sar_ctrl_async_phys_0.sg13g2_buf_1$1_13.A a_31828_37440# 0.06203f
C2923 a_34651_32911# a_35391_33261# 0.26905f
C2924 sar_ctrl_async_phys_0.sg13g2_dfrbpq_1$1_0.CLK a_31195_39820# 0.01051f
C2925 sar_ctrl_async_phys_0.sg13g2_nor2b_1$1_0.A a_30390_39698# 0.04304f
C2926 sar_ctrl_async_phys_0.dac_code_n[1] oa_sar8_acore18_opt_0.sw_bitcell_opt_b2_0.bot 0.0615f
C2927 a_34106_30849# a_34549_30605# 0.02242f
C2928 a_33846_30626# a_34132_30944# 0.41329f
C2929 sar_ctrl_async_phys_0.sg13g2_nor2_1$1_0.Y a_32149_45007# 0.03211f
C2930 sar_ctrl_async_phys_0.sg13g2_and2_1$1_0.A a_25596_41174# 0.01547f
C2931 oa_sar8_acore18_opt_0.bstrap_opt_w2_c1200_1.out oa_sar8_acore18_opt_0.bstrap_opt_w2_c1200_1.gb 9.06338f
C2932 sar_ctrl_async_phys_0.sg13g2_a21oi_1$1_5.Y a_30676_35928# 0.03339f
C2933 sar_ctrl_async_phys_0.sg13g2_nor2_1$1_10.B a_30390_36362# 0.02912f
C2934 sar_ctrl_async_phys_0.dac_code_n[5] sar_ctrl_async_phys_0.sample 0.04464f
C2935 sar_ctrl_async_phys_0.sg13g2_buf_1$1_37.A sar_ctrl_async_phys_0.sg13g2_buf_1$1_35.A 0.16743f
C2936 sar_ctrl_async_phys_0.sg13g2_nor2_1$1_4.Y sar_ctrl_async_phys_0.sg13g2_dfrbpq_1$1_0.CLK 0.04525f
C2937 a_31060_44552# VDD 0.07278f
C2938 a_28977_36864# sar_ctrl_async_phys_0.sg13g2_dlygate4sd3_1$1_0.A 0.05263f
C2939 sar_ctrl_async_phys_0.dac_code[0] sar_ctrl_async_phys_0.sg13g2_buf_1$1_37.A 2.51623f
C2940 sar_ctrl_async_phys_0.sg13g2_nand2_1$1_3.Y sar_ctrl_async_phys_0.dac_code[1] 0.04496f
C2941 oa_sar8_acore18_opt_0.bstrap_opt_w2_c1200_1.out oa_sar8_acore18_opt_0.sw_bitcell_opt_b1_1.bot 3.90438f
C2942 oa_sar8_acore18_opt_0.sw_bitcell_opt_term_1.bot oa_sar8_acore18_opt_0.sw_bitcell_opt_b2_1.bot 0.36249f
C2943 a_31071_33727# VDD 0.17395f
C2944 sar_ctrl_async_phys_0.sg13g2_a21oi_1$1_6.A2 a_32897_45357# 0.0125f
C2945 a_21332_n9711# vinp 0.80795f
C2946 sar_ctrl_async_phys_0.sg13g2_buf_1$1_1.A a_34808_35200# 0.01141f
C2947 a_31450_40460# VDD 0.3828f
C2948 sar_ctrl_async_phys_0.dac_code[0] sar_ctrl_async_phys_0.sg13g2_buf_1$1_35.A 0.03317f
C2949 a_33248_45238# VDD 0.17235f
C2950 sar_ctrl_async_phys_0.sg13g2_nor2_1$1_4.Y sar_ctrl_async_phys_0.sg13g2_buf_1$1_26.X 0.8903f
C2951 sar_ctrl_async_phys_0.sg13g2_dfrbpq_1$1_0.CLK a_31093_35935# 0.25967f
C2952 a_30746_31356# a_31189_31399# 0.02242f
C2953 sar_ctrl_async_phys_0.sg13g2_o21ai_1$1_1.B1 a_29653_38959# 0.04464f
C2954 a_26454_41972# VDD 0.22809f
C2955 sar_ctrl_async_phys_0.sg13g2_a21oi_1$1_3.A2 a_35595_40460# 0.09842f
C2956 sar_ctrl_async_phys_0.sg13g2_nor2_1$1_6.Y sar_ctrl_async_phys_0.sg13g2_nor2_1$1_8.B 0.06192f
C2957 sar_ctrl_async_phys_0.sg13g2_buf_1$1_6.X a_33183_32215# 0.13527f
C2958 sar_ctrl_async_phys_0.dac_code_n[4] oa_sar8_acore18_opt_0.sw_bitcell_opt_term_1.bot 0.06773f
C2959 sar_ctrl_async_phys_0.sg13g2_nand2_1$1_2.B a_36336_40546# 0.01804f
C2960 a_29755_38959# a_30752_39190# 0.03061f
C2961 a_29653_38959# a_30401_39309# 0.01058f
C2962 sar_ctrl_async_phys_0.sg13g2_dfrbpq_1$1_0.CLK a_33846_33338# 0.01389f
C2963 sar_ctrl_async_phys_0.sg13g2_a22oi_1$1_0.B1 sar_ctrl_async_phys_0.sg13g2_buf_1$1_6.X 2.55587f
C2964 oa_sar8_acore18_opt_0.sw_bitcell_opt_b5_1.bot oa_sar8_acore18_opt_0.sw_bitcell_opt_b7_1.bot 1.18965f
C2965 sar_ctrl_async_phys_0.sg13g2_o21ai_1$1_1.B1 VDD 9.46402f
C2966 sar_ctrl_async_phys_0.sg13g2_nor4_1$1_0.C sar_ctrl_async_phys_0.sg13g2_nand2b_1$1_4.A_N 0.02589f
C2967 a_34520_42760# VDD 0.23307f
C2968 sar_ctrl_async_phys_0.sg13g2_and2_1$1_0.A VDD 4.05646f
C2969 sar_ctrl_async_phys_0.dac_code_n[2] sar_ctrl_async_phys_0.dac_code[2] 0.06321f
C2970 a_27800_41342# a_27984_41342# 0.0524f
C2971 sar_ctrl_async_phys_0.sg13g2_a22oi_1$1_2.A2 a_31828_37440# 0.01802f
C2972 sar_ctrl_async_phys_0.sg13g2_and2_1$1_0.A a_25596_43448# 0.01177f
C2973 sar_ctrl_async_phys_0.sg13g2_dfrbpq_1$1_0.CLK sar_ctrl_async_phys_0.sg13g2_dlygate4sd3_1$1_5.A 0.02187f
C2974 sar_ctrl_async_phys_0.sg13g2_inv_1$1_2.Y a_33464_30664# 0.02194f
C2975 sar_ctrl_async_phys_0.sg13g2_buf_1$1_15.A sar_ctrl_async_phys_0.bit_active[7] 0.02688f
C2976 a_29941_40471# a_30043_40471# 0.47795f
C2977 a_33846_34850# a_34651_34423# 0.097f
C2978 a_34132_34416# a_34549_34423# 0.37583f
C2979 sar_ctrl_async_phys_0.dac_code[5] oa_sar8_acore18_opt_0.sw_bitcell_opt_b5_0.bot 1.97955f
C2980 sar_ctrl_async_phys_0.sg13g2_a22oi_1$1_0.B1 sar_ctrl_async_phys_0.sg13g2_a22oi_1$1_1.B2 0.14807f
C2981 sar_ctrl_async_phys_0.sg13g2_a21oi_1$1_2.B1 a_29498_40428# 0.03293f
C2982 sar_ctrl_async_phys_0.sg13g2_buf_1$1_29.X a_26160_45878# 0.01154f
C2983 sar_ctrl_async_phys_0.sg13g2_buf_1$1_10.A rst_n 0.01219f
C2984 sar_ctrl_async_phys_0.sg13g2_a22oi_1$1_2.B2 sar_ctrl_async_phys_0.sg13g2_a22oi_1$1_4.Y 0.18456f
C2985 a_31446_45434# a_31732_45000# 0.41329f
C2986 sar_ctrl_async_phys_0.sg13g2_nand2_1$1_5.B sar_ctrl_async_phys_0.sg13g2_buf_1$1_13.A 0.02047f
C2987 a_34636_31749# result[2] 0.01885f
C2988 sar_ctrl_async_phys_0.sg13g2_buf_1$1_3.A sar_ctrl_async_phys_0.dac_code[5] 0.6581f
C2989 sar_ctrl_async_phys_0.sg13g2_nor2_1$1_1.Y sar_ctrl_async_phys_0.sg13g2_a21oi_1$1_0.A1 0.0888f
C2990 sar_ctrl_async_phys_0.sg13g2_buf_1$1_3.A a_35672_38948# 0.02737f
C2991 sar_ctrl_async_phys_0.sg13g2_nor2_1$1_8.A a_29258_36642# 0.07536f
C2992 sar_ctrl_async_phys_0.sg13g2_nor2_1$1_3.B sar_ctrl_async_phys_0.sg13g2_and2_1$1_3.A 0.18471f
C2993 sar_ctrl_async_phys_0.sg13g2_inv_1$1_7.A sar_ctrl_async_phys_0.sg13g2_dlygate4sd3_1$1_0.X 0.01698f
C2994 sar_ctrl_async_phys_0.sg13g2_nor2b_1$1_1.Y VDD 0.5473f
C2995 sar_ctrl_async_phys_0.sg13g2_nor2_1$1_10.B sar_ctrl_async_phys_0.sg13g2_buf_1$1_1.A 0.09438f
C2996 sar_ctrl_async_phys_0.sg13g2_buf_1$1_4.A done 0.02552f
C2997 sar_ctrl_async_phys_0.dac_code_n[1] oa_sar8_acore18_opt_0.sw_bitcell_opt_b7_1.VSS 0.9753f
C2998 a_31261_38232# VDD 0.41012f
C2999 a_31935_39775# a_32602_39996# 0.0894f
C3000 sar_ctrl_async_phys_0.dac_code_n[5] oa_sar8_acore18_opt_0.sw_tg_opt_0.bot 0.79013f
C3001 oa_sar8_acore18_opt_0.sw_tg_opt_0.bot oa_sar8_acore18_opt_0.sw_bitcell_opt_term_0.gb 0.14616f
C3002 sar_ctrl_async_phys_0.sg13g2_nor2_1$1_4.Y sar_ctrl_async_phys_0.sg13g2_dlygate4sd3_1$1_9.A 0.04987f
C3003 sar_ctrl_async_phys_0.sg13g2_nor2_1$1_10.B sar_ctrl_async_phys_0.sg13g2_buf_1$1_7.A 0.01678f
C3004 sar_ctrl_async_phys_0.sg13g2_dlygate4sd3_1$1_6.X VDD 0.25849f
C3005 sar_ctrl_async_phys_0.sg13g2_and2_1$1_3.A a_25496_34412# 0.26471f
C3006 sar_ctrl_async_phys_0.sg13g2_nand2_1$1_5.B sar_ctrl_async_phys_0.sg13g2_nor2_1$1_2.Y 0.11847f
C3007 sar_ctrl_async_phys_0.sg13g2_nor2b_1$1_0.A sar_ctrl_async_phys_0.sg13g2_dfrbpq_1$1_5.D 0.13354f
C3008 sar_ctrl_async_phys_0.sg13g2_buf_1$1_21.A a_36056_38224# 0.25449f
C3009 result[4] result[5] 0.16465f
C3010 sar_ctrl_async_phys_0.sg13g2_inv_1$1_3.Y a_31823_32876# 0.02813f
C3011 sar_ctrl_async_phys_0.sg13g2_buf_1$1_15.A a_34896_40546# 0.01792f
C3012 sar_ctrl_async_phys_0.sg13g2_dfrbpq_1$1_0.CLK sar_ctrl_async_phys_0.sg13g2_nor2_1$1_1.Y 0.03525f
C3013 sar_ctrl_async_phys_0.sg13g2_buf_1$1_3.A a_35391_34773# 0.0323f
C3014 oa_sar8_acore18_opt_0.sw_bitcell_opt_term_1.bot oa_sar8_acore18_opt_0.sw_bitcell_opt_b6_1.bot 0.66133f
C3015 oa_sar8_acore18_opt_0.bstrap_opt_w2_c1200_1.out oa_sar8_acore18_opt_0.sw_bitcell_opt_b5_1.bot 4.17877f
C3016 sar_ctrl_async_phys_0.sg13g2_buf_1$1_32.A sar_ctrl_async_phys_0.sg13g2_buf_1$1_20.A 0.0299f
C3017 sar_ctrl_async_phys_0.sg13g2_inv_1$1_5.A sar_ctrl_async_phys_0.sg13g2_a22oi_1$1_2.Y 0.02991f
C3018 sar_ctrl_async_phys_0.sg13g2_dfrbpq_1$1_0.CLK a_31924_32456# 0.08885f
C3019 a_28680_40460# VDD 0.01187f
C3020 a_34132_34416# VDD 0.10832f
C3021 a_33914_44457# a_33654_44234# 0.75507f
C3022 sar_ctrl_async_phys_0.hold_req sar_ctrl_async_phys_0.dac_code[6] 0.12355f
C3023 sar_ctrl_async_phys_0.sg13g2_nor2_1$1_0.Y sar_ctrl_async_phys_0.sg13g2_buf_1$1_3.A 0.61389f
C3024 sar_ctrl_async_phys_0.sg13g2_o21ai_1$1_1.B1 sar_ctrl_async_phys_0.sg13g2_nor2b_1$1_3.Y 0.26215f
C3025 sar_ctrl_async_phys_0.sg13g2_a22oi_1$1_3.B1 VDD 0.71417f
C3026 a_29238_41972# VDD 0.22729f
C3027 sar_ctrl_async_phys_0.sg13g2_nor2_1$1_6.Y a_28506_37436# 0.01297f
C3028 a_32696_30664# VDD 0.29152f
C3029 sar_ctrl_async_phys_0.sg13g2_a21oi_1$1_6.A2 a_33072_42854# 0.01615f
C3030 sar_ctrl_async_phys_0.sg13g2_nand2b_1$1_5.A_N sar_ctrl_async_phys_0.sg13g2_nand2b_1$1_3.Y 0.78067f
C3031 sar_ctrl_async_phys_0.dac_code[1] VDD 4.13963f
C3032 sar_ctrl_async_phys_0.sg13g2_buf_1$1_8.A VDD 0.56921f
C3033 sar_ctrl_async_phys_0.sg13g2_buf_1$1_6.X a_31898_32361# 0.26843f
C3034 sar_ctrl_async_phys_0.sg13g2_a21oi_1$1_0.B1 sar_ctrl_async_phys_0.sg13g2_nand2b_1$1_4.A_N 0.69766f
C3035 sar_ctrl_async_phys_0.dac_code_n[1] sar_ctrl_async_phys_0.sg13g2_nand2b_1$1_3.Y 0.57188f
C3036 a_32715_43020# VDD 0.24211f
C3037 a_28950_39386# a_29755_38959# 0.097f
C3038 a_29236_38952# a_29653_38959# 0.37583f
C3039 a_31828_37440# a_32116_37861# 0.43707f
C3040 sar_ctrl_async_phys_0.dac_code[5] sar_ctrl_async_phys_0.dac_code[7] 0.26072f
C3041 sar_ctrl_async_phys_0.sg13g2_buf_1$1_5.A a_35288_33688# 0.25862f
C3042 a_36058_34412# sar_ctrl_async_phys_0.bit_active[1] 0.01328f
C3043 sar_ctrl_async_phys_0.sg13g2_buf_1$1_7.A result[4] 0.36154f
C3044 sar_ctrl_async_phys_0.sg13g2_dlygate4sd3_1$1_5.A sar_ctrl_async_phys_0.sg13g2_dlygate4sd3_1$1_9.A 0.08132f
C3045 sar_ctrl_async_phys_0.dac_code[4] oa_sar8_acore18_opt_0.sw_bitcell_opt_term_0.vin 1.88518f
C3046 sar_ctrl_async_phys_0.sg13g2_dfrbpq_1$1_0.CLK sar_ctrl_async_phys_0.sg13g2_inv_1$1_5.A 0.19135f
C3047 a_32192_36166# a_32602_35924# 0.10373f
C3048 sar_ctrl_async_phys_0.sg13g2_a21oi_1$1_2.B1 sar_ctrl_async_phys_0.sg13g2_nand2_1$1_2.B 0.01697f
C3049 a_29236_38952# VDD 0.07301f
C3050 sar_ctrl_async_phys_0.sg13g2_and2_1$1_0.X a_34904_38224# 0.01068f
C3051 sar_ctrl_async_phys_0.sg13g2_dfrbpq_1$1_0.CLK sar_ctrl_async_phys_0.sg13g2_nand2_1$1_3.A 1.02984f
C3052 sar_ctrl_async_phys_0.hold_req sar_ctrl_async_phys_0.dac_code[3] 0.11624f
C3053 sar_ctrl_async_phys_0.cmp_fire a_30632_22281# 0.85224f
C3054 sar_ctrl_async_phys_0.sg13g2_buf_1$1_20.A a_34132_43909# 0.01123f
C3055 sar_ctrl_async_phys_0.dac_code_n[2] oa_sar8_acore18_opt_0.sw_bitcell_opt_b3_0.bot 0.0829f
C3056 sar_ctrl_async_phys_0.sg13g2_buf_1$1_41.X sar_ctrl_async_phys_0.sg13g2_nand2b_1$1_5.A_N 0.15459f
C3057 sar_ctrl_async_phys_0.sg13g2_nor4_1$1_0.C sar_ctrl_async_phys_0.sg13g2_nor2_1$1_0.Y 0.01507f
C3058 sar_ctrl_async_phys_0.dac_code[1] oa_sar8_acore18_opt_0.sw_bitcell_opt_b6_0.bot 1.17468f
C3059 w_39600_n9960# sar_ctrl_async_phys_0.dac_code[1] 0.04601f
C3060 sar_ctrl_async_phys_0.sg13g2_buf_1$1_20.A sar_ctrl_async_phys_0.sg13g2_buf_1$1_15.A 3.10982f
C3061 sar_ctrl_async_phys_0.dac_code[5] oa_sar8_acore18_opt_0.sw_bitcell_opt_b1_0.bot 0.15267f
C3062 sar_ctrl_async_phys_0.dac_code_n[5] sar_ctrl_async_phys_0.dac_code_n[3] 0.19661f
C3063 sar_ctrl_async_phys_0.sg13g2_buf_1$1_2.A sar_ctrl_async_phys_0.sg13g2_a22oi_1$1_0.A2 0.01768f
C3064 sar_ctrl_async_phys_0.dac_code_n[3] oa_sar8_acore18_opt_0.sw_bitcell_opt_term_0.gb 0.06524f
C3065 sar_ctrl_async_phys_0.dac_code_n[4] sar_ctrl_async_phys_0.dac_code_n[1] 0.13991f
C3066 sar_ctrl_async_phys_0.sg13g2_a21oi_1$1_6.B1 sar_ctrl_async_phys_0.sg13g2_buf_1$1_36.A 0.38134f
C3067 sar_ctrl_async_phys_0.cmp_fire sar_ctrl_async_phys_0.sg13g2_dlygate4sd3_1$1_7.A 0.26989f
C3068 sar_ctrl_async_phys_0.sg13g2_dlygate4sd3_1$1_6.X a_27032_39034# 0.01182f
C3069 sar_ctrl_async_phys_0.sg13g2_buf_1$1_10.A a_32443_32260# 0.02479f
C3070 sar_ctrl_async_phys_0.sg13g2_buf_1$1_19.A a_33375_40821# 0.01743f
C3071 a_36248_44366# VDD 0.12775f
C3072 a_30676_40016# a_31935_39775# 0.01529f
C3073 sar_ctrl_async_phys_0.sg13g2_a22oi_1$1_0.A2 sar_ctrl_async_phys_0.sg13g2_nor2b_1$1_2.Y 0.61711f
C3074 sar_ctrl_async_phys_0.bit_active[0] sar_ctrl_async_phys_0.bit_active[3] 0.01368f
C3075 sar_ctrl_async_phys_0.sg13g2_a22oi_1$1_2.Y a_30848_32358# 0.02843f
C3076 sar_ctrl_async_phys_0.sg13g2_nor2_1$1_18.A a_31195_39820# 0.02876f
C3077 sar_ctrl_async_phys_0.sg13g2_and2_1$1_6.X sar_ctrl_async_phys_0.sg13g2_dfrbpq_1$1_11.D 0.35627f
C3078 sar_ctrl_async_phys_0.sg13g2_inv_1$1_5.A sar_ctrl_async_phys_0.sg13g2_inv_1$1_5.Y 0.14595f
C3079 oa_sar8_acore18_opt_0.sw_bitcell_opt_term_0.gb m3_48572_n2380# 1.52466f
C3080 oa_sar8_acore18_opt_0.bstrap_opt_w2_c1200_1.out vinp 0.70055f
C3081 sar_ctrl_async_phys_0.sg13g2_nor2_1$1_10.B a_30783_40821# 0.01056f
C3082 w_16692_n9960# VDD 1.20674f
C3083 sar_ctrl_async_phys_0.sg13g2_nor2_1$1_10.B sar_ctrl_async_phys_0.sg13g2_a21oi_1$1_2.B1 0.02347f
C3084 sar_ctrl_async_phys_0.sg13g2_a21oi_1$1_2.Y a_29808_39830# 0.02363f
C3085 sar_ctrl_async_phys_0.cmp_n sar_ctrl_async_phys_0.cmp_p 5.78145f
C3086 sar_ctrl_async_phys_0.sg13g2_a21oi_1$1_3.B1 a_34765_42242# 0.10357f
C3087 sar_ctrl_async_phys_0.sg13g2_a21oi_1$1_1.B1 sar_ctrl_async_phys_0.dac_code_n[7] 0.03147f
C3088 sar_ctrl_async_phys_0.dac_code_n[5] vcm 0.06598f
C3089 sar_ctrl_async_phys_0.sg13g2_buf_1$1_36.A sar_ctrl_async_phys_0.sg13g2_nand2b_1$1_1.B 0.81364f
C3090 sar_ctrl_async_phys_0.sg13g2_nand2_1$1_3.A a_35245_45936# 0.03312f
C3091 sar_ctrl_async_phys_0.sg13g2_buf_1$1_13.A sar_ctrl_async_phys_0.sg13g2_buf_1$1_19.A 0.12208f
C3092 sar_ctrl_async_phys_0.sg13g2_buf_1$1_13.A sar_ctrl_async_phys_0.bit_active[6] 0.10366f
C3093 sar_ctrl_async_phys_0.sg13g2_dfrbpq_1$1_0.CLK sar_ctrl_async_phys_0.sg13g2_buf_1$1_5.A 0.12587f
C3094 sar_ctrl_async_phys_0.sg13g2_buf_1$1_41.X sar_ctrl_async_phys_0.sg13g2_buf_1$1_32.A 0.1268f
C3095 sar_ctrl_async_phys_0.sg13g2_dfrbpq_1$1_0.CLK a_30848_32358# 0.01719f
C3096 sar_ctrl_async_phys_0.sg13g2_nand2b_1$1_3.Y a_33652_41528# 0.02054f
C3097 a_29238_40898# VDD 0.77764f
C3098 sar_ctrl_async_phys_0.sg13g2_buf_1$1_13.A sar_ctrl_async_phys_0.sg13g2_and2_1$1_0.X 2.50253f
C3099 sar_ctrl_async_phys_0.sg13g2_nand2b_1$1_1.B a_35360_43726# 0.05709f
C3100 sar_ctrl_async_phys_0.sg13g2_a22oi_1$1_1.A2 a_34132_34416# 0.01901f
C3101 sar_ctrl_async_phys_0.sg13g2_a21oi_1$1_2.Y a_30676_35928# 0.03264f
C3102 sar_ctrl_async_phys_0.sg13g2_buf_1$1_6.X a_31328_33870# 0.11651f
C3103 sar_ctrl_async_phys_0.dac_code[2] oa_sar8_acore18_opt_0.sw_tg_opt_0.bot 0.89256f
C3104 a_26558_40727# VDD 0.18854f
C3105 sar_ctrl_async_phys_0.dac_code_n[1] sar_ctrl_async_phys_0.dac_code[0] 0.08211f
C3106 sar_ctrl_async_phys_0.bit_active[3] sar_ctrl_async_phys_0.bit_active[4] 0.12989f
C3107 sar_ctrl_async_phys_0.sg13g2_a21oi_1$1_6.B1 a_33658_44996# 0.01041f
C3108 sar_ctrl_async_phys_0.sg13g2_a21oi_1$1_5.A2 a_32400_41413# 0.13014f
C3109 sar_ctrl_async_phys_0.sg13g2_a22oi_1$1_0.A1 a_32687_33292# 0.01735f
C3110 sar_ctrl_async_phys_0.sg13g2_o21ai_1$1_1.B1 a_34815_39775# 0.13308f
C3111 sar_ctrl_async_phys_0.sg13g2_nor2_1$1_2.Y sar_ctrl_async_phys_0.sg13g2_buf_1$1_19.A 0.01742f
C3112 sar_ctrl_async_phys_0.sg13g2_o21ai_1$1_1.B1 sar_ctrl_async_phys_0.sg13g2_buf_1$1_20.A 0.02f
C3113 a_31802_37404# a_32245_37447# 0.02242f
C3114 sar_ctrl_async_phys_0.sg13g2_buf_1$1_2.A sar_ctrl_async_phys_0.sg13g2_buf_1$1_3.A 0.02145f
C3115 sar_ctrl_async_phys_0.sg13g2_a22oi_1$1_0.B2 a_34895_32460# 0.06671f
C3116 sar_ctrl_async_phys_0.sg13g2_dlygate4sd3_1$1_5.A sar_ctrl_async_phys_0.sg13g2_nand2b_1$1_0.A_N 0.01982f
C3117 sar_ctrl_async_phys_0.sg13g2_and2_1$1_0.A sar_ctrl_async_phys_0.sg13g2_buf_1$1_20.A 0.02031f
C3118 sar_ctrl_async_phys_0.sg13g2_nand2b_1$1_3.Y sar_ctrl_async_phys_0.sg13g2_buf_1$1_15.A 1.31433f
C3119 sar_ctrl_async_phys_0.sg13g2_o21ai_1$1_1.B1 sar_ctrl_async_phys_0.sg13g2_nor2b_1$1_0.A 0.28198f
C3120 sar_ctrl_async_phys_0.sg13g2_nor2_1$1_2.Y sar_ctrl_async_phys_0.sg13g2_and2_1$1_0.X 0.0403f
C3121 sar_ctrl_async_phys_0.sg13g2_and2_1$1_0.A sar_ctrl_async_phys_0.sg13g2_nor2b_1$1_0.A 0.741f
C3122 VDD result[3] 0.15815f
C3123 a_30676_35928# a_31195_35935# 0.34102f
C3124 a_31093_35935# a_30964_36349# 0.01562f
C3125 sar_ctrl_async_phys_0.sg13g2_dfrbpq_1$1_0.CLK a_31716_38912# 0.02327f
C3126 sar_ctrl_async_phys_0.sg13g2_dlygate4sd3_1$1_9.X sar_ctrl_async_phys_0.sg13g2_and2_1$1_3.X 0.13469f
C3127 sar_ctrl_async_phys_0.dac_code_n[2] oa_sar8_acore18_opt_0.sw_bitcell_opt_term_0.bot 0.35018f
C3128 a_26666_38912# VDD 0.32474f
C3129 sar_ctrl_async_phys_0.dac_code[1] oa_sar8_acore18_opt_0.sw_bitcell_opt_b2_0.bot 0.52609f
C3130 sar_ctrl_async_phys_0.sg13g2_buf_1$1_2.A sar_ctrl_async_phys_0.sg13g2_a22oi_1$1_0.A1 0.52523f
C3131 a_32480_46750# VDD 0.17328f
C3132 sar_ctrl_async_phys_0.dac_code_n[4] a_36056_46508# 0.02428f
C3133 sar_ctrl_async_phys_0.sg13g2_inv_1$1_1.Y a_33846_33338# 0.273f
C3134 a_36056_38224# VDD 0.21706f
C3135 sar_ctrl_async_phys_0.sg13g2_a22oi_1$1_4.A2 a_33375_40821# 0.02895f
C3136 sar_ctrl_async_phys_0.sg13g2_nor4_1$1_0.Y sar_ctrl_async_phys_0.sg13g2_nor2_1$1_14.A 0.03339f
C3137 sar_ctrl_async_phys_0.sg13g2_buf_1$1_41.X sar_ctrl_async_phys_0.sg13g2_buf_1$1_15.A 0.07144f
C3138 sar_ctrl_async_phys_0.sg13g2_nand2b_1$1_1.B a_35245_45266# 0.29735f
C3139 sar_ctrl_async_phys_0.sg13g2_nor2b_1$1_2.Y sar_ctrl_async_phys_0.sg13g2_a22oi_1$1_0.A1 0.67353f
C3140 sar_ctrl_async_phys_0.sg13g2_inv_1$1_3.Y a_31638_32138# 0.3239f
C3141 a_25496_34412# sar_ctrl_async_phys_0.cmp_n 0.26679f
C3142 a_33658_35460# VDD 0.38713f
C3143 sar_ctrl_async_phys_0.sg13g2_nor2b_1$1_0.A sar_ctrl_async_phys_0.sg13g2_nor2b_1$1_1.Y 0.20667f
C3144 sar_ctrl_async_phys_0.sg13g2_nor4_1$1_0.C sar_ctrl_async_phys_0.sg13g2_buf_1$1_2.A 0.55906f
C3145 sar_ctrl_async_phys_0.sg13g2_dlygate4sd3_1$1_6.A a_26673_40726# 0.01669f
C3146 a_35199_44311# VDD 0.17431f
C3147 sar_ctrl_async_phys_0.sg13g2_dfrbpq_1$1_0.CLK sar_ctrl_async_phys_0.sg13g2_nand2_1$1_1.B 0.24757f
C3148 sar_ctrl_async_phys_0.sg13g2_buf_1$1_15.A sar_ctrl_async_phys_0.sg13g2_and2_1$1_1.B 0.01087f
C3149 a_33846_33338# a_34106_32868# 0.75507f
C3150 a_36056_33688# VDD 0.21753f
C3151 sar_ctrl_async_phys_0.dac_code_n[2] m3_38288_n2380# 0.04834f
C3152 sar_ctrl_async_phys_0.dac_code_n[5] a_20412_n9612# 1.21641f
C3153 sar_ctrl_async_phys_0.sg13g2_buf_1$1_17.A VDD 0.8222f
C3154 a_34767_31359# a_35557_31435# 0.02242f
C3155 sar_ctrl_async_phys_0.sg13g2_buf_1$1_0.A VDD 1.02617f
C3156 sar_ctrl_async_phys_0.sg13g2_a22oi_1$1_2.A2 sar_ctrl_async_phys_0.sg13g2_and2_1$1_0.X 0.01483f
C3157 sar_ctrl_async_phys_0.sg13g2_nand2_1$1_5.Y a_34171_41332# 0.01037f
C3158 sar_ctrl_async_phys_0.dac_code_n[2] oa_sar8_acore18_opt_0.bstrap_opt_w2_c1200_1.gb 0.12464f
C3159 sar_ctrl_async_phys_0.dac_code_n[1] oa_sar8_acore18_opt_0.sw_bitcell_opt_term_1.bot 0.06659f
C3160 sar_ctrl_async_phys_0.sg13g2_a21oi_1$1_6.B1 sar_ctrl_async_phys_0.dac_code_n[2] 0.07801f
C3161 sar_ctrl_async_phys_0.sg13g2_a22oi_1$1_4.Y sar_ctrl_async_phys_0.sg13g2_buf_1$1_10.A 0.30664f
C3162 sar_ctrl_async_phys_0.dac_code[6] oa_sar8_acore18_opt_0.sw_bitcell_opt_term_0.VSS 1.42606f
C3163 sar_ctrl_async_phys_0.sg13g2_buf_1$1_13.A sar_ctrl_async_phys_0.sg13g2_a22oi_1$1_4.A2 2.48807f
C3164 sar_ctrl_async_phys_0.sg13g2_inv_1$1_6.A a_30480_32986# 0.01975f
C3165 sar_ctrl_async_phys_0.sg13g2_and2_1$1_3.X a_26352_38318# 0.0171f
C3166 sar_ctrl_async_phys_0.sg13g2_buf_1$1_41.X a_31060_44552# 0.40828f
C3167 sar_ctrl_async_phys_0.sg13g2_dfrbpq_1$1_0.CLK a_29812_33968# 0.0785f
C3168 sar_ctrl_async_phys_0.dac_code_n[3] sar_ctrl_async_phys_0.dac_code[2] 1.94379f
C3169 sar_ctrl_async_phys_0.sg13g2_nand3_1$1_0.Y sar_ctrl_async_phys_0.sg13g2_dlygate4sd3_1$1_11.X 0.02462f
C3170 sar_ctrl_async_phys_0.sg13g2_nand2b_1$1_3.Y sar_ctrl_async_phys_0.sg13g2_o21ai_1$1_1.B1 0.04686f
C3171 sar_ctrl_async_phys_0.dac_code_n[2] oa_sar8_acore18_opt_0.sw_bitcell_opt_b1_1.bot 0.12058f
C3172 sar_ctrl_async_phys_0.sg13g2_nand2b_1$1_3.Y sar_ctrl_async_phys_0.sg13g2_and2_1$1_0.A 0.03719f
C3173 sar_ctrl_async_phys_0.sg13g2_dfrbpq_1$1_0.CLK a_32149_45007# 0.27139f
C3174 sar_ctrl_async_phys_0.sg13g2_buf_1$1_37.A sar_ctrl_async_phys_0.sg13g2_buf_1$1_15.A 0.01476f
C3175 sar_ctrl_async_phys_0.sg13g2_nor2b_1$1_0.A sar_ctrl_async_phys_0.sg13g2_a22oi_1$1_3.B1 0.17416f
C3176 sar_ctrl_async_phys_0.sg13g2_buf_1$1_41.X a_33248_45238# 0.10395f
C3177 a_36056_46508# sar_ctrl_async_phys_0.dac_code[0] 0.2552f
C3178 sar_ctrl_async_phys_0.sg13g2_nor2_1$1_2.Y sar_ctrl_async_phys_0.sg13g2_a22oi_1$1_4.A2 3.35224f
C3179 sar_ctrl_async_phys_0.sg13g2_buf_1$1_20.A sar_ctrl_async_phys_0.dac_code[1] 0.03243f
C3180 sar_ctrl_async_phys_0.sg13g2_nor2b_1$1_1.Y sar_ctrl_async_phys_0.sg13g2_nor2b_1$1_1.B_N 0.11708f
C3181 sar_ctrl_async_phys_0.sg13g2_nor4_1$1_0.Y sar_ctrl_async_phys_0.sg13g2_and2_1$1_3.X 0.01197f
C3182 sar_ctrl_async_phys_0.sg13g2_a21oi_1$1_6.B1 a_31732_45000# 0.04729f
C3183 sar_ctrl_async_phys_0.sg13g2_nor2_1$1_15.Y VDD 0.35304f
C3184 sar_ctrl_async_phys_0.sg13g2_and2_1$1_6.X VDD 0.92658f
C3185 sar_ctrl_async_phys_0.sg13g2_buf_1$1_3.A a_36336_39830# 0.01532f
C3186 oa_sar8_acore18_opt_0.sw_tg_opt_0.bot oa_sar8_acore18_opt_0.sw_bitcell_opt_b3_0.bot 3.25813f
C3187 sar_ctrl_async_phys_0.dac_code[3] oa_sar8_acore18_opt_0.sw_bitcell_opt_term_0.VSS 1.12902f
C3188 a_34520_46508# sar_ctrl_async_phys_0.sg13g2_a21oi_1$1_3.B1 0.01409f
C3189 sar_ctrl_async_phys_0.sg13g2_buf_1$1_41.X sar_ctrl_async_phys_0.sg13g2_o21ai_1$1_1.B1 0.04649f
C3190 a_26289_42912# VDD 0.22208f
C3191 sar_ctrl_async_phys_0.sg13g2_dlygate4sd3_1$1_9.X a_26454_39702# 0.02299f
C3192 sar_ctrl_async_phys_0.sg13g2_buf_1$1_41.X sar_ctrl_async_phys_0.sg13g2_and2_1$1_0.A 0.01253f
C3193 a_30390_36362# a_30650_35892# 0.75507f
C3194 sar_ctrl_async_phys_0.sg13g2_buf_1$1_3.A a_35288_38224# 0.25258f
C3195 sar_ctrl_async_phys_0.sg13g2_a21oi_1$1_4.B1 sar_ctrl_async_phys_0.sg13g2_nor2_1$1_0.Y 0.02332f
C3196 sar_ctrl_async_phys_0.sg13g2_a21oi_1$1_0.A1 sar_ctrl_async_phys_0.sg13g2_a22oi_1$1_0.A2 0.76159f
C3197 sar_ctrl_async_phys_0.sg13g2_a22oi_1$1_0.B1 a_30390_36362# 0.27598f
C3198 a_32480_46750# a_32223_46869# 0.34468f
C3199 sar_ctrl_async_phys_0.sg13g2_buf_1$1_7.A a_31247_32876# 0.08804f
C3200 a_29306_32361# a_29332_32456# 0.36952f
C3201 a_31933_43832# VDD 0.38759f
C3202 oa_sar8_acore18_opt_0.sw_bitcell_opt_term_0.trkb m3_54868_n2380# 0.03859f
C3203 a_36056_38224# sar_ctrl_async_phys_0.bit_active[7] 0.0972f
C3204 sar_ctrl_async_phys_0.sg13g2_inv_1$1_2.Y a_33080_31388# 0.04483f
C3205 a_30879_43845# VDD 0.17446f
C3206 a_35288_38224# sar_ctrl_async_phys_0.sg13g2_a22oi_1$1_0.A1 0.0902f
C3207 m3_41836_n2380# VDD 0.02576f
C3208 sar_ctrl_async_phys_0.sg13g2_nor2_1$1_7.A a_29701_36874# 0.18054f
C3209 sar_ctrl_async_phys_0.sg13g2_buf_1$1_3.A a_35288_33688# 0.01284f
C3210 sar_ctrl_async_phys_0.sg13g2_nor2_1$1_0.Y a_31830_40898# 0.03436f
C3211 sar_ctrl_async_phys_0.sg13g2_a21oi_1$1_0.B1 sar_ctrl_async_phys_0.sg13g2_buf_1$1_2.A 0.1656f
C3212 sar_ctrl_async_phys_0.sg13g2_buf_1$1_2.A a_33940_44552# 0.01021f
C3213 sar_ctrl_async_phys_0.sg13g2_dfrbpq_1$1_0.CLK sar_ctrl_async_phys_0.sg13g2_a22oi_1$1_0.A2 0.36846f
C3214 sar_ctrl_async_phys_0.sg13g2_nand2b_1$1_1.B a_34765_42242# 0.26074f
C3215 sar_ctrl_async_phys_0.sg13g2_buf_1$1_3.A sar_ctrl_async_phys_0.sg13g2_nand2_1$1_2.Y 0.44034f
C3216 sar_ctrl_async_phys_0.sg13g2_nor2b_1$1_3.Y a_34554_40460# 0.01371f
C3217 sar_ctrl_async_phys_0.sg13g2_buf_1$1_42.A a_34520_46508# 0.05041f
C3218 sar_ctrl_async_phys_0.sg13g2_buf_1$1_3.A a_35053_40730# 0.27387f
C3219 a_32149_35141# VDD 0.26117f
C3220 sar_ctrl_async_phys_0.sg13g2_buf_1$1_2.A a_34136_33688# 0.02193f
C3221 sar_ctrl_async_phys_0.sg13g2_a22oi_1$1_2.A2 sar_ctrl_async_phys_0.sg13g2_a22oi_1$1_4.A2 0.16619f
C3222 sar_ctrl_async_phys_0.sg13g2_buf_1$1_6.X VDD 10.5898f
C3223 sar_ctrl_async_phys_0.sg13g2_a21oi_1$1_3.B1 sar_ctrl_async_phys_0.sg13g2_nand2_1$1_2.B 0.20146f
C3224 sar_ctrl_async_phys_0.sg13g2_nor2_1$1_13.A sar_ctrl_async_phys_0.sg13g2_nor2_1$1_14.A 0.10115f
C3225 a_32149_35141# a_32897_35239# 0.01058f
C3226 sar_ctrl_async_phys_0.sg13g2_a22oi_1$1_4.Y a_32687_32876# 0.16258f
C3227 sar_ctrl_async_phys_0.sg13g2_o21ai_1$1_1.B1 sar_ctrl_async_phys_0.sg13g2_buf_1$1_37.A 0.71802f
C3228 a_35552_36166# VDD 0.16971f
C3229 a_34636_31749# a_35557_31435# 0.36952f
C3230 sar_ctrl_async_phys_0.sg13g2_a21oi_1$1_0.A1 a_29524_40464# 0.01612f
C3231 a_35648_34654# busy 0.04908f
C3232 a_30584_44366# VDD 0.16507f
C3233 sar_ctrl_async_phys_0.sg13g2_a22oi_1$1_1.A2 sar_ctrl_async_phys_0.sg13g2_buf_1$1_17.A 0.17799f
C3234 sar_ctrl_async_phys_0.sg13g2_dlygate4sd3_1$1_0.X sar_ctrl_async_phys_0.sg13g2_dlygate4sd3_1$1_0.A 0.01467f
C3235 sar_ctrl_async_phys_0.sample oa_sar8_acore18_opt_0.bstrap_opt_w2_c1200_1.gb 18.5935f
C3236 sar_ctrl_async_phys_0.sg13g2_a22oi_1$1_0.A2 sar_ctrl_async_phys_0.sg13g2_a21oi_1$1_0.A2 0.09657f
C3237 a_34911_41287# a_34817_41287# 0.28931f
C3238 a_35962_35924# sar_ctrl_async_phys_0.bit_active[3] 0.02752f
C3239 sar_ctrl_async_phys_0.sg13g2_nor2b_1$1_1.Y a_33754_37436# 0.01929f
C3240 a_35199_44311# a_35456_44454# 0.34468f
C3241 a_33940_44552# a_35105_44311# 0.43239f
C3242 a_34459_44356# a_34228_44247# 0.12701f
C3243 sar_ctrl_async_phys_0.sg13g2_nand2_1$1_3.Y a_35672_42760# 0.25619f
C3244 sar_ctrl_async_phys_0.sg13g2_buf_1$1_17.A a_34424_35200# 0.26673f
C3245 sar_ctrl_async_phys_0.sg13g2_a21oi_1$1_2.Y a_30507_35204# 0.14301f
C3246 sar_ctrl_async_phys_0.sg13g2_nand2b_1$1_3.Y sar_ctrl_async_phys_0.dac_code[1] 0.02348f
C3247 a_27134_39887# sar_ctrl_async_phys_0.sg13g2_dlygate4sd3_1$1_6.X 0.15631f
C3248 sar_ctrl_async_phys_0.sg13g2_nand3_1$1_0.Y a_25896_39706# 0.01478f
C3249 sar_ctrl_async_phys_0.sg13g2_nor2_1$1_14.A a_27304_38928# 0.01075f
C3250 sar_ctrl_async_phys_0.sg13g2_buf_1$1_26.X a_25496_31388# 0.25068f
C3251 sar_ctrl_async_phys_0.sg13g2_nor4_1$1_0.C a_34520_47296# 0.26143f
C3252 sar_ctrl_async_phys_0.sg13g2_a22oi_1$1_1.B2 VDD 0.60751f
C3253 sar_ctrl_async_phys_0.sg13g2_dfrbpq_1$1_11.D a_31935_39775# 0.02895f
C3254 sar_ctrl_async_phys_0.sample oa_sar8_acore18_opt_0.sw_bitcell_opt_b1_1.bot 1.6206f
C3255 sar_ctrl_async_phys_0.sg13g2_nand2_1$1_3.B a_36248_44366# 0.0243f
C3256 sar_ctrl_async_phys_0.sg13g2_nor2b_1$1_3.Y sar_ctrl_async_phys_0.sg13g2_nor2_1$1_15.Y 0.1758f
C3257 sar_ctrl_async_phys_0.sg13g2_dfrbpq_1$1_0.CLK a_29524_40464# 0.08795f
C3258 a_33818_36897# VDD 0.12235f
C3259 sar_ctrl_async_phys_0.sg13g2_a21oi_1$1_3.A2 sar_ctrl_async_phys_0.sg13g2_nand2_1$1_2.Y 0.23771f
C3260 sar_ctrl_async_phys_0.dac_code_n[3] oa_sar8_acore18_opt_0.sw_bitcell_opt_b3_0.bot 0.43391f
C3261 sar_ctrl_async_phys_0.sg13g2_a21oi_1$1_0.A1 sar_ctrl_async_phys_0.sg13g2_buf_1$1_3.A 0.54132f
C3262 sar_ctrl_async_phys_0.dac_code[4] sar_ctrl_async_phys_0.dac_code[5] 3.88527f
C3263 sar_ctrl_async_phys_0.sg13g2_nor2_1$1_5.A sar_ctrl_async_phys_0.sg13g2_nand2_1$1_1.B 0.09778f
C3264 sar_ctrl_async_phys_0.sg13g2_and2_1$1_6.X sar_ctrl_async_phys_0.sg13g2_buf_1$1_14.A 0.09865f
C3265 a_32031_31749# VDD 0.1722f
C3266 sar_ctrl_async_phys_0.sg13g2_a21oi_1$1_1.B1 sar_ctrl_async_phys_0.sg13g2_nand2_1$1_3.A 0.30908f
C3267 sar_ctrl_async_phys_0.dac_code_n[1] sar_ctrl_async_phys_0.sg13g2_nand2b_1$1_5.A_N 0.03571f
C3268 sar_ctrl_async_phys_0.sg13g2_a22oi_1$1_0.A1 sar_ctrl_async_phys_0.sg13g2_a22oi_1$1_2.Y 0.37958f
C3269 sar_ctrl_async_phys_0.sg13g2_a22oi_1$1_0.B1 sar_ctrl_async_phys_0.sg13g2_buf_1$1_1.A 0.05401f
C3270 oa_sar8_acore18_opt_0.sw_tg_opt_0.bot oa_sar8_acore18_opt_0.sw_bitcell_opt_term_0.bot 0.70818f
C3271 sar_ctrl_async_phys_0.sg13g2_o21ai_1$1_1.B1 a_32192_39918# 0.10407f
C3272 sar_ctrl_async_phys_0.dac_code_n[4] sar_ctrl_async_phys_0.dac_code[1] 0.06321f
C3273 sar_ctrl_async_phys_0.sg13g2_a22oi_1$1_0.B1 sar_ctrl_async_phys_0.sg13g2_buf_1$1_7.A 0.1547f
C3274 sar_ctrl_async_phys_0.sg13g2_a21oi_1$1_0.A1 sar_ctrl_async_phys_0.sg13g2_a22oi_1$1_0.A1 0.85464f
C3275 sar_ctrl_async_phys_0.sg13g2_nor2_1$1_7.A sar_ctrl_async_phys_0.sg13g2_nor2_1$1_8.A 0.04572f
C3276 a_31924_32456# a_32443_32260# 0.34114f
C3277 oa_sar8_acore18_opt_0.sw_bitcell_opt_b3_0.bot m3_48572_n2380# 1.64099f
C3278 sar_ctrl_async_phys_0.sg13g2_dfrbpq_1$1_0.CLK sar_ctrl_async_phys_0.sg13g2_buf_1$1_3.A 0.11713f
C3279 sar_ctrl_async_phys_0.sg13g2_nor2_1$1_18.A a_31716_38912# 0.2573f
C3280 a_33464_30664# result[0] 0.09521f
C3281 sar_ctrl_async_phys_0.sg13g2_a22oi_1$1_0.B2 a_36058_30924# 0.12508f
C3282 a_34815_39775# a_34721_39775# 0.28931f
C3283 sar_ctrl_async_phys_0.sg13g2_a22oi_1$1_0.Y a_34132_32904# 0.01475f
C3284 a_30938_46476# VDD 0.09895f
C3285 sar_ctrl_async_phys_0.sg13g2_nor4_1$1_0.C sar_ctrl_async_phys_0.sg13g2_a21oi_1$1_0.A1 0.02316f
C3286 sar_ctrl_async_phys_0.sg13g2_dfrbpq_1$1_0.CLK sar_ctrl_async_phys_0.sg13g2_a22oi_1$1_0.A1 0.40909f
C3287 oa_sar8_acore18_opt_0.sw_bitcell_opt_term_0.trkb a_35028_n9612# 0.70727f
C3288 sar_ctrl_async_phys_0.sg13g2_a21oi_1$1_4.B1 sar_ctrl_async_phys_0.sg13g2_buf_1$1_2.A 0.03495f
C3289 sar_ctrl_async_phys_0.sg13g2_nor2_1$1_8.B a_28026_36972# 0.01358f
C3290 a_29594_43452# VDD 0.09683f
C3291 sar_ctrl_async_phys_0.sg13g2_dlygate4sd3_1$1_3.A a_28760_42058# 0.03706f
C3292 sar_ctrl_async_phys_0.sg13g2_nand2b_1$1_0.Y sar_ctrl_async_phys_0.sg13g2_nor2_1$1_11.Y 0.01073f
C3293 sar_ctrl_async_phys_0.sg13g2_buf_1$1_3.A sar_ctrl_async_phys_0.sg13g2_a21oi_1$1_0.A2 0.82995f
C3294 sar_ctrl_async_phys_0.sg13g2_a21oi_1$1_0.A1 sar_ctrl_async_phys_0.sg13g2_a21oi_1$1_3.A2 0.9002f
C3295 sar_ctrl_async_phys_0.sg13g2_a21oi_1$1_4.B1 sar_ctrl_async_phys_0.sg13g2_a21oi_1$1_6.A2 0.04473f
C3296 sar_ctrl_async_phys_0.sg13g2_nand2_1$1_5.Y a_34765_42242# 0.02233f
C3297 m3_54868_n2380# m3_57896_n2380# 0.0157f
C3298 sar_ctrl_async_phys_0.cmp_fault VDD 0.34961f
C3299 w_16692_n9960# oa_sar8_acore18_opt_0.sw_bitcell_opt_b2_1.bot 0.05461f
C3300 sar_ctrl_async_phys_0.sg13g2_a22oi_1$1_0.B2 result[1] 0.94709f
C3301 sar_ctrl_async_phys_0.dac_code[6] VDD 5.59215f
C3302 a_26566_39766# VDD 0.18743f
C3303 sar_ctrl_async_phys_0.sg13g2_nand2b_1$1_5.A_N sar_ctrl_async_phys_0.sg13g2_buf_1$1_32.A 0.01287f
C3304 sar_ctrl_async_phys_0.sg13g2_buf_1$1_37.A sar_ctrl_async_phys_0.dac_code[1] 0.58737f
C3305 sar_ctrl_async_phys_0.sg13g2_buf_1$1_3.A a_32116_40464# 0.01507f
C3306 a_25990_40484# a_25878_40460# 0.55452f
C3307 sar_ctrl_async_phys_0.sg13g2_a22oi_1$1_4.A2 a_33168_32986# 0.03112f
C3308 VDD vinn 0.2997f
C3309 sar_ctrl_async_phys_0.sg13g2_buf_1$1_37.A a_32715_43020# 0.03169f
C3310 sar_ctrl_async_phys_0.sg13g2_nand2_1$1_2.Y a_35482_39996# 0.05063f
C3311 sar_ctrl_async_phys_0.sg13g2_a22oi_1$1_1.A2 sar_ctrl_async_phys_0.sg13g2_buf_1$1_6.X 0.02649f
C3312 a_33087_37797# VDD 0.18341f
C3313 sar_ctrl_async_phys_0.sg13g2_a21oi_1$1_0.A1 sar_ctrl_async_phys_0.dac_code[7] 0.01201f
C3314 sar_ctrl_async_phys_0.sg13g2_nor4_1$1_0.C sar_ctrl_async_phys_0.sg13g2_dfrbpq_1$1_0.CLK 0.32761f
C3315 sar_ctrl_async_phys_0.sg13g2_a21oi_1$1_1.B1 a_35725_45266# 0.28766f
C3316 sar_ctrl_async_phys_0.sg13g2_nor2b_1$1_0.A sar_ctrl_async_phys_0.sg13g2_buf_1$1_17.A 0.03289f
C3317 a_35391_34773# done 0.014f
C3318 sar_ctrl_async_phys_0.sg13g2_buf_1$1_4.A sar_ctrl_async_phys_0.bit_active[0] 0.02572f
C3319 sar_ctrl_async_phys_0.sg13g2_buf_1$1_35.A sar_ctrl_async_phys_0.dac_code[1] 0.01817f
C3320 a_34010_35892# VDD 0.12455f
C3321 a_34055_31352# a_34526_31826# 0.28931f
C3322 sar_ctrl_async_phys_0.hold_req sar_ctrl_async_phys_0.dac_code_n[5] 0.05239f
C3323 sar_ctrl_async_phys_0.dac_code[0] sar_ctrl_async_phys_0.dac_code[1] 5.73305f
C3324 sar_ctrl_async_phys_0.sg13g2_a21oi_1$1_0.A2 a_35280_35365# 0.27844f
C3325 a_34171_41332# a_35168_41430# 0.02979f
C3326 a_33366_41210# a_33940_41223# 0.31978f
C3327 sar_ctrl_async_phys_0.hold_req oa_sar8_acore18_opt_0.sw_bitcell_opt_term_0.gb 0.05514f
C3328 w_16692_n9960# sar_ctrl_async_phys_0.dac_code_n[4] 0.02244f
C3329 sar_ctrl_async_phys_0.sg13g2_nand2b_1$1_2.A_N VDD 0.63646f
C3330 a_34357_44213# a_34459_44356# 0.47622f
C3331 sar_ctrl_async_phys_0.sg13g2_nor2_1$1_4.Y sar_ctrl_async_phys_0.sg13g2_and2_1$1_3.A 0.2622f
C3332 sar_ctrl_async_phys_0.sg13g2_buf_1$1_17.A a_32251_35284# 0.01243f
C3333 sar_ctrl_async_phys_0.dac_code_n[2] oa_sar8_acore18_opt_0.sw_bitcell_opt_term_0.vin 0.11612f
C3334 sar_ctrl_async_phys_0.sg13g2_buf_1$1_42.A a_34904_47296# 0.26856f
C3335 sar_ctrl_async_phys_0.sample oa_sar8_acore18_opt_0.sw_bitcell_opt_b5_1.bot 1.83229f
C3336 sar_ctrl_async_phys_0.dac_code[6] oa_sar8_acore18_opt_0.sw_bitcell_opt_b6_0.bot 2.63211f
C3337 sar_ctrl_async_phys_0.sg13g2_dfrbpq_1$1_9.D VDD 0.35733f
C3338 w_39600_n9960# sar_ctrl_async_phys_0.dac_code[6] 0.02212f
C3339 sar_ctrl_async_phys_0.sg13g2_buf_1$1_13.A sar_ctrl_async_phys_0.sg13g2_a22oi_1$1_3.A2 0.6091f
C3340 a_32986_44532# a_33368_44366# 0.01012f
C3341 sar_ctrl_async_phys_0.sg13g2_dlygate4sd3_1$1_3.A VDD 0.49238f
C3342 a_34651_32911# VDD 0.20979f
C3343 w_39600_n9960# vinn 0.01233f
C3344 sar_ctrl_async_phys_0.sg13g2_a22oi_1$1_0.A1 a_33359_32876# 0.01401f
C3345 a_36156_45710# VDD 0.2202f
C3346 a_32319_44311# a_32225_44311# 0.28931f
C3347 sar_ctrl_async_phys_0.dac_code[3] VDD 4.56444f
C3348 sar_ctrl_async_phys_0.sg13g2_nand2_1$1_3.B a_35199_44311# 0.04708f
C3349 sar_ctrl_async_phys_0.dac_code_n[3] oa_sar8_acore18_opt_0.sw_bitcell_opt_term_0.bot 0.11466f
C3350 a_35962_35924# a_36336_36010# 0.01061f
C3351 sar_ctrl_async_phys_0.dac_code[7] m3_34580_n2380# 0.04394f
C3352 sar_ctrl_async_phys_0.sg13g2_a22oi_1$1_1.A2 sar_ctrl_async_phys_0.sg13g2_a22oi_1$1_1.B2 0.65098f
C3353 sar_ctrl_async_phys_0.sg13g2_nor2_1$1_10.B sar_ctrl_async_phys_0.sg13g2_a21oi_1$1_5.Y 0.08637f
C3354 a_33211_45868# VDD 0.22955f
C3355 a_26289_42912# a_26570_42690# 0.26306f
C3356 sar_ctrl_async_phys_0.sg13g2_nor4_1$1_0.C a_32116_40464# 0.01673f
C3357 a_35672_42760# VDD 0.26763f
C3358 a_34731_37436# VDD 0.2372f
C3359 a_33752_33688# result[4] 0.24549f
C3360 sar_ctrl_async_phys_0.dac_code_n[6] oa_sar8_acore18_opt_0.sw_bitcell_opt_term_0.trkb 2.0677f
C3361 sar_ctrl_async_phys_0.sg13g2_nor2b_1$1_1.B_N a_33658_35460# 0.01051f
C3362 a_30746_31356# VDD 0.09738f
C3363 sar_ctrl_async_phys_0.sg13g2_buf_1$1_37.A a_36248_44366# 0.01794f
C3364 a_33632_40702# a_33375_40821# 0.34468f
C3365 sar_ctrl_async_phys_0.sg13g2_nor2_1$1_2.Y sar_ctrl_async_phys_0.sg13g2_a22oi_1$1_3.A2 0.24574f
C3366 sar_ctrl_async_phys_0.sg13g2_buf_1$1_7.A a_31898_32361# 0.01646f
C3367 a_35103_43845# a_35009_43845# 0.28931f
C3368 sar_ctrl_async_phys_0.sg13g2_nor2b_1$1_0.A sar_ctrl_async_phys_0.sg13g2_and2_1$1_6.X 0.46552f
C3369 sar_ctrl_async_phys_0.sg13g2_buf_1$1_4.A sar_ctrl_async_phys_0.bit_active[4] 0.019f
C3370 sar_ctrl_async_phys_0.sg13g2_o21ai_1$1_1.B1 a_30390_39698# 0.10404f
C3371 sar_ctrl_async_phys_0.sg13g2_nand2b_1$1_1.B a_35866_44532# 0.01043f
C3372 sar_ctrl_async_phys_0.dac_code_n[6] sar_ctrl_async_phys_0.cmp_n 0.0675f
C3373 sar_ctrl_async_phys_0.sg13g2_nor2_1$1_4.Y a_26673_40726# 0.0235f
C3374 sar_ctrl_async_phys_0.sg13g2_and2_1$1_0.A a_30390_39698# 0.01436f
C3375 sar_ctrl_async_phys_0.sg13g2_a22oi_1$1_2.A2 sar_ctrl_async_phys_0.sg13g2_a22oi_1$1_2.B2 0.15773f
C3376 oa_sar8_acore18_opt_0.sw_bitcell_opt_b1_0.bot m3_34580_n2380# 0.01682f
C3377 sar_ctrl_async_phys_0.dac_code[3] oa_sar8_acore18_opt_0.sw_bitcell_opt_b6_0.bot 1.17374f
C3378 w_39600_n9960# sar_ctrl_async_phys_0.dac_code[3] 0.04487f
C3379 sar_ctrl_async_phys_0.sg13g2_a21oi_1$1_5.A2 a_32602_39996# 0.11536f
C3380 sar_ctrl_async_phys_0.sg13g2_a22oi_1$1_0.B2 a_33846_30626# 0.02377f
C3381 a_33270_39698# a_33844_39711# 0.31978f
C3382 sar_ctrl_async_phys_0.sg13g2_and2_1$1_0.B a_31162_38948# 0.12315f
C3383 sar_ctrl_async_phys_0.sg13g2_a22oi_1$1_4.A2 a_31828_37440# 0.04066f
C3384 a_31381_46519# a_31483_46519# 0.47795f
C3385 sar_ctrl_async_phys_0.sg13g2_a21oi_1$1_0.B1 sar_ctrl_async_phys_0.sg13g2_a21oi_1$1_0.A1 0.06241f
C3386 a_31933_43832# sar_ctrl_async_phys_0.sg13g2_buf_1$1_20.A 0.10586f
C3387 a_31935_39775# VDD 0.17715f
C3388 sar_ctrl_async_phys_0.dac_code_n[6] oa_sar8_acore18_opt_0.sw_bitcell_opt_b4_0.bot 0.32658f
C3389 sar_ctrl_async_phys_0.dac_code_n[3] oa_sar8_acore18_opt_0.bstrap_opt_w2_c1200_1.gb 0.12632f
C3390 sar_ctrl_async_phys_0.sg13g2_buf_1$1_41.X a_32480_46750# 0.09868f
C3391 sar_ctrl_async_phys_0.sg13g2_a21oi_1$1_6.B1 sar_ctrl_async_phys_0.dac_code_n[3] 0.13719f
C3392 a_31933_43832# sar_ctrl_async_phys_0.sg13g2_nor2b_1$1_0.A 0.01568f
C3393 sar_ctrl_async_phys_0.dac_code_n[0] oa_sar8_acore18_opt_0.sw_bitcell_opt_term_0.trkb 2.06857f
C3394 a_30879_43845# a_31546_43484# 0.0894f
C3395 sar_ctrl_async_phys_0.sg13g2_buf_1$1_14.A sar_ctrl_async_phys_0.dac_code[6] 0.11225f
C3396 a_27530_39666# VDD 0.34608f
C3397 m3_41836_n2380# m3_45264_n2380# 0.0157f
C3398 sar_ctrl_async_phys_0.dac_code_n[0] sar_ctrl_async_phys_0.cmp_n 0.06905f
C3399 sar_ctrl_async_phys_0.dac_code[6] sar_ctrl_async_phys_0.bit_active[7] 0.01293f
C3400 result[7] busy 0.01194f
C3401 sar_ctrl_async_phys_0.dac_code_n[3] oa_sar8_acore18_opt_0.sw_bitcell_opt_b1_1.bot 0.06598f
C3402 sar_ctrl_async_phys_0.sg13g2_buf_1$1_36.A sar_ctrl_async_phys_0.sg13g2_nand2b_1$1_4.A_N 1.09439f
C3403 sar_ctrl_async_phys_0.sg13g2_a21oi_1$1_0.B1 sar_ctrl_async_phys_0.sg13g2_dfrbpq_1$1_0.CLK 0.08086f
C3404 sar_ctrl_async_phys_0.sg13g2_dfrbpq_1$1_0.CLK a_33940_44552# 0.07604f
C3405 sar_ctrl_async_phys_0.sg13g2_buf_1$1_14.A a_34010_35892# 0.02119f
C3406 sar_ctrl_async_phys_0.sg13g2_buf_1$1_32.A a_34132_43909# 0.01217f
C3407 sar_ctrl_async_phys_0.sg13g2_buf_1$1_41.X a_35199_44311# 0.13295f
C3408 sar_ctrl_async_phys_0.sg13g2_inv_1$1_0.Y VDD 0.29719f
C3409 sar_ctrl_async_phys_0.sg13g2_o21ai_1$1_1.B1 sar_ctrl_async_phys_0.sg13g2_nor2_1$1_13.B 0.04278f
C3410 sar_ctrl_async_phys_0.sg13g2_buf_1$1_32.A sar_ctrl_async_phys_0.sg13g2_buf_1$1_15.A 0.03016f
C3411 a_32149_35141# a_32251_35284# 0.47622f
C3412 a_32192_36166# VDD 0.17023f
C3413 sar_ctrl_async_phys_0.sg13g2_buf_1$1_6.X a_32251_35284# 0.42048f
C3414 a_33936_31675# a_34055_31352# 0.0894f
C3415 sar_ctrl_async_phys_0.sg13g2_buf_1$1_2.A a_34224_42058# 0.024f
C3416 sar_ctrl_async_phys_0.sg13g2_nor2_1$1_10.Y a_30879_43845# 0.01312f
C3417 sar_ctrl_async_phys_0.sg13g2_dfrbpq_1$1_0.CLK a_32635_40471# 0.01851f
C3418 sar_ctrl_async_phys_0.sg13g2_a22oi_1$1_0.A2 a_35384_32176# 0.03467f
C3419 sar_ctrl_async_phys_0.dac_code_n[0] oa_sar8_acore18_opt_0.sw_bitcell_opt_b4_0.bot 0.08701f
C3420 a_34136_47296# a_33944_47390# 0.01226f
C3421 sar_ctrl_async_phys_0.sg13g2_a21oi_1$1_0.B1 a_35288_47296# 0.25851f
C3422 a_33366_41210# a_34069_41189# 0.02454f
C3423 sar_ctrl_async_phys_0.dac_code_n[7] oa_sar8_acore18_opt_0.sw_bitcell_opt_term_0.trkb 2.23075f
C3424 a_30632_22281# VDD 0.75713f
C3425 sar_ctrl_async_phys_0.dac_code_n[3] sar_ctrl_async_phys_0.sg13g2_nand2b_1$1_1.B 0.04635f
C3426 sar_ctrl_async_phys_0.dac_code[6] oa_sar8_acore18_opt_0.sw_bitcell_opt_b2_0.bot 0.18621f
C3427 a_33276_42686# sar_ctrl_async_phys_0.sg13g2_buf_1$1_13.A 0.26959f
C3428 a_30507_35204# a_30733_35460# 0.02726f
C3429 sar_ctrl_async_phys_0.sg13g2_buf_1$1_4.A sar_ctrl_async_phys_0.bit_active[1] 0.11969f
C3430 sar_ctrl_async_phys_0.sg13g2_nand2b_1$1_3.Y sar_ctrl_async_phys_0.sg13g2_and2_1$1_6.X 0.01557f
C3431 sar_ctrl_async_phys_0.sg13g2_a21oi_1$1_5.Y a_31640_41342# 0.01132f
C3432 a_30296_42854# a_30480_42854# 0.0524f
C3433 sar_ctrl_async_phys_0.sg13g2_a21oi_1$1_0.A1 a_31563_43020# 0.03359f
C3434 sar_ctrl_async_phys_0.dac_code_n[7] sar_ctrl_async_phys_0.cmp_n 0.06815f
C3435 sar_ctrl_async_phys_0.sg13g2_a21oi_1$1_0.A1 a_31947_41508# 0.04457f
C3436 sar_ctrl_async_phys_0.sg13g2_a21oi_1$1_0.A2 a_35201_36285# 0.01968f
C3437 a_34549_32911# VDD 0.24969f
C3438 a_30774_44234# a_31348_44247# 0.31978f
C3439 a_31579_44356# a_32576_44454# 0.02979f
C3440 sar_ctrl_async_phys_0.sg13g2_a22oi_1$1_1.A2 a_34651_32911# 0.011f
C3441 a_35552_36166# a_35295_36285# 0.34468f
C3442 sar_ctrl_async_phys_0.sg13g2_dlygate4sd3_1$1_7.A VDD 0.37757f
C3443 sar_ctrl_async_phys_0.sg13g2_a22oi_1$1_1.Y sar_ctrl_async_phys_0.sg13g2_buf_1$1_0.A 0.06218f
C3444 sar_ctrl_async_phys_0.sg13g2_buf_1$1_15.A a_33652_41528# 0.03545f
C3445 a_30584_44366# sar_ctrl_async_phys_0.sg13g2_nor2_1$1_10.Y 0.03136f
C3446 sar_ctrl_async_phys_0.sg13g2_nor2_1$1_2.Y a_33276_42686# 0.03136f
C3447 sar_ctrl_async_phys_0.sg13g2_inv_1$1_2.Y a_33183_32215# 0.02706f
C3448 sar_ctrl_async_phys_0.sg13g2_nand2_1$1_3.A a_33844_43488# 0.0172f
C3449 sar_ctrl_async_phys_0.sg13g2_a22oi_1$1_1.A2 a_34731_37436# 0.17827f
C3450 w_16692_n9960# oa_sar8_acore18_opt_0.sw_bitcell_opt_term_1.bot 0.17968f
C3451 sar_ctrl_async_phys_0.dac_code_n[7] oa_sar8_acore18_opt_0.sw_bitcell_opt_b4_0.bot 0.155f
C3452 sar_ctrl_async_phys_0.sg13g2_buf_1$1_42.A a_35000_45878# 0.02362f
C3453 sar_ctrl_async_phys_0.sg13g2_a22oi_1$1_0.B1 sar_ctrl_async_phys_0.sg13g2_inv_1$1_2.Y 0.01613f
C3454 a_32533_40471# a_32404_40885# 0.01562f
C3455 a_32116_40464# a_32635_40471# 0.34102f
C3456 sar_ctrl_async_phys_0.sg13g2_nor4_1$1_0.C sar_ctrl_async_phys_0.sg13g2_nor2_1$1_5.A 0.20449f
C3457 a_33844_43488# a_35103_43845# 0.01529f
C3458 sar_ctrl_async_phys_0.dac_code[3] oa_sar8_acore18_opt_0.sw_bitcell_opt_b2_0.bot 0.1569f
C3459 sar_ctrl_async_phys_0.hold_req sar_ctrl_async_phys_0.dac_code[2] 0.11497f
C3460 sar_ctrl_async_phys_0.sg13g2_buf_1$1_42.A sar_ctrl_async_phys_0.cmp_valid 0.07943f
C3461 sar_ctrl_async_phys_0.sg13g2_nor2_1$1_10.A sar_ctrl_async_phys_0.sg13g2_a21oi_1$1_0.A1 0.01349f
C3462 sar_ctrl_async_phys_0.sg13g2_and2_1$1_0.A sar_ctrl_async_phys_0.sg13g2_dfrbpq_1$1_5.D 0.10791f
C3463 sar_ctrl_async_phys_0.sg13g2_a21oi_1$1_1.B1 sar_ctrl_async_phys_0.sg13g2_a22oi_1$1_0.A2 0.45881f
C3464 sar_ctrl_async_phys_0.sg13g2_nand2_1$1_5.Y sar_ctrl_async_phys_0.sg13g2_nand2_1$1_2.B 0.06628f
C3465 sar_ctrl_async_phys_0.sg13g2_nor2_1$1_2.Y a_33556_40016# 0.04412f
C3466 sar_ctrl_async_phys_0.sg13g2_a21oi_1$1_4.B1 sar_ctrl_async_phys_0.sg13g2_a21oi_1$1_0.A1 0.78221f
C3467 a_33270_39698# a_34075_39820# 0.097f
C3468 a_33556_40016# a_33973_39677# 0.3749f
C3469 sar_ctrl_async_phys_0.sg13g2_inv_1$1_0.A sar_ctrl_async_phys_0.sg13g2_a22oi_1$1_0.B2 0.0204f
C3470 sar_ctrl_async_phys_0.sg13g2_and2_1$1_0.A sar_ctrl_async_phys_0.sg13g2_nand3_1$1_0.C 0.19269f
C3471 sar_ctrl_async_phys_0.dac_code_n[6] oa_sar8_acore18_opt_0.sw_bitcell_opt_b0_0.bot 0.08014f
C3472 sar_ctrl_async_phys_0.sg13g2_buf_1$1_32.A a_34520_42760# 0.26353f
C3473 a_34363_36796# a_35103_36751# 0.26905f
C3474 sar_ctrl_async_phys_0.sg13g2_nor4_1$1_0.C sar_ctrl_async_phys_0.sg13g2_nand2b_1$1_0.A_N 0.16635f
C3475 a_29144_39830# VDD 0.12794f
C3476 sar_ctrl_async_phys_0.sg13g2_buf_1$1_41.X a_31933_43832# 0.0126f
C3477 sar_ctrl_async_phys_0.sg13g2_nor2b_1$1_4.Y a_30576_46594# 0.03037f
C3478 sar_ctrl_async_phys_0.sg13g2_buf_1$1_41.X a_30879_43845# 0.17545f
C3479 sar_ctrl_async_phys_0.sg13g2_dfrbpq_1$1_0.CLK sar_ctrl_async_phys_0.sg13g2_nor2_1$1_10.A 0.61089f
C3480 a_29620_43488# a_30879_43845# 0.01529f
C3481 sar_ctrl_async_phys_0.sg13g2_a21oi_1$1_2.B1 a_34069_41189# 0.01775f
C3482 sar_ctrl_async_phys_0.sg13g2_nor2_1$1_10.A a_30139_43495# 0.01161f
C3483 sar_ctrl_async_phys_0.sg13g2_buf_1$1_20.A sar_ctrl_async_phys_0.dac_code[6] 0.02644f
C3484 sar_ctrl_async_phys_0.sg13g2_inv_1$1_5.A a_29332_32456# 0.04001f
C3485 a_35028_n9612# a_35948_n9612# 0.23797f
C3486 sar_ctrl_async_phys_0.sg13g2_a21oi_1$1_4.B1 sar_ctrl_async_phys_0.sg13g2_dfrbpq_1$1_0.CLK 0.02057f
C3487 sar_ctrl_async_phys_0.dac_code_n[5] oa_sar8_acore18_opt_0.sw_bitcell_opt_term_0.VSS 0.01411f
C3488 sar_ctrl_async_phys_0.sg13g2_a21oi_1$1_4.B1 sar_ctrl_async_phys_0.sg13g2_nor2b_1$1_4.Y 0.07947f
C3489 oa_sar8_acore18_opt_0.sw_tg_opt_0.bot oa_sar8_acore18_opt_0.sw_bitcell_opt_term_0.vin 0.20174f
C3490 oa_sar8_acore18_opt_0.sw_bitcell_opt_term_0.VSS oa_sar8_acore18_opt_0.sw_bitcell_opt_term_0.gb 0.0224f
C3491 oa_sar8_acore18_opt_0.bstrap_opt_w2_c1200_1.gb a_20412_n9612# 3.45782f
C3492 sar_ctrl_async_phys_0.sg13g2_a22oi_1$1_0.A1 sar_ctrl_async_phys_0.sg13g2_inv_1$1_1.Y 0.02556f
C3493 a_36058_30924# result[1] 0.01388f
C3494 sar_ctrl_async_phys_0.sg13g2_nor2_1$1_3.B a_26728_37416# 0.01075f
C3495 sar_ctrl_async_phys_0.dac_code_n[0] oa_sar8_acore18_opt_0.sw_bitcell_opt_b0_0.bot 0.40215f
C3496 sar_ctrl_async_phys_0.sg13g2_a21oi_1$1_6.B1 a_35672_47296# 0.2768f
C3497 a_30390_36362# VDD 0.78634f
C3498 sar_ctrl_async_phys_0.sg13g2_o21ai_1$1_1.B1 a_33652_41528# 0.39342f
C3499 sar_ctrl_async_phys_0.sg13g2_nor4_1$1_0.C a_28651_39740# 0.0114f
C3500 a_30772_31392# a_31937_31749# 0.43239f
C3501 a_32031_31749# a_32698_31388# 0.0894f
C3502 a_27504_36010# VDD 0.08336f
C3503 sar_ctrl_async_phys_0.sg13g2_nor2b_1$1_0.A a_30689_40821# 0.01608f
C3504 sar_ctrl_async_phys_0.sg13g2_nand3_1$1_0.C sar_ctrl_async_phys_0.sg13g2_dlygate4sd3_1$1_6.X 0.18639f
C3505 sar_ctrl_async_phys_0.sg13g2_and2_1$1_3.X sar_ctrl_async_phys_0.sg13g2_dlygate4sd3_1$1_11.X 0.03116f
C3506 sar_ctrl_async_phys_0.sg13g2_buf_1$1_19.A sar_ctrl_async_phys_0.sg13g2_and2_1$1_0.X 0.01069f
C3507 oa_sar8_acore18_opt_0.sw_bitcell_opt_b1_1.bot a_20412_n9612# 0.08205f
C3508 sar_ctrl_async_phys_0.dac_code_n[1] sar_ctrl_async_phys_0.dac_code[1] 0.05494f
C3509 sar_ctrl_async_phys_0.sg13g2_and2_1$1_0.X sar_ctrl_async_phys_0.bit_active[6] 0.69324f
C3510 sar_ctrl_async_phys_0.sg13g2_buf_1$1_4.A a_35962_35924# 0.05381f
C3511 sar_ctrl_async_phys_0.sg13g2_buf_1$1_6.X sar_ctrl_async_phys_0.sg13g2_a22oi_1$1_1.Y 0.02603f
C3512 sar_ctrl_async_phys_0.sg13g2_buf_1$1_20.A sar_ctrl_async_phys_0.dac_code[3] 0.2595f
C3513 sar_ctrl_async_phys_0.sg13g2_a22oi_1$1_0.A1 a_34106_32868# 0.01068f
C3514 a_30774_44234# a_31477_44213# 0.02454f
C3515 sar_ctrl_async_phys_0.sg13g2_o21ai_1$1_1.B1 sar_ctrl_async_phys_0.sg13g2_buf_1$1_15.A 0.0159f
C3516 sar_ctrl_async_phys_0.dac_code_n[6] oa_sar8_acore18_opt_0.sw_bitcell_opt_b0_1.bot 0.06598f
C3517 a_34453_35935# a_34555_35935# 0.47795f
C3518 a_35578_41508# VDD 0.38131f
C3519 sar_ctrl_async_phys_0.dac_code[3] m3_45264_n2380# 0.05703f
C3520 sar_ctrl_async_phys_0.sg13g2_a21oi_1$1_2.B1 sar_ctrl_async_phys_0.sg13g2_buf_1$1_21.A 0.10627f
C3521 sar_ctrl_async_phys_0.sg13g2_a21oi_1$1_1.B1 sar_ctrl_async_phys_0.sg13g2_buf_1$1_3.A 0.11864f
C3522 sar_ctrl_async_phys_0.dac_code_n[7] oa_sar8_acore18_opt_0.sw_bitcell_opt_b0_0.bot 0.0722f
C3523 sar_ctrl_async_phys_0.sg13g2_buf_1$1_1.A a_34549_34423# 0.03782f
C3524 a_30229_33629# a_30100_33663# 0.01562f
C3525 sar_ctrl_async_phys_0.sg13g2_buf_1$1_6.X a_35648_33142# 0.1084f
C3526 sar_ctrl_async_phys_0.sg13g2_buf_1$1_4.A a_35103_36751# 0.02664f
C3527 sar_ctrl_async_phys_0.sg13g2_and2_1$1_6.X a_32192_39918# 0.03342f
C3528 a_25496_42854# VDD 0.12976f
C3529 a_31830_40898# a_32116_40464# 0.41329f
C3530 sar_ctrl_async_phys_0.dac_code[0] m3_41836_n2380# 0.05621f
C3531 VDD result[5] 0.16993f
C3532 sar_ctrl_async_phys_0.sg13g2_a22oi_1$1_1.Y sar_ctrl_async_phys_0.sg13g2_a22oi_1$1_1.B2 0.58933f
C3533 sar_ctrl_async_phys_0.sg13g2_a21oi_1$1_6.B1 sar_ctrl_async_phys_0.cmp_valid 0.02936f
C3534 sar_ctrl_async_phys_0.dac_code_n[6] a_35948_n9612# 0.05089f
C3535 sar_ctrl_async_phys_0.sg13g2_buf_1$1_0.A a_30671_32876# 0.08501f
C3536 a_33558_43922# a_33844_43488# 0.41329f
C3537 sar_ctrl_async_phys_0.sg13g2_a21oi_1$1_2.B1 sar_ctrl_async_phys_0.sg13g2_dfrbpq_1$1_11.D 0.0625f
C3538 a_32251_45007# a_32991_45357# 0.26905f
C3539 sar_ctrl_async_phys_0.sg13g2_buf_1$1_6.X a_30772_31392# 0.43513f
C3540 sar_ctrl_async_phys_0.sg13g2_nor2_1$1_10.B sar_ctrl_async_phys_0.sg13g2_a21oi_1$1_2.Y 0.25729f
C3541 sar_ctrl_async_phys_0.sg13g2_nor2_1$1_0.Y a_31579_44356# 0.01399f
C3542 sar_ctrl_async_phys_0.dac_code_n[0] oa_sar8_acore18_opt_0.sw_bitcell_opt_b0_1.bot 1.30615f
C3543 sar_ctrl_async_phys_0.hold_req oa_sar8_acore18_opt_0.sw_bitcell_opt_b3_0.bot 0.10376f
C3544 a_35288_33688# done 0.2475f
C3545 sar_ctrl_async_phys_0.sg13g2_nor4_1$1_0.C sar_ctrl_async_phys_0.sg13g2_a21oi_1$1_1.B1 0.01963f
C3546 a_30938_46476# a_30964_46512# 0.36952f
C3547 a_26566_41996# sar_ctrl_async_phys_0.sg13g2_dlygate4sd3_1$1_8.X 0.15635f
C3548 sar_ctrl_async_phys_0.sg13g2_a22oi_1$1_3.A2 a_31828_37440# 0.01039f
C3549 a_33558_36674# a_33844_36992# 0.41329f
C3550 sar_ctrl_async_phys_0.sg13g2_o21ai_1$1_1.B1 a_31450_40460# 0.01038f
C3551 sar_ctrl_async_phys_0.dac_code_n[3] oa_sar8_acore18_opt_0.sw_bitcell_opt_term_0.vin 0.05835f
C3552 w_16692_n9960# sar_ctrl_async_phys_0.dac_code_n[1] 0.02265f
C3553 a_35245_45936# a_35327_45750# 0.01117f
C3554 sar_ctrl_async_phys_0.sg13g2_buf_1$1_41.X a_30938_46476# 0.26754f
C3555 sar_ctrl_async_phys_0.sg13g2_a21oi_1$1_1.B1 sar_ctrl_async_phys_0.sg13g2_a21oi_1$1_3.A2 0.03962f
C3556 sar_ctrl_async_phys_0.sg13g2_and2_1$1_0.A a_31450_40460# 0.04644f
C3557 sar_ctrl_async_phys_0.sg13g2_nor2_1$1_10.B sar_ctrl_async_phys_0.sg13g2_inv_1$1_7.A 0.0405f
C3558 sar_ctrl_async_phys_0.sg13g2_buf_1$1_41.X a_29594_43452# 0.26195f
C3559 a_29594_43452# a_29620_43488# 0.36952f
C3560 sar_ctrl_async_phys_0.sg13g2_buf_1$1_2.A result[2] 0.0468f
C3561 sar_ctrl_async_phys_0.sg13g2_dfrbpq_1$1_0.CLK sar_ctrl_async_phys_0.sg13g2_nor2_1$1_6.Y 0.09473f
C3562 a_33914_44457# VDD 0.12219f
C3563 sar_ctrl_async_phys_0.sg13g2_nor2_1$1_10.A a_29334_43922# 0.29787f
C3564 sar_ctrl_async_phys_0.sg13g2_buf_1$1_19.A sar_ctrl_async_phys_0.sg13g2_nand2b_1$1_1.Y 0.02366f
C3565 sar_ctrl_async_phys_0.sg13g2_buf_1$1_1.A VDD 0.6424f
C3566 a_36336_40546# VDD 0.07168f
C3567 sar_ctrl_async_phys_0.dac_code_n[0] a_35948_n9612# 0.0551f
C3568 a_34208_45966# a_34618_46044# 0.10373f
C3569 a_32986_44532# VDD 0.38215f
C3570 sar_ctrl_async_phys_0.sg13g2_a22oi_1$1_2.Y a_31823_32876# 0.17399f
C3571 sar_ctrl_async_phys_0.sg13g2_buf_1$1_7.A VDD 0.81601f
C3572 sar_ctrl_async_phys_0.dac_code_n[2] sar_ctrl_async_phys_0.dac_code[5] 0.06321f
C3573 sar_ctrl_async_phys_0.dac_code_n[4] sar_ctrl_async_phys_0.dac_code[6] 0.20098f
C3574 a_33846_30626# result[1] 0.0515f
C3575 sar_ctrl_async_phys_0.sg13g2_a21oi_1$1_4.B1 a_36056_47296# 0.26788f
C3576 sar_ctrl_async_phys_0.sg13g2_buf_1$1_19.A sar_ctrl_async_phys_0.sg13g2_a22oi_1$1_4.A2 0.48457f
C3577 sar_ctrl_async_phys_0.dac_code_n[7] oa_sar8_acore18_opt_0.sw_bitcell_opt_b0_1.bot 0.15253f
C3578 oa_sar8_acore18_opt_0.sw_bitcell_opt_term_0.vin m3_48572_n2380# 0.05057f
C3579 sar_ctrl_async_phys_0.sg13g2_a22oi_1$1_4.A2 sar_ctrl_async_phys_0.sg13g2_and2_1$1_0.X 0.17815f
C3580 sar_ctrl_async_phys_0.sg13g2_and2_1$1_0.A sar_ctrl_async_phys_0.sg13g2_o21ai_1$1_1.B1 0.06933f
C3581 oa_sar8_acore18_opt_0.sw_tg_opt_1.bot oa_sar8_acore18_opt_0.sw_bitcell_opt_term_0.trkb 2.17679f
C3582 a_30772_31392# a_32031_31749# 0.01529f
C3583 sar_ctrl_async_phys_0.cmp_n oa_sar8_acore18_opt_0.sw_tg_opt_1.bot 0.15381f
C3584 sar_ctrl_async_phys_0.sg13g2_buf_1$1_15.A sar_ctrl_async_phys_0.dac_code[1] 0.03558f
C3585 a_33087_37797# a_33754_37436# 0.0894f
C3586 sar_ctrl_async_phys_0.dac_code_n[7] a_35948_n9612# 0.04308f
C3587 sar_ctrl_async_phys_0.sg13g2_buf_1$1_41.X sar_ctrl_async_phys_0.sg13g2_dfrbpq_1$1_9.D 0.22283f
C3588 sar_ctrl_async_phys_0.dac_code_n[6] oa_sar8_acore18_opt_0.sw_bitcell_opt_b4_1.bot 0.06598f
C3589 a_34010_35892# a_34036_35928# 0.36952f
C3590 a_33366_41210# VDD 0.823f
C3591 sar_ctrl_async_phys_0.dac_code_n[4] sar_ctrl_async_phys_0.dac_code[3] 0.06321f
C3592 sar_ctrl_async_phys_0.sg13g2_a22oi_1$1_2.B2 a_32341_32117# 0.0474f
C3593 sar_ctrl_async_phys_0.sg13g2_buf_1$1_41.X a_33211_45868# 0.03014f
C3594 sar_ctrl_async_phys_0.dac_code[2] oa_sar8_acore18_opt_0.sw_bitcell_opt_term_0.VSS 1.06103f
C3595 a_35672_46508# VDD 0.26693f
C3596 a_26550_41214# a_26662_41278# 0.55452f
C3597 a_29812_33968# a_30331_33772# 0.34114f
C3598 sar_ctrl_async_phys_0.sg13g2_and2_1$1_0.A a_31261_38232# 0.14162f
C3599 sar_ctrl_async_phys_0.sg13g2_a21oi_1$1_5.Y a_30676_40016# 0.02355f
C3600 sar_ctrl_async_phys_0.sg13g2_nand2_1$1_1.Y sar_ctrl_async_phys_0.sg13g2_nor2_1$1_6.B 0.46908f
C3601 sar_ctrl_async_phys_0.sg13g2_dfrbpq_1$1_0.CLK done 0.07223f
C3602 sar_ctrl_async_phys_0.sg13g2_a21oi_1$1_5.Y sar_ctrl_async_phys_0.sg13g2_and2_1$1_0.B 0.01167f
C3603 sar_ctrl_async_phys_0.sg13g2_a22oi_1$1_1.A2 result[5] 0.01534f
C3604 a_34132_34416# a_35297_34773# 0.43239f
C3605 sar_ctrl_async_phys_0.sg13g2_and2_1$1_0.A sar_ctrl_async_phys_0.sg13g2_dlygate4sd3_1$1_6.X 0.17844f
C3606 a_31732_45000# a_32020_45421# 0.43707f
C3607 a_34765_42242# a_34847_42342# 0.01117f
C3608 sar_ctrl_async_phys_0.dac_code[0] sar_ctrl_async_phys_0.dac_code[6] 0.14172f
C3609 sar_ctrl_async_phys_0.sg13g2_nor4_1$1_0.Y a_28130_40838# 0.02895f
C3610 sar_ctrl_async_phys_0.hold_req oa_sar8_acore18_opt_0.sw_bitcell_opt_term_0.bot 6.49491f
C3611 sar_ctrl_async_phys_0.sg13g2_buf_1$1_37.A sar_ctrl_async_phys_0.sg13g2_nand2b_1$1_2.A_N 0.12006f
C3612 sar_ctrl_async_phys_0.sg13g2_buf_1$1_13.A a_31802_37404# 0.02685f
C3613 sar_ctrl_async_phys_0.sg13g2_a21oi_1$1_0.B1 sar_ctrl_async_phys_0.sg13g2_a21oi_1$1_1.B1 0.23639f
C3614 sar_ctrl_async_phys_0.dac_code_n[5] VDD 5.24435f
C3615 sar_ctrl_async_phys_0.sg13g2_nor2_1$1_8.B a_28368_36877# 0.02459f
C3616 a_34651_32911# a_35648_33142# 0.03061f
C3617 sar_ctrl_async_phys_0.sg13g2_dfrbpq_1$1_0.CLK a_31093_39677# 0.25723f
C3618 oa_sar8_acore18_opt_0.sw_bitcell_opt_term_0.gb VDD 3.92089f
C3619 sar_ctrl_async_phys_0.sg13g2_buf_1$1_35.A sar_ctrl_async_phys_0.sg13g2_nand2b_1$1_2.A_N 0.19641f
C3620 sar_ctrl_async_phys_0.sg13g2_a21oi_1$1_5.Y a_31542_37874# 0.03111f
C3621 sar_ctrl_async_phys_0.sg13g2_nand3_1$1_0.C a_25914_38948# 0.01434f
C3622 a_34106_30849# a_34132_30944# 0.36952f
C3623 a_36156_45710# sar_ctrl_async_phys_0.sg13g2_buf_1$1_37.A 0.25856f
C3624 sar_ctrl_async_phys_0.sg13g2_nor2_1$1_0.Y a_31732_45000# 0.02021f
C3625 sar_ctrl_async_phys_0.sg13g2_buf_1$1_37.A sar_ctrl_async_phys_0.dac_code[3] 0.0839f
C3626 a_36056_38948# VDD 0.21706f
C3627 sar_ctrl_async_phys_0.sg13g2_nand3_1$1_0.Y VDD 0.62923f
C3628 sar_ctrl_async_phys_0.sg13g2_buf_1$1_2.A sar_ctrl_async_phys_0.sg13g2_a22oi_1$1_0.Y 0.16126f
C3629 sar_ctrl_async_phys_0.sg13g2_a21oi_1$1_5.Y sar_ctrl_async_phys_0.sg13g2_a22oi_1$1_0.B1 0.04142f
C3630 sar_ctrl_async_phys_0.sg13g2_and2_1$1_0.A sar_ctrl_async_phys_0.sg13g2_a22oi_1$1_3.B1 0.49116f
C3631 sar_ctrl_async_phys_0.sg13g2_buf_1$1_37.A a_35672_42760# 0.01143f
C3632 sar_ctrl_async_phys_0.sg13g2_buf_1$1_35.A sar_ctrl_async_phys_0.dac_code[3] 0.25657f
C3633 sar_ctrl_async_phys_0.sg13g2_nor4_1$1_0.Y sar_ctrl_async_phys_0.sg13g2_inv_1$1_10.Y 0.06157f
C3634 a_32692_46064# a_33951_45823# 0.01529f
C3635 a_30774_44234# VDD 0.78071f
C3636 sar_ctrl_async_phys_0.sg13g2_a22oi_1$1_1.A2 sar_ctrl_async_phys_0.sg13g2_buf_1$1_1.A 0.14474f
C3637 sar_ctrl_async_phys_0.dac_code[0] a_36156_45710# 0.04333f
C3638 sar_ctrl_async_phys_0.dac_code[0] sar_ctrl_async_phys_0.dac_code[3] 0.21885f
C3639 a_34520_42760# sar_ctrl_async_phys_0.dac_code[1] 0.24585f
C3640 sar_ctrl_async_phys_0.dac_code_n[7] oa_sar8_acore18_opt_0.sw_bitcell_opt_b4_1.bot 0.11279f
C3641 a_20412_n9612# vinp 0.98838f
C3642 sar_ctrl_async_phys_0.dac_code_n[5] oa_sar8_acore18_opt_0.sw_bitcell_opt_b6_0.bot 0.95229f
C3643 w_39600_n9960# sar_ctrl_async_phys_0.dac_code_n[5] 0.11753f
C3644 sar_ctrl_async_phys_0.sg13g2_a22oi_1$1_1.A2 sar_ctrl_async_phys_0.sg13g2_buf_1$1_7.A 0.01356f
C3645 a_30783_40821# VDD 0.17863f
C3646 oa_sar8_acore18_opt_0.sw_bitcell_opt_b6_0.bot oa_sar8_acore18_opt_0.sw_bitcell_opt_term_0.gb 0.65179f
C3647 a_36058_34412# VDD 0.37732f
C3648 w_39600_n9960# oa_sar8_acore18_opt_0.sw_bitcell_opt_term_0.gb 3.49667f
C3649 a_32251_45007# VDD 0.20825f
C3650 sar_ctrl_async_phys_0.sg13g2_a21oi_1$1_2.B1 VDD 0.98365f
C3651 sar_ctrl_async_phys_0.sg13g2_nor2_1$1_4.Y a_26544_38389# 0.03772f
C3652 sar_ctrl_async_phys_0.sg13g2_dfrbpq_1$1_0.CLK a_30676_35928# 0.07828f
C3653 a_29851_32260# VDD 0.20494f
C3654 sar_ctrl_async_phys_0.sg13g2_nor2b_1$1_0.A a_30390_36362# 0.04903f
C3655 sar_ctrl_async_phys_0.hold_req oa_sar8_acore18_opt_0.bstrap_opt_w2_c1200_1.gb 0.01335f
C3656 sar_ctrl_async_phys_0.sg13g2_buf_1$1_42.A a_33368_44366# 0.01619f
C3657 sar_ctrl_async_phys_0.sg13g2_buf_1$1_17.A sar_ctrl_async_phys_0.sg13g2_dfrbpq_1$1_5.D 0.03602f
C3658 a_30746_31356# a_30772_31392# 0.36952f
C3659 sar_ctrl_async_phys_0.sg13g2_nand2b_1$1_0.Y VDD 0.4979f
C3660 sar_ctrl_async_phys_0.sg13g2_o21ai_1$1_1.B1 a_29236_38952# 0.41789f
C3661 a_34651_30748# VDD 0.20769f
C3662 a_26566_41996# VDD 0.18949f
C3663 sar_ctrl_async_phys_0.dac_code_n[6] oa_sar8_acore18_opt_0.sw_bitcell_opt_b7_0.bot 2.0842f
C3664 sar_ctrl_async_phys_0.sg13g2_nand2b_1$1_4.A_N a_35866_44532# 0.02492f
C3665 a_29236_38952# a_30401_39309# 0.43239f
C3666 sar_ctrl_async_phys_0.sg13g2_buf_1$1_26.X a_26630_37814# 0.10818f
C3667 a_32666_45969# VDD 0.0981f
C3668 a_34093_42912# VDD 0.26182f
C3669 sar_ctrl_async_phys_0.sg13g2_a22oi_1$1_0.A1 sar_ctrl_async_phys_0.sg13g2_a22oi_1$1_4.Y 0.55051f
C3670 a_26364_45710# VDD 0.28924f
C3671 sar_ctrl_async_phys_0.sg13g2_nor2_1$1_5.A sar_ctrl_async_phys_0.sg13g2_nor2_1$1_6.Y 0.55553f
C3672 a_34904_38948# VDD 0.26735f
C3673 sar_ctrl_async_phys_0.sg13g2_inv_1$1_11.Y VDD 0.59364f
C3674 a_31162_38948# VDD 0.3793f
C3675 sar_ctrl_async_phys_0.sg13g2_buf_1$1_5.A result[7] 1.15062f
C3676 oa_sar8_acore18_opt_0.sw_bitcell_opt_b3_0.bot oa_sar8_acore18_opt_0.sw_bitcell_opt_term_0.VSS 1.74142f
C3677 sar_ctrl_async_phys_0.sg13g2_nor2_1$1_1.Y sar_ctrl_async_phys_0.sg13g2_buf_1$1_13.A 0.04357f
C3678 a_29941_40471# a_29812_40885# 0.01562f
C3679 a_29524_40464# a_30043_40471# 0.34102f
C3680 sar_ctrl_async_phys_0.dac_code_n[0] oa_sar8_acore18_opt_0.sw_bitcell_opt_b7_0.bot 1.14414f
C3681 a_33846_34850# a_34420_34837# 0.31978f
C3682 a_34106_34380# a_34549_34423# 0.02242f
C3683 a_31446_45434# a_31706_44964# 0.75507f
C3684 sar_ctrl_async_phys_0.sg13g2_nand2_1$1_5.B a_33276_42686# 0.01244f
C3685 sar_ctrl_async_phys_0.sg13g2_nand2_1$1_3.A a_34459_44356# 0.05901f
C3686 sar_ctrl_async_phys_0.sg13g2_nand2b_1$1_0.A_N sar_ctrl_async_phys_0.sg13g2_nor2_1$1_6.Y 0.1422f
C3687 sar_ctrl_async_phys_0.sg13g2_buf_1$1_10.A sar_ctrl_async_phys_0.sg13g2_a22oi_1$1_0.B2 0.02428f
C3688 sar_ctrl_async_phys_0.sg13g2_a21oi_1$1_4.B1 sar_ctrl_async_phys_0.sg13g2_a21oi_1$1_1.B1 0.03401f
C3689 sar_ctrl_async_phys_0.sg13g2_inv_1$1_7.A a_28368_36877# 0.01499f
C3690 a_31093_39677# a_31841_39775# 0.01058f
C3691 a_31935_39775# a_32192_39918# 0.34468f
C3692 sar_ctrl_async_phys_0.sg13g2_nor2_1$1_4.Y a_26662_41278# 0.02394f
C3693 a_34132_32904# a_35391_33261# 0.01529f
C3694 sar_ctrl_async_phys_0.sg13g2_nor2_1$1_10.B a_30977_33727# 0.01839f
C3695 sar_ctrl_async_phys_0.sg13g2_a22oi_1$1_3.B1 sar_ctrl_async_phys_0.sg13g2_buf_1$1_8.A 0.09571f
C3696 sar_ctrl_async_phys_0.sg13g2_nor2_1$1_13.A a_28130_40838# 0.09468f
C3697 sar_ctrl_async_phys_0.dac_code[5] oa_sar8_acore18_opt_0.sw_tg_opt_0.bot 0.88851f
C3698 sar_ctrl_async_phys_0.sg13g2_nor2_1$1_1.Y sar_ctrl_async_phys_0.sg13g2_nor2_1$1_2.Y 0.09972f
C3699 a_36056_38948# sar_ctrl_async_phys_0.bit_active[7] 0.01587f
C3700 sar_ctrl_async_phys_0.sg13g2_o21ai_1$1_1.B1 a_29238_40898# 0.13511f
C3701 sar_ctrl_async_phys_0.sg13g2_nand2_1$1_5.B a_33085_43832# 0.03392f
C3702 sar_ctrl_async_phys_0.sg13g2_buf_1$1_21.A a_35672_38224# 0.01656f
C3703 sar_ctrl_async_phys_0.sg13g2_a21oi_1$1_2.B1 sar_ctrl_async_phys_0.sg13g2_nor2b_1$1_3.Y 0.06688f
C3704 sar_ctrl_async_phys_0.sg13g2_nor2_1$1_3.B track 0.02848f
C3705 sar_ctrl_async_phys_0.sg13g2_nor2b_1$1_0.A sar_ctrl_async_phys_0.sg13g2_buf_1$1_1.A 0.05652f
C3706 sar_ctrl_async_phys_0.sg13g2_buf_1$1_3.A a_35648_34654# 0.0303f
C3707 sar_ctrl_async_phys_0.sg13g2_inv_1$1_2.Y VDD 0.81433f
C3708 sar_ctrl_async_phys_0.dac_code_n[7] oa_sar8_acore18_opt_0.sw_bitcell_opt_b7_0.bot 1.39746f
C3709 sar_ctrl_async_phys_0.sg13g2_nor2_1$1_6.Y a_28651_39740# 0.26243f
C3710 sar_ctrl_async_phys_0.sg13g2_dfrbpq_1$1_0.CLK result[2] 0.03616f
C3711 sar_ctrl_async_phys_0.dac_code_n[5] oa_sar8_acore18_opt_0.sw_bitcell_opt_b2_0.bot 0.08014f
C3712 oa_sar8_acore18_opt_0.sw_tg_opt_1.bot oa_sar8_acore18_opt_0.sw_bitcell_opt_b0_1.bot 0.92598f
C3713 oa_sar8_acore18_opt_0.sw_bitcell_opt_b2_0.bot oa_sar8_acore18_opt_0.sw_bitcell_opt_term_0.gb 0.63441f
C3714 sar_ctrl_async_phys_0.sg13g2_a21oi_1$1_2.B1 sar_ctrl_async_phys_0.sg13g2_buf_1$1_14.A 0.11672f
C3715 sar_ctrl_async_phys_0.sg13g2_a21oi_1$1_6.A2 a_31732_45000# 0.01055f
C3716 sar_ctrl_async_phys_0.sg13g2_buf_1$1_2.A a_33948_41936# 0.27142f
C3717 sar_ctrl_async_phys_0.sg13g2_buf_1$1_1.A a_32251_35284# 0.01278f
C3718 sar_ctrl_async_phys_0.sg13g2_dfrbpq_1$1_5.D sar_ctrl_async_phys_0.sg13g2_buf_1$1_6.X 0.06274f
C3719 sar_ctrl_async_phys_0.sg13g2_dfrbpq_1$1_0.CLK a_31638_32138# 0.02448f
C3720 a_34106_34380# VDD 0.12697f
C3721 a_31446_45434# VDD 0.7775f
C3722 sar_ctrl_async_phys_0.sg13g2_nor2_1$1_0.Y a_32400_41413# 0.03867f
C3723 sar_ctrl_async_phys_0.sg13g2_buf_1$1_19.A sar_ctrl_async_phys_0.sg13g2_a22oi_1$1_3.A2 0.02582f
C3724 a_29350_41996# VDD 0.18735f
C3725 sar_ctrl_async_phys_0.sg13g2_a21oi_1$1_3.B1 sar_ctrl_async_phys_0.sg13g2_nand2_1$1_3.Y 0.02508f
C3726 sar_ctrl_async_phys_0.sg13g2_a22oi_1$1_3.A2 sar_ctrl_async_phys_0.sg13g2_and2_1$1_0.X 0.01374f
C3727 a_30872_30758# VDD 0.1445f
C3728 sar_ctrl_async_phys_0.sg13g2_nand2_1$1_1.B sar_ctrl_async_phys_0.sg13g2_nand2_1$1_1.Y 0.21911f
C3729 sar_ctrl_async_phys_0.dac_code[2] VDD 4.33543f
C3730 sar_ctrl_async_phys_0.hold_req oa_sar8_acore18_opt_0.sw_bitcell_opt_b5_1.bot 0.09387f
C3731 a_33675_43020# VDD 0.24988f
C3732 sar_ctrl_async_phys_0.sg13g2_buf_1$1_6.X a_30497_32215# 0.01213f
C3733 sar_ctrl_async_phys_0.sg13g2_a22oi_1$1_0.A2 sar_ctrl_async_phys_0.bit_active[2] 0.06266f
C3734 a_36056_42760# VDD 0.21757f
C3735 a_29210_38916# a_29653_38959# 0.02242f
C3736 a_28950_39386# a_29524_39373# 0.31978f
C3737 sar_ctrl_async_phys_0.sg13g2_buf_1$1_42.A a_32991_45357# 0.0286f
C3738 sar_ctrl_async_phys_0.sg13g2_nor2_1$1_11.Y sar_ctrl_async_phys_0.sg13g2_a21oi_1$1_2.Y 0.17228f
C3739 sar_ctrl_async_phys_0.sg13g2_buf_1$1_14.A a_34904_38948# 0.01261f
C3740 sar_ctrl_async_phys_0.sg13g2_nor4_1$1_0.C a_30043_40471# 0.01244f
C3741 sar_ctrl_async_phys_0.sg13g2_dfrbpq_1$1_0.CLK a_34171_41332# 0.03551f
C3742 sar_ctrl_async_phys_0.sg13g2_a22oi_1$1_2.A2 sar_ctrl_async_phys_0.sg13g2_nor2_1$1_1.Y 0.01026f
C3743 sar_ctrl_async_phys_0.sg13g2_buf_1$1_19.A a_34520_38224# 0.27539f
C3744 a_32192_36166# a_31935_36285# 0.34468f
C3745 sar_ctrl_async_phys_0.sg13g2_a21oi_1$1_5.A2 VDD 0.49997f
C3746 a_29210_38916# VDD 0.09624f
C3747 sar_ctrl_async_phys_0.sg13g2_nor2b_1$1_1.B_N sar_ctrl_async_phys_0.sg13g2_buf_1$1_1.A 0.01198f
C3748 sar_ctrl_async_phys_0.dac_code[2] oa_sar8_acore18_opt_0.sw_bitcell_opt_b6_0.bot 1.17676f
C3749 w_39600_n9960# sar_ctrl_async_phys_0.dac_code[2] 0.04487f
C3750 oa_sar8_acore18_opt_0.sw_bitcell_opt_term_0.bot oa_sar8_acore18_opt_0.sw_bitcell_opt_term_0.VSS 1.4091f
C3751 sar_ctrl_async_phys_0.sg13g2_and2_1$1_0.A sar_ctrl_async_phys_0.sg13g2_buf_1$1_17.A 0.07711f
C3752 sar_ctrl_async_phys_0.bit_active[3] VDD 0.23005f
C3753 sar_ctrl_async_phys_0.dac_code_n[3] sar_ctrl_async_phys_0.dac_code[5] 0.13755f
C3754 sar_ctrl_async_phys_0.dac_code_n[1] sar_ctrl_async_phys_0.dac_code[6] 0.20753f
C3755 sar_ctrl_async_phys_0.sg13g2_buf_1$1_10.A a_32341_32117# 0.03513f
C3756 sar_ctrl_async_phys_0.sg13g2_buf_1$1_19.A a_33632_40702# 0.04265f
C3757 sar_ctrl_async_phys_0.sg13g2_nor2_1$1_13.A a_28236_40440# 0.01075f
C3758 sar_ctrl_async_phys_0.sg13g2_a22oi_1$1_0.B1 sar_ctrl_async_phys_0.sg13g2_inv_1$1_3.Y 0.02892f
C3759 sar_ctrl_async_phys_0.sg13g2_a21oi_1$1_5.Y a_31328_33870# 0.04982f
C3760 sar_ctrl_async_phys_0.sg13g2_a22oi_1$1_2.Y a_30591_32215# 0.01928f
C3761 sar_ctrl_async_phys_0.sg13g2_nor2_1$1_18.A a_31093_39677# 0.01984f
C3762 sar_ctrl_async_phys_0.sg13g2_a22oi_1$1_1.Y result[5] 0.63376f
C3763 sar_ctrl_async_phys_0.sg13g2_a21oi_1$1_5.Y sar_ctrl_async_phys_0.sg13g2_dfrbpq_1$1_11.D 1.37485f
C3764 oa_sar8_acore18_opt_0.sw_bitcell_opt_term_0.gb m3_45264_n2380# 1.58415f
C3765 sar_ctrl_async_phys_0.dac_code[5] m3_48572_n2380# 0.05732f
C3766 sar_ctrl_async_phys_0.sg13g2_a21oi_1$1_2.Y sar_ctrl_async_phys_0.sg13g2_and2_1$1_0.B 0.05327f
C3767 sar_ctrl_async_phys_0.dac_code_n[5] oa_sar8_acore18_opt_0.sw_bitcell_opt_b7_1.VSS 1.3094f
C3768 sar_ctrl_async_phys_0.sg13g2_buf_1$1_41.X a_33914_44457# 0.26596f
C3769 sar_ctrl_async_phys_0.sg13g2_dfrbpq_1$1_0.CLK a_31579_44356# 0.03751f
C3770 oa_sar8_acore18_opt_0.sw_tg_opt_1.bot oa_sar8_acore18_opt_0.sw_bitcell_opt_b4_1.bot 6.40154f
C3771 sar_ctrl_async_phys_0.sg13g2_dfrbpq_1$1_0.CLK sar_ctrl_async_phys_0.sg13g2_a22oi_1$1_0.Y 0.7318f
C3772 sar_ctrl_async_phys_0.sg13g2_buf_1$1_3.A sar_ctrl_async_phys_0.bit_active[2] 0.04164f
C3773 sar_ctrl_async_phys_0.sg13g2_nand2_1$1_3.A sar_ctrl_async_phys_0.sg13g2_nand2b_1$1_6.A_N 0.1253f
C3774 sar_ctrl_async_phys_0.sg13g2_o21ai_1$1_1.B1 sar_ctrl_async_phys_0.sg13g2_nor2_1$1_15.Y 0.07315f
C3775 sar_ctrl_async_phys_0.sg13g2_a22oi_1$1_4.A2 sar_ctrl_async_phys_0.sg13g2_a22oi_1$1_3.A2 1.0382f
C3776 sar_ctrl_async_phys_0.sg13g2_a22oi_1$1_0.A2 result[7] 0.03588f
C3777 sar_ctrl_async_phys_0.sg13g2_a21oi_1$1_2.B1 a_34815_39775# 0.03394f
C3778 sar_ctrl_async_phys_0.sg13g2_nand2_1$1_3.A a_34618_46044# 0.04316f
C3779 sar_ctrl_async_phys_0.sg13g2_o21ai_1$1_1.B1 sar_ctrl_async_phys_0.sg13g2_and2_1$1_6.X 1.36881f
C3780 sar_ctrl_async_phys_0.dac_code_n[1] sar_ctrl_async_phys_0.dac_code[3] 0.05494f
C3781 sar_ctrl_async_phys_0.sg13g2_nor2_1$1_10.B sar_ctrl_async_phys_0.sg13g2_dlygate4sd3_1$1_0.A 0.01184f
C3782 sar_ctrl_async_phys_0.sg13g2_buf_1$1_8.A result[3] 0.36369f
C3783 sar_ctrl_async_phys_0.sg13g2_nor2b_1$1_0.A a_30783_40821# 0.04129f
C3784 sar_ctrl_async_phys_0.sg13g2_nor2b_1$1_0.A sar_ctrl_async_phys_0.sg13g2_a21oi_1$1_2.B1 0.03088f
C3785 sar_ctrl_async_phys_0.sg13g2_and2_1$1_0.A sar_ctrl_async_phys_0.sg13g2_and2_1$1_6.X 1.04116f
C3786 sar_ctrl_async_phys_0.sg13g2_dfrbpq_1$1_0.CLK a_30591_32215# 0.0322f
C3787 sar_ctrl_async_phys_0.sg13g2_a22oi_1$1_1.A2 a_34106_34380# 0.02234f
C3788 sar_ctrl_async_phys_0.sg13g2_a21oi_1$1_2.Y a_30650_35892# 0.03068f
C3789 sar_ctrl_async_phys_0.hold_req oa_sar8_acore18_opt_0.sw_bitcell_opt_term_0.vin 0.05699f
C3790 a_35672_46508# sar_ctrl_async_phys_0.sg13g2_nand2b_1$1_3.Y 0.25456f
C3791 sar_ctrl_async_phys_0.sg13g2_buf_1$1_6.X a_31071_33727# 0.14424f
C3792 a_25990_40484# VDD 0.18606f
C3793 sar_ctrl_async_phys_0.sg13g2_nor2_1$1_10.B a_30495_39309# 0.04249f
C3794 a_34767_31359# VDD 0.249f
C3795 sar_ctrl_async_phys_0.sg13g2_a21oi_1$1_6.B1 a_34765_45266# 0.28443f
C3796 sar_ctrl_async_phys_0.sg13g2_a21oi_1$1_5.A2 sar_ctrl_async_phys_0.sg13g2_nor2b_1$1_3.Y 0.01609f
C3797 sar_ctrl_async_phys_0.sg13g2_a21oi_1$1_6.B1 a_32991_45357# 0.01238f
C3798 sar_ctrl_async_phys_0.sg13g2_nor2_1$1_10.Y a_30774_44234# 0.27282f
C3799 a_31034_44457# a_31477_44213# 0.02242f
C3800 sar_ctrl_async_phys_0.sg13g2_a22oi_1$1_0.A1 a_30480_32986# 0.01965f
C3801 sar_ctrl_async_phys_0.sg13g2_buf_1$1_7.A sar_ctrl_async_phys_0.sg13g2_a22oi_1$1_1.Y 0.0133f
C3802 a_31802_37404# a_31828_37440# 0.36952f
C3803 sar_ctrl_async_phys_0.sg13g2_buf_1$1_19.A a_33556_40016# 0.03635f
C3804 oa_sar8_acore18_opt_0.sw_bitcell_opt_term_0.trkb oa_sar8_acore18_opt_0.sw_bitcell_opt_b5_0.bot 1.47626f
C3805 oa_sar8_acore18_opt_0.sw_bitcell_opt_b3_0.bot VDD 3.00009f
C3806 sar_ctrl_async_phys_0.sg13g2_buf_1$1_17.A a_34132_34416# 0.03855f
C3807 sar_ctrl_async_phys_0.sg13g2_and2_1$1_0.A a_31933_43832# 0.28436f
C3808 a_35725_45266# a_36152_45082# 0.0144f
C3809 sar_ctrl_async_phys_0.sg13g2_nand2_1$1_5.B sar_ctrl_async_phys_0.dac_code_n[7] 0.01378f
C3810 sar_ctrl_async_phys_0.sg13g2_inv_1$1_6.Y a_30100_33663# 0.01899f
C3811 a_34765_45266# a_34847_45366# 0.01117f
C3812 sar_ctrl_async_phys_0.sg13g2_buf_1$1_17.A sar_ctrl_async_phys_0.sg13g2_a22oi_1$1_3.B1 0.0152f
C3813 a_30676_35928# a_30964_36349# 0.43707f
C3814 sar_ctrl_async_phys_0.sg13g2_nor2b_1$1_0.A a_31162_38948# 0.01722f
C3815 sar_ctrl_async_phys_0.sg13g2_a21oi_1$1_3.B1 VDD 0.68469f
C3816 a_27206_39326# VDD 0.01185f
C3817 a_32890_46508# sar_ctrl_async_phys_0.sg13g2_a21oi_1$1_6.A2 0.11728f
C3818 sar_ctrl_async_phys_0.dac_code[2] oa_sar8_acore18_opt_0.sw_bitcell_opt_b2_0.bot 1.44589f
C3819 a_26270_39215# VDD 0.18567f
C3820 sar_ctrl_async_phys_0.sg13g2_a21oi_1$1_5.Y sar_ctrl_async_phys_0.sg13g2_nor2b_1$1_0.Y 0.23094f
C3821 a_31483_46519# VDD 0.21123f
C3822 sar_ctrl_async_phys_0.sg13g2_a22oi_1$1_2.B2 sar_ctrl_async_phys_0.sg13g2_inv_1$1_0.A 0.02232f
C3823 sar_ctrl_async_phys_0.sg13g2_nor2_1$1_2.Y a_33558_43922# 0.26316f
C3824 sar_ctrl_async_phys_0.sg13g2_buf_1$1_0.A sar_ctrl_async_phys_0.sg13g2_buf_1$1_8.A 0.01987f
C3825 sar_ctrl_async_phys_0.sg13g2_and2_1$1_0.A sar_ctrl_async_phys_0.sg13g2_buf_1$1_6.X 0.01313f
C3826 sar_ctrl_async_phys_0.sg13g2_dlygate4sd3_1$1_6.A track 0.03055f
C3827 sar_ctrl_async_phys_0.dac_code_n[5] oa_sar8_acore18_opt_0.sw_bitcell_opt_b2_1.bot 0.06598f
C3828 sar_ctrl_async_phys_0.sg13g2_buf_1$1_14.A sar_ctrl_async_phys_0.bit_active[3] 0.0491f
C3829 a_35672_38224# VDD 0.21896f
C3830 sar_ctrl_async_phys_0.sg13g2_a22oi_1$1_4.A2 a_33632_40702# 0.01232f
C3831 sar_ctrl_async_phys_0.sg13g2_nand2b_1$1_1.B a_34765_45266# 0.26736f
C3832 oa_sar8_acore18_opt_0.sw_bitcell_opt_b5_0.bot oa_sar8_acore18_opt_0.sw_bitcell_opt_b4_0.bot 6.20451f
C3833 oa_sar8_acore18_opt_0.sw_bitcell_opt_b6_0.bot oa_sar8_acore18_opt_0.sw_bitcell_opt_b3_0.bot 0.52132f
C3834 w_39600_n9960# oa_sar8_acore18_opt_0.sw_bitcell_opt_b3_0.bot 0.02055f
C3835 sar_ctrl_async_phys_0.sg13g2_nor2_1$1_0.Y a_32404_40885# 0.01091f
C3836 sar_ctrl_async_phys_0.sg13g2_inv_1$1_3.Y a_31898_32361# 0.02446f
C3837 a_33248_35382# VDD 0.17726f
C3838 sar_ctrl_async_phys_0.sg13g2_buf_1$1_15.A sar_ctrl_async_phys_0.dac_code[6] 0.02995f
C3839 sar_ctrl_async_phys_0.sg13g2_buf_1$1_3.A result[7] 0.02367f
C3840 sar_ctrl_async_phys_0.sg13g2_buf_1$1_42.A VDD 0.99072f
C3841 a_35672_33688# VDD 0.21969f
C3842 sar_ctrl_async_phys_0.dac_code_n[4] sar_ctrl_async_phys_0.dac_code_n[5] 26.7765f
C3843 sar_ctrl_async_phys_0.sg13g2_nand2b_1$1_3.Y sar_ctrl_async_phys_0.sg13g2_a21oi_1$1_2.B1 4.18347f
C3844 a_36336_36010# VDD 0.06839f
C3845 a_29144_39830# a_29328_39830# 0.0524f
C3846 a_33752_33688# VDD 0.26988f
C3847 a_34615_31475# a_35463_31435# 0.097f
C3848 sar_ctrl_async_phys_0.dac_code_n[4] oa_sar8_acore18_opt_0.sw_bitcell_opt_term_0.gb 0.17205f
C3849 sar_ctrl_async_phys_0.sg13g2_nand2b_1$1_1.B sar_ctrl_async_phys_0.sg13g2_nand2_1$1_3.Y 0.21711f
C3850 a_35288_47296# sar_ctrl_async_phys_0.dac_code_n[2] 0.25084f
C3851 a_35770_43484# sar_ctrl_async_phys_0.dac_code_n[7] 0.01095f
C3852 a_33276_42686# sar_ctrl_async_phys_0.sg13g2_a22oi_1$1_4.A2 0.05797f
C3853 sar_ctrl_async_phys_0.sg13g2_a22oi_1$1_3.A2 sar_ctrl_async_phys_0.sg13g2_inv_1$1_0.A 0.02959f
C3854 sar_ctrl_async_phys_0.sg13g2_and2_1$1_3.X a_26168_38318# 0.01111f
C3855 sar_ctrl_async_phys_0.sg13g2_buf_1$1_41.X a_30774_44234# 0.12023f
C3856 sar_ctrl_async_phys_0.dac_code[7] oa_sar8_acore18_opt_0.sw_bitcell_opt_term_0.trkb 2.57544f
C3857 sar_ctrl_async_phys_0.sg13g2_a21oi_1$1_0.A1 a_32817_42748# 0.01132f
C3858 sar_ctrl_async_phys_0.sg13g2_dfrbpq_1$1_0.CLK sar_ctrl_async_phys_0.sg13g2_nor4_1$1_0.Y 0.69394f
C3859 sar_ctrl_async_phys_0.sg13g2_dfrbpq_1$1_0.CLK a_31732_45000# 0.08335f
C3860 sar_ctrl_async_phys_0.sg13g2_buf_1$1_15.A sar_ctrl_async_phys_0.dac_code[3] 0.06503f
C3861 sar_ctrl_async_phys_0.sg13g2_dfrbpq_1$1_0.CLK a_34765_42242# 0.04393f
C3862 sar_ctrl_async_phys_0.sg13g2_buf_1$1_41.X a_32251_45007# 0.42365f
C3863 sar_ctrl_async_phys_0.sg13g2_nor2_1$1_14.A VDD 0.83396f
C3864 sar_ctrl_async_phys_0.sg13g2_buf_1$1_20.A sar_ctrl_async_phys_0.dac_code[2] 0.0448f
C3865 sar_ctrl_async_phys_0.sg13g2_a22oi_1$1_4.A2 a_33556_40016# 0.0393f
C3866 a_34636_31749# VDD 0.07541f
C3867 oa_sar8_acore18_opt_0.sw_bitcell_opt_term_0.trkb oa_sar8_acore18_opt_0.sw_bitcell_opt_b1_0.bot 1.39779f
C3868 sar_ctrl_async_phys_0.dac_code_n[5] sar_ctrl_async_phys_0.sg13g2_buf_1$1_37.A 1.29473f
C3869 oa_sar8_acore18_opt_0.sw_bitcell_opt_term_0.bot VDD 3.70504f
C3870 sar_ctrl_async_phys_0.dac_code[1] m3_41836_n2380# 0.05732f
C3871 sar_ctrl_async_phys_0.sg13g2_buf_1$1_6.X sar_ctrl_async_phys_0.sg13g2_a22oi_1$1_3.B1 0.40119f
C3872 sar_ctrl_async_phys_0.sg13g2_a21oi_1$1_5.Y VDD 0.94766f
C3873 sar_ctrl_async_phys_0.dac_code[7] oa_sar8_acore18_opt_0.sw_bitcell_opt_b4_0.bot 0.59176f
C3874 a_32443_32260# a_33440_32358# 0.02979f
C3875 sar_ctrl_async_phys_0.sg13g2_dlygate4sd3_1$1_9.X a_26184_39702# 0.45185f
C3876 sar_ctrl_async_phys_0.sg13g2_buf_1$1_6.X sar_ctrl_async_phys_0.sg13g2_buf_1$1_8.A 0.09878f
C3877 sar_ctrl_async_phys_0.dac_code_n[5] sar_ctrl_async_phys_0.dac_code[0] 0.2763f
C3878 sar_ctrl_async_phys_0.dac_code[0] oa_sar8_acore18_opt_0.sw_bitcell_opt_term_0.gb 0.18846f
C3879 a_31483_46519# a_32223_46869# 0.26905f
C3880 sar_ctrl_async_phys_0.sg13g2_dlygate4sd3_1$1_7.A sar_ctrl_async_phys_0.sg13g2_nand3_1$1_0.C 0.56051f
C3881 sar_ctrl_async_phys_0.bit_active[6] sar_ctrl_async_phys_0.bit_active[5] 0.09413f
C3882 a_32580_43448# VDD 0.2027f
C3883 a_29306_32361# a_29046_32138# 0.75507f
C3884 sar_ctrl_async_phys_0.sg13g2_a22oi_1$1_2.A2 a_32149_45007# 0.03335f
C3885 oa_sar8_acore18_opt_0.sw_bitcell_opt_b6_0.bot oa_sar8_acore18_opt_0.sw_bitcell_opt_term_0.bot 0.62648f
C3886 oa_sar8_acore18_opt_0.sw_bitcell_opt_b5_0.bot oa_sar8_acore18_opt_0.sw_bitcell_opt_b0_0.bot 0.36258f
C3887 oa_sar8_acore18_opt_0.sw_bitcell_opt_term_0.trkb m3_51760_n2380# 0.03859f
C3888 oa_sar8_acore18_opt_0.sw_bitcell_opt_b4_0.bot oa_sar8_acore18_opt_0.sw_bitcell_opt_b1_0.bot 1.11867f
C3889 oa_sar8_acore18_opt_0.sw_bitcell_opt_b3_0.bot oa_sar8_acore18_opt_0.sw_bitcell_opt_b2_0.bot 16.507f
C3890 a_35672_38224# sar_ctrl_async_phys_0.bit_active[7] 0.24507f
C3891 a_31136_43726# VDD 0.16934f
C3892 sar_ctrl_async_phys_0.sg13g2_nor2_1$1_2.Y sar_ctrl_async_phys_0.sg13g2_a22oi_1$1_0.A2 0.14283f
C3893 a_34904_38224# sar_ctrl_async_phys_0.sg13g2_a22oi_1$1_0.A1 0.25509f
C3894 m3_38288_n2380# VDD 0.0275f
C3895 sar_ctrl_async_phys_0.sg13g2_nor2_1$1_7.A a_29258_36642# 0.03261f
C3896 sar_ctrl_async_phys_0.sg13g2_a22oi_1$1_3.A2 sar_ctrl_async_phys_0.sg13g2_a22oi_1$1_2.B2 0.36942f
C3897 sar_ctrl_async_phys_0.sg13g2_dfrbpq_1$1_0.CLK sar_ctrl_async_phys_0.bit_active[0] 0.58167f
C3898 sar_ctrl_async_phys_0.sg13g2_buf_1$1_42.A a_34236_46472# 0.02492f
C3899 sar_ctrl_async_phys_0.sg13g2_nor2b_1$1_3.Y a_33281_40821# 0.02216f
C3900 a_31732_35480# VDD 0.07846f
C3901 sar_ctrl_async_phys_0.sg13g2_buf_1$1_8.A sar_ctrl_async_phys_0.sg13g2_a22oi_1$1_1.B2 0.01558f
C3902 sar_ctrl_async_phys_0.sg13g2_a21oi_1$1_6.B1 VDD 0.91682f
C3903 oa_sar8_acore18_opt_0.bstrap_opt_w2_c1200_1.gb VDD 3.8068f
C3904 a_31706_35385# VDD 0.09611f
C3905 sar_ctrl_async_phys_0.sg13g2_and2_1$1_3.X VDD 0.81074f
C3906 a_31732_35480# a_32897_35239# 0.43239f
C3907 sar_ctrl_async_phys_0.sg13g2_buf_1$1_2.A result[4] 0.01234f
C3908 a_32251_35284# a_32020_35175# 0.12701f
C3909 sar_ctrl_async_phys_0.sg13g2_buf_1$1_37.A a_34093_42912# 0.27187f
C3910 a_34555_35935# VDD 0.20941f
C3911 sar_ctrl_async_phys_0.sg13g2_nor4_1$1_0.Y sar_ctrl_async_phys_0.sg13g2_dlygate4sd3_1$1_9.A 0.02013f
C3912 a_31034_44457# VDD 0.09718f
C3913 sar_ctrl_async_phys_0.sg13g2_nand2_1$1_3.Y sar_ctrl_async_phys_0.sg13g2_nand2_1$1_5.Y 0.02553f
C3914 sar_ctrl_async_phys_0.sg13g2_a22oi_1$1_4.A2 sar_ctrl_async_phys_0.sg13g2_buf_1$1_10.A 0.1086f
C3915 sar_ctrl_async_phys_0.sg13g2_a22oi_1$1_0.A2 a_34308_37400# 0.01323f
C3916 oa_sar8_acore18_opt_0.sw_bitcell_opt_b1_1.bot VDD 2.57264f
C3917 sar_ctrl_async_phys_0.sg13g2_a21oi_1$1_0.A2 sar_ctrl_async_phys_0.bit_active[0] 0.05325f
C3918 sar_ctrl_async_phys_0.sg13g2_o21ai_1$1_1.B1 a_33211_45868# 0.42048f
C3919 a_35295_36285# sar_ctrl_async_phys_0.bit_active[3] 0.01275f
C3920 a_32533_40471# VDD 0.25115f
C3921 oa_sar8_acore18_opt_0.sw_bitcell_opt_b6_0.bot m3_38288_n2380# 1.82939f
C3922 sar_ctrl_async_phys_0.sg13g2_nor2b_1$1_1.Y a_33087_37797# 0.02368f
C3923 a_34357_44213# a_34228_44247# 0.01562f
C3924 oa_sar8_acore18_opt_0.sw_bitcell_opt_term_0.vin oa_sar8_acore18_opt_0.sw_bitcell_opt_term_0.VSS 0.08642f
C3925 sar_ctrl_async_phys_0.sg13g2_nand2_1$1_5.B sar_ctrl_async_phys_0.sg13g2_nor2_1$1_1.Y 0.04447f
C3926 sar_ctrl_async_phys_0.sg13g2_inv_1$1_11.Y a_30772_31392# 0.01389f
C3927 a_34363_36796# VDD 0.2106f
C3928 sar_ctrl_async_phys_0.sg13g2_buf_1$1_13.A sar_ctrl_async_phys_0.sg13g2_buf_1$1_3.A 0.01402f
C3929 a_32400_41413# a_32792_41342# 0.01798f
C3930 sar_ctrl_async_phys_0.dac_code_n[5] oa_sar8_acore18_opt_0.sw_bitcell_opt_term_1.bot 0.06773f
C3931 sar_ctrl_async_phys_0.sg13g2_nand2b_1$1_1.B VDD 1.37613f
C3932 sar_ctrl_async_phys_0.sg13g2_buf_1$1_41.X a_31446_45434# 0.12084f
C3933 sar_ctrl_async_phys_0.sg13g2_nor4_1$1_0.C a_33375_40821# 0.01155f
C3934 sar_ctrl_async_phys_0.sg13g2_nand2b_1$1_3.Y sar_ctrl_async_phys_0.sg13g2_a21oi_1$1_5.A2 0.03416f
C3935 a_35053_40730# a_35135_40830# 0.01117f
C3936 sar_ctrl_async_phys_0.sg13g2_nand2_1$1_2.B sar_ctrl_async_phys_0.sg13g2_nand2_1$1_2.Y 0.21233f
C3937 sar_ctrl_async_phys_0.sg13g2_a22oi_1$1_0.Y sar_ctrl_async_phys_0.sg13g2_inv_1$1_1.Y 0.04629f
C3938 sar_ctrl_async_phys_0.sg13g2_a21oi_1$1_1.B1 sar_ctrl_async_phys_0.sg13g2_buf_1$1_36.A 0.21086f
C3939 a_26174_42911# sar_ctrl_async_phys_0.sg13g2_dlygate4sd3_1$1_5.X 0.15862f
C3940 sar_ctrl_async_phys_0.sg13g2_nand2_1$1_2.B a_35053_40730# 0.1712f
C3941 a_32288_31630# VDD 0.1729f
C3942 a_36056_32176# result[4] 0.01377f
C3943 a_34042_40460# sar_ctrl_async_phys_0.sg13g2_nand2_1$1_2.B 0.1204f
C3944 sar_ctrl_async_phys_0.dac_code[7] oa_sar8_acore18_opt_0.sw_bitcell_opt_b0_0.bot 0.11554f
C3945 sar_ctrl_async_phys_0.sg13g2_a22oi_1$1_0.A1 a_31823_33292# 0.01767f
C3946 sar_ctrl_async_phys_0.sg13g2_nor2_1$1_0.Y a_32602_39996# 0.01759f
C3947 sar_ctrl_async_phys_0.dac_code_n[4] sar_ctrl_async_phys_0.dac_code[2] 0.06321f
C3948 sar_ctrl_async_phys_0.sg13g2_buf_1$1_13.A sar_ctrl_async_phys_0.sg13g2_a22oi_1$1_0.A1 0.0269f
C3949 sar_ctrl_async_phys_0.sg13g2_o21ai_1$1_1.B1 a_31935_39775# 0.14322f
C3950 sar_ctrl_async_phys_0.sg13g2_nor2_1$1_2.Y sar_ctrl_async_phys_0.sg13g2_buf_1$1_3.A 0.01175f
C3951 sar_ctrl_async_phys_0.sg13g2_a21oi_1$1_0.A2 sar_ctrl_async_phys_0.bit_active[4] 0.15852f
C3952 a_31638_32138# a_32443_32260# 0.097f
C3953 a_31924_32456# a_32341_32117# 0.3749f
C3954 sar_ctrl_async_phys_0.sg13g2_a21oi_1$1_3.B1 sar_ctrl_async_phys_0.sg13g2_buf_1$1_20.A 0.03198f
C3955 sar_ctrl_async_phys_0.sg13g2_buf_1$1_6.X a_35418_31668# 0.01173f
C3956 sar_ctrl_async_phys_0.dac_code[1] sar_ctrl_async_phys_0.dac_code[6] 0.13606f
C3957 sar_ctrl_async_phys_0.sg13g2_a21oi_1$1_5.A2 a_32984_39830# 0.0243f
C3958 a_33080_30664# result[0] 0.24585f
C3959 a_36056_41972# sar_ctrl_async_phys_0.dac_code[4] 0.24512f
C3960 sar_ctrl_async_phys_0.sg13g2_nor4_1$1_0.C sar_ctrl_async_phys_0.sg13g2_buf_1$1_13.A 0.0204f
C3961 sar_ctrl_async_phys_0.sg13g2_nor2_1$1_12.Y sar_ctrl_async_phys_0.sg13g2_dlygate4sd3_1$1_5.A 0.15869f
C3962 oa_sar8_acore18_opt_0.sw_bitcell_opt_b1_0.bot oa_sar8_acore18_opt_0.sw_bitcell_opt_b0_0.bot 18.5938f
C3963 oa_sar8_acore18_opt_0.sw_bitcell_opt_b2_0.bot oa_sar8_acore18_opt_0.sw_bitcell_opt_term_0.bot 0.3507f
C3964 a_33530_39921# VDD 0.11719f
C3965 sar_ctrl_async_phys_0.sg13g2_nand2b_1$1_1.Y sar_ctrl_async_phys_0.dac_code_n[7] 0.1745f
C3966 sar_ctrl_async_phys_0.sg13g2_nor2_1$1_5.A a_29048_40546# 0.04205f
C3967 sar_ctrl_async_phys_0.sg13g2_buf_1$1_6.X result[3] 0.60277f
C3968 sar_ctrl_async_phys_0.sg13g2_a22oi_1$1_2.A2 a_31832_34412# 0.01093f
C3969 oa_sar8_acore18_opt_0.sw_bitcell_opt_term_0.trkb a_21332_n9711# 0.71191f
C3970 sar_ctrl_async_phys_0.sg13g2_nand2_1$1_3.A sar_ctrl_async_phys_0.sg13g2_nand2_1$1_5.B 0.01582f
C3971 sar_ctrl_async_phys_0.sg13g2_dlygate4sd3_1$1_3.A a_29238_41972# 0.01189f
C3972 sar_ctrl_async_phys_0.dac_code[1] sar_ctrl_async_phys_0.sg13g2_nand2b_1$1_2.A_N 0.01177f
C3973 sar_ctrl_async_phys_0.sg13g2_and2_1$1_3.X a_27032_39034# 0.03689f
C3974 sar_ctrl_async_phys_0.sg13g2_a21oi_1$1_0.A1 sar_ctrl_async_phys_0.sg13g2_nand2_1$1_2.B 0.01882f
C3975 a_33944_47390# VDD 0.15335f
C3976 sar_ctrl_async_phys_0.sg13g2_dfrbpq_1$1_0.CLK a_34808_35200# 0.02207f
C3977 sar_ctrl_async_phys_0.sg13g2_buf_1$1_37.A sar_ctrl_async_phys_0.dac_code[2] 0.45476f
C3978 sar_ctrl_async_phys_0.sg13g2_nor2b_1$1_3.Y a_32533_40471# 0.0122f
C3979 sar_ctrl_async_phys_0.sg13g2_buf_1$1_4.A VDD 0.7823f
C3980 a_26454_39702# VDD 0.22632f
C3981 sar_ctrl_async_phys_0.sg13g2_a21oi_1$1_3.B1 sar_ctrl_async_phys_0.sg13g2_nand2_1$1_3.B 0.02685f
C3982 sar_ctrl_async_phys_0.sg13g2_nor4_1$1_0.C sar_ctrl_async_phys_0.sg13g2_nor2_1$1_2.Y 0.01188f
C3983 sar_ctrl_async_phys_0.sg13g2_buf_1$1_42.A sar_ctrl_async_phys_0.sg13g2_buf_1$1_20.A 0.02213f
C3984 sar_ctrl_async_phys_0.dac_code[1] sar_ctrl_async_phys_0.dac_code[3] 0.22334f
C3985 sar_ctrl_async_phys_0.sg13g2_buf_1$1_3.A a_32090_40428# 0.01287f
C3986 a_25608_40501# a_25878_40460# 0.26306f
C3987 sar_ctrl_async_phys_0.sg13g2_buf_1$1_14.A a_34555_35935# 0.01767f
C3988 sar_ctrl_async_phys_0.sg13g2_buf_1$1_37.A a_36056_42760# 0.0225f
C3989 VDD result[0] 0.12545f
C3990 a_33344_37678# VDD 0.1747f
C3991 sar_ctrl_async_phys_0.sg13g2_nor4_1$1_0.Y sar_ctrl_async_phys_0.sg13g2_nand2b_1$1_0.A_N 0.75532f
C3992 sar_ctrl_async_phys_0.sg13g2_a22oi_1$1_0.A1 a_34308_37400# 0.0731f
C3993 sar_ctrl_async_phys_0.sg13g2_nand2b_1$1_4.A_N a_36152_43570# 0.0243f
C3994 sar_ctrl_async_phys_0.sg13g2_a21oi_1$1_1.B1 a_35245_45266# 0.10627f
C3995 oa_sar8_acore18_opt_0.sw_bitcell_opt_term_0.trkb oa_sar8_acore18_opt_0.sw_bitcell_opt_b3_1.bot 1.42826f
C3996 sar_ctrl_async_phys_0.sg13g2_buf_1$1_35.A sar_ctrl_async_phys_0.dac_code[2] 0.09661f
C3997 a_32251_35284# a_33248_35382# 0.02979f
C3998 sar_ctrl_async_phys_0.sg13g2_buf_1$1_10.A sar_ctrl_async_phys_0.sg13g2_inv_1$1_0.A 0.01732f
C3999 oa_sar8_acore18_opt_0.sw_bitcell_opt_b5_1.bot VDD 3.86899f
C4000 sar_ctrl_async_phys_0.sg13g2_and2_1$1_1.B sar_ctrl_async_phys_0.bit_active[3] 0.06981f
C4001 sar_ctrl_async_phys_0.sg13g2_a22oi_1$1_2.A2 sar_ctrl_async_phys_0.sg13g2_buf_1$1_3.A 0.17927f
C4002 sar_ctrl_async_phys_0.dac_code[0] sar_ctrl_async_phys_0.dac_code[2] 0.20601f
C4003 sar_ctrl_async_phys_0.sg13g2_buf_1$1_35.A a_36056_42760# 0.27101f
C4004 sar_ctrl_async_phys_0.sg13g2_a22oi_1$1_1.A2 a_34555_35935# 0.05142f
C4005 sar_ctrl_async_phys_0.sg13g2_and2_1$1_0.A sar_ctrl_async_phys_0.sg13g2_dlygate4sd3_1$1_7.A 0.33074f
C4006 sar_ctrl_async_phys_0.sg13g2_nor2_1$1_8.B VDD 0.65167f
C4007 sar_ctrl_async_phys_0.sg13g2_dfrbpq_1$1_0.CLK sar_ctrl_async_phys_0.sg13g2_nand2_1$1_2.B 0.01677f
C4008 a_34171_41332# a_34911_41287# 0.26905f
C4009 a_33940_44552# a_34459_44356# 0.34114f
C4010 sar_ctrl_async_phys_0.dac_code[0] a_36056_42760# 0.01743f
C4011 sar_ctrl_async_phys_0.hold_req sar_ctrl_async_phys_0.dac_code[5] 0.11185f
C4012 sar_ctrl_async_phys_0.sg13g2_buf_1$1_1.A sar_ctrl_async_phys_0.sg13g2_dfrbpq_1$1_5.D 0.01167f
C4013 sar_ctrl_async_phys_0.sg13g2_buf_1$1_17.A sar_ctrl_async_phys_0.sg13g2_buf_1$1_6.X 0.03383f
C4014 sar_ctrl_async_phys_0.sg13g2_buf_1$1_14.A a_34363_36796# 0.05597f
C4015 sar_ctrl_async_phys_0.sg13g2_buf_1$1_6.X sar_ctrl_async_phys_0.sg13g2_buf_1$1_0.A 0.7555f
C4016 sar_ctrl_async_phys_0.sg13g2_dlygate4sd3_1$1_9.A sar_ctrl_async_phys_0.sg13g2_nor2_1$1_13.A 0.01044f
C4017 sar_ctrl_async_phys_0.sg13g2_a22oi_1$1_2.A2 sar_ctrl_async_phys_0.sg13g2_a22oi_1$1_0.A1 0.12606f
C4018 sar_ctrl_async_phys_0.dac_code[7] a_35948_n9612# 1.21129f
C4019 sar_ctrl_async_phys_0.sg13g2_nand2_1$1_5.Y VDD 0.63821f
C4020 a_33252_36642# VDD 0.23977f
C4021 sar_ctrl_async_phys_0.sg13g2_nor2_1$1_10.B sar_ctrl_async_phys_0.sg13g2_a21oi_1$1_0.A1 0.40253f
C4022 sar_ctrl_async_phys_0.sg13g2_a22oi_1$1_1.A2 a_34363_36796# 0.02819f
C4023 sar_ctrl_async_phys_0.sg13g2_buf_1$1_15.A a_35578_41508# 0.01092f
C4024 sar_ctrl_async_phys_0.sg13g2_and2_1$1_3.A a_26630_37814# 0.10236f
C4025 sar_ctrl_async_phys_0.sg13g2_a21oi_1$1_1.B1 sar_ctrl_async_phys_0.sg13g2_buf_1$1_46.A 0.02229f
C4026 a_33109_45725# VDD 0.25449f
C4027 sar_ctrl_async_phys_0.sg13g2_a21oi_1$1_3.B1 sar_ctrl_async_phys_0.sg13g2_nand2b_1$1_3.Y 0.1655f
C4028 sar_ctrl_async_phys_0.sg13g2_buf_1$1_32.A a_33914_44457# 0.01263f
C4029 sar_ctrl_async_phys_0.sg13g2_inv_1$1_3.Y VDD 0.52039f
C4030 sar_ctrl_async_phys_0.sg13g2_nor2_1$1_4.Y track 0.09427f
C4031 a_34266_37436# VDD 0.01262f
C4032 a_32635_40471# a_33375_40821# 0.26905f
C4033 sar_ctrl_async_phys_0.sg13g2_nor4_1$1_0.C sar_ctrl_async_phys_0.sg13g2_a22oi_1$1_2.A2 0.01442f
C4034 a_34442_45366# sar_ctrl_async_phys_0.sg13g2_buf_1$1_32.A 0.01562f
C4035 a_35103_43845# a_35770_43484# 0.0894f
C4036 sar_ctrl_async_phys_0.sg13g2_nor2b_1$1_0.A sar_ctrl_async_phys_0.sg13g2_a21oi_1$1_5.Y 0.15492f
C4037 sar_ctrl_async_phys_0.sg13g2_nand2b_1$1_1.B a_35456_44454# 0.04929f
C4038 sar_ctrl_async_phys_0.sg13g2_dfrbpq_1$1_0.CLK sar_ctrl_async_phys_0.sg13g2_nor2_1$1_10.B 1.00387f
C4039 sar_ctrl_async_phys_0.sg13g2_a21oi_1$1_4.A2 sar_ctrl_async_phys_0.sg13g2_a21oi_1$1_0.A1 0.19524f
C4040 sar_ctrl_async_phys_0.sg13g2_dlygate4sd3_1$1_7.A sar_ctrl_async_phys_0.sg13g2_dlygate4sd3_1$1_6.X 0.03088f
C4041 oa_sar8_acore18_opt_0.sw_bitcell_opt_b1_0.bot a_35948_n9612# 0.02266f
C4042 sar_ctrl_async_phys_0.dac_code_n[4] oa_sar8_acore18_opt_0.sw_bitcell_opt_b3_0.bot 0.0829f
C4043 sar_ctrl_async_phys_0.sg13g2_nor2_1$1_1.Y sar_ctrl_async_phys_0.sg13g2_buf_1$1_19.A 0.05145f
C4044 sar_ctrl_async_phys_0.sg13g2_a21oi_1$1_0.B1 sar_ctrl_async_phys_0.sg13g2_buf_1$1_13.A 0.02885f
C4045 a_34075_39820# a_35072_39918# 0.02979f
C4046 sar_ctrl_async_phys_0.dac_code_n[5] sar_ctrl_async_phys_0.dac_code_n[1] 0.1418f
C4047 a_32580_43448# sar_ctrl_async_phys_0.sg13g2_buf_1$1_20.A 0.26377f
C4048 sar_ctrl_async_phys_0.sg13g2_a22oi_1$1_2.B2 sar_ctrl_async_phys_0.sg13g2_buf_1$1_10.A 0.47439f
C4049 sar_ctrl_async_phys_0.sg13g2_a21oi_1$1_2.Y a_29653_38959# 0.04042f
C4050 sar_ctrl_async_phys_0.sg13g2_nor2_1$1_1.Y sar_ctrl_async_phys_0.sg13g2_and2_1$1_0.X 0.02502f
C4051 sar_ctrl_async_phys_0.dac_code_n[1] oa_sar8_acore18_opt_0.sw_bitcell_opt_term_0.gb 0.09676f
C4052 a_30964_46512# a_31483_46519# 0.34102f
C4053 sar_ctrl_async_phys_0.sg13g2_buf_1$1_42.A sar_ctrl_async_phys_0.sg13g2_nand2b_1$1_3.Y 0.19597f
C4054 sar_ctrl_async_phys_0.sg13g2_nor2b_1$1_0.A a_32580_43448# 0.05783f
C4055 sar_ctrl_async_phys_0.sg13g2_buf_1$1_41.X a_31483_46519# 0.42542f
C4056 sar_ctrl_async_phys_0.sg13g2_buf_1$1_13.A a_32635_40471# 0.01796f
C4057 a_31136_43726# a_31546_43484# 0.10373f
C4058 sar_ctrl_async_phys_0.sg13g2_a21oi_1$1_2.Y VDD 0.78477f
C4059 sar_ctrl_async_phys_0.sg13g2_inv_1$1_6.Y sar_ctrl_async_phys_0.sg13g2_inv_1$1_6.A 0.08186f
C4060 sar_ctrl_async_phys_0.sg13g2_nor2b_1$1_4.Y sar_ctrl_async_phys_0.sg13g2_a21oi_1$1_4.A2 0.02024f
C4061 sar_ctrl_async_phys_0.sg13g2_nor2_1$1_13.B sar_ctrl_async_phys_0.sg13g2_nand2b_1$1_0.Y 0.01727f
C4062 sar_ctrl_async_phys_0.sg13g2_buf_1$1_14.A sar_ctrl_async_phys_0.sg13g2_buf_1$1_4.A 0.07842f
C4063 a_27249_39888# VDD 0.23064f
C4064 sar_ctrl_async_phys_0.sg13g2_a21oi_1$1_6.B1 sar_ctrl_async_phys_0.sg13g2_buf_1$1_20.A 0.25254f
C4065 sar_ctrl_async_phys_0.sg13g2_dlygate4sd3_1$1_5.A track 0.08891f
C4066 VDD vinp 0.29538f
C4067 oa_sar8_acore18_opt_0.sw_bitcell_opt_term_0.trkb oa_sar8_acore18_opt_0.sw_bitcell_opt_b7_1.bot 1.58763f
C4068 oa_sar8_acore18_opt_0.sw_bitcell_opt_term_0.vin VDD 4.17846f
C4069 sar_ctrl_async_phys_0.sg13g2_a22oi_1$1_1.A2 sar_ctrl_async_phys_0.sg13g2_buf_1$1_4.A 0.02767f
C4070 sar_ctrl_async_phys_0.sg13g2_buf_1$1_42.A sar_ctrl_async_phys_0.sg13g2_buf_1$1_41.X 0.39116f
C4071 a_31732_35480# a_32251_35284# 0.34114f
C4072 sar_ctrl_async_phys_0.sg13g2_inv_1$1_7.A VDD 0.73699f
C4073 sar_ctrl_async_phys_0.sg13g2_nor2_1$1_2.Y a_32635_40471# 0.02196f
C4074 a_31195_35935# VDD 0.20835f
C4075 sar_ctrl_async_phys_0.dac_code[4] oa_sar8_acore18_opt_0.sw_bitcell_opt_term_0.trkb 1.96931f
C4076 sar_ctrl_async_phys_0.sg13g2_buf_1$1_6.X a_32149_35141# 0.03452f
C4077 a_32031_31749# a_31937_31749# 0.28931f
C4078 sar_ctrl_async_phys_0.sg13g2_dlygate4sd3_1$1_5.X a_26184_42013# 0.4069f
C4079 sar_ctrl_async_phys_0.sg13g2_a22oi_1$1_0.A2 a_34895_32460# 0.01618f
C4080 sar_ctrl_async_phys_0.sg13g2_dfrbpq_1$1_0.CLK result[4] 0.03054f
C4081 sar_ctrl_async_phys_0.sg13g2_nor2_1$1_3.Y VDD 0.60765f
C4082 oa_sar8_acore18_opt_0.sw_bitcell_opt_b7_1.VSS oa_sar8_acore18_opt_0.bstrap_opt_w2_c1200_1.gb 0.08336f
C4083 sar_ctrl_async_phys_0.sg13g2_a21oi_1$1_3.B1 sar_ctrl_async_phys_0.sg13g2_buf_1$1_37.A 0.02666f
C4084 a_33626_41433# a_34069_41189# 0.02242f
C4085 a_33366_41210# a_33652_41528# 0.41329f
C4086 sar_ctrl_async_phys_0.sg13g2_a22oi_1$1_0.A2 sar_ctrl_async_phys_0.sg13g2_a22oi_1$1_0.B2 0.22784f
C4087 sar_ctrl_async_phys_0.sg13g2_nand2b_1$1_0.A_N sar_ctrl_async_phys_0.sg13g2_nor2_1$1_13.A 0.22406f
C4088 sar_ctrl_async_phys_0.dac_code[4] sar_ctrl_async_phys_0.cmp_n 0.07718f
C4089 a_30507_35204# a_30384_35294# 0.01108f
C4090 sar_ctrl_async_phys_0.sg13g2_nand3_1$1_0.C sar_ctrl_async_phys_0.sg13g2_nand3_1$1_0.Y 0.01089f
C4091 sar_ctrl_async_phys_0.dac_code[0] oa_sar8_acore18_opt_0.sw_bitcell_opt_b3_0.bot 0.10525f
C4092 sar_ctrl_async_phys_0.sg13g2_nand2b_1$1_3.Y sar_ctrl_async_phys_0.sg13g2_a21oi_1$1_5.Y 0.31957f
C4093 sar_ctrl_async_phys_0.sg13g2_nand2_1$1_5.Y sar_ctrl_async_phys_0.sg13g2_buf_1$1_14.A 0.04499f
C4094 sar_ctrl_async_phys_0.sg13g2_a21oi_1$1_0.A1 a_31640_41342# 0.01977f
C4095 sar_ctrl_async_phys_0.sg13g2_a21oi_1$1_0.A2 a_35962_35924# 0.12547f
C4096 a_34132_32904# VDD 0.10126f
C4097 sar_ctrl_async_phys_0.sg13g2_a22oi_1$1_0.A1 a_33168_32986# 0.02056f
C4098 oa_sar8_acore18_opt_0.sw_bitcell_opt_term_0.vin oa_sar8_acore18_opt_0.sw_bitcell_opt_b6_0.bot 4.13837f
C4099 oa_sar8_acore18_opt_0.sw_bitcell_opt_b7_0.bot oa_sar8_acore18_opt_0.sw_bitcell_opt_b5_0.bot 1.04844f
C4100 oa_sar8_acore18_opt_0.sw_bitcell_opt_b1_1.bot oa_sar8_acore18_opt_0.sw_bitcell_opt_b7_1.VSS 1.52045f
C4101 w_39600_n9960# oa_sar8_acore18_opt_0.sw_bitcell_opt_term_0.vin 0.03635f
C4102 sar_ctrl_async_phys_0.sg13g2_nand2b_1$1_1.B sar_ctrl_async_phys_0.sg13g2_buf_1$1_20.A 0.05856f
C4103 a_31579_44356# a_32319_44311# 0.26905f
C4104 sar_ctrl_async_phys_0.sg13g2_nor2_1$1_6.Y sar_ctrl_async_phys_0.sg13g2_nand2_1$1_1.Y 0.14809f
C4105 sar_ctrl_async_phys_0.sg13g2_nand2_1$1_5.Y sar_ctrl_async_phys_0.bit_active[7] 0.01326f
C4106 sar_ctrl_async_phys_0.sg13g2_a22oi_1$1_1.A2 a_34420_33325# 0.01751f
C4107 a_34555_35935# a_35295_36285# 0.26905f
C4108 a_36336_41342# VDD 0.07215f
C4109 sar_ctrl_async_phys_0.sg13g2_a22oi_1$1_1.Y a_33752_33688# 0.01408f
C4110 sar_ctrl_async_phys_0.dac_code[4] oa_sar8_acore18_opt_0.sw_bitcell_opt_b4_0.bot 1.73599f
C4111 sar_ctrl_async_phys_0.sg13g2_buf_1$1_6.X sar_ctrl_async_phys_0.sg13g2_a22oi_1$1_1.B2 0.06993f
C4112 a_32116_40464# a_32404_40885# 0.43707f
C4113 sar_ctrl_async_phys_0.sg13g2_a21oi_1$1_0.A2 a_35103_36751# 0.02986f
C4114 sar_ctrl_async_phys_0.sg13g2_a21oi_1$1_0.B1 sar_ctrl_async_phys_0.sg13g2_nand2b_1$1_6.A_N 0.04109f
C4115 a_34261_43495# a_34363_43495# 0.47795f
C4116 a_33658_44996# a_34040_45082# 0.01012f
C4117 sar_ctrl_async_phys_0.dac_code_n[4] oa_sar8_acore18_opt_0.sw_bitcell_opt_term_0.bot 0.19145f
C4118 sar_ctrl_async_phys_0.sg13g2_nor2_1$1_10.A a_30480_42854# 0.01652f
C4119 sar_ctrl_async_phys_0.sg13g2_nor2_1$1_1.Y sar_ctrl_async_phys_0.sg13g2_a22oi_1$1_4.A2 0.07868f
C4120 a_34520_47296# sar_ctrl_async_phys_0.cmp_valid 0.25546f
C4121 a_30848_32358# a_31258_32436# 0.10373f
C4122 sar_ctrl_async_phys_0.sg13g2_a22oi_1$1_2.A2 a_32635_40471# 0.01547f
C4123 oa_sar8_acore18_opt_0.bstrap_opt_w2_c1200_1.out oa_sar8_acore18_opt_0.sw_bitcell_opt_term_0.trkb 10.7665f
C4124 sar_ctrl_async_phys_0.dac_code_n[5] a_36056_46508# 0.01311f
C4125 sar_ctrl_async_phys_0.sg13g2_nor2_1$1_10.A a_31140_42690# 0.26798f
C4126 sar_ctrl_async_phys_0.sg13g2_a21oi_1$1_4.B1 sar_ctrl_async_phys_0.sg13g2_buf_1$1_13.A 0.02355f
C4127 sar_ctrl_async_phys_0.sg13g2_buf_1$1_6.X a_32031_31749# 0.14533f
C4128 sar_ctrl_async_phys_0.sg13g2_nor2_1$1_2.Y a_33270_39698# 0.03027f
C4129 sar_ctrl_async_phys_0.sg13g2_a21oi_1$1_6.B1 sar_ctrl_async_phys_0.sg13g2_nand2b_1$1_3.Y 0.15232f
C4130 sar_ctrl_async_phys_0.sg13g2_nand2b_1$1_1.B sar_ctrl_async_phys_0.sg13g2_nand2_1$1_3.B 0.6502f
C4131 sar_ctrl_async_phys_0.sg13g2_o21ai_1$1_1.B1 a_32986_44532# 0.05395f
C4132 sar_ctrl_async_phys_0.sg13g2_and2_1$1_0.A sar_ctrl_async_phys_0.sg13g2_buf_1$1_1.A 0.04452f
C4133 sar_ctrl_async_phys_0.sg13g2_a22oi_1$1_0.B2 a_35463_31435# 0.01363f
C4134 a_33270_39698# a_33973_39677# 0.02454f
C4135 sar_ctrl_async_phys_0.cmp_fire a_25608_40501# 0.02225f
C4136 oa_sar8_acore18_opt_0.sw_bitcell_opt_b2_1.bot oa_sar8_acore18_opt_0.bstrap_opt_w2_c1200_1.gb 0.64344f
C4137 a_35648_30846# a_36058_30924# 0.10373f
C4138 a_31381_46519# sar_ctrl_async_phys_0.sg13g2_dfrbpq_1$1_0.CLK 0.26619f
C4139 sar_ctrl_async_phys_0.sg13g2_buf_1$1_32.A a_34093_42912# 0.01833f
C4140 sar_ctrl_async_phys_0.sg13g2_dfrbpq_1$1_0.CLK a_30037_43495# 0.29224f
C4141 sar_ctrl_async_phys_0.sg13g2_inv_1$1_0.Y result[3] 0.05325f
C4142 sar_ctrl_async_phys_0.sg13g2_nor2_1$1_4.Y sar_ctrl_async_phys_0.sg13g2_nor2_1$1_3.B 0.04369f
C4143 sar_ctrl_async_phys_0.sg13g2_a21oi_1$1_4.B1 sar_ctrl_async_phys_0.sg13g2_nor2_1$1_2.Y 0.01676f
C4144 sar_ctrl_async_phys_0.sg13g2_buf_1$1_41.X a_31136_43726# 0.12858f
C4145 a_30037_43495# a_30139_43495# 0.47795f
C4146 sar_ctrl_async_phys_0.sg13g2_a21oi_1$1_2.B1 a_33652_41528# 0.05263f
C4147 result[7] done 0.20772f
C4148 sar_ctrl_async_phys_0.dac_code_n[4] m3_38288_n2380# 0.04834f
C4149 oa_sar8_acore18_opt_0.sw_bitcell_opt_b0_1.bot oa_sar8_acore18_opt_0.sw_bitcell_opt_b3_1.bot 0.42343f
C4150 oa_sar8_acore18_opt_0.sw_bitcell_opt_b1_1.bot oa_sar8_acore18_opt_0.sw_bitcell_opt_b2_1.bot 14.4109f
C4151 sar_ctrl_async_phys_0.sg13g2_nor2b_1$1_0.A sar_ctrl_async_phys_0.sg13g2_buf_1$1_4.A 0.1696f
C4152 sar_ctrl_async_phys_0.sg13g2_buf_1$1_36.A a_36056_41972# 0.2594f
C4153 sar_ctrl_async_phys_0.sg13g2_a21oi_1$1_6.B1 sar_ctrl_async_phys_0.sg13g2_buf_1$1_41.X 0.06907f
C4154 sar_ctrl_async_phys_0.dac_code[7] oa_sar8_acore18_opt_0.sw_bitcell_opt_b7_0.bot 3.77656f
C4155 sar_ctrl_async_phys_0.dac_code_n[4] oa_sar8_acore18_opt_0.bstrap_opt_w2_c1200_1.gb 0.12881f
C4156 a_35648_30846# result[1] 0.0139f
C4157 sar_ctrl_async_phys_0.sg13g2_a21oi_1$1_6.B1 sar_ctrl_async_phys_0.dac_code_n[4] 0.25923f
C4158 sar_ctrl_async_phys_0.sg13g2_buf_1$1_2.A sar_ctrl_async_phys_0.sg13g2_a22oi_1$1_0.B1 0.03338f
C4159 sar_ctrl_async_phys_0.sg13g2_a22oi_1$1_0.A1 a_34895_32460# 0.01865f
C4160 sar_ctrl_async_phys_0.dac_code[5] oa_sar8_acore18_opt_0.sw_bitcell_opt_term_0.VSS 1.32817f
C4161 sar_ctrl_async_phys_0.sg13g2_dfrbpq_1$1_0.CLK a_34453_35935# 0.30917f
C4162 a_36058_32900# result[6] 0.01398f
C4163 sar_ctrl_async_phys_0.sg13g2_a22oi_1$1_0.A1 sar_ctrl_async_phys_0.sg13g2_a22oi_1$1_0.B2 0.14188f
C4164 sar_ctrl_async_phys_0.sg13g2_nand2b_1$1_3.Y sar_ctrl_async_phys_0.sg13g2_nand2b_1$1_1.B 0.11013f
C4165 sar_ctrl_async_phys_0.sg13g2_buf_1$1_15.A sar_ctrl_async_phys_0.sg13g2_a21oi_1$1_2.B1 0.86267f
C4166 sar_ctrl_async_phys_0.sg13g2_o21ai_1$1_1.B1 a_33366_41210# 0.08569f
C4167 a_32288_31630# a_32698_31388# 0.10373f
C4168 sar_ctrl_async_phys_0.sg13g2_buf_1$1_41.X a_31034_44457# 0.26628f
C4169 sar_ctrl_async_phys_0.sg13g2_a22oi_1$1_2.Y a_31189_31399# 0.01088f
C4170 a_27894_35924# VDD 0.27286f
C4171 a_35672_38948# sar_ctrl_async_phys_0.sg13g2_buf_1$1_21.A 0.02393f
C4172 sar_ctrl_async_phys_0.dac_code_n[1] sar_ctrl_async_phys_0.dac_code[2] 0.05494f
C4173 sar_ctrl_async_phys_0.sg13g2_and2_1$1_3.X a_27134_39887# 0.01135f
C4174 sar_ctrl_async_phys_0.dac_code[0] oa_sar8_acore18_opt_0.sw_bitcell_opt_term_0.bot 0.17387f
C4175 sar_ctrl_async_phys_0.dac_code_n[4] oa_sar8_acore18_opt_0.sw_bitcell_opt_b1_1.bot 0.06598f
C4176 a_31716_38912# sar_ctrl_async_phys_0.sg13g2_and2_1$1_0.X 0.28341f
C4177 oa_sar8_acore18_opt_0.sw_bitcell_opt_b7_0.bot oa_sar8_acore18_opt_0.sw_bitcell_opt_b1_0.bot 1.00641f
C4178 oa_sar8_acore18_opt_0.sw_bitcell_opt_term_0.vin oa_sar8_acore18_opt_0.sw_bitcell_opt_b2_0.bot 3.9682f
C4179 oa_sar8_acore18_opt_0.sw_bitcell_opt_b5_1.bot oa_sar8_acore18_opt_0.sw_bitcell_opt_b7_1.VSS 2.114f
C4180 sar_ctrl_async_phys_0.sg13g2_a21oi_1$1_0.A2 a_34453_35935# 0.02235f
C4181 sar_ctrl_async_phys_0.sg13g2_buf_1$1_20.A sar_ctrl_async_phys_0.sg13g2_nand2_1$1_5.Y 0.44595f
C4182 a_30774_44234# a_31060_44552# 0.41329f
C4183 sar_ctrl_async_phys_0.sg13g2_nor2b_1$1_0.A a_33252_36642# 0.05972f
C4184 a_34453_35935# a_34324_36349# 0.01562f
C4185 a_34036_35928# a_34555_35935# 0.34102f
C4186 sar_ctrl_async_phys_0.sg13g2_a22oi_1$1_1.A2 a_34132_32904# 0.01499f
C4187 a_35168_41430# VDD 0.17006f
C4188 sar_ctrl_async_phys_0.dac_code[4] oa_sar8_acore18_opt_0.sw_bitcell_opt_b0_0.bot 0.1489f
C4189 sar_ctrl_async_phys_0.sg13g2_a21oi_1$1_4.B1 sar_ctrl_async_phys_0.sg13g2_a22oi_1$1_2.A2 0.01387f
C4190 sar_ctrl_async_phys_0.sg13g2_buf_1$1_41.X sar_ctrl_async_phys_0.sg13g2_nand2b_1$1_1.B 0.02478f
C4191 sar_ctrl_async_phys_0.dac_code_n[4] sar_ctrl_async_phys_0.sg13g2_nand2b_1$1_1.B 0.03315f
C4192 sar_ctrl_async_phys_0.sg13g2_buf_1$1_1.A a_34132_34416# 0.02027f
C4193 a_29812_33968# a_30100_33663# 0.43707f
C4194 sar_ctrl_async_phys_0.sg13g2_buf_1$1_6.X a_34651_32911# 0.43424f
C4195 sar_ctrl_async_phys_0.sg13g2_dfrbpq_1$1_0.CLK a_31189_31399# 0.27125f
C4196 a_34520_46508# sar_ctrl_async_phys_0.sg13g2_a21oi_1$1_1.B1 0.26716f
C4197 sar_ctrl_async_phys_0.sg13g2_buf_1$1_1.A sar_ctrl_async_phys_0.sg13g2_a22oi_1$1_3.B1 0.03128f
C4198 sar_ctrl_async_phys_0.cmp_p oa_sar8_acore18_opt_0.sw_tg_opt_1.bot 0.1185f
C4199 sar_ctrl_async_phys_0.sg13g2_and2_1$1_6.X a_31935_39775# 0.0232f
C4200 a_26174_42911# VDD 0.18891f
C4201 sar_ctrl_async_phys_0.sg13g2_buf_1$1_4.A sar_ctrl_async_phys_0.sg13g2_nor2b_1$1_1.B_N 0.02136f
C4202 a_31830_40898# a_32090_40428# 0.75507f
C4203 a_35288_47296# sar_ctrl_async_phys_0.cmp_valid 0.0124f
C4204 sar_ctrl_async_phys_0.sg13g2_a22oi_1$1_3.B1 sar_ctrl_async_phys_0.sg13g2_buf_1$1_7.A 0.46905f
C4205 a_33558_43922# a_33818_43452# 0.75507f
C4206 a_30783_40821# a_31450_40460# 0.0894f
C4207 a_34261_36653# a_34453_35935# 0.01774f
C4208 sar_ctrl_async_phys_0.sg13g2_a21oi_1$1_2.B1 a_31450_40460# 0.12091f
C4209 sar_ctrl_async_phys_0.sg13g2_nor2_1$1_10.B sar_ctrl_async_phys_0.sg13g2_nor2_1$1_18.A 0.02751f
C4210 a_32251_45007# a_33248_45238# 0.03061f
C4211 sar_ctrl_async_phys_0.sg13g2_a22oi_1$1_2.B2 a_33846_33338# 0.01449f
C4212 a_29332_32456# a_30591_32215# 0.01529f
C4213 sar_ctrl_async_phys_0.sg13g2_a22oi_1$1_2.A2 a_31830_40898# 0.02658f
C4214 sar_ctrl_async_phys_0.sg13g2_buf_1$1_6.X a_30746_31356# 0.2505f
C4215 sar_ctrl_async_phys_0.sg13g2_and2_1$1_0.A sar_ctrl_async_phys_0.sg13g2_nand3_1$1_0.Y 0.19783f
C4216 sar_ctrl_async_phys_0.sg13g2_buf_1$1_7.A sar_ctrl_async_phys_0.sg13g2_buf_1$1_8.A 0.01477f
C4217 sar_ctrl_async_phys_0.sg13g2_nand2_1$1_3.B sar_ctrl_async_phys_0.sg13g2_nand2_1$1_5.Y 0.02162f
C4218 oa_sar8_acore18_opt_0.sw_bitcell_opt_b6_1.bot oa_sar8_acore18_opt_0.bstrap_opt_w2_c1200_1.gb 0.73114f
C4219 a_34132_30944# a_35391_30703# 0.01529f
C4220 a_30678_46946# a_31381_46519# 0.02432f
C4221 a_26566_41996# a_26454_41972# 0.55452f
C4222 sar_ctrl_async_phys_0.sg13g2_o21ai_1$1_1.B1 a_30783_40821# 0.15268f
C4223 sar_ctrl_async_phys_0.sg13g2_a21oi_1$1_5.Y a_31935_36285# 0.04293f
C4224 a_35245_45936# a_35000_45878# 0.01096f
C4225 sar_ctrl_async_phys_0.sg13g2_o21ai_1$1_1.B1 a_32251_45007# 0.02801f
C4226 sar_ctrl_async_phys_0.sg13g2_o21ai_1$1_1.B1 sar_ctrl_async_phys_0.sg13g2_a21oi_1$1_2.B1 0.43902f
C4227 sar_ctrl_async_phys_0.sg13g2_nor2b_1$1_0.A sar_ctrl_async_phys_0.sg13g2_a21oi_1$1_2.Y 0.45157f
C4228 sar_ctrl_async_phys_0.sg13g2_nand2b_1$1_1.B sar_ctrl_async_phys_0.sg13g2_buf_1$1_37.A 0.11535f
C4229 sar_ctrl_async_phys_0.sg13g2_and2_1$1_0.A sar_ctrl_async_phys_0.sg13g2_a21oi_1$1_2.B1 0.05637f
C4230 a_29334_43922# a_30037_43495# 0.02432f
C4231 oa_sar8_acore18_opt_0.sw_bitcell_opt_b2_1.bot oa_sar8_acore18_opt_0.sw_bitcell_opt_b5_1.bot 0.56612f
C4232 oa_sar8_acore18_opt_0.sw_bitcell_opt_b0_1.bot oa_sar8_acore18_opt_0.sw_bitcell_opt_b7_1.bot 1.09239f
C4233 oa_sar8_acore18_opt_0.sw_bitcell_opt_b1_1.bot oa_sar8_acore18_opt_0.sw_bitcell_opt_b6_1.bot 0.51968f
C4234 oa_sar8_acore18_opt_0.sw_bitcell_opt_b3_1.bot oa_sar8_acore18_opt_0.sw_bitcell_opt_b4_1.bot 14.9891f
C4235 a_33252_36642# sar_ctrl_async_phys_0.sg13g2_nor2b_1$1_1.B_N 0.26291f
C4236 sar_ctrl_async_phys_0.sg13g2_a21oi_1$1_1.B1 sar_ctrl_async_phys_0.sg13g2_nand2_1$1_2.B 0.02917f
C4237 sar_ctrl_async_phys_0.sg13g2_o21ai_1$1_1.B1 sar_ctrl_async_phys_0.sg13g2_nand2b_1$1_0.Y 0.02458f
C4238 a_35595_40460# VDD 0.29276f
C4239 a_33951_45823# a_34618_46044# 0.0894f
C4240 a_32576_44454# VDD 0.17061f
C4241 sar_ctrl_async_phys_0.sg13g2_a22oi_1$1_2.Y a_31247_32876# 0.02339f
C4242 sar_ctrl_async_phys_0.sg13g2_nand2b_1$1_1.B sar_ctrl_async_phys_0.sg13g2_buf_1$1_35.A 0.22469f
C4243 a_34106_30849# result[1] 0.01999f
C4244 a_34224_45082# VDD 0.07738f
C4245 sar_ctrl_async_phys_0.sg13g2_nor4_1$1_0.C a_28176_39830# 0.01267f
C4246 oa_sar8_acore18_opt_0.sw_bitcell_opt_term_0.vin m3_45264_n2380# 0.05057f
C4247 sar_ctrl_async_phys_0.sg13g2_nand2b_1$1_4.A_N VDD 0.60516f
C4248 a_32666_45969# sar_ctrl_async_phys_0.sg13g2_o21ai_1$1_1.B1 0.24352f
C4249 sar_ctrl_async_phys_0.sg13g2_nand2b_1$1_3.Y sar_ctrl_async_phys_0.sg13g2_nand2_1$1_5.Y 0.32688f
C4250 a_34093_42912# a_34520_42760# 0.08015f
C4251 sar_ctrl_async_phys_0.sg13g2_nor2b_1$1_0.A a_31195_35935# 0.02282f
C4252 sar_ctrl_async_phys_0.sg13g2_dfrbpq_1$1_0.CLK a_32602_35924# 0.05943f
C4253 sar_ctrl_async_phys_0.sg13g2_nand3_1$1_0.Y sar_ctrl_async_phys_0.sg13g2_dlygate4sd3_1$1_6.X 0.03854f
C4254 a_31189_31399# a_31291_31399# 0.47795f
C4255 sar_ctrl_async_phys_0.dac_code[6] vinn 0.10725f
C4256 a_26364_45710# sar_ctrl_async_phys_0.sg13g2_and2_1$1_0.A 0.26739f
C4257 sar_ctrl_async_phys_0.sg13g2_and2_1$1_1.B sar_ctrl_async_phys_0.sg13g2_buf_1$1_4.A 0.37074f
C4258 sar_ctrl_async_phys_0.sg13g2_nor4_1$1_0.C sar_ctrl_async_phys_0.sg13g2_nand2_1$1_5.B 0.02717f
C4259 sar_ctrl_async_phys_0.sg13g2_buf_1$1_6.X sar_ctrl_async_phys_0.sg13g2_inv_1$1_0.Y 0.3663f
C4260 sar_ctrl_async_phys_0.sg13g2_and2_1$1_0.A a_31162_38948# 0.05526f
C4261 sar_ctrl_async_phys_0.dac_code[4] a_35948_n9612# 2.00726f
C4262 a_33344_37678# a_33754_37436# 0.10373f
C4263 sar_ctrl_async_phys_0.dac_code_n[1] oa_sar8_acore18_opt_0.sw_bitcell_opt_b3_0.bot 0.06138f
C4264 oa_sar8_acore18_opt_0.sw_bitcell_opt_term_1.bot oa_sar8_acore18_opt_0.bstrap_opt_w2_c1200_1.gb 0.64577f
C4265 sar_ctrl_async_phys_0.sg13g2_a21oi_1$1_3.B1 sar_ctrl_async_phys_0.sg13g2_nand2b_1$1_5.A_N 0.18314f
C4266 sar_ctrl_async_phys_0.sg13g2_inv_1$1_1.Y result[4] 0.14275f
C4267 a_33750_36362# a_34453_35935# 0.02432f
C4268 a_33626_41433# VDD 0.11868f
C4269 sar_ctrl_async_phys_0.sg13g2_a21oi_1$1_1.B1 sar_ctrl_async_phys_0.dac_code_n[3] 0.6999f
C4270 sar_ctrl_async_phys_0.dac_code_n[1] sar_ctrl_async_phys_0.sg13g2_a21oi_1$1_3.B1 0.1008f
C4271 sar_ctrl_async_phys_0.sg13g2_a22oi_1$1_2.B2 a_31924_32456# 0.01919f
C4272 sar_ctrl_async_phys_0.dac_code_n[5] sar_ctrl_async_phys_0.dac_code[1] 0.06252f
C4273 sar_ctrl_async_phys_0.sg13g2_buf_1$1_41.X a_33109_45725# 0.03846f
C4274 sar_ctrl_async_phys_0.dac_code[1] oa_sar8_acore18_opt_0.sw_bitcell_opt_term_0.gb 0.19794f
C4275 sar_ctrl_async_phys_0.sg13g2_nor2_1$1_0.Y sar_ctrl_async_phys_0.sg13g2_nor2b_1$1_0.Y 0.10159f
C4276 sar_ctrl_async_phys_0.dac_code[3] sar_ctrl_async_phys_0.dac_code[6] 0.13268f
C4277 sar_ctrl_async_phys_0.sg13g2_buf_1$1_19.A sar_ctrl_async_phys_0.sg13g2_a22oi_1$1_0.A2 0.39413f
C4278 sar_ctrl_async_phys_0.sg13g2_buf_1$1_6.X a_34549_32911# 0.0455f
C4279 a_29526_33650# a_30331_33772# 0.097f
C4280 a_29812_33968# a_30229_33629# 0.3749f
C4281 a_36056_47296# sar_ctrl_async_phys_0.cmp_valid 0.0103f
C4282 sar_ctrl_async_phys_0.sg13g2_nor2_1$1_4.Y sar_ctrl_async_phys_0.sg13g2_dlygate4sd3_1$1_6.A 0.0359f
C4283 oa_sar8_acore18_opt_0.bstrap_opt_w2_c1200_1.out oa_sar8_acore18_opt_0.sw_bitcell_opt_b0_1.bot 3.86223f
C4284 oa_sar8_acore18_opt_0.sw_bitcell_opt_term_1.bot oa_sar8_acore18_opt_0.sw_bitcell_opt_b1_1.bot 0.38845f
C4285 a_34261_43495# VDD 0.2522f
C4286 sar_ctrl_async_phys_0.sg13g2_a22oi_1$1_1.Y a_34420_33325# 0.01328f
C4287 sar_ctrl_async_phys_0.sg13g2_a22oi_1$1_2.A2 a_31841_36285# 0.01339f
C4288 sar_ctrl_async_phys_0.sg13g2_buf_1$1_4.A a_35211_37436# 0.08968f
C4289 sar_ctrl_async_phys_0.dac_code_n[0] sar_ctrl_async_phys_0.dac_code_n[6] 0.14233f
C4290 a_32888_43570# VDD 0.13563f
C4291 a_34420_34837# a_34651_34423# 0.12701f
C4292 sar_ctrl_async_phys_0.sg13g2_a21oi_1$1_0.A1 sar_ctrl_async_phys_0.sg13g2_and2_1$1_0.B 0.6523f
C4293 a_34615_31475# result[2] 0.01959f
C4294 sar_ctrl_async_phys_0.sg13g2_buf_1$1_15.A sar_ctrl_async_phys_0.bit_active[3] 0.24998f
C4295 sar_ctrl_async_phys_0.sg13g2_nor2_1$1_1.Y sar_ctrl_async_phys_0.sg13g2_a22oi_1$1_3.A2 0.04004f
C4296 a_34328_41972# sar_ctrl_async_phys_0.sg13g2_nand2b_1$1_1.Y 0.27814f
C4297 sar_ctrl_async_phys_0.dac_code[3] sar_ctrl_async_phys_0.sg13g2_nand2b_1$1_2.A_N 0.01148f
C4298 sar_ctrl_async_phys_0.sg13g2_buf_1$1_42.A sar_ctrl_async_phys_0.sg13g2_nand2b_1$1_5.A_N 0.049f
C4299 sar_ctrl_async_phys_0.sg13g2_buf_1$1_42.A sar_ctrl_async_phys_0.dac_code_n[1] 0.03993f
C4300 sar_ctrl_async_phys_0.sg13g2_dfrbpq_1$1_0.CLK a_30676_40016# 0.1104f
C4301 sar_ctrl_async_phys_0.sg13g2_a22oi_1$1_0.B1 sar_ctrl_async_phys_0.sg13g2_a22oi_1$1_2.Y 0.99078f
C4302 a_34106_30849# a_33846_30626# 0.75507f
C4303 sar_ctrl_async_phys_0.sg13g2_buf_1$1_0.A result[5] 0.17413f
C4304 sar_ctrl_async_phys_0.dac_code[5] VDD 5.33453f
C4305 oa_sar8_acore18_opt_0.sw_bitcell_opt_b5_1.bot oa_sar8_acore18_opt_0.sw_bitcell_opt_b6_1.bot 10.6639f
C4306 oa_sar8_acore18_opt_0.sw_bitcell_opt_b4_1.bot oa_sar8_acore18_opt_0.sw_bitcell_opt_b7_1.bot 1.0619f
C4307 sar_ctrl_async_phys_0.sg13g2_dfrbpq_1$1_0.CLK sar_ctrl_async_phys_0.sg13g2_and2_1$1_0.B 0.47326f
C4308 sar_ctrl_async_phys_0.sg13g2_buf_1$1_37.A sar_ctrl_async_phys_0.sg13g2_nand2_1$1_5.Y 0.04905f
C4309 a_35672_38948# VDD 0.26746f
C4310 sar_ctrl_async_phys_0.sg13g2_nor2_1$1_13.B sar_ctrl_async_phys_0.sg13g2_nor2_1$1_14.A 0.17706f
C4311 sar_ctrl_async_phys_0.sg13g2_nor2b_1$1_0.Y a_32120_38318# 0.01966f
C4312 a_25496_39830# VDD 0.13116f
C4313 a_31644_36638# a_31352_36806# 0.01f
C4314 sar_ctrl_async_phys_0.sg13g2_buf_1$1_10.A a_32687_32876# 0.08575f
C4315 sar_ctrl_async_phys_0.dac_code_n[6] sar_ctrl_async_phys_0.dac_code_n[7] 25.2455f
C4316 sar_ctrl_async_phys_0.sg13g2_nor2_1$1_1.Y a_34520_38224# 0.05381f
C4317 a_28977_36864# a_29258_36642# 0.26306f
C4318 a_28862_36863# sar_ctrl_async_phys_0.sg13g2_dlygate4sd3_1$1_0.A 0.02888f
C4319 sar_ctrl_async_phys_0.sg13g2_a21oi_1$1_6.A2 a_32991_45357# 0.03892f
C4320 sar_ctrl_async_phys_0.sg13g2_buf_1$1_1.A a_33658_35460# 0.12411f
C4321 w_16692_n9960# sar_ctrl_async_phys_0.dac_code_n[5] 0.02244f
C4322 sar_ctrl_async_phys_0.sg13g2_dfrbpq_1$1_0.CLK a_33183_32215# 0.0129f
C4323 a_27134_39887# a_27249_39888# 0.55452f
C4324 a_31040_40702# VDD 0.17149f
C4325 sar_ctrl_async_phys_0.dac_code_n[4] oa_sar8_acore18_opt_0.sw_bitcell_opt_term_0.vin 0.05585f
C4326 a_35391_34773# VDD 0.17438f
C4327 a_29749_32117# VDD 0.25358f
C4328 sar_ctrl_async_phys_0.sg13g2_inv_1$1_6.A sar_ctrl_async_phys_0.sg13g2_inv_1$1_5.A 0.01071f
C4329 sar_ctrl_async_phys_0.sg13g2_a21oi_1$1_0.B1 sar_ctrl_async_phys_0.sg13g2_nand2_1$1_5.B 0.01751f
C4330 sar_ctrl_async_phys_0.dac_code[5] oa_sar8_acore18_opt_0.sw_bitcell_opt_b6_0.bot 1.19314f
C4331 sar_ctrl_async_phys_0.sg13g2_dfrbpq_1$1_0.CLK sar_ctrl_async_phys_0.sg13g2_a22oi_1$1_0.B1 2.5098f
C4332 w_39600_n9960# sar_ctrl_async_phys_0.dac_code[5] 0.20213f
C4333 a_30486_31826# a_31189_31399# 0.02432f
C4334 sar_ctrl_async_phys_0.sg13g2_buf_1$1_17.A sar_ctrl_async_phys_0.sg13g2_buf_1$1_1.A 0.74942f
C4335 a_28130_40838# VDD 0.01882f
C4336 sar_ctrl_async_phys_0.sg13g2_buf_1$1_19.A sar_ctrl_async_phys_0.sg13g2_buf_1$1_3.A 0.01694f
C4337 sar_ctrl_async_phys_0.sg13g2_o21ai_1$1_1.B1 sar_ctrl_async_phys_0.sg13g2_a21oi_1$1_5.A2 0.57336f
C4338 sar_ctrl_async_phys_0.sg13g2_o21ai_1$1_1.B1 a_29210_38916# 0.2588f
C4339 a_34549_30605# VDD 0.24242f
C4340 a_26184_42013# VDD 0.3541f
C4341 sar_ctrl_async_phys_0.sg13g2_buf_1$1_3.A sar_ctrl_async_phys_0.bit_active[6] 0.02268f
C4342 sar_ctrl_async_phys_0.sg13g2_and2_1$1_0.A a_29210_38916# 0.01281f
C4343 sar_ctrl_async_phys_0.sg13g2_buf_1$1_3.A sar_ctrl_async_phys_0.sg13g2_and2_1$1_0.X 0.08571f
C4344 sar_ctrl_async_phys_0.dac_code_n[1] oa_sar8_acore18_opt_0.sw_bitcell_opt_term_0.bot 0.42807f
C4345 sar_ctrl_async_phys_0.sg13g2_buf_1$1_42.A sar_ctrl_async_phys_0.sg13g2_buf_1$1_32.A 0.02027f
C4346 sar_ctrl_async_phys_0.sg13g2_dlygate4sd3_1$1_0.A VDD 0.3618f
C4347 a_29524_39373# a_29755_38959# 0.12701f
C4348 a_32245_37447# a_32993_37797# 0.01058f
C4349 sar_ctrl_async_phys_0.sg13g2_buf_1$1_7.A sar_ctrl_async_phys_0.sg13g2_buf_1$1_0.A 0.58415f
C4350 sar_ctrl_async_phys_0.sg13g2_nor2_1$1_0.Y VDD 0.95708f
C4351 sar_ctrl_async_phys_0.dac_code_n[0] sar_ctrl_async_phys_0.dac_code_n[7] 0.13499f
C4352 a_26160_45878# VDD 0.084f
C4353 sar_ctrl_async_phys_0.sg13g2_buf_1$1_19.A sar_ctrl_async_phys_0.sg13g2_a22oi_1$1_0.A1 0.0833f
C4354 a_29912_31474# VDD 0.14258f
C4355 sar_ctrl_async_phys_0.bit_active[6] sar_ctrl_async_phys_0.sg13g2_a22oi_1$1_0.A1 0.04358f
C4356 a_30495_39309# VDD 0.17399f
C4357 sar_ctrl_async_phys_0.sg13g2_and2_1$1_0.X sar_ctrl_async_phys_0.sg13g2_a22oi_1$1_0.A1 0.03586f
C4358 sar_ctrl_async_phys_0.sg13g2_a21oi_1$1_3.B1 sar_ctrl_async_phys_0.sg13g2_buf_1$1_15.A 0.05237f
C4359 oa_sar8_acore18_opt_0.sw_bitcell_opt_term_1.bot oa_sar8_acore18_opt_0.sw_bitcell_opt_b5_1.bot 0.44946f
C4360 oa_sar8_acore18_opt_0.bstrap_opt_w2_c1200_1.out oa_sar8_acore18_opt_0.sw_bitcell_opt_b4_1.bot 4.12808f
C4361 sar_ctrl_async_phys_0.sg13g2_inv_1$1_10.Y VDD 0.38371f
C4362 sar_ctrl_async_phys_0.sg13g2_a22oi_1$1_3.B1 sar_ctrl_async_phys_0.sg13g2_inv_1$1_2.Y 0.07597f
C4363 sar_ctrl_async_phys_0.sg13g2_a22oi_1$1_1.Y a_34132_32904# 0.0251f
C4364 sar_ctrl_async_phys_0.dac_code_n[1] m3_38288_n2380# 0.04007f
C4365 sar_ctrl_async_phys_0.sg13g2_inv_1$1_2.Y sar_ctrl_async_phys_0.sg13g2_buf_1$1_8.A 0.14382f
C4366 sar_ctrl_async_phys_0.sg13g2_nor4_1$1_0.C sar_ctrl_async_phys_0.sg13g2_buf_1$1_19.A 0.01722f
C4367 a_29524_40464# a_29812_40885# 0.43707f
C4368 a_34106_34380# a_34132_34416# 0.36952f
C4369 sar_ctrl_async_phys_0.sg13g2_a21oi_1$1_2.B1 a_29238_40898# 0.04848f
C4370 sar_ctrl_async_phys_0.sg13g2_a21oi_1$1_5.Y sar_ctrl_async_phys_0.sg13g2_dfrbpq_1$1_5.D 0.09121f
C4371 a_34055_31352# result[2] 0.01273f
C4372 sar_ctrl_async_phys_0.sg13g2_a21oi_1$1_6.B1 sar_ctrl_async_phys_0.sg13g2_nand2b_1$1_5.A_N 1.18889f
C4373 sar_ctrl_async_phys_0.sg13g2_nand2_1$1_3.A a_34357_44213# 0.03667f
C4374 a_31370_34782# sar_ctrl_async_phys_0.sg13g2_a22oi_1$1_3.B1 0.01634f
C4375 sar_ctrl_async_phys_0.sg13g2_buf_1$1_10.A a_33850_32436# 0.12307f
C4376 sar_ctrl_async_phys_0.dac_code[0] oa_sar8_acore18_opt_0.sw_bitcell_opt_term_0.vin 1.67827f
C4377 sar_ctrl_async_phys_0.dac_code_n[1] oa_sar8_acore18_opt_0.bstrap_opt_w2_c1200_1.gb 0.1221f
C4378 sar_ctrl_async_phys_0.sg13g2_a21oi_1$1_6.B1 sar_ctrl_async_phys_0.dac_code_n[1] 1.15473f
C4379 a_29350_41996# a_29238_41972# 0.55452f
C4380 a_32120_38318# VDD 0.16675f
C4381 sar_ctrl_async_phys_0.sg13g2_nor2_1$1_5.A sar_ctrl_async_phys_0.sg13g2_nor2_1$1_11.Y 0.78625f
C4382 sar_ctrl_async_phys_0.dac_code_n[2] oa_sar8_acore18_opt_0.sw_bitcell_opt_term_0.trkb 1.90235f
C4383 sar_ctrl_async_phys_0.sg13g2_buf_1$1_6.X result[5] 1.52484f
C4384 a_30676_40016# a_31841_39775# 0.43239f
C4385 a_31195_39820# a_30964_39711# 0.12701f
C4386 sar_ctrl_async_phys_0.sg13g2_nor2_1$1_4.Y a_26550_41214# 0.06483f
C4387 a_34549_32911# a_34651_32911# 0.47795f
C4388 sar_ctrl_async_phys_0.sg13g2_buf_1$1_42.A sar_ctrl_async_phys_0.sg13g2_buf_1$1_15.A 0.34842f
C4389 sar_ctrl_async_phys_0.dac_code_n[2] sar_ctrl_async_phys_0.cmp_n 0.0682f
C4390 sar_ctrl_async_phys_0.bit_active[6] sar_ctrl_async_phys_0.dac_code[7] 0.02126f
C4391 sar_ctrl_async_phys_0.dac_code_n[1] oa_sar8_acore18_opt_0.sw_bitcell_opt_b1_1.bot 1.3067f
C4392 sar_ctrl_async_phys_0.dac_code[1] sar_ctrl_async_phys_0.dac_code[2] 4.91055f
C4393 sar_ctrl_async_phys_0.sg13g2_buf_1$1_21.A a_35288_38224# 0.02574f
C4394 sar_ctrl_async_phys_0.dac_code[4] oa_sar8_acore18_opt_0.sw_bitcell_opt_b7_0.bot 2.35443f
C4395 sar_ctrl_async_phys_0.sg13g2_nor4_1$1_0.Y a_28662_41214# 0.01077f
C4396 sar_ctrl_async_phys_0.sg13g2_buf_1$1_3.A a_34651_34423# 0.01036f
C4397 sar_ctrl_async_phys_0.sg13g2_and2_1$1_0.A a_25990_40484# 0.02693f
C4398 sar_ctrl_async_phys_0.sg13g2_a22oi_1$1_1.B2 result[5] 1.9247f
C4399 a_30830_35166# a_30944_35166# 0.0308f
C4400 sar_ctrl_async_phys_0.sg13g2_a21oi_1$1_2.B1 a_34721_39775# 0.019f
C4401 sar_ctrl_async_phys_0.dac_code_n[2] oa_sar8_acore18_opt_0.sw_bitcell_opt_b4_0.bot 0.23086f
C4402 sar_ctrl_async_phys_0.sg13g2_nand2b_1$1_4.A_N sar_ctrl_async_phys_0.sg13g2_buf_1$1_20.A 0.04209f
C4403 sar_ctrl_async_phys_0.sg13g2_buf_1$1_1.A a_32149_35141# 0.01149f
C4404 sar_ctrl_async_phys_0.sg13g2_nand2b_1$1_5.A_N sar_ctrl_async_phys_0.sg13g2_nand2b_1$1_1.B 0.12975f
C4405 sar_ctrl_async_phys_0.sg13g2_a21oi_1$1_4.B1 sar_ctrl_async_phys_0.sg13g2_nand2_1$1_5.B 1.36049f
C4406 sar_ctrl_async_phys_0.dac_code[5] oa_sar8_acore18_opt_0.sw_bitcell_opt_b2_0.bot 0.16249f
C4407 sar_ctrl_async_phys_0.sg13g2_nor2_1$1_15.Y a_33366_41210# 0.27095f
C4408 sar_ctrl_async_phys_0.sg13g2_dfrbpq_1$1_0.CLK a_31898_32361# 0.01103f
C4409 sar_ctrl_async_phys_0.sg13g2_buf_1$1_1.A sar_ctrl_async_phys_0.sg13g2_buf_1$1_6.X 0.0315f
C4410 a_28236_40440# VDD 0.02621f
C4411 sar_ctrl_async_phys_0.sg13g2_a22oi_1$1_4.A2 sar_ctrl_async_phys_0.sg13g2_buf_1$1_3.A 0.01175f
C4412 sar_ctrl_async_phys_0.sg13g2_buf_1$1_2.A a_33080_30664# 0.10148f
C4413 a_30872_45082# VDD 0.15535f
C4414 sar_ctrl_async_phys_0.sg13g2_nand2_1$1_2.Y sar_ctrl_async_phys_0.sg13g2_buf_1$1_21.A 0.01184f
C4415 a_28968_42013# VDD 0.33584f
C4416 sar_ctrl_async_phys_0.sg13g2_nand3_1$1_0.C sar_ctrl_async_phys_0.sg13g2_and2_1$1_3.X 0.25851f
C4417 sar_ctrl_async_phys_0.sg13g2_buf_1$1_6.X sar_ctrl_async_phys_0.sg13g2_buf_1$1_7.A 0.37968f
C4418 a_25496_31388# sar_ctrl_async_phys_0.cmp_p 0.26592f
C4419 sar_ctrl_async_phys_0.sg13g2_a21oi_1$1_6.B1 sar_ctrl_async_phys_0.sg13g2_buf_1$1_32.A 0.04903f
C4420 sar_ctrl_async_phys_0.sg13g2_a22oi_1$1_0.Y a_34904_33688# 0.02715f
C4421 sar_ctrl_async_phys_0.bit_active[0] sar_ctrl_async_phys_0.bit_active[2] 0.01183f
C4422 a_29210_38916# a_29236_38952# 0.36952f
C4423 sar_ctrl_async_phys_0.sg13g2_a22oi_1$1_4.A2 sar_ctrl_async_phys_0.sg13g2_a22oi_1$1_0.A1 0.1548f
C4424 a_31542_37874# a_32347_37447# 0.097f
C4425 sar_ctrl_async_phys_0.sg13g2_buf_1$1_42.A a_33248_45238# 0.04004f
C4426 sar_ctrl_async_phys_0.sg13g2_inv_1$1_7.A a_29660_37436# 0.01498f
C4427 sar_ctrl_async_phys_0.sg13g2_a22oi_1$1_0.A2 sar_ctrl_async_phys_0.sg13g2_inv_1$1_0.A 0.02052f
C4428 sar_ctrl_async_phys_0.sg13g2_dfrbpq_1$1_0.CLK a_34069_41189# 0.27938f
C4429 sar_ctrl_async_phys_0.sg13g2_nor4_1$1_0.C sar_ctrl_async_phys_0.sg13g2_nand2b_1$1_1.Y 0.01597f
C4430 a_31195_35935# a_31935_36285# 0.26905f
C4431 sar_ctrl_async_phys_0.sg13g2_nand2b_1$1_4.A_N sar_ctrl_async_phys_0.sg13g2_nand2_1$1_3.B 0.19598f
C4432 a_28774_41278# VDD 0.19056f
C4433 sar_ctrl_async_phys_0.sg13g2_nor2_1$1_6.B sar_ctrl_async_phys_0.sg13g2_nor2_1$1_7.A 0.15084f
C4434 sar_ctrl_async_phys_0.sg13g2_buf_1$1_2.A VDD 2.8158f
C4435 sar_ctrl_async_phys_0.sg13g2_buf_1$1_7.A sar_ctrl_async_phys_0.sg13g2_a22oi_1$1_1.B2 1.70932f
C4436 sar_ctrl_async_phys_0.sg13g2_a21oi_1$1_6.A2 VDD 0.76449f
C4437 sar_ctrl_async_phys_0.sg13g2_buf_1$1_20.A a_34261_43495# 0.01345f
C4438 sar_ctrl_async_phys_0.sg13g2_nor4_1$1_0.C sar_ctrl_async_phys_0.sg13g2_a22oi_1$1_4.A2 0.01175f
C4439 sar_ctrl_async_phys_0.sg13g2_buf_1$1_42.A sar_ctrl_async_phys_0.sg13g2_o21ai_1$1_1.B1 0.01613f
C4440 sar_ctrl_async_phys_0.sg13g2_buf_1$1_20.A a_32888_43570# 0.01954f
C4441 sar_ctrl_async_phys_0.sg13g2_a21oi_1$1_0.B1 sar_ctrl_async_phys_0.sg13g2_buf_1$1_19.A 0.02019f
C4442 sar_ctrl_async_phys_0.sg13g2_dfrbpq_1$1_0.CLK a_34363_43495# 0.02175f
C4443 sar_ctrl_async_phys_0.sg13g2_a21oi_1$1_0.B1 sar_ctrl_async_phys_0.sg13g2_and2_1$1_0.X 0.02328f
C4444 sar_ctrl_async_phys_0.sg13g2_a21oi_1$1_0.A1 sar_ctrl_async_phys_0.sg13g2_buf_1$1_21.A 0.04248f
C4445 a_29524_40464# a_29941_40471# 0.37583f
C4446 a_31832_34412# a_31640_34498# 0.01226f
C4447 sar_ctrl_async_phys_0.sg13g2_nor2b_1$1_2.Y VDD 0.73115f
C4448 sar_ctrl_async_phys_0.sample oa_sar8_acore18_opt_0.sw_bitcell_opt_term_0.trkb 12.3826f
C4449 sar_ctrl_async_phys_0.sg13g2_buf_1$1_10.A a_31924_32456# 0.03286f
C4450 sar_ctrl_async_phys_0.sg13g2_dlygate4sd3_1$1_6.X a_26270_39215# 0.01747f
C4451 sar_ctrl_async_phys_0.bit_active[2] sar_ctrl_async_phys_0.bit_active[4] 0.02992f
C4452 sar_ctrl_async_phys_0.sg13g2_nand2b_1$1_2.A_N a_35578_41508# 0.13058f
C4453 sar_ctrl_async_phys_0.sg13g2_inv_1$1_2.Y result[3] 0.01217f
C4454 sar_ctrl_async_phys_0.sg13g2_a21oi_1$1_5.Y a_31071_33727# 0.02415f
C4455 sar_ctrl_async_phys_0.sg13g2_dlygate4sd3_1$1_0.X a_28488_35965# 0.01053f
C4456 sar_ctrl_async_phys_0.sg13g2_buf_1$1_20.A sar_ctrl_async_phys_0.dac_code[5] 0.04808f
C4457 sar_ctrl_async_phys_0.sample sar_ctrl_async_phys_0.cmp_n 0.12068f
C4458 a_30650_39921# a_31093_39677# 0.02242f
C4459 sar_ctrl_async_phys_0.sg13g2_nor2_1$1_18.A a_30676_40016# 0.03713f
C4460 a_36056_35200# sar_ctrl_async_phys_0.bit_active[0] 0.01179f
C4461 sar_ctrl_async_phys_0.sg13g2_and2_1$1_6.X a_30783_40821# 0.01681f
C4462 sar_ctrl_async_phys_0.sg13g2_nor2_1$1_10.B a_30331_33772# 0.02612f
C4463 sar_ctrl_async_phys_0.sg13g2_nand2b_1$1_3.Y sar_ctrl_async_phys_0.sg13g2_nand2b_1$1_4.A_N 0.01294f
C4464 sar_ctrl_async_phys_0.sg13g2_and2_1$1_6.X sar_ctrl_async_phys_0.sg13g2_a21oi_1$1_2.B1 0.06989f
C4465 oa_sar8_acore18_opt_0.sw_bitcell_opt_term_0.gb m3_41836_n2380# 1.64364f
C4466 sar_ctrl_async_phys_0.sg13g2_and2_1$1_0.B sar_ctrl_async_phys_0.sg13g2_nor2_1$1_18.A 0.35436f
C4467 sar_ctrl_async_phys_0.sg13g2_nor2_1$1_10.B a_30043_40471# 0.02188f
C4468 sar_ctrl_async_phys_0.dac_code_n[6] oa_sar8_acore18_opt_0.sw_tg_opt_1.bot 0.07694f
C4469 a_36056_32176# VDD 0.21841f
C4470 sar_ctrl_async_phys_0.sg13g2_o21ai_1$1_1.B1 sar_ctrl_async_phys_0.sg13g2_nor2_1$1_14.A 0.25811f
C4471 sar_ctrl_async_phys_0.sg13g2_dfrbpq_1$1_0.CLK a_31477_44213# 0.26729f
C4472 sar_ctrl_async_phys_0.dac_code_n[2] oa_sar8_acore18_opt_0.sw_bitcell_opt_b0_0.bot 0.0836f
C4473 sar_ctrl_async_phys_0.sg13g2_buf_1$1_36.A sar_ctrl_async_phys_0.sg13g2_nand2b_1$1_6.A_N 0.12296f
C4474 sar_ctrl_async_phys_0.sg13g2_buf_1$1_41.X a_32576_44454# 0.10173f
C4475 sar_ctrl_async_phys_0.dac_code[1] oa_sar8_acore18_opt_0.sw_bitcell_opt_b3_0.bot 0.13373f
C4476 a_34651_32911# result[5] 0.01844f
C4477 sar_ctrl_async_phys_0.sg13g2_dlygate4sd3_1$1_1.A VDD 0.32219f
C4478 sar_ctrl_async_phys_0.sg13g2_o21ai_1$1_1.B1 sar_ctrl_async_phys_0.sg13g2_a21oi_1$1_5.Y 0.04654f
C4479 sar_ctrl_async_phys_0.sg13g2_nor2b_1$1_0.A a_31040_40702# 0.01749f
C4480 sar_ctrl_async_phys_0.sg13g2_a21oi_1$1_3.B1 sar_ctrl_async_phys_0.dac_code[1] 0.28763f
C4481 sar_ctrl_async_phys_0.sg13g2_and2_1$1_0.A sar_ctrl_async_phys_0.sg13g2_a21oi_1$1_5.Y 0.69214f
C4482 sar_ctrl_async_phys_0.sg13g2_and2_1$1_6.X a_34904_38948# 0.25823f
C4483 sar_ctrl_async_phys_0.sg13g2_buf_1$1_41.X sar_ctrl_async_phys_0.sg13g2_nand2b_1$1_4.A_N 0.01785f
C4484 sar_ctrl_async_phys_0.dac_code_n[4] sar_ctrl_async_phys_0.sg13g2_nand2b_1$1_4.A_N 0.28839f
C4485 sar_ctrl_async_phys_0.sg13g2_nand2b_1$1_1.B sar_ctrl_async_phys_0.sg13g2_buf_1$1_15.A 0.20415f
C4486 a_25608_40501# VDD 0.3106f
C4487 sar_ctrl_async_phys_0.sg13g2_inv_1$1_2.Y sar_ctrl_async_phys_0.sg13g2_buf_1$1_0.A 0.01919f
C4488 sar_ctrl_async_phys_0.sg13g2_nor2_1$1_10.B a_30752_39190# 0.02033f
C4489 sar_ctrl_async_phys_0.sg13g2_a22oi_1$1_0.A1 sar_ctrl_async_phys_0.sg13g2_inv_1$1_0.A 0.35293f
C4490 sar_ctrl_async_phys_0.dac_code_n[0] oa_sar8_acore18_opt_0.sw_tg_opt_1.bot 0.09046f
C4491 a_31034_44457# a_31060_44552# 0.36952f
C4492 a_36056_35200# sar_ctrl_async_phys_0.bit_active[4] 0.24512f
C4493 sar_ctrl_async_phys_0.sg13g2_nor2_1$1_0.Y sar_ctrl_async_phys_0.sg13g2_buf_1$1_20.A 0.04606f
C4494 sar_ctrl_async_phys_0.sg13g2_buf_1$1_2.A sar_ctrl_async_phys_0.sg13g2_nor2b_1$1_3.Y 0.01981f
C4495 sar_ctrl_async_phys_0.sg13g2_buf_1$1_6.X a_29851_32260# 0.47745f
C4496 a_34808_35200# sar_ctrl_async_phys_0.bit_active[2] 0.24559f
C4497 sar_ctrl_async_phys_0.sg13g2_nand2b_1$1_3.Y a_34261_43495# 0.01296f
C4498 sar_ctrl_async_phys_0.sg13g2_nor2_1$1_0.Y sar_ctrl_async_phys_0.sg13g2_nor2b_1$1_0.A 0.29951f
C4499 a_28376_39034# a_28560_39034# 0.0524f
C4500 a_31542_37874# a_32245_37447# 0.02432f
C4501 sar_ctrl_async_phys_0.sg13g2_nor2_1$1_4.Y a_26394_37436# 0.01284f
C4502 sar_ctrl_async_phys_0.sg13g2_buf_1$1_19.A a_33270_39698# 0.04304f
C4503 sar_ctrl_async_phys_0.sg13g2_dfrbpq_1$1_0.CLK sar_ctrl_async_phys_0.sg13g2_nand2_1$1_3.Y 0.01475f
C4504 sar_ctrl_async_phys_0.sg13g2_a21oi_1$1_0.B1 sar_ctrl_async_phys_0.sg13g2_nand2b_1$1_1.Y 0.01204f
C4505 sar_ctrl_async_phys_0.sg13g2_nor4_1$1_0.C a_29941_40471# 0.01506f
C4506 sar_ctrl_async_phys_0.sg13g2_buf_1$1_6.X a_34651_30748# 0.4305f
C4507 a_35725_45266# a_35807_45366# 0.01117f
C4508 a_34236_46472# sar_ctrl_async_phys_0.sg13g2_buf_1$1_2.A 0.26791f
C4509 sar_ctrl_async_phys_0.bit_active[2] sar_ctrl_async_phys_0.bit_active[1] 0.08584f
C4510 sar_ctrl_async_phys_0.sg13g2_dfrbpq_1$1_11.D a_32116_40464# 0.02265f
C4511 a_36336_39830# VDD 0.06741f
C4512 sar_ctrl_async_phys_0.sg13g2_a21oi_1$1_6.B1 sar_ctrl_async_phys_0.sg13g2_o21ai_1$1_1.B1 0.52776f
C4513 sar_ctrl_async_phys_0.sg13g2_a21oi_1$1_4.B1 sar_ctrl_async_phys_0.sg13g2_buf_1$1_19.A 0.10063f
C4514 sar_ctrl_async_phys_0.sg13g2_a21oi_1$1_0.A1 sar_ctrl_async_phys_0.sg13g2_nor2b_1$1_0.Y 0.11395f
C4515 a_33844_39711# VDD 0.02104f
C4516 oa_sar8_acore18_opt_0.sw_tg_opt_0.bot oa_sar8_acore18_opt_0.sw_bitcell_opt_term_0.trkb 1.28268f
C4517 sar_ctrl_async_phys_0.sg13g2_buf_1$1_3.A a_35672_35200# 0.02718f
C4518 sar_ctrl_async_phys_0.sg13g2_buf_1$1_2.A sar_ctrl_async_phys_0.sg13g2_a22oi_1$1_1.A2 0.12951f
C4519 sar_ctrl_async_phys_0.sg13g2_buf_1$1_6.X sar_ctrl_async_phys_0.sg13g2_inv_1$1_11.Y 0.10055f
C4520 sar_ctrl_async_phys_0.sg13g2_and2_1$1_0.A sar_ctrl_async_phys_0.sg13g2_and2_1$1_3.X 0.31033f
C4521 sar_ctrl_async_phys_0.sg13g2_buf_1$1_14.A sar_ctrl_async_phys_0.sg13g2_nor2b_1$1_2.Y 0.0502f
C4522 sar_ctrl_async_phys_0.sg13g2_buf_1$1_41.X a_34261_43495# 0.03702f
C4523 sar_ctrl_async_phys_0.dac_code_n[7] oa_sar8_acore18_opt_0.sw_tg_opt_1.bot 0.07362f
C4524 a_35288_38224# VDD 0.21936f
C4525 sar_ctrl_async_phys_0.dac_code_n[2] oa_sar8_acore18_opt_0.sw_bitcell_opt_b0_1.bot 0.06598f
C4526 sar_ctrl_async_phys_0.cmp_n oa_sar8_acore18_opt_0.sw_tg_opt_0.bot 0.42046f
C4527 m3_60844_n2380# VDD 0.10028f
C4528 sar_ctrl_async_phys_0.sg13g2_o21ai_1$1_1.B1 a_32533_40471# 0.06841f
C4529 sar_ctrl_async_phys_0.sg13g2_nor2_1$1_4.Y sar_ctrl_async_phys_0.sg13g2_dlygate4sd3_1$1_5.A 0.12576f
C4530 a_32991_35239# VDD 0.18497f
C4531 sar_ctrl_async_phys_0.sg13g2_nor2b_1$1_2.Y sar_ctrl_async_phys_0.sg13g2_a22oi_1$1_1.A2 0.08404f
C4532 sar_ctrl_async_phys_0.sg13g2_buf_1$1_15.A sar_ctrl_async_phys_0.sg13g2_buf_1$1_4.A 1.15867f
C4533 sar_ctrl_async_phys_0.dac_code_n[1] oa_sar8_acore18_opt_0.sw_bitcell_opt_term_0.vin 0.17064f
C4534 sar_ctrl_async_phys_0.dac_code[0] sar_ctrl_async_phys_0.sg13g2_nand2b_1$1_4.A_N 0.29155f
C4535 a_34520_47296# VDD 0.22221f
C4536 a_32991_35239# a_32897_35239# 0.28931f
C4537 a_35280_35365# a_35672_35200# 0.04376f
C4538 a_35288_33688# VDD 0.22015f
C4539 sar_ctrl_async_phys_0.dac_code_n[2] a_35948_n9612# 0.05817f
C4540 oa_sar8_acore18_opt_0.sw_tg_opt_0.bot oa_sar8_acore18_opt_0.sw_bitcell_opt_b4_0.bot 6.44761f
C4541 sar_ctrl_async_phys_0.sg13g2_nand2_1$1_2.Y VDD 0.63167f
C4542 a_34767_31359# a_35418_31668# 0.01562f
C4543 sar_ctrl_async_phys_0.sg13g2_buf_1$1_5.A busy 0.0137f
C4544 sar_ctrl_async_phys_0.sg13g2_a21oi_1$1_5.Y sar_ctrl_async_phys_0.sg13g2_a22oi_1$1_3.B1 0.05839f
C4545 a_35053_40730# VDD 0.24085f
C4546 sar_ctrl_async_phys_0.sg13g2_a22oi_1$1_0.A1 sar_ctrl_async_phys_0.sg13g2_a22oi_1$1_2.B2 0.5825f
C4547 sar_ctrl_async_phys_0.sg13g2_nand2_1$1_3.A sar_ctrl_async_phys_0.dac_code_n[7] 0.09262f
C4548 sar_ctrl_async_phys_0.dac_code_n[5] sar_ctrl_async_phys_0.dac_code[6] 0.17632f
C4549 sar_ctrl_async_phys_0.dac_code_n[4] sar_ctrl_async_phys_0.dac_code[5] 0.06328f
C4550 a_34042_40460# VDD 0.41677f
C4551 sar_ctrl_async_phys_0.sg13g2_nand2_1$1_5.Y a_33652_41528# 0.01384f
C4552 sar_ctrl_async_phys_0.sg13g2_buf_1$1_46.A sar_ctrl_async_phys_0.sg13g2_nand2b_1$1_6.A_N 0.09835f
C4553 a_36056_35200# sar_ctrl_async_phys_0.bit_active[1] 0.01271f
C4554 sar_ctrl_async_phys_0.dac_code[6] oa_sar8_acore18_opt_0.sw_bitcell_opt_term_0.gb 0.29684f
C4555 sar_ctrl_async_phys_0.sg13g2_buf_1$1_17.A a_32020_35175# 0.01787f
C4556 sar_ctrl_async_phys_0.dac_code[1] oa_sar8_acore18_opt_0.sw_bitcell_opt_term_0.bot 0.17583f
C4557 a_35103_43845# sar_ctrl_async_phys_0.dac_code_n[7] 0.01124f
C4558 a_33276_42686# a_33072_42854# 0.01048f
C4559 oa_sar8_acore18_opt_0.sw_bitcell_opt_term_0.gb vinn 1.71556f
C4560 a_36056_38948# sar_ctrl_async_phys_0.dac_code[6] 0.093f
C4561 sar_ctrl_async_phys_0.sg13g2_dlygate4sd3_1$1_8.X sar_ctrl_async_phys_0.sg13g2_dlygate4sd3_1$1_9.A 0.02229f
C4562 a_34767_31359# result[3] 0.01085f
C4563 sar_ctrl_async_phys_0.sg13g2_nand2b_1$1_3.Y sar_ctrl_async_phys_0.sg13g2_nor2_1$1_0.Y 0.01271f
C4564 sar_ctrl_async_phys_0.sg13g2_a21oi_1$1_0.A1 a_31665_42748# 0.01174f
C4565 sar_ctrl_async_phys_0.sg13g2_dfrbpq_1$1_11.D a_31841_39775# 0.01287f
C4566 sar_ctrl_async_phys_0.sg13g2_and2_1$1_3.X sar_ctrl_async_phys_0.sg13g2_dlygate4sd3_1$1_6.X 0.70072f
C4567 a_34132_36687# VDD 0.01342f
C4568 sar_ctrl_async_phys_0.sg13g2_dfrbpq_1$1_0.CLK a_34549_34423# 0.29082f
C4569 sar_ctrl_async_phys_0.sg13g2_buf_1$1_6.X sar_ctrl_async_phys_0.sg13g2_inv_1$1_2.Y 0.14404f
C4570 sar_ctrl_async_phys_0.sg13g2_buf_1$1_37.A a_32888_43570# 0.01453f
C4571 sar_ctrl_async_phys_0.sg13g2_nand2_1$1_1.B sar_ctrl_async_phys_0.sg13g2_nor2_1$1_7.A 0.07832f
C4572 sar_ctrl_async_phys_0.sg13g2_buf_1$1_15.A sar_ctrl_async_phys_0.sg13g2_nand2_1$1_5.Y 1.49609f
C4573 sar_ctrl_async_phys_0.sg13g2_and2_1$1_6.X sar_ctrl_async_phys_0.sg13g2_a21oi_1$1_5.A2 0.0833f
C4574 sar_ctrl_async_phys_0.sg13g2_buf_1$1_3.A sar_ctrl_async_phys_0.sg13g2_a22oi_1$1_3.A2 0.18265f
C4575 sar_ctrl_async_phys_0.bit_active[1] result[7] 0.03732f
C4576 sar_ctrl_async_phys_0.sg13g2_a21oi_1$1_0.A1 a_29653_38959# 0.02508f
C4577 sar_ctrl_async_phys_0.sg13g2_a22oi_1$1_4.A2 a_33270_39698# 0.01078f
C4578 a_34268_31826# VDD 0.1854f
C4579 sar_ctrl_async_phys_0.sg13g2_buf_1$1_7.A sar_ctrl_async_phys_0.sg13g2_inv_1$1_0.Y 0.02972f
C4580 sar_ctrl_async_phys_0.sg13g2_a22oi_1$1_2.Y VDD 0.50252f
C4581 sar_ctrl_async_phys_0.sg13g2_nor2b_1$1_1.Y a_33210_36972# 0.01522f
C4582 sar_ctrl_async_phys_0.sg13g2_a22oi_1$1_0.B2 result[2] 0.35022f
C4583 sar_ctrl_async_phys_0.dac_code_n[5] sar_ctrl_async_phys_0.dac_code[3] 0.06252f
C4584 sar_ctrl_async_phys_0.dac_code_n[5] a_36156_45710# 0.02101f
C4585 sar_ctrl_async_phys_0.dac_code[2] m3_41836_n2380# 0.04566f
C4586 a_32792_41342# VDD 0.14576f
C4587 sar_ctrl_async_phys_0.sg13g2_o21ai_1$1_1.B1 a_33530_39921# 0.25385f
C4588 sar_ctrl_async_phys_0.dac_code[3] oa_sar8_acore18_opt_0.sw_bitcell_opt_term_0.gb 0.19973f
C4589 sar_ctrl_async_phys_0.sg13g2_a22oi_1$1_0.A1 sar_ctrl_async_phys_0.sg13g2_inv_1$1_6.A 1.26964f
C4590 a_32341_32117# a_33089_32215# 0.01058f
C4591 sar_ctrl_async_phys_0.sg13g2_buf_1$1_41.X sar_ctrl_async_phys_0.sg13g2_nor2_1$1_0.Y 0.12857f
C4592 sar_ctrl_async_phys_0.sg13g2_a21oi_1$1_0.A1 VDD 1.85537f
C4593 sar_ctrl_async_phys_0.sg13g2_buf_1$1_3.A a_35952_39901# 0.17322f
C4594 a_26666_38912# a_27206_39326# 0.01209f
C4595 sar_ctrl_async_phys_0.dac_code_n[3] oa_sar8_acore18_opt_0.sw_bitcell_opt_term_0.trkb 1.8925f
C4596 a_32443_32260# a_33183_32215# 0.26905f
C4597 sar_ctrl_async_phys_0.sg13g2_a22oi_1$1_3.A2 sar_ctrl_async_phys_0.sg13g2_a22oi_1$1_0.A1 0.145f
C4598 a_29786_33873# a_30229_33629# 0.02242f
C4599 sar_ctrl_async_phys_0.sg13g2_inv_1$1_6.Y a_29812_33968# 0.04594f
C4600 sar_ctrl_async_phys_0.sg13g2_a21oi_1$1_4.B1 sar_ctrl_async_phys_0.sg13g2_a22oi_1$1_4.A2 0.01009f
C4601 sar_ctrl_async_phys_0.sg13g2_inv_1$1_2.Y sar_ctrl_async_phys_0.sg13g2_a22oi_1$1_1.B2 0.75721f
C4602 sar_ctrl_async_phys_0.sg13g2_a22oi_1$1_0.B1 a_32443_32260# 0.05746f
C4603 sar_ctrl_async_phys_0.sg13g2_dfrbpq_1$1_0.CLK a_29653_38959# 0.26902f
C4604 sar_ctrl_async_phys_0.sg13g2_a21oi_1$1_6.B1 a_32715_43020# 0.02728f
C4605 sar_ctrl_async_phys_0.sg13g2_buf_1$1_2.A sar_ctrl_async_phys_0.sg13g2_buf_1$1_20.A 0.02487f
C4606 sar_ctrl_async_phys_0.dac_code_n[3] sar_ctrl_async_phys_0.cmp_n 0.07717f
C4607 a_30783_40821# a_30689_40821# 0.28931f
C4608 sar_ctrl_async_phys_0.sg13g2_a21oi_1$1_6.A2 sar_ctrl_async_phys_0.sg13g2_buf_1$1_20.A 0.02447f
C4609 sar_ctrl_async_phys_0.sg13g2_buf_1$1_2.A sar_ctrl_async_phys_0.sg13g2_nor2b_1$1_0.A 0.02973f
C4610 a_31483_46519# a_32480_46750# 0.03061f
C4611 sar_ctrl_async_phys_0.dac_code[0] sar_ctrl_async_phys_0.dac_code[5] 0.97853f
C4612 a_34075_39820# VDD 0.24863f
C4613 sar_ctrl_async_phys_0.sg13g2_dfrbpq_1$1_0.CLK VDD 6.01496f
C4614 sar_ctrl_async_phys_0.sg13g2_a22oi_1$1_2.A2 a_31732_45000# 0.02595f
C4615 oa_sar8_acore18_opt_0.sw_bitcell_opt_term_0.trkb m3_48572_n2380# 0.03859f
C4616 sar_ctrl_async_phys_0.sample oa_sar8_acore18_opt_0.sw_bitcell_opt_b0_1.bot 1.57868f
C4617 sar_ctrl_async_phys_0.sg13g2_nor4_1$1_0.C sar_ctrl_async_phys_0.sg13g2_a22oi_1$1_3.A2 0.01501f
C4618 a_30139_43495# VDD 0.20601f
C4619 oa_sar8_acore18_opt_0.sw_tg_opt_0.bot m3_57896_n2380# 0.05699f
C4620 sar_ctrl_async_phys_0.sg13g2_nor2_1$1_7.A a_28977_36864# 0.01883f
C4621 m3_34580_n2380# VDD 0.02982f
C4622 sar_ctrl_async_phys_0.sg13g2_nor2b_1$1_4.Y VDD 0.88729f
C4623 sar_ctrl_async_phys_0.dac_code_n[3] oa_sar8_acore18_opt_0.sw_bitcell_opt_b4_0.bot 0.46047f
C4624 sar_ctrl_async_phys_0.sg13g2_buf_1$1_26.X VDD 1.99482f
C4625 a_31446_35162# VDD 0.77428f
C4626 a_35288_47296# VDD 0.21882f
C4627 oa_sar8_acore18_opt_0.sw_bitcell_opt_term_0.trkb vcm 3.3216f
C4628 sar_ctrl_async_phys_0.sg13g2_nand2_1$1_2.Y sar_ctrl_async_phys_0.sg13g2_buf_1$1_14.A 0.03402f
C4629 oa_sar8_acore18_opt_0.sw_tg_opt_0.bot oa_sar8_acore18_opt_0.sw_bitcell_opt_b0_0.bot 0.88299f
C4630 sar_ctrl_async_phys_0.sg13g2_a21oi_1$1_0.A2 VDD 0.62014f
C4631 sar_ctrl_async_phys_0.sg13g2_nand2b_1$1_1.B sar_ctrl_async_phys_0.dac_code[1] 0.10864f
C4632 sar_ctrl_async_phys_0.sg13g2_a21oi_1$1_3.A2 a_35952_39901# 0.2761f
C4633 a_32149_35141# a_32020_35175# 0.01562f
C4634 a_29701_36874# a_29862_36682# 0.01251f
C4635 a_33248_35382# a_33658_35460# 0.10373f
C4636 sar_ctrl_async_phys_0.sg13g2_nand2_1$1_3.Y a_35018_42726# 0.01573f
C4637 sar_ctrl_async_phys_0.sg13g2_nor4_1$1_0.Y a_26662_41278# 0.01f
C4638 a_34636_31749# a_35418_31668# 0.43707f
C4639 sar_ctrl_async_phys_0.sg13g2_nor2b_1$1_1.Y sar_ctrl_async_phys_0.sg13g2_buf_1$1_4.A 0.53671f
C4640 a_36336_45082# VDD 0.05621f
C4641 sar_ctrl_async_phys_0.sg13g2_o21ai_1$1_1.B1 sar_ctrl_async_phys_0.sg13g2_nand2_1$1_5.Y 0.02013f
C4642 sar_ctrl_async_phys_0.sg13g2_buf_1$1_3.A a_35770_36972# 0.04633f
C4643 sar_ctrl_async_phys_0.sg13g2_o21ai_1$1_1.B1 a_33109_45725# 0.03503f
C4644 a_35552_36166# sar_ctrl_async_phys_0.bit_active[3] 0.02784f
C4645 a_32116_40464# VDD 0.07467f
C4646 sar_ctrl_async_phys_0.sg13g2_nor2b_1$1_1.Y a_33344_37678# 0.04994f
C4647 a_33940_44552# a_34228_44247# 0.43707f
C4648 sar_ctrl_async_phys_0.sg13g2_nor2b_1$1_0.Y a_32347_37447# 0.01147f
C4649 sar_ctrl_async_phys_0.sg13g2_buf_1$1_14.A a_34132_36687# 0.01227f
C4650 sar_ctrl_async_phys_0.sg13g2_buf_1$1_2.A sar_ctrl_async_phys_0.sg13g2_nor2b_1$1_1.B_N 0.04249f
C4651 sar_ctrl_async_phys_0.sg13g2_inv_1$1_5.Y VDD 0.43593f
C4652 w_16692_n9960# oa_sar8_acore18_opt_0.bstrap_opt_w2_c1200_1.gb 3.49708f
C4653 a_34636_31749# result[3] 0.03425f
C4654 a_33359_32876# VDD 0.30586f
C4655 sar_ctrl_async_phys_0.sg13g2_inv_1$1_11.Y a_30746_31356# 0.01061f
C4656 sar_ctrl_async_phys_0.sg13g2_nand2_1$1_3.B a_35105_44311# 0.02987f
C4657 a_34261_36653# VDD 0.25544f
C4658 sar_ctrl_async_phys_0.sg13g2_nor2b_1$1_3.Y a_32792_41342# 0.01685f
C4659 sar_ctrl_async_phys_0.sg13g2_dfrbpq_1$1_11.D sar_ctrl_async_phys_0.sg13g2_nor2_1$1_18.A 0.10613f
C4660 a_32888_36806# VDD 0.13752f
C4661 a_33752_33688# sar_ctrl_async_phys_0.sg13g2_buf_1$1_0.A 0.01137f
C4662 a_35245_45936# VDD 0.29151f
C4663 a_35053_40730# a_34896_40546# 0.01157f
C4664 sar_ctrl_async_phys_0.sg13g2_nor2b_1$1_2.Y sar_ctrl_async_phys_0.sg13g2_nor2b_1$1_1.B_N 0.10629f
C4665 w_16692_n9960# oa_sar8_acore18_opt_0.sw_bitcell_opt_b1_1.bot 0.09222f
C4666 sar_ctrl_async_phys_0.sg13g2_buf_1$1_2.A sar_ctrl_async_phys_0.sg13g2_nand2b_1$1_3.Y 0.01906f
C4667 sar_ctrl_async_phys_0.sg13g2_a22oi_1$1_0.Y a_34895_32460# 0.18309f
C4668 a_31291_31399# VDD 0.20406f
C4669 sar_ctrl_async_phys_0.sg13g2_a22oi_1$1_0.Y sar_ctrl_async_phys_0.sg13g2_a22oi_1$1_0.B2 0.1992f
C4670 sar_ctrl_async_phys_0.sg13g2_nor2b_1$1_1.Y a_33252_36642# 0.30017f
C4671 sar_ctrl_async_phys_0.sg13g2_nor2_1$1_0.Y a_32192_39918# 0.04083f
C4672 sar_ctrl_async_phys_0.sg13g2_a21oi_1$1_0.A1 sar_ctrl_async_phys_0.sg13g2_buf_1$1_14.A 0.33627f
C4673 result[4] result[7] 0.0312f
C4674 sar_ctrl_async_phys_0.sg13g2_nor2b_1$1_0.Y a_32580_36642# 0.24618f
C4675 sar_ctrl_async_phys_0.sg13g2_a21oi_1$1_0.A1 sar_ctrl_async_phys_0.bit_active[7] 0.1643f
C4676 sar_ctrl_async_phys_0.dac_code[2] sar_ctrl_async_phys_0.dac_code[6] 1.03175f
C4677 oa_sar8_acore18_opt_0.sw_bitcell_opt_b1_0.bot m3_54868_n2380# 1.55726f
C4678 sar_ctrl_async_phys_0.sg13g2_nor4_1$1_0.C sar_ctrl_async_phys_0.sg13g2_dlygate4sd3_1$1_6.A 0.03669f
C4679 sar_ctrl_async_phys_0.sg13g2_dfrbpq_1$1_0.CLK sar_ctrl_async_phys_0.sg13g2_nor2b_1$1_3.Y 0.15371f
C4680 a_31638_32138# a_32341_32117# 0.02454f
C4681 sar_ctrl_async_phys_0.sg13g2_buf_1$1_6.X a_34767_31359# 0.04664f
C4682 sar_ctrl_async_phys_0.sg13g2_nor2_1$1_18.A a_31674_38948# 0.01352f
C4683 sar_ctrl_async_phys_0.sg13g2_a21oi_1$1_0.A1 sar_ctrl_async_phys_0.sg13g2_a22oi_1$1_1.A2 0.4054f
C4684 sar_ctrl_async_phys_0.sg13g2_dlygate4sd3_1$1_9.A VDD 0.34947f
C4685 sar_ctrl_async_phys_0.sg13g2_o21ai_1$1_1.B1 sar_ctrl_async_phys_0.sg13g2_a21oi_1$1_2.Y 0.31594f
C4686 sar_ctrl_async_phys_0.sg13g2_dlygate4sd3_1$1_7.A sar_ctrl_async_phys_0.sg13g2_nand3_1$1_0.Y 0.04369f
C4687 sar_ctrl_async_phys_0.sg13g2_and2_1$1_0.A sar_ctrl_async_phys_0.sg13g2_a21oi_1$1_2.Y 1.34302f
C4688 a_34453_35935# sar_ctrl_async_phys_0.bit_active[2] 0.02689f
C4689 sar_ctrl_async_phys_0.dac_code_n[2] oa_sar8_acore18_opt_0.sw_bitcell_opt_b7_0.bot 1.68148f
C4690 sar_ctrl_async_phys_0.sg13g2_dfrbpq_1$1_0.CLK sar_ctrl_async_phys_0.sg13g2_buf_1$1_14.A 0.28362f
C4691 sar_ctrl_async_phys_0.sg13g2_buf_1$1_41.X sar_ctrl_async_phys_0.sg13g2_buf_1$1_2.A 0.12463f
C4692 sar_ctrl_async_phys_0.sample oa_sar8_acore18_opt_0.sw_bitcell_opt_b4_1.bot 1.76782f
C4693 sar_ctrl_async_phys_0.sg13g2_a21oi_1$1_0.B1 sar_ctrl_async_phys_0.sg13g2_a22oi_1$1_3.A2 0.02751f
C4694 sar_ctrl_async_phys_0.sg13g2_buf_1$1_41.X sar_ctrl_async_phys_0.sg13g2_a21oi_1$1_6.A2 0.43433f
C4695 sar_ctrl_async_phys_0.sg13g2_dfrbpq_1$1_9.D a_31446_45434# 0.27504f
C4696 a_34328_41972# sar_ctrl_async_phys_0.dac_code_n[7] 0.25356f
C4697 sar_ctrl_async_phys_0.sg13g2_nand2b_1$1_1.Y a_34224_42058# 0.0236f
C4698 a_30678_46946# VDD 0.78444f
C4699 sar_ctrl_async_phys_0.sg13g2_a21oi_1$1_5.Y sar_ctrl_async_phys_0.sg13g2_buf_1$1_17.A 0.0212f
C4700 sar_ctrl_async_phys_0.dac_code[2] sar_ctrl_async_phys_0.sg13g2_nand2b_1$1_2.A_N 0.05958f
C4701 oa_sar8_acore18_opt_0.sw_bitcell_opt_term_0.trkb a_20412_n9612# 0.80047f
C4702 sar_ctrl_async_phys_0.bit_active[1] result[6] 0.01275f
C4703 sar_ctrl_async_phys_0.dac_code_n[3] oa_sar8_acore18_opt_0.sw_bitcell_opt_b0_0.bot 0.10702f
C4704 a_29334_43922# VDD 0.78161f
C4705 sar_ctrl_async_phys_0.sg13g2_dfrbpq_1$1_0.CLK sar_ctrl_async_phys_0.sg13g2_a22oi_1$1_1.A2 1.42711f
C4706 sar_ctrl_async_phys_0.sg13g2_a21oi_1$1_1.B1 sar_ctrl_async_phys_0.sg13g2_buf_1$1_21.A 0.03302f
C4707 sar_ctrl_async_phys_0.sg13g2_and2_1$1_0.A sar_ctrl_async_phys_0.sg13g2_inv_1$1_7.A 0.09601f
C4708 sar_ctrl_async_phys_0.sg13g2_and2_1$1_0.A a_31195_35935# 0.06326f
C4709 sar_ctrl_async_phys_0.sg13g2_a22oi_1$1_0.B1 sar_ctrl_async_phys_0.sg13g2_a22oi_1$1_4.Y 0.28244f
C4710 m3_51760_n2380# m3_54868_n2380# 0.0157f
C4711 a_36056_47296# VDD 0.21644f
C4712 sar_ctrl_async_phys_0.sg13g2_and2_1$1_3.X a_26666_38912# 0.01528f
C4713 sar_ctrl_async_phys_0.sg13g2_a22oi_1$1_3.A2 a_32635_40471# 0.01688f
C4714 sar_ctrl_async_phys_0.sg13g2_dfrbpq_1$1_0.CLK a_34424_35200# 0.01058f
C4715 sar_ctrl_async_phys_0.sg13g2_and2_1$1_0.A sar_ctrl_async_phys_0.sg13g2_nor2_1$1_3.Y 0.0208f
C4716 sar_ctrl_async_phys_0.dac_code[2] sar_ctrl_async_phys_0.dac_code[3] 1.36178f
C4717 sar_ctrl_async_phys_0.sg13g2_nor2b_1$1_3.Y a_32116_40464# 0.03903f
C4718 sar_ctrl_async_phys_0.sg13g2_buf_1$1_14.A sar_ctrl_async_phys_0.sg13g2_a21oi_1$1_0.A2 0.0795f
C4719 a_26184_39702# VDD 0.3091f
C4720 sar_ctrl_async_phys_0.sg13g2_buf_1$1_2.A sar_ctrl_async_phys_0.sg13g2_a22oi_1$1_1.Y 1.04397f
C4721 sar_ctrl_async_phys_0.sg13g2_buf_1$1_14.A a_34324_36349# 0.02233f
C4722 sar_ctrl_async_phys_0.sg13g2_nand2b_1$1_5.A_N sar_ctrl_async_phys_0.sg13g2_nand2b_1$1_4.A_N 0.11122f
C4723 a_36056_42760# sar_ctrl_async_phys_0.dac_code[3] 0.24511f
C4724 sar_ctrl_async_phys_0.dac_code[1] sar_ctrl_async_phys_0.sg13g2_nand2_1$1_5.Y 0.02374f
C4725 sar_ctrl_async_phys_0.sg13g2_nand2_1$1_2.Y a_34815_39775# 0.01051f
C4726 sar_ctrl_async_phys_0.sg13g2_nor4_1$1_0.Y a_28392_41214# 0.04475f
C4727 a_32347_37447# VDD 0.2125f
C4728 a_35672_42760# sar_ctrl_async_phys_0.dac_code[2] 0.24511f
C4729 a_32251_35284# a_32991_35239# 0.26905f
C4730 sar_ctrl_async_phys_0.sg13g2_a22oi_1$1_1.A2 sar_ctrl_async_phys_0.sg13g2_a21oi_1$1_0.A2 0.20922f
C4731 a_33750_36362# VDD 0.80472f
C4732 sar_ctrl_async_phys_0.sg13g2_buf_1$1_6.X a_33248_35382# 0.10165f
C4733 sar_ctrl_async_phys_0.sg13g2_a22oi_1$1_2.A2 a_32400_41413# 0.02659f
C4734 oa_sar8_acore18_opt_0.sw_bitcell_opt_b2_0.bot m3_34580_n2380# 0.01914f
C4735 sar_ctrl_async_phys_0.sg13g2_nor2b_1$1_2.Y a_33754_37436# 0.02885f
C4736 sar_ctrl_async_phys_0.sg13g2_nor2b_1$1_0.A a_34042_40460# 0.01516f
C4737 a_33654_44234# a_34459_44356# 0.097f
C4738 sar_ctrl_async_phys_0.sg13g2_a22oi_1$1_0.A1 sar_ctrl_async_phys_0.sg13g2_inv_1$1_6.Y 0.01813f
C4739 a_33940_44552# a_34357_44213# 0.3749f
C4740 sar_ctrl_async_phys_0.sg13g2_buf_1$1_17.A a_31732_35480# 0.03314f
C4741 sar_ctrl_async_phys_0.sg13g2_buf_1$1_2.A sar_ctrl_async_phys_0.sg13g2_buf_1$1_37.A 0.0452f
C4742 a_33114_41508# sar_ctrl_async_phys_0.sg13g2_nor2_1$1_15.Y 0.01284f
C4743 sar_ctrl_async_phys_0.sg13g2_buf_1$1_17.A a_31706_35385# 0.01604f
C4744 sar_ctrl_async_phys_0.sg13g2_a21oi_1$1_6.A2 sar_ctrl_async_phys_0.sg13g2_buf_1$1_37.A 0.39062f
C4745 sar_ctrl_async_phys_0.sg13g2_buf_1$1_14.A a_34261_36653# 0.01347f
C4746 sar_ctrl_async_phys_0.sg13g2_dlygate4sd3_1$1_9.A a_26954_40424# 0.41941f
C4747 sar_ctrl_async_phys_0.sg13g2_nor2_1$1_5.A VDD 1.03363f
C4748 sar_ctrl_async_phys_0.sg13g2_and2_1$1_6.X sar_ctrl_async_phys_0.sg13g2_a21oi_1$1_5.Y 0.1214f
C4749 sar_ctrl_async_phys_0.dac_code_n[6] oa_sar8_acore18_opt_0.sw_bitcell_opt_b5_0.bot 0.59547f
C4750 sar_ctrl_async_phys_0.sg13g2_a21oi_1$1_1.B1 sar_ctrl_async_phys_0.sg13g2_nand2_1$1_3.Y 0.02736f
C4751 a_32580_36642# VDD 0.19602f
C4752 sar_ctrl_async_phys_0.sg13g2_nor2_1$1_10.B a_31140_42690# 0.09558f
C4753 sar_ctrl_async_phys_0.sg13g2_a22oi_1$1_1.A2 a_34261_36653# 0.04892f
C4754 sar_ctrl_async_phys_0.sg13g2_buf_1$1_15.A a_35168_41430# 0.01122f
C4755 sar_ctrl_async_phys_0.sg13g2_and2_1$1_3.A a_26160_37522# 0.01851f
C4756 a_32692_46064# VDD 0.0868f
C4757 sar_ctrl_async_phys_0.sg13g2_buf_1$1_3.A busy 0.2613f
C4758 sar_ctrl_async_phys_0.sg13g2_buf_1$1_36.A a_35770_43484# 0.04504f
C4759 sar_ctrl_async_phys_0.sg13g2_nand2b_1$1_0.Y a_29144_39830# 0.02763f
C4760 sar_ctrl_async_phys_0.sg13g2_a22oi_1$1_0.A1 sar_ctrl_async_phys_0.sg13g2_buf_1$1_10.A 0.25f
C4761 sar_ctrl_async_phys_0.dac_code_n[3] oa_sar8_acore18_opt_0.sw_bitcell_opt_b0_1.bot 0.06598f
C4762 a_30486_31826# VDD 0.7766f
C4763 a_32635_40471# a_33632_40702# 0.03061f
C4764 sar_ctrl_async_phys_0.sg13g2_buf_1$1_20.A sar_ctrl_async_phys_0.sg13g2_a21oi_1$1_0.A1 0.01282f
C4765 a_35360_43726# a_35770_43484# 0.10373f
C4766 sar_ctrl_async_phys_0.sg13g2_a22oi_1$1_3.A2 a_33270_39698# 0.0173f
C4767 sar_ctrl_async_phys_0.sg13g2_nand2b_1$1_1.B a_35199_44311# 0.02268f
C4768 sar_ctrl_async_phys_0.sg13g2_nand2b_1$1_4.A_N sar_ctrl_async_phys_0.sg13g2_buf_1$1_32.A 0.11804f
C4769 sar_ctrl_async_phys_0.sg13g2_nor2b_1$1_0.A sar_ctrl_async_phys_0.sg13g2_a21oi_1$1_0.A1 1.10755f
C4770 sar_ctrl_async_phys_0.sg13g2_nand2b_1$1_0.A_N VDD 0.65306f
C4771 sar_ctrl_async_phys_0.sg13g2_a22oi_1$1_0.B1 a_30331_33772# 0.04744f
C4772 sar_ctrl_async_phys_0.sg13g2_buf_1$1_6.X a_34636_31749# 0.42549f
C4773 sar_ctrl_async_phys_0.dac_code_n[0] oa_sar8_acore18_opt_0.sw_bitcell_opt_b5_0.bot 0.34793f
C4774 sar_ctrl_async_phys_0.dac_code_n[3] a_35948_n9612# 1.18417f
C4775 sar_ctrl_async_phys_0.dac_code[1] oa_sar8_acore18_opt_0.sw_bitcell_opt_term_0.vin 1.75101f
C4776 sar_ctrl_async_phys_0.sg13g2_a22oi_1$1_0.B2 a_33464_30664# 0.27031f
C4777 a_34075_39820# a_34815_39775# 0.26905f
C4778 sar_ctrl_async_phys_0.dac_code[6] oa_sar8_acore18_opt_0.sw_bitcell_opt_b3_0.bot 0.52232f
C4779 sar_ctrl_async_phys_0.sg13g2_a21oi_1$1_5.Y sar_ctrl_async_phys_0.sg13g2_buf_1$1_6.X 1.88795f
C4780 sar_ctrl_async_phys_0.sg13g2_a21oi_1$1_2.Y a_29236_38952# 0.0205f
C4781 sar_ctrl_async_phys_0.sg13g2_nor2b_1$1_0.A a_34075_39820# 0.0346f
C4782 sar_ctrl_async_phys_0.sg13g2_dfrbpq_1$1_0.CLK sar_ctrl_async_phys_0.sg13g2_buf_1$1_20.A 0.07891f
C4783 sar_ctrl_async_phys_0.sg13g2_buf_1$1_3.A sar_ctrl_async_phys_0.bit_active[5] 0.02252f
C4784 sar_ctrl_async_phys_0.sg13g2_dfrbpq_1$1_0.CLK sar_ctrl_async_phys_0.sg13g2_nor2b_1$1_0.A 1.56161f
C4785 sar_ctrl_async_phys_0.dac_code_n[1] sar_ctrl_async_phys_0.dac_code[5] 0.05494f
C4786 sar_ctrl_async_phys_0.sg13g2_nor2_1$1_6.Y sar_ctrl_async_phys_0.sg13g2_nor2_1$1_3.B 0.02512f
C4787 sar_ctrl_async_phys_0.sg13g2_buf_1$1_3.A a_35664_37695# 0.1742f
C4788 a_35360_36894# a_35770_36972# 0.10373f
C4789 sar_ctrl_async_phys_0.sg13g2_nor2_1$1_18.A VDD 0.39627f
C4790 sar_ctrl_async_phys_0.sg13g2_nor2_1$1_10.Y a_30714_43020# 0.01369f
C4791 sar_ctrl_async_phys_0.sg13g2_nor2b_1$1_4.Y sar_ctrl_async_phys_0.sg13g2_buf_1$1_20.A 0.09786f
C4792 result[2] result[1] 0.11092f
C4793 sar_ctrl_async_phys_0.sg13g2_nand2b_1$1_3.Y a_35053_40730# 0.28484f
C4794 a_31136_43726# a_30879_43845# 0.34468f
C4795 sar_ctrl_async_phys_0.sg13g2_nor2b_1$1_4.Y sar_ctrl_async_phys_0.sg13g2_nor2b_1$1_0.A 0.33247f
C4796 a_28651_39740# VDD 0.24577f
C4797 sar_ctrl_async_phys_0.sg13g2_nor2b_1$1_4.Y a_31546_43484# 0.01244f
C4798 m3_38288_n2380# m3_41836_n2380# 0.0157f
C4799 sar_ctrl_async_phys_0.sg13g2_dfrbpq_1$1_0.CLK a_32251_35284# 0.04561f
C4800 result[4] result[6] 0.08567f
C4801 sar_ctrl_async_phys_0.dac_code_n[6] sar_ctrl_async_phys_0.dac_code[7] 0.13099f
C4802 sar_ctrl_async_phys_0.dac_code_n[7] oa_sar8_acore18_opt_0.sw_bitcell_opt_b5_0.bot 0.42877f
C4803 VDD rst_n 0.14182f
C4804 sar_ctrl_async_phys_0.sg13g2_inv_1$1_1.Y VDD 0.44405f
C4805 sar_ctrl_async_phys_0.sg13g2_buf_1$1_14.A a_33750_36362# 0.05128f
C4806 sar_ctrl_async_phys_0.sg13g2_buf_1$1_32.A a_34261_43495# 0.01329f
C4807 a_35384_32176# VDD 0.2812f
C4808 a_32245_37447# VDD 0.25613f
C4809 sar_ctrl_async_phys_0.dac_code[3] oa_sar8_acore18_opt_0.sw_bitcell_opt_b3_0.bot 1.93967f
C4810 a_31732_35480# a_32149_35141# 0.3749f
C4811 a_31446_35162# a_32251_35284# 0.097f
C4812 sar_ctrl_async_phys_0.sg13g2_dfrbpq_1$1_0.CLK sar_ctrl_async_phys_0.sg13g2_nor2_1$1_10.Y 0.25594f
C4813 sar_ctrl_async_phys_0.sg13g2_o21ai_1$1_1.B1 a_35168_41430# 0.10165f
C4814 a_31706_35385# a_32149_35141# 0.02242f
C4815 sar_ctrl_async_phys_0.sg13g2_buf_1$1_6.X a_31732_35480# 0.417f
C4816 sar_ctrl_async_phys_0.sg13g2_nor2_1$1_10.Y a_30139_43495# 0.0259f
C4817 a_31706_35385# sar_ctrl_async_phys_0.sg13g2_buf_1$1_6.X 0.25335f
C4818 a_27120_37522# VDD 0.08569f
C4819 sar_ctrl_async_phys_0.sg13g2_nor2b_1$1_4.Y sar_ctrl_async_phys_0.sg13g2_nor2_1$1_10.Y 0.14456f
C4820 a_33626_41433# a_33652_41528# 0.36952f
C4821 sar_ctrl_async_phys_0.cmp_fire sar_ctrl_async_phys_0.cmp_n 1.23f
C4822 sar_ctrl_async_phys_0.sg13g2_inv_1$1_10.Y sar_ctrl_async_phys_0.sg13g2_nor2_1$1_13.B 0.01892f
C4823 sar_ctrl_async_phys_0.sg13g2_buf_1$1_4.A a_36056_33688# 0.26497f
C4824 sar_ctrl_async_phys_0.dac_code_n[6] oa_sar8_acore18_opt_0.sw_bitcell_opt_b1_0.bot 0.42248f
C4825 sar_ctrl_async_phys_0.sg13g2_nand3_1$1_0.C a_25496_39830# 0.01893f
C4826 sar_ctrl_async_phys_0.sg13g2_buf_1$1_29.X sar_ctrl_async_phys_0.sg13g2_nor2_1$1_4.Y 0.2508f
C4827 w_16692_n9960# vinp 0.01233f
C4828 sar_ctrl_async_phys_0.sg13g2_a21oi_1$1_0.A2 a_35295_36285# 0.04318f
C4829 sar_ctrl_async_phys_0.sg13g2_nand2_1$1_1.B sar_ctrl_async_phys_0.sg13g2_nor2_1$1_6.B 0.12629f
C4830 sar_ctrl_async_phys_0.sg13g2_nand2b_1$1_3.Y sar_ctrl_async_phys_0.sg13g2_a21oi_1$1_0.A1 0.09503f
C4831 sar_ctrl_async_phys_0.sg13g2_and2_1$1_0.A a_26174_42911# 0.01912f
C4832 a_34106_32868# VDD 0.12037f
C4833 sar_ctrl_async_phys_0.sg13g2_dfrbpq_1$1_0.CLK sar_ctrl_async_phys_0.sg13g2_nor2b_1$1_1.B_N 0.42822f
C4834 sar_ctrl_async_phys_0.sg13g2_nor2b_1$1_0.A a_32888_36806# 0.02094f
C4835 a_34555_35935# a_35552_36166# 0.03061f
C4836 sar_ctrl_async_phys_0.dac_code_n[0] sar_ctrl_async_phys_0.dac_code[7] 0.13858f
C4837 a_31071_33727# a_30977_33727# 0.28931f
C4838 sar_ctrl_async_phys_0.sg13g2_buf_1$1_42.A a_33857_45823# 0.01294f
C4839 oa_sar8_acore18_opt_0.sw_tg_opt_0.bot oa_sar8_acore18_opt_0.sw_bitcell_opt_b7_0.bot 59.4553f
C4840 sar_ctrl_async_phys_0.sg13g2_dfrbpq_1$1_0.CLK sar_ctrl_async_phys_0.sg13g2_nand2b_1$1_3.Y 0.72391f
C4841 a_34261_43495# a_34132_43909# 0.01562f
C4842 a_33844_43488# a_34363_43495# 0.34102f
C4843 sar_ctrl_async_phys_0.sg13g2_a21oi_1$1_1.B1 VDD 0.87593f
C4844 sar_ctrl_async_phys_0.sg13g2_a21oi_1$1_0.A2 sar_ctrl_async_phys_0.sg13g2_nor2b_1$1_1.B_N 0.06127f
C4845 sar_ctrl_async_phys_0.sg13g2_buf_1$1_42.A a_33211_45868# 0.02435f
C4846 sar_ctrl_async_phys_0.sg13g2_a22oi_1$1_2.B2 a_31823_32876# 0.07329f
C4847 sar_ctrl_async_phys_0.dac_code_n[0] oa_sar8_acore18_opt_0.sw_bitcell_opt_b1_0.bot 0.18225f
C4848 sar_ctrl_async_phys_0.sg13g2_a22oi_1$1_2.A2 a_32404_40885# 0.02381f
C4849 a_30591_32215# a_31258_32436# 0.0894f
C4850 a_29749_32117# a_30497_32215# 0.01058f
C4851 sar_ctrl_async_phys_0.sg13g2_buf_1$1_6.X a_32288_31630# 0.10533f
C4852 sar_ctrl_async_phys_0.dac_code[6] oa_sar8_acore18_opt_0.sw_bitcell_opt_term_0.bot 0.36001f
C4853 sar_ctrl_async_phys_0.sg13g2_buf_1$1_0.A sar_ctrl_async_phys_0.sg13g2_inv_1$1_3.Y 0.10594f
C4854 sar_ctrl_async_phys_0.dac_code_n[7] sar_ctrl_async_phys_0.dac_code[7] 0.13774f
C4855 oa_sar8_acore18_opt_0.sw_bitcell_opt_b0_1.bot a_20412_n9612# 0.14526f
C4856 a_33270_39698# a_33556_40016# 0.41329f
C4857 sar_ctrl_async_phys_0.sg13g2_inv_1$1_0.A a_33440_32358# 0.02435f
C4858 sar_ctrl_async_phys_0.sg13g2_a21oi_1$1_0.A1 sar_ctrl_async_phys_0.sg13g2_and2_1$1_1.B 0.22114f
C4859 a_34549_30605# a_35297_30703# 0.01058f
C4860 a_35391_30703# a_36058_30924# 0.0894f
C4861 a_31381_46519# a_31252_46933# 0.01562f
C4862 a_30964_46512# sar_ctrl_async_phys_0.sg13g2_dfrbpq_1$1_0.CLK 0.07275f
C4863 a_33844_36992# a_35103_36751# 0.01529f
C4864 sar_ctrl_async_phys_0.sg13g2_a22oi_1$1_0.B1 a_30480_32986# 0.01151f
C4865 sar_ctrl_async_phys_0.sg13g2_buf_1$1_41.X sar_ctrl_async_phys_0.sg13g2_dfrbpq_1$1_0.CLK 0.60685f
C4866 sar_ctrl_async_phys_0.sg13g2_dfrbpq_1$1_0.CLK a_29620_43488# 0.09474f
C4867 a_30037_43495# a_30785_43845# 0.01058f
C4868 sar_ctrl_async_phys_0.sg13g2_buf_1$1_15.A sar_ctrl_async_phys_0.dac_code[5] 0.04617f
C4869 sar_ctrl_async_phys_0.sg13g2_nor2_1$1_4.Y a_26385_39214# 0.05017f
C4870 sar_ctrl_async_phys_0.sg13g2_buf_1$1_41.X a_30139_43495# 0.45163f
C4871 a_30037_43495# a_29908_43909# 0.01562f
C4872 a_29620_43488# a_30139_43495# 0.34102f
C4873 sar_ctrl_async_phys_0.sg13g2_nand2b_1$1_3.Y a_32116_40464# 0.01748f
C4874 sar_ctrl_async_phys_0.sg13g2_a21oi_1$1_2.B1 a_33366_41210# 0.01063f
C4875 sar_ctrl_async_phys_0.sg13g2_nor2b_1$1_4.Y sar_ctrl_async_phys_0.sg13g2_buf_1$1_41.X 1.84295f
C4876 sar_ctrl_async_phys_0.hold_req oa_sar8_acore18_opt_0.sw_bitcell_opt_term_0.trkb 0.18928f
C4877 sar_ctrl_async_phys_0.dac_code_n[7] oa_sar8_acore18_opt_0.sw_bitcell_opt_b1_0.bot 0.105f
C4878 sar_ctrl_async_phys_0.dac_code_n[5] oa_sar8_acore18_opt_0.sw_bitcell_opt_term_0.gb 0.1574f
C4879 sar_ctrl_async_phys_0.dac_code[6] m3_38288_n2380# 0.04464f
C4880 sar_ctrl_async_phys_0.hold_req sar_ctrl_async_phys_0.cmp_n 0.26913f
C4881 sar_ctrl_async_phys_0.sg13g2_nor2_1$1_1.Y sar_ctrl_async_phys_0.sg13g2_a22oi_1$1_0.A2 0.01075f
C4882 sar_ctrl_async_phys_0.dac_code[3] oa_sar8_acore18_opt_0.sw_bitcell_opt_term_0.bot 0.16685f
C4883 a_35391_30703# result[1] 0.01708f
C4884 sar_ctrl_async_phys_0.sg13g2_nor2_1$1_3.B a_26630_37814# 0.09468f
C4885 sar_ctrl_async_phys_0.sg13g2_a22oi_1$1_0.A1 a_34319_32460# 0.02619f
C4886 sar_ctrl_async_phys_0.sg13g2_a21oi_1$1_0.B1 sar_ctrl_async_phys_0.dac_code_n[0] 0.08194f
C4887 sar_ctrl_async_phys_0.sg13g2_buf_1$1_37.A sar_ctrl_async_phys_0.sg13g2_a21oi_1$1_0.A1 0.68249f
C4888 sar_ctrl_async_phys_0.sg13g2_dfrbpq_1$1_0.CLK a_34036_35928# 0.08927f
C4889 a_32443_32260# VDD 0.21005f
C4890 sar_ctrl_async_phys_0.sg13g2_nand2b_1$1_3.Y a_35245_45936# 0.01583f
C4891 sar_ctrl_async_phys_0.sg13g2_o21ai_1$1_1.B1 a_33626_41433# 0.23968f
C4892 a_32288_31630# a_32031_31749# 0.34468f
C4893 sar_ctrl_async_phys_0.sg13g2_a21oi_1$1_2.Y sar_ctrl_async_phys_0.sg13g2_buf_1$1_17.A 0.05812f
C4894 sar_ctrl_async_phys_0.sg13g2_a22oi_1$1_2.Y a_30772_31392# 0.02842f
C4895 a_28870_35948# VDD 0.19286f
C4896 sar_ctrl_async_phys_0.sg13g2_a21oi_1$1_0.A1 a_35211_37436# 0.03314f
C4897 sar_ctrl_async_phys_0.sg13g2_and2_1$1_3.X a_26566_39766# 0.0131f
C4898 sar_ctrl_async_phys_0.sg13g2_nor2_1$1_4.Y sar_ctrl_async_phys_0.sg13g2_nor4_1$1_0.C 0.03153f
C4899 sar_ctrl_async_phys_0.sg13g2_a21oi_1$1_0.A2 sar_ctrl_async_phys_0.sg13g2_and2_1$1_1.B 0.04862f
C4900 sar_ctrl_async_phys_0.hold_req oa_sar8_acore18_opt_0.sw_bitcell_opt_b4_0.bot 0.10625f
C4901 sar_ctrl_async_phys_0.sg13g2_dlygate4sd3_1$1_7.A a_26270_39215# 0.16093f
C4902 sar_ctrl_async_phys_0.sg13g2_a21oi_1$1_0.A2 a_34036_35928# 0.06475f
C4903 sar_ctrl_async_phys_0.sg13g2_dfrbpq_1$1_0.CLK sar_ctrl_async_phys_0.sg13g2_buf_1$1_37.A 0.02373f
C4904 sar_ctrl_async_phys_0.sg13g2_a22oi_1$1_0.A1 a_33846_33338# 0.01643f
C4905 sar_ctrl_async_phys_0.sg13g2_nor2b_1$1_0.A a_32580_36642# 0.07149f
C4906 sar_ctrl_async_phys_0.dac_code_n[3] oa_sar8_acore18_opt_0.sw_bitcell_opt_b7_0.bot 2.23254f
C4907 sar_ctrl_async_phys_0.sg13g2_a22oi_1$1_1.A2 a_34106_32868# 0.01847f
C4908 a_34036_35928# a_34324_36349# 0.43707f
C4909 a_34911_41287# VDD 0.17713f
C4910 sar_ctrl_async_phys_0.sg13g2_buf_1$1_7.A sar_ctrl_async_phys_0.sg13g2_inv_1$1_2.Y 0.01502f
C4911 sar_ctrl_async_phys_0.sg13g2_buf_1$1_2.A sar_ctrl_async_phys_0.sg13g2_nand2b_1$1_5.A_N 0.03666f
C4912 sar_ctrl_async_phys_0.sg13g2_a21oi_1$1_0.B1 sar_ctrl_async_phys_0.dac_code_n[7] 0.02676f
C4913 a_30331_33772# a_31328_33870# 0.02979f
C4914 a_29526_33650# a_30100_33663# 0.31978f
C4915 sar_ctrl_async_phys_0.sg13g2_dfrbpq_1$1_0.CLK a_30772_31392# 0.08781f
C4916 sar_ctrl_async_phys_0.sg13g2_nor2_1$1_14.A a_27530_39666# 0.06683f
C4917 sar_ctrl_async_phys_0.sg13g2_a21oi_1$1_1.B1 sar_ctrl_async_phys_0.sg13g2_buf_1$1_14.A 0.03342f
C4918 sar_ctrl_async_phys_0.sg13g2_buf_1$1_4.A a_33818_36897# 0.01853f
C4919 sar_ctrl_async_phys_0.sg13g2_a21oi_1$1_5.Y a_31935_39775# 0.03918f
C4920 a_29786_33873# sar_ctrl_async_phys_0.sg13g2_inv_1$1_6.Y 0.01391f
C4921 sar_ctrl_async_phys_0.sg13g2_buf_1$1_6.X sar_ctrl_async_phys_0.sg13g2_inv_1$1_3.Y 0.37566f
C4922 sar_ctrl_async_phys_0.sg13g2_buf_1$1_0.A a_34132_32904# 0.05017f
C4923 a_31040_40702# a_31450_40460# 0.10373f
C4924 a_35391_34773# a_35297_34773# 0.28931f
C4925 sar_ctrl_async_phys_0.sg13g2_nor2_1$1_10.B a_30650_39921# 0.02532f
C4926 a_32149_45007# a_32897_45357# 0.01058f
C4927 sar_ctrl_async_phys_0.sg13g2_nor2b_1$1_1.B_N a_33750_36362# 0.01033f
C4928 sar_ctrl_async_phys_0.sg13g2_a21oi_1$1_4.B1 sar_ctrl_async_phys_0.dac_code_n[6] 2.00218f
C4929 sar_ctrl_async_phys_0.sg13g2_a22oi_1$1_4.A2 sar_ctrl_async_phys_0.sg13g2_a22oi_1$1_0.Y 0.02831f
C4930 sar_ctrl_async_phys_0.sg13g2_nor2_1$1_0.Y a_31060_44552# 0.01464f
C4931 sar_ctrl_async_phys_0.sg13g2_inv_1$1_0.Y a_34636_31749# 0.03036f
C4932 sar_ctrl_async_phys_0.sg13g2_nor2_1$1_1.Y sar_ctrl_async_phys_0.sg13g2_buf_1$1_3.A 0.02106f
C4933 sar_ctrl_async_phys_0.sg13g2_nand2b_1$1_1.B sar_ctrl_async_phys_0.sg13g2_nand2b_1$1_2.A_N 0.81378f
C4934 sar_ctrl_async_phys_0.sg13g2_nor2_1$1_7.A sar_ctrl_async_phys_0.sg13g2_dlygate4sd3_1$1_0.X 0.01483f
C4935 sar_ctrl_async_phys_0.sg13g2_buf_1$1_13.A a_32602_35924# 0.11497f
C4936 sar_ctrl_async_phys_0.sg13g2_nor2b_1$1_0.A sar_ctrl_async_phys_0.sg13g2_nor2_1$1_18.A 0.70084f
C4937 sar_ctrl_async_phys_0.dac_code_n[6] oa_sar8_acore18_opt_0.sw_bitcell_opt_b3_1.bot 0.06598f
C4938 sar_ctrl_async_phys_0.sg13g2_nand2b_1$1_6.A_N a_35000_45878# 0.02439f
C4939 a_30678_46946# a_30964_46512# 0.41329f
C4940 a_26184_42013# a_26454_41972# 0.26306f
C4941 sar_ctrl_async_phys_0.sg13g2_o21ai_1$1_1.B1 a_31040_40702# 0.1095f
C4942 sar_ctrl_async_phys_0.sg13g2_buf_1$1_41.X a_30678_46946# 0.11631f
C4943 a_34618_46044# a_35000_45878# 0.01012f
C4944 sar_ctrl_async_phys_0.sg13g2_and2_1$1_0.A a_31040_40702# 0.01497f
C4945 sar_ctrl_async_phys_0.sg13g2_buf_1$1_41.X a_29334_43922# 0.09798f
C4946 a_29334_43922# a_29620_43488# 0.41329f
C4947 a_30384_35294# VDD 0.06815f
C4948 sar_ctrl_async_phys_0.sg13g2_a21oi_1$1_2.B1 a_34904_38948# 0.05088f
C4949 sar_ctrl_async_phys_0.sg13g2_buf_1$1_19.A a_33948_41936# 0.01944f
C4950 sar_ctrl_async_phys_0.sg13g2_nor2_1$1_1.Y sar_ctrl_async_phys_0.sg13g2_a22oi_1$1_0.A1 0.04153f
C4951 sar_ctrl_async_phys_0.sg13g2_o21ai_1$1_1.B1 a_28130_40838# 0.05762f
C4952 a_33951_45823# a_34208_45966# 0.34468f
C4953 a_32319_44311# VDD 0.17729f
C4954 sar_ctrl_async_phys_0.sample sar_ctrl_async_phys_0.sg13g2_nor2_1$1_12.Y 0.05522f
C4955 a_36056_47296# sar_ctrl_async_phys_0.dac_code_n[4] 0.08995f
C4956 sar_ctrl_async_phys_0.sg13g2_nand2b_1$1_1.B a_35672_42760# 0.05714f
C4957 sar_ctrl_async_phys_0.sg13g2_a21oi_1$1_4.B1 sar_ctrl_async_phys_0.dac_code_n[0] 0.03101f
C4958 a_33464_30664# result[1] 0.25342f
C4959 sar_ctrl_async_phys_0.sg13g2_o21ai_1$1_1.B1 sar_ctrl_async_phys_0.sg13g2_nor2_1$1_0.Y 0.09998f
C4960 a_34040_45082# VDD 0.15286f
C4961 oa_sar8_acore18_opt_0.sw_bitcell_opt_term_0.vin m3_41836_n2380# 0.05057f
C4962 sar_ctrl_async_phys_0.sg13g2_and2_1$1_0.A sar_ctrl_async_phys_0.sg13g2_nor2_1$1_0.Y 0.12036f
C4963 sar_ctrl_async_phys_0.sg13g2_dfrbpq_1$1_0.CLK a_31935_36285# 0.02585f
C4964 sar_ctrl_async_phys_0.sg13g2_nor2b_1$1_0.A a_30964_36349# 0.02056f
C4965 a_26454_39702# a_26566_39766# 0.55452f
C4966 sar_ctrl_async_phys_0.sg13g2_and2_1$1_3.X a_27530_39666# 0.01557f
C4967 a_30772_31392# a_31291_31399# 0.34102f
C4968 a_31189_31399# a_31060_31813# 0.01562f
C4969 sar_ctrl_async_phys_0.sg13g2_nor4_1$1_0.C sar_ctrl_async_phys_0.sg13g2_nor2_1$1_1.Y 0.02002f
C4970 sar_ctrl_async_phys_0.sg13g2_o21ai_1$1_1.B1 a_30495_39309# 0.13475f
C4971 sar_ctrl_async_phys_0.hold_req oa_sar8_acore18_opt_0.sw_bitcell_opt_b0_0.bot 0.13521f
C4972 sar_ctrl_async_phys_0.sg13g2_and2_1$1_0.A a_30495_39309# 0.01586f
C4973 sar_ctrl_async_phys_0.sg13g2_o21ai_1$1_1.B1 sar_ctrl_async_phys_0.sg13g2_inv_1$1_10.Y 0.07321f
C4974 sar_ctrl_async_phys_0.sg13g2_a22oi_1$1_2.A2 a_32602_39996# 0.04363f
C4975 sar_ctrl_async_phys_0.sg13g2_nor2_1$1_6.Y sar_ctrl_async_phys_0.sg13g2_nor2_1$1_7.A 0.0611f
C4976 a_33344_37678# a_33087_37797# 0.34468f
C4977 a_30495_39309# a_30401_39309# 0.28931f
C4978 sar_ctrl_async_phys_0.sg13g2_a22oi_1$1_4.Y VDD 0.20459f
C4979 sar_ctrl_async_phys_0.sg13g2_a21oi_1$1_4.B1 sar_ctrl_async_phys_0.dac_code_n[7] 0.3539f
C4980 a_33750_36362# a_34036_35928# 0.41329f
C4981 sar_ctrl_async_phys_0.dac_code_n[5] sar_ctrl_async_phys_0.dac_code[2] 0.06252f
C4982 sar_ctrl_async_phys_0.sg13g2_a22oi_1$1_0.A1 sar_ctrl_async_phys_0.sg13g2_inv_1$1_5.A 0.3138f
C4983 sar_ctrl_async_phys_0.sg13g2_buf_1$1_41.X a_32692_46064# 0.0464f
C4984 sar_ctrl_async_phys_0.dac_code[2] oa_sar8_acore18_opt_0.sw_bitcell_opt_term_0.gb 0.19971f
C4985 sar_ctrl_async_phys_0.sg13g2_buf_1$1_6.X a_34132_32904# 0.37886f
C4986 a_29526_33650# a_30229_33629# 0.02454f
C4987 sar_ctrl_async_phys_0.sg13g2_buf_1$1_2.A sar_ctrl_async_phys_0.sg13g2_buf_1$1_15.A 0.02734f
C4988 sar_ctrl_async_phys_0.dac_code[1] sar_ctrl_async_phys_0.dac_code[5] 0.27276f
C4989 sar_ctrl_async_phys_0.sg13g2_nand2_1$1_5.Y sar_ctrl_async_phys_0.dac_code[6] 0.15028f
C4990 sar_ctrl_async_phys_0.dac_code_n[7] oa_sar8_acore18_opt_0.sw_bitcell_opt_b3_1.bot 0.13522f
C4991 sar_ctrl_async_phys_0.sg13g2_a21oi_1$1_1.B1 sar_ctrl_async_phys_0.sg13g2_buf_1$1_20.A 0.04313f
C4992 a_33844_43488# VDD 0.09727f
C4993 sar_ctrl_async_phys_0.sg13g2_dlygate4sd3_1$1_7.A sar_ctrl_async_phys_0.sg13g2_and2_1$1_3.X 0.0534f
C4994 a_34132_34416# a_35391_34773# 0.01529f
C4995 a_31446_45434# a_32251_45007# 0.097f
C4996 sar_ctrl_async_phys_0.sg13g2_a22oi_1$1_0.Y sar_ctrl_async_phys_0.sg13g2_inv_1$1_0.A 0.01046f
C4997 sar_ctrl_async_phys_0.sg13g2_nand2b_1$1_1.Y a_34765_42242# 0.28431f
C4998 sar_ctrl_async_phys_0.sg13g2_nand2b_1$1_0.Y a_28578_40460# 0.02356f
C4999 sar_ctrl_async_phys_0.sg13g2_nor4_1$1_0.C sar_ctrl_async_phys_0.sg13g2_nand2_1$1_3.A 0.0134f
C5000 sar_ctrl_async_phys_0.sg13g2_buf_1$1_13.A a_31542_37874# 0.03073f
C5001 oa_sar8_acore18_opt_0.sw_bitcell_opt_term_0.trkb oa_sar8_acore18_opt_0.sw_bitcell_opt_term_0.VSS 0.57977f
C5002 sar_ctrl_async_phys_0.sg13g2_dfrbpq_1$1_0.CLK a_30390_39698# 0.04941f
C5003 a_34420_33325# a_34651_32911# 0.12701f
C5004 sar_ctrl_async_phys_0.sg13g2_and2_1$1_3.A VDD 1.38182f
C5005 sar_ctrl_async_phys_0.dac_code_n[6] sar_ctrl_async_phys_0.dac_code[4] 0.06252f
C5006 a_33109_45725# a_33857_45823# 0.01058f
C5007 sar_ctrl_async_phys_0.sg13g2_a21oi_1$1_1.B1 sar_ctrl_async_phys_0.sg13g2_nand2_1$1_3.B 0.08478f
C5008 sar_ctrl_async_phys_0.sg13g2_buf_1$1_3.A sar_ctrl_async_phys_0.sg13g2_buf_1$1_5.A 0.02657f
C5009 sar_ctrl_async_phys_0.sg13g2_a21oi_1$1_2.B1 sar_ctrl_async_phys_0.sg13g2_a21oi_1$1_5.A2 0.24992f
C5010 a_33109_45725# a_33211_45868# 0.47622f
C5011 a_35672_42760# sar_ctrl_async_phys_0.sg13g2_nand2_1$1_5.Y 0.02538f
C5012 sar_ctrl_async_phys_0.sg13g2_inv_1$1_11.Y a_30872_30758# 0.02888f
C5013 a_30331_33772# VDD 0.20623f
C5014 a_30043_40471# VDD 0.20722f
C5015 oa_sar8_acore18_opt_0.sw_bitcell_opt_b4_0.bot oa_sar8_acore18_opt_0.sw_bitcell_opt_term_0.VSS 1.93948f
C5016 a_35648_34654# VDD 0.17038f
C5017 a_36056_41972# VDD 0.21853f
C5018 a_29332_32456# VDD 0.07664f
C5019 sar_ctrl_async_phys_0.sg13g2_nand2_1$1_5.B a_33654_44234# 0.01151f
C5020 a_30486_31826# a_30772_31392# 0.41329f
C5021 sar_ctrl_async_phys_0.dac_code[6] oa_sar8_acore18_opt_0.sw_bitcell_opt_term_0.vin 2.07616f
C5022 a_26673_40726# VDD 0.2264f
C5023 sar_ctrl_async_phys_0.sample track 0.05333f
C5024 a_34132_30944# VDD 0.10158f
C5025 oa_sar8_acore18_opt_0.sw_bitcell_opt_term_0.vin vinn 0.73522f
C5026 sar_ctrl_async_phys_0.dac_code_n[0] sar_ctrl_async_phys_0.dac_code[4] 0.06405f
C5027 sar_ctrl_async_phys_0.sg13g2_buf_1$1_2.A sar_ctrl_async_phys_0.sg13g2_o21ai_1$1_1.B1 0.08746f
C5028 sar_ctrl_async_phys_0.sg13g2_a21oi_1$1_6.A2 sar_ctrl_async_phys_0.sg13g2_o21ai_1$1_1.B1 2.35552f
C5029 a_29701_36874# VDD 0.2609f
C5030 a_29236_38952# a_30495_39309# 0.01529f
C5031 a_31828_37440# a_32993_37797# 0.43239f
C5032 sar_ctrl_async_phys_0.sg13g2_a22oi_1$1_0.Y sar_ctrl_async_phys_0.sg13g2_a22oi_1$1_2.B2 0.02051f
C5033 sar_ctrl_async_phys_0.sg13g2_a22oi_1$1_1.Y sar_ctrl_async_phys_0.sg13g2_inv_1$1_1.Y 0.11565f
C5034 sar_ctrl_async_phys_0.sg13g2_a21oi_1$1_1.B1 sar_ctrl_async_phys_0.sg13g2_nand2b_1$1_3.Y 0.03124f
C5035 a_26174_42911# a_26289_42912# 0.55452f
C5036 done busy 0.17133f
C5037 sar_ctrl_async_phys_0.dac_code_n[6] oa_sar8_acore18_opt_0.bstrap_opt_w2_c1200_1.out 1.86099f
C5038 a_30752_39190# VDD 0.16828f
C5039 sar_ctrl_async_phys_0.dac_code_n[7] oa_sar8_acore18_opt_0.sw_bitcell_opt_b7_1.bot 1.34338f
C5040 a_27984_41342# VDD 0.07685f
C5041 sar_ctrl_async_phys_0.dac_code_n[5] oa_sar8_acore18_opt_0.sw_bitcell_opt_b3_0.bot 0.08014f
C5042 sar_ctrl_async_phys_0.dac_code[3] oa_sar8_acore18_opt_0.sw_bitcell_opt_term_0.vin 1.79718f
C5043 oa_sar8_acore18_opt_0.sw_bitcell_opt_b3_0.bot oa_sar8_acore18_opt_0.sw_bitcell_opt_term_0.gb 0.62478f
C5044 sar_ctrl_async_phys_0.sg13g2_a22oi_1$1_1.Y a_34106_32868# 0.02521f
C5045 sar_ctrl_async_phys_0.dac_code_n[7] sar_ctrl_async_phys_0.dac_code[4] 0.06317f
C5046 sar_ctrl_async_phys_0.sg13g2_buf_1$1_2.A sar_ctrl_async_phys_0.sg13g2_nor2b_1$1_1.Y 0.0223f
C5047 sar_ctrl_async_phys_0.sg13g2_a22oi_1$1_2.A2 sar_ctrl_async_phys_0.sg13g2_a22oi_1$1_0.B1 0.32655f
C5048 a_33846_34850# a_34549_34423# 0.02432f
C5049 sar_ctrl_async_phys_0.sg13g2_nor2_1$1_13.A track 0.01114f
C5050 a_33936_31675# result[2] 0.013f
C5051 sar_ctrl_async_phys_0.sg13g2_a21oi_1$1_5.Y sar_ctrl_async_phys_0.sg13g2_buf_1$1_1.A 0.02287f
C5052 sar_ctrl_async_phys_0.sg13g2_a21oi_1$1_0.B1 sar_ctrl_async_phys_0.sg13g2_nand2_1$1_3.A 0.08682f
C5053 sar_ctrl_async_phys_0.sg13g2_nand2_1$1_3.A a_33940_44552# 0.01425f
C5054 sar_ctrl_async_phys_0.sg13g2_buf_1$1_19.A sar_ctrl_async_phys_0.sg13g2_nand2_1$1_2.B 0.02263f
C5055 a_28968_42013# a_29238_41972# 0.26306f
C5056 sar_ctrl_async_phys_0.dac_code_n[0] oa_sar8_acore18_opt_0.bstrap_opt_w2_c1200_1.out 1.87221f
C5057 sar_ctrl_async_phys_0.sg13g2_nand3_1$1_0.Y a_27206_39326# 0.05687f
C5058 a_31093_39677# a_30964_39711# 0.01562f
C5059 sar_ctrl_async_phys_0.hold_req oa_sar8_acore18_opt_0.sw_bitcell_opt_b4_1.bot 0.01501f
C5060 sar_ctrl_async_phys_0.sg13g2_a22oi_1$1_3.A2 sar_ctrl_async_phys_0.sg13g2_a22oi_1$1_0.Y 0.15482f
C5061 sar_ctrl_async_phys_0.sg13g2_a21oi_1$1_5.Y sar_ctrl_async_phys_0.sg13g2_buf_1$1_7.A 0.40679f
C5062 sar_ctrl_async_phys_0.sg13g2_a21oi_1$1_1.B1 sar_ctrl_async_phys_0.sg13g2_and2_1$1_1.B 0.08964f
C5063 sar_ctrl_async_phys_0.sg13g2_nor2b_1$1_1.Y sar_ctrl_async_phys_0.sg13g2_nor2b_1$1_2.Y 0.19995f
C5064 a_34132_32904# a_34651_32911# 0.34102f
C5065 a_34549_32911# a_34420_33325# 0.01562f
C5066 a_26954_40424# a_26673_40726# 0.26306f
C5067 sar_ctrl_async_phys_0.sg13g2_nand2_1$1_3.B a_35009_43845# 0.01323f
C5068 a_25680_39034# track 0.01781f
C5069 a_36056_42760# sar_ctrl_async_phys_0.dac_code[2] 0.08886f
C5070 sar_ctrl_async_phys_0.sg13g2_nand2b_1$1_1.B a_35578_41508# 0.03774f
C5071 sar_ctrl_async_phys_0.sg13g2_a21oi_1$1_3.B1 sar_ctrl_async_phys_0.sg13g2_a21oi_1$1_2.B1 0.10217f
C5072 sar_ctrl_async_phys_0.sg13g2_buf_1$1_35.A a_36074_41214# 0.01562f
C5073 sar_ctrl_async_phys_0.sg13g2_and2_1$1_0.A a_25608_40501# 0.03001f
C5074 sar_ctrl_async_phys_0.sg13g2_nor2_1$1_8.A VDD 0.73974f
C5075 a_27249_39888# a_27530_39666# 0.26306f
C5076 a_30830_35166# a_30733_35166# 0.01625f
C5077 sar_ctrl_async_phys_0.sg13g2_dfrbpq_1$1_5.D a_31446_35162# 0.30006f
C5078 sar_ctrl_async_phys_0.sg13g2_buf_1$1_2.A sar_ctrl_async_phys_0.sg13g2_a22oi_1$1_3.B1 0.03122f
C5079 oa_sar8_acore18_opt_0.sw_bitcell_opt_b0_0.bot oa_sar8_acore18_opt_0.sw_bitcell_opt_term_0.VSS 1.37505f
C5080 sar_ctrl_async_phys_0.sg13g2_dfrbpq_1$1_0.CLK sar_ctrl_async_phys_0.sg13g2_buf_1$1_32.A 0.10181f
C5081 sar_ctrl_async_phys_0.sg13g2_a21oi_1$1_4.B1 sar_ctrl_async_phys_0.sg13g2_nor2_1$1_1.Y 0.02283f
C5082 sar_ctrl_async_phys_0.sample sar_ctrl_async_phys_0.cmp_p 0.47693f
C5083 sar_ctrl_async_phys_0.sg13g2_buf_1$1_1.A a_31732_35480# 0.02949f
C5084 sar_ctrl_async_phys_0.sg13g2_a21oi_1$1_1.B1 sar_ctrl_async_phys_0.sg13g2_buf_1$1_37.A 0.04937f
C5085 sar_ctrl_async_phys_0.dac_code_n[7] oa_sar8_acore18_opt_0.bstrap_opt_w2_c1200_1.out 2.1309f
C5086 sar_ctrl_async_phys_0.sg13g2_nand2b_1$1_3.Y a_34911_41287# 0.01966f
C5087 a_33846_34850# VDD 0.81687f
C5088 sar_ctrl_async_phys_0.sg13g2_buf_1$1_2.A a_32696_30664# 0.25337f
C5089 sar_ctrl_async_phys_0.sg13g2_a21oi_1$1_6.B1 a_32986_44532# 0.01127f
C5090 sar_ctrl_async_phys_0.sg13g2_buf_1$1_2.A sar_ctrl_async_phys_0.sg13g2_buf_1$1_8.A 0.0216f
C5091 sar_ctrl_async_phys_0.bit_active[2] VDD 0.17606f
C5092 sar_ctrl_async_phys_0.sg13g2_a21oi_1$1_1.B1 sar_ctrl_async_phys_0.sg13g2_buf_1$1_35.A 0.01135f
C5093 sar_ctrl_async_phys_0.sg13g2_a21oi_1$1_6.A2 a_32715_43020# 0.10301f
C5094 sar_ctrl_async_phys_0.sg13g2_a21oi_1$1_1.B1 sar_ctrl_async_phys_0.dac_code[0] 0.01458f
C5095 a_30480_32986# VDD 0.07899f
C5096 sar_ctrl_async_phys_0.sg13g2_buf_1$1_6.X a_29620_32151# 0.03977f
C5097 sar_ctrl_async_phys_0.sg13g2_nand2b_1$1_3.Y a_35009_43845# 0.01351f
C5098 a_28950_39386# a_29653_38959# 0.02432f
C5099 sar_ctrl_async_phys_0.sg13g2_nor2_1$1_5.A a_29328_39830# 0.01936f
C5100 a_31542_37874# a_32116_37861# 0.31978f
C5101 sar_ctrl_async_phys_0.sg13g2_dfrbpq_1$1_0.CLK a_33652_41528# 0.08047f
C5102 a_31195_35935# a_32192_36166# 0.03061f
C5103 a_31093_35935# a_31841_36285# 0.01058f
C5104 a_28662_41214# VDD 0.22963f
C5105 a_28950_39386# VDD 0.77635f
C5106 sar_ctrl_async_phys_0.sg13g2_nor2_1$1_14.A sar_ctrl_async_phys_0.sg13g2_nand3_1$1_0.Y 0.49191f
C5107 sar_ctrl_async_phys_0.dac_code_n[5] oa_sar8_acore18_opt_0.sw_bitcell_opt_term_0.bot 0.09629f
C5108 oa_sar8_acore18_opt_0.sw_tg_opt_1.bot oa_sar8_acore18_opt_0.sw_bitcell_opt_b3_1.bot 3.20561f
C5109 a_33944_46594# VDD 0.15676f
C5110 oa_sar8_acore18_opt_0.sw_bitcell_opt_term_0.bot oa_sar8_acore18_opt_0.sw_bitcell_opt_term_0.gb 0.60025f
C5111 sar_ctrl_async_phys_0.sg13g2_buf_1$1_3.A sar_ctrl_async_phys_0.sg13g2_a22oi_1$1_0.A2 0.02144f
C5112 sar_ctrl_async_phys_0.sg13g2_buf_1$1_20.A a_33844_43488# 0.02726f
C5113 oa_sar8_acore18_opt_0.sw_bitcell_opt_term_0.trkb VDD 44.7664f
C5114 sar_ctrl_async_phys_0.sg13g2_buf_1$1_13.A sar_ctrl_async_phys_0.sg13g2_buf_1$1_21.A 0.26238f
C5115 sar_ctrl_async_phys_0.sg13g2_dfrbpq_1$1_0.CLK sar_ctrl_async_phys_0.sg13g2_buf_1$1_15.A 1.028f
C5116 sar_ctrl_async_phys_0.sg13g2_a21oi_1$1_6.B1 a_35672_46508# 0.0464f
C5117 sar_ctrl_async_phys_0.sg13g2_a21oi_1$1_4.B1 sar_ctrl_async_phys_0.sg13g2_nand2_1$1_3.A 0.03352f
C5118 a_29498_40428# a_29941_40471# 0.02242f
C5119 sar_ctrl_async_phys_0.cmp_n VDD 6.82098f
C5120 a_36056_35200# VDD 0.21856f
C5121 sar_ctrl_async_phys_0.hold_req oa_sar8_acore18_opt_0.sw_bitcell_opt_b7_0.bot 0.09707f
C5122 sar_ctrl_async_phys_0.sg13g2_a22oi_1$1_0.A2 sar_ctrl_async_phys_0.sg13g2_a22oi_1$1_0.A1 0.49649f
C5123 sar_ctrl_async_phys_0.sg13g2_dlygate4sd3_1$1_6.A sar_ctrl_async_phys_0.sg13g2_dlygate4sd3_1$1_9.X 0.2861f
C5124 a_31093_39677# a_31195_39820# 0.47622f
C5125 a_30650_39921# a_30676_40016# 0.36952f
C5126 sar_ctrl_async_phys_0.sg13g2_nor2_1$1_18.A a_30390_39698# 0.28379f
C5127 a_35672_35200# sar_ctrl_async_phys_0.bit_active[0] 0.01136f
C5128 a_34132_32904# a_34549_32911# 0.37583f
C5129 sar_ctrl_async_phys_0.sg13g2_and2_1$1_6.X a_31040_40702# 0.049f
C5130 sar_ctrl_async_phys_0.dac_code_n[5] m3_38288_n2380# 0.04765f
C5131 sar_ctrl_async_phys_0.sg13g2_nor2_1$1_10.B a_30229_33629# 0.0236f
C5132 sar_ctrl_async_phys_0.sg13g2_buf_1$1_15.A sar_ctrl_async_phys_0.sg13g2_a21oi_1$1_0.A2 0.16792f
C5133 oa_sar8_acore18_opt_0.sw_bitcell_opt_term_0.trkb oa_sar8_acore18_opt_0.sw_bitcell_opt_b6_0.bot 1.46562f
C5134 w_39600_n9960# oa_sar8_acore18_opt_0.sw_bitcell_opt_term_0.trkb 2.16982f
C5135 oa_sar8_acore18_opt_0.sw_bitcell_opt_term_0.gb m3_38288_n2380# 1.70313f
C5136 sar_ctrl_async_phys_0.sg13g2_a21oi_1$1_2.B1 sar_ctrl_async_phys_0.sg13g2_a21oi_1$1_5.Y 0.03915f
C5137 oa_sar8_acore18_opt_0.sw_bitcell_opt_b4_0.bot VDD 3.42666f
C5138 sar_ctrl_async_phys_0.cmp_p oa_sar8_acore18_opt_0.sw_tg_opt_0.bot 0.01619f
C5139 sar_ctrl_async_phys_0.dac_code[5] m3_41836_n2380# 0.04394f
C5140 sar_ctrl_async_phys_0.sg13g2_nand2_1$1_3.B a_33844_43488# 0.02151f
C5141 sar_ctrl_async_phys_0.dac_code_n[5] oa_sar8_acore18_opt_0.bstrap_opt_w2_c1200_1.gb 0.1313f
C5142 VDD result[7] 0.16512f
C5143 sar_ctrl_async_phys_0.sg13g2_dfrbpq_1$1_0.CLK a_31060_44552# 0.10293f
C5144 sar_ctrl_async_phys_0.dac_code[2] oa_sar8_acore18_opt_0.sw_bitcell_opt_b3_0.bot 0.57135f
C5145 sar_ctrl_async_phys_0.sg13g2_buf_1$1_41.X a_32319_44311# 0.13405f
C5146 sar_ctrl_async_phys_0.sg13g2_nand2_1$1_1.Y VDD 0.52314f
C5147 sar_ctrl_async_phys_0.sg13g2_nor2b_1$1_4.Y a_31060_44552# 0.04267f
C5148 sar_ctrl_async_phys_0.sg13g2_nor2_1$1_0.Y sar_ctrl_async_phys_0.sg13g2_and2_1$1_6.X 1.82213f
C5149 sar_ctrl_async_phys_0.sg13g2_o21ai_1$1_1.B1 a_32792_41342# 0.01103f
C5150 sar_ctrl_async_phys_0.sg13g2_nand2_1$1_3.A a_33951_45823# 0.01145f
C5151 sar_ctrl_async_phys_0.sg13g2_inv_1$1_5.A a_30384_31474# 0.01802f
C5152 a_28006_35948# VDD 0.23794f
C5153 sar_ctrl_async_phys_0.sg13g2_nand2b_1$1_0.A_N sar_ctrl_async_phys_0.sg13g2_nor2_1$1_13.B 0.85121f
C5154 sar_ctrl_async_phys_0.dac_code_n[5] oa_sar8_acore18_opt_0.sw_bitcell_opt_b1_1.bot 0.06598f
C5155 sar_ctrl_async_phys_0.sg13g2_o21ai_1$1_1.B1 sar_ctrl_async_phys_0.sg13g2_a21oi_1$1_0.A1 0.13979f
C5156 sar_ctrl_async_phys_0.sg13g2_and2_1$1_3.X sar_ctrl_async_phys_0.sg13g2_nand3_1$1_0.Y 0.66853f
C5157 sar_ctrl_async_phys_0.sg13g2_buf_1$1_14.A sar_ctrl_async_phys_0.bit_active[2] 0.03616f
C5158 sar_ctrl_async_phys_0.sg13g2_and2_1$1_0.A sar_ctrl_async_phys_0.sg13g2_a21oi_1$1_0.A1 0.62757f
C5159 oa_sar8_acore18_opt_0.sw_bitcell_opt_b6_0.bot oa_sar8_acore18_opt_0.sw_bitcell_opt_b4_0.bot 0.87004f
C5160 w_39600_n9960# oa_sar8_acore18_opt_0.sw_bitcell_opt_b4_0.bot 0.01745f
C5161 sar_ctrl_async_phys_0.sg13g2_a22oi_1$1_1.A2 a_33846_34850# 0.05342f
C5162 sar_ctrl_async_phys_0.sg13g2_buf_1$1_36.A sar_ctrl_async_phys_0.dac_code_n[6] 0.02886f
C5163 sar_ctrl_async_phys_0.sg13g2_a21oi_1$1_0.A1 a_30401_39309# 0.01341f
C5164 sar_ctrl_async_phys_0.sg13g2_a21oi_1$1_2.Y a_30390_36362# 0.03713f
C5165 sar_ctrl_async_phys_0.sg13g2_nor2_1$1_6.Y sar_ctrl_async_phys_0.sg13g2_nor2_1$1_6.B 1.13105f
C5166 a_34615_31475# VDD 0.2064f
C5167 sar_ctrl_async_phys_0.sg13g2_a22oi_1$1_1.A2 sar_ctrl_async_phys_0.bit_active[2] 0.07834f
C5168 sar_ctrl_async_phys_0.sg13g2_a22oi_1$1_0.A1 a_33359_33292# 0.01741f
C5169 sar_ctrl_async_phys_0.sg13g2_a21oi_1$1_6.B1 a_32251_45007# 0.01468f
C5170 a_31034_44457# a_30774_44234# 0.75507f
C5171 sar_ctrl_async_phys_0.sg13g2_buf_1$1_6.X a_29749_32117# 0.05394f
C5172 sar_ctrl_async_phys_0.sg13g2_o21ai_1$1_1.B1 a_34075_39820# 0.42048f
C5173 sar_ctrl_async_phys_0.sg13g2_nand2b_1$1_3.Y a_33844_43488# 0.03422f
C5174 a_31542_37874# a_31828_37440# 0.41329f
C5175 sar_ctrl_async_phys_0.sg13g2_nor2_1$1_4.Y a_26630_37814# 0.01472f
C5176 sar_ctrl_async_phys_0.sg13g2_dfrbpq_1$1_0.CLK sar_ctrl_async_phys_0.sg13g2_o21ai_1$1_1.B1 0.52884f
C5177 sar_ctrl_async_phys_0.sg13g2_dfrbpq_1$1_0.CLK a_34520_42760# 0.01256f
C5178 sar_ctrl_async_phys_0.sg13g2_nor2_1$1_3.B a_27304_38928# 0.01074f
C5179 a_33440_32358# a_33850_32436# 0.10373f
C5180 sar_ctrl_async_phys_0.sg13g2_nor4_1$1_0.C a_29524_40464# 0.02976f
C5181 sar_ctrl_async_phys_0.sg13g2_dfrbpq_1$1_0.CLK sar_ctrl_async_phys_0.sg13g2_and2_1$1_0.A 0.93508f
C5182 sar_ctrl_async_phys_0.sg13g2_buf_1$1_6.X a_34549_30605# 0.0419f
C5183 sar_ctrl_async_phys_0.sg13g2_nor2_1$1_13.B a_28651_39740# 0.05509f
C5184 sar_ctrl_async_phys_0.sg13g2_a22oi_1$1_0.B1 a_34895_32460# 0.04582f
C5185 a_34236_46472# a_33944_46594# 0.01f
C5186 a_30676_35928# a_31093_35935# 0.37583f
C5187 a_30390_36362# a_31195_35935# 0.097f
C5188 sar_ctrl_async_phys_0.sg13g2_a22oi_1$1_0.B1 sar_ctrl_async_phys_0.sg13g2_a22oi_1$1_0.B2 0.16781f
C5189 sar_ctrl_async_phys_0.sg13g2_dfrbpq_1$1_0.CLK a_30401_39309# 0.01199f
C5190 oa_sar8_acore18_opt_0.sw_tg_opt_1.bot oa_sar8_acore18_opt_0.sw_bitcell_opt_b7_1.bot 59.3946f
C5191 sar_ctrl_async_phys_0.sg13g2_buf_1$1_3.A sar_ctrl_async_phys_0.sg13g2_a22oi_1$1_0.A1 0.01361f
C5192 sar_ctrl_async_phys_0.sg13g2_nor2b_1$1_4.Y sar_ctrl_async_phys_0.sg13g2_and2_1$1_0.A 0.03754f
C5193 sar_ctrl_async_phys_0.sg13g2_dfrbpq_1$1_11.D a_32090_40428# 0.0274f
C5194 sar_ctrl_async_phys_0.sg13g2_buf_1$1_13.A sar_ctrl_async_phys_0.sg13g2_nor2b_1$1_0.Y 0.70892f
C5195 sar_ctrl_async_phys_0.sg13g2_buf_1$1_42.A a_33675_43020# 0.0171f
C5196 sar_ctrl_async_phys_0.sg13g2_a21oi_1$1_0.A1 sar_ctrl_async_phys_0.sg13g2_nor2b_1$1_1.Y 0.03507f
C5197 sar_ctrl_async_phys_0.sg13g2_and2_1$1_0.A sar_ctrl_async_phys_0.sg13g2_buf_1$1_26.X 0.37987f
C5198 sar_ctrl_async_phys_0.sg13g2_and2_1$1_0.A a_31446_35162# 0.01149f
C5199 sar_ctrl_async_phys_0.sg13g2_buf_1$1_3.A a_35280_35365# 0.14254f
C5200 sar_ctrl_async_phys_0.sg13g2_nor4_1$1_0.Y sar_ctrl_async_phys_0.sg13g2_dlygate4sd3_1$1_6.A 0.02471f
C5201 sar_ctrl_async_phys_0.sg13g2_buf_1$1_41.X a_33844_43488# 0.42137f
C5202 a_34904_38224# VDD 0.22257f
C5203 sar_ctrl_async_phys_0.sg13g2_buf_1$1_7.A sar_ctrl_async_phys_0.sg13g2_inv_1$1_3.Y 0.16887f
C5204 sar_ctrl_async_phys_0.cmp_n a_26184_21025# 1.17508f
C5205 m3_57896_n2380# VDD 0.01918f
C5206 sar_ctrl_async_phys_0.sg13g2_nor4_1$1_0.C sar_ctrl_async_phys_0.sg13g2_buf_1$1_3.A 2.09042f
C5207 sar_ctrl_async_phys_0.sg13g2_nand2b_1$1_1.B sar_ctrl_async_phys_0.sg13g2_a21oi_1$1_2.B1 0.21853f
C5208 sar_ctrl_async_phys_0.sg13g2_o21ai_1$1_1.B1 a_32116_40464# 0.3907f
C5209 sar_ctrl_async_phys_0.sg13g2_buf_1$1_3.A sar_ctrl_async_phys_0.sg13g2_a21oi_1$1_3.A2 0.8151f
C5210 sar_ctrl_async_phys_0.sg13g2_buf_1$1_2.A sar_ctrl_async_phys_0.sg13g2_buf_1$1_17.A 0.07686f
C5211 sar_ctrl_async_phys_0.sg13g2_buf_1$1_2.A sar_ctrl_async_phys_0.sg13g2_buf_1$1_0.A 0.05993f
C5212 a_34459_44356# VDD 0.20905f
C5213 oa_sar8_acore18_opt_0.sw_bitcell_opt_term_0.trkb oa_sar8_acore18_opt_0.sw_bitcell_opt_b2_0.bot 1.3964f
C5214 oa_sar8_acore18_opt_0.sw_bitcell_opt_b0_0.bot VDD 2.43191f
C5215 sar_ctrl_async_phys_0.sg13g2_a22oi_1$1_3.B1 sar_ctrl_async_phys_0.sg13g2_a22oi_1$1_2.Y 0.01078f
C5216 a_34904_33688# VDD 0.22366f
C5217 sar_ctrl_async_phys_0.dac_code[7] oa_sar8_acore18_opt_0.sw_bitcell_opt_b5_0.bot 0.77683f
C5218 sar_ctrl_async_phys_0.sg13g2_buf_1$1_46.A a_35786_45750# 0.01506f
C5219 sar_ctrl_async_phys_0.sg13g2_buf_1$1_36.A sar_ctrl_async_phys_0.dac_code_n[7] 0.02631f
C5220 sar_ctrl_async_phys_0.sg13g2_a21oi_1$1_0.B1 sar_ctrl_async_phys_0.sg13g2_a22oi_1$1_0.A2 0.19327f
C5221 sar_ctrl_async_phys_0.sg13g2_buf_1$1_3.A sar_ctrl_async_phys_0.dac_code[7] 0.08063f
C5222 a_34596_40424# VDD 0.19715f
C5223 sar_ctrl_async_phys_0.sg13g2_nor2_1$1_10.B a_29941_40471# 0.01647f
C5224 sar_ctrl_async_phys_0.dac_code[2] oa_sar8_acore18_opt_0.sw_bitcell_opt_term_0.bot 0.16617f
C5225 a_33375_40821# VDD 0.18027f
C5226 a_35199_44311# a_35105_44311# 0.28931f
C5227 sar_ctrl_async_phys_0.sg13g2_a21oi_1$1_2.Y a_31007_35460# 0.01192f
C5228 sar_ctrl_async_phys_0.dac_code[6] sar_ctrl_async_phys_0.dac_code[5] 5.55042f
C5229 sar_ctrl_async_phys_0.sg13g2_a21oi_1$1_2.Y sar_ctrl_async_phys_0.sg13g2_buf_1$1_1.A 0.40228f
C5230 a_35672_38948# sar_ctrl_async_phys_0.dac_code[6] 0.24844f
C5231 sar_ctrl_async_phys_0.sg13g2_dlygate4sd3_1$1_8.X a_26662_41278# 0.03712f
C5232 sar_ctrl_async_phys_0.dac_code_n[5] oa_sar8_acore18_opt_0.sw_bitcell_opt_b5_1.bot 1.32572f
C5233 sar_ctrl_async_phys_0.sg13g2_a21oi_1$1_0.A1 a_32715_43020# 0.03396f
C5234 oa_sar8_acore18_opt_0.sw_tg_opt_1.bot oa_sar8_acore18_opt_0.bstrap_opt_w2_c1200_1.out 0.19002f
C5235 a_34132_32904# result[5] 0.04063f
C5236 oa_sar8_acore18_opt_0.sw_bitcell_opt_b5_0.bot oa_sar8_acore18_opt_0.sw_bitcell_opt_b1_0.bot 0.42516f
C5237 oa_sar8_acore18_opt_0.sw_bitcell_opt_b6_0.bot oa_sar8_acore18_opt_0.sw_bitcell_opt_b0_0.bot 0.56024f
C5238 sar_ctrl_async_phys_0.sg13g2_dfrbpq_1$1_0.CLK a_34132_34416# 0.10626f
C5239 oa_sar8_acore18_opt_0.sw_bitcell_opt_b4_0.bot oa_sar8_acore18_opt_0.sw_bitcell_opt_b2_0.bot 1.46065f
C5240 sar_ctrl_async_phys_0.dac_code_n[6] sar_ctrl_async_phys_0.sg13g2_buf_1$1_46.A 0.05248f
C5241 sar_ctrl_async_phys_0.sg13g2_dfrbpq_1$1_0.CLK a_29238_41972# 0.02491f
C5242 sar_ctrl_async_phys_0.sg13g2_dlygate4sd3_1$1_11.X track 0.02737f
C5243 sar_ctrl_async_phys_0.sg13g2_a21oi_1$1_5.A2 sar_ctrl_async_phys_0.sg13g2_a21oi_1$1_5.Y 0.05536f
C5244 sar_ctrl_async_phys_0.sg13g2_a21oi_1$1_0.A1 a_29236_38952# 0.04506f
C5245 sar_ctrl_async_phys_0.sg13g2_buf_1$1_2.A sar_ctrl_async_phys_0.sg13g2_and2_1$1_6.X 0.02271f
C5246 sar_ctrl_async_phys_0.sg13g2_a22oi_1$1_2.A2 sar_ctrl_async_phys_0.sg13g2_nor2b_1$1_0.Y 0.58551f
C5247 a_34055_31352# VDD 0.19851f
C5248 sar_ctrl_async_phys_0.sg13g2_dfrbpq_1$1_0.CLK sar_ctrl_async_phys_0.dac_code[1] 0.24921f
C5249 sar_ctrl_async_phys_0.sg13g2_dfrbpq_1$1_0.CLK sar_ctrl_async_phys_0.sg13g2_buf_1$1_8.A 0.02208f
C5250 sar_ctrl_async_phys_0.sg13g2_nor2b_1$1_1.Y a_32888_36806# 0.0107f
C5251 sar_ctrl_async_phys_0.sg13g2_buf_1$1_4.A a_36058_34412# 0.04867f
C5252 sar_ctrl_async_phys_0.sg13g2_a21oi_1$1_1.B1 sar_ctrl_async_phys_0.sg13g2_nand2b_1$1_5.A_N 0.02957f
C5253 sar_ctrl_async_phys_0.sg13g2_buf_1$1_13.A VDD 1.9126f
C5254 sar_ctrl_async_phys_0.sg13g2_nor2b_1$1_0.Y a_32538_36972# 0.01292f
C5255 sar_ctrl_async_phys_0.sg13g2_a21oi_1$1_1.B1 sar_ctrl_async_phys_0.dac_code_n[1] 0.06401f
C5256 a_30480_42854# VDD 0.07103f
C5257 sar_ctrl_async_phys_0.sg13g2_nor2_1$1_13.B a_28410_39996# 0.01682f
C5258 a_32443_32260# a_32212_32151# 0.12701f
C5259 a_31924_32456# a_33089_32215# 0.43239f
C5260 a_31140_42690# VDD 0.19172f
C5261 sar_ctrl_async_phys_0.dac_code[3] sar_ctrl_async_phys_0.dac_code[5] 0.84792f
C5262 VDD result[6] 0.1714f
C5263 sar_ctrl_async_phys_0.sg13g2_nand2_1$1_1.B sar_ctrl_async_phys_0.sg13g2_dlygate4sd3_1$1_0.X 0.14779f
C5264 sar_ctrl_async_phys_0.sg13g2_inv_1$1_6.Y a_29526_33650# 0.28964f
C5265 a_29786_33873# a_29812_33968# 0.36952f
C5266 sar_ctrl_async_phys_0.sg13g2_nand2_1$1_5.Y a_36056_38948# 0.26458f
C5267 oa_sar8_acore18_opt_0.sw_bitcell_opt_b0_1.bot VDD 2.34084f
C5268 sar_ctrl_async_phys_0.sg13g2_a22oi_1$1_0.B1 a_32341_32117# 0.03238f
C5269 sar_ctrl_async_phys_0.sg13g2_dfrbpq_1$1_0.CLK a_29236_38952# 0.1124f
C5270 a_35295_36285# sar_ctrl_async_phys_0.bit_active[2] 0.01534f
C5271 sar_ctrl_async_phys_0.dac_code_n[2] sar_ctrl_async_phys_0.dac_code_n[6] 0.19645f
C5272 a_28870_35948# a_28758_35924# 0.55452f
C5273 sar_ctrl_async_phys_0.sg13g2_a22oi_1$1_4.A2 a_32993_37797# 0.01763f
C5274 sar_ctrl_async_phys_0.sg13g2_nor2_1$1_2.Y VDD 0.93922f
C5275 a_33973_39677# VDD 0.27787f
C5276 oa_sar8_acore18_opt_0.sw_bitcell_opt_b7_0.bot oa_sar8_acore18_opt_0.sw_bitcell_opt_term_0.VSS 2.55598f
C5277 sar_ctrl_async_phys_0.sg13g2_a22oi_1$1_2.A2 a_31706_44964# 0.016f
C5278 oa_sar8_acore18_opt_0.sw_bitcell_opt_term_0.trkb m3_45264_n2380# 0.03859f
C5279 sar_ctrl_async_phys_0.sg13g2_a21oi_1$1_0.B1 sar_ctrl_async_phys_0.sg13g2_buf_1$1_3.A 0.02927f
C5280 sar_ctrl_async_phys_0.sg13g2_a22oi_1$1_3.B1 a_33359_32876# 0.04582f
C5281 sar_ctrl_async_phys_0.sg13g2_buf_1$1_42.A sar_ctrl_async_phys_0.sg13g2_a21oi_1$1_3.B1 0.04417f
C5282 a_35948_n9612# VDD 1.37558f
C5283 sar_ctrl_async_phys_0.sg13g2_nand2_1$1_5.Y sar_ctrl_async_phys_0.sg13g2_a21oi_1$1_2.B1 0.62597f
C5284 sar_ctrl_async_phys_0.sg13g2_buf_1$1_2.A sar_ctrl_async_phys_0.sg13g2_buf_1$1_6.X 0.06101f
C5285 sar_ctrl_async_phys_0.sg13g2_buf_1$1_3.A a_35201_36285# 0.0183f
C5286 sar_ctrl_async_phys_0.sg13g2_a22oi_1$1_3.A2 sar_ctrl_async_phys_0.sg13g2_nand2_1$1_2.B 1.25601f
C5287 sar_ctrl_async_phys_0.sg13g2_nor2b_1$1_3.Y a_34596_40424# 0.24824f
C5288 sar_ctrl_async_phys_0.sg13g2_nor2b_1$1_1.B_N sar_ctrl_async_phys_0.bit_active[2] 0.21663f
C5289 sar_ctrl_async_phys_0.sg13g2_buf_1$1_35.A a_36056_41972# 0.04344f
C5290 a_26544_38389# VDD 0.4124f
C5291 sar_ctrl_async_phys_0.sg13g2_nor2b_1$1_3.Y a_33375_40821# 0.01125f
C5292 oa_sar8_acore18_opt_0.sw_bitcell_opt_term_0.trkb oa_sar8_acore18_opt_0.sw_bitcell_opt_b7_1.VSS 0.68655f
C5293 sar_ctrl_async_phys_0.sg13g2_buf_1$1_8.A a_33359_32876# 0.08223f
C5294 sar_ctrl_async_phys_0.dac_code[7] oa_sar8_acore18_opt_0.sw_bitcell_opt_b1_0.bot 0.13826f
C5295 sar_ctrl_async_phys_0.sg13g2_a21oi_1$1_0.B1 sar_ctrl_async_phys_0.sg13g2_a22oi_1$1_0.A1 0.21461f
C5296 sar_ctrl_async_phys_0.sg13g2_nand2b_1$1_1.B sar_ctrl_async_phys_0.dac_code[2] 0.05982f
C5297 sar_ctrl_async_phys_0.sg13g2_a21oi_1$1_5.A2 a_32533_40471# 0.01192f
C5298 a_34308_37400# VDD 0.20335f
C5299 sar_ctrl_async_phys_0.sg13g2_o21ai_1$1_1.B1 sar_ctrl_async_phys_0.sg13g2_nor2_1$1_5.A 0.13992f
C5300 sar_ctrl_async_phys_0.sg13g2_o21ai_1$1_1.B1 a_32980_45759# 0.01223f
C5301 sar_ctrl_async_phys_0.sg13g2_a21oi_1$1_3.A2 a_35482_39996# 0.11619f
C5302 a_32991_35239# a_33658_35460# 0.0894f
C5303 a_29701_36874# a_29760_36682# 0.01242f
C5304 a_31732_35480# a_32020_35175# 0.43707f
C5305 sar_ctrl_async_phys_0.sg13g2_and2_1$1_0.A sar_ctrl_async_phys_0.sg13g2_nor2_1$1_5.A 0.19189f
C5306 sar_ctrl_async_phys_0.dac_code_n[0] sar_ctrl_async_phys_0.dac_code_n[2] 0.349f
C5307 sar_ctrl_async_phys_0.sg13g2_buf_1$1_5.A done 0.04028f
C5308 a_34636_31749# a_34767_31359# 0.3749f
C5309 sar_ctrl_async_phys_0.sg13g2_a21oi_1$1_0.A1 a_29238_40898# 0.01197f
C5310 sar_ctrl_async_phys_0.sg13g2_nor2_1$1_6.Y sar_ctrl_async_phys_0.sg13g2_nand2_1$1_1.B 0.12293f
C5311 a_36152_45082# VDD 0.12034f
C5312 oa_sar8_acore18_opt_0.sw_bitcell_opt_b4_0.bot m3_45264_n2380# 1.70379f
C5313 sar_ctrl_async_phys_0.sg13g2_buf_1$1_3.A a_35360_36894# 0.0217f
C5314 a_32666_45969# a_33109_45725# 0.02242f
C5315 sar_ctrl_async_phys_0.sg13g2_o21ai_1$1_1.B1 a_32692_46064# 0.41214f
C5316 a_35168_41430# a_35578_41508# 0.10373f
C5317 a_32090_40428# VDD 0.09655f
C5318 w_39600_n9960# a_35948_n9612# 5.05953f
C5319 a_34459_44356# a_35456_44454# 0.02979f
C5320 a_33654_44234# a_34228_44247# 0.31978f
C5321 sar_ctrl_async_phys_0.sg13g2_buf_1$1_2.A sar_ctrl_async_phys_0.sg13g2_a22oi_1$1_1.B2 0.03587f
C5322 sar_ctrl_async_phys_0.dac_code_n[5] oa_sar8_acore18_opt_0.sw_bitcell_opt_term_0.vin 0.11076f
C5323 sar_ctrl_async_phys_0.sg13g2_nor2b_1$1_0.Y a_32116_37861# 0.02772f
C5324 sar_ctrl_async_phys_0.sg13g2_nand3_1$1_0.Y a_27249_39888# 0.02103f
C5325 oa_sar8_acore18_opt_0.sw_bitcell_opt_term_0.vin oa_sar8_acore18_opt_0.sw_bitcell_opt_term_0.gb 9.48667f
C5326 sar_ctrl_async_phys_0.sg13g2_nor4_1$1_0.C sar_ctrl_async_phys_0.sg13g2_a21oi_1$1_0.B1 1.55935f
C5327 a_33552_44366# sar_ctrl_async_phys_0.sg13g2_nor2_1$1_1.Y 0.02856f
C5328 a_28856_32270# VDD 0.15711f
C5329 sar_ctrl_async_phys_0.sg13g2_nor2_1$1_14.A a_27206_39326# 0.09468f
C5330 oa_sar8_acore18_opt_0.sw_bitcell_opt_b2_0.bot oa_sar8_acore18_opt_0.sw_bitcell_opt_b0_0.bot 0.3275f
C5331 oa_sar8_acore18_opt_0.sw_bitcell_opt_b3_0.bot oa_sar8_acore18_opt_0.sw_bitcell_opt_term_0.bot 0.47416f
C5332 sar_ctrl_async_phys_0.sg13g2_a22oi_1$1_2.A2 VDD 1.3831f
C5333 sar_ctrl_async_phys_0.sg13g2_nand2_1$1_5.B a_33368_44366# 0.0243f
C5334 sar_ctrl_async_phys_0.sg13g2_buf_1$1_13.A sar_ctrl_async_phys_0.sg13g2_nor2b_1$1_3.Y 0.15645f
C5335 a_33844_36992# VDD 0.09994f
C5336 sar_ctrl_async_phys_0.sg13g2_nor2_1$1_10.B sar_ctrl_async_phys_0.sg13g2_inv_1$1_6.A 0.01724f
C5337 sar_ctrl_async_phys_0.dac_code[7] m3_51760_n2380# 0.05799f
C5338 sar_ctrl_async_phys_0.sg13g2_o21ai_1$1_1.B1 sar_ctrl_async_phys_0.sg13g2_nand2b_1$1_0.A_N 0.07149f
C5339 sar_ctrl_async_phys_0.sg13g2_nand2b_1$1_6.A_N VDD 0.4664f
C5340 a_34618_46044# VDD 0.38278f
C5341 sar_ctrl_async_phys_0.sg13g2_inv_1$1_2.Y result[0] 0.01461f
C5342 sar_ctrl_async_phys_0.sg13g2_a21oi_1$1_2.B1 sar_ctrl_async_phys_0.sg13g2_a21oi_1$1_2.Y 0.28229f
C5343 sar_ctrl_async_phys_0.dac_code_n[2] sar_ctrl_async_phys_0.dac_code_n[7] 0.12929f
C5344 sar_ctrl_async_phys_0.sg13g2_nor2b_1$1_2.Y a_33818_36897# 0.01787f
C5345 sar_ctrl_async_phys_0.sg13g2_buf_1$1_13.A sar_ctrl_async_phys_0.sg13g2_buf_1$1_14.A 0.04057f
C5346 sar_ctrl_async_phys_0.sg13g2_nor2b_1$1_1.Y a_32580_36642# 0.02008f
C5347 sar_ctrl_async_phys_0.sg13g2_a22oi_1$1_0.A1 a_31247_33292# 0.01831f
C5348 sar_ctrl_async_phys_0.sg13g2_nor2_1$1_0.Y a_31935_39775# 0.01677f
C5349 a_35770_43484# a_36152_43570# 0.01012f
C5350 sar_ctrl_async_phys_0.sg13g2_nor2_1$1_2.Y sar_ctrl_async_phys_0.sg13g2_nor2b_1$1_3.Y 0.4418f
C5351 sar_ctrl_async_phys_0.cmp_fire track 0.06444f
C5352 sar_ctrl_async_phys_0.sg13g2_o21ai_1$1_1.B1 sar_ctrl_async_phys_0.sg13g2_nor2_1$1_18.A 0.13158f
C5353 oa_sar8_acore18_opt_0.sw_bitcell_opt_term_0.trkb oa_sar8_acore18_opt_0.sw_bitcell_opt_b2_1.bot 1.41202f
C5354 sar_ctrl_async_phys_0.sg13g2_a21oi_1$1_1.B1 sar_ctrl_async_phys_0.sg13g2_buf_1$1_15.A 0.03022f
C5355 oa_sar8_acore18_opt_0.sw_bitcell_opt_b4_1.bot VDD 3.45183f
C5356 sar_ctrl_async_phys_0.sg13g2_nor2_1$1_4.Y sar_ctrl_async_phys_0.sg13g2_dlygate4sd3_1$1_9.X 0.23026f
C5357 a_31898_32361# a_32341_32117# 0.02242f
C5358 sar_ctrl_async_phys_0.sg13g2_and2_1$1_0.A sar_ctrl_async_phys_0.sg13g2_nor2_1$1_18.A 0.37974f
C5359 a_31638_32138# a_31924_32456# 0.41329f
C5360 sar_ctrl_async_phys_0.sg13g2_dfrbpq_1$1_0.CLK result[3] 0.03516f
C5361 a_26662_41278# VDD 0.19027f
C5362 sar_ctrl_async_phys_0.sg13g2_dlygate4sd3_1$1_7.A a_25496_39830# 0.01103f
C5363 sar_ctrl_async_phys_0.dac_code_n[6] sar_ctrl_async_phys_0.sample 0.04464f
C5364 a_34036_35928# sar_ctrl_async_phys_0.bit_active[2] 0.02079f
C5365 sar_ctrl_async_phys_0.sg13g2_and2_1$1_0.B sar_ctrl_async_phys_0.sg13g2_and2_1$1_0.X 0.08895f
C5366 sar_ctrl_async_phys_0.bit_active[0] busy 0.12548f
C5367 sar_ctrl_async_phys_0.sg13g2_nor2_1$1_12.Y sar_ctrl_async_phys_0.sg13g2_dlygate4sd3_1$1_5.X 0.01747f
C5368 sar_ctrl_async_phys_0.sg13g2_buf_1$1_41.X a_33944_46594# 0.03018f
C5369 sar_ctrl_async_phys_0.sg13g2_buf_1$1_0.A sar_ctrl_async_phys_0.sg13g2_a22oi_1$1_2.Y 0.18833f
C5370 sar_ctrl_async_phys_0.sg13g2_nor2_1$1_2.Y a_33882_38484# 0.01644f
C5371 sar_ctrl_async_phys_0.sg13g2_a22oi_1$1_2.B2 a_33080_31388# 0.09928f
C5372 a_28008_23477# oa_sar8_acore18_opt_0.sw_tg_opt_1.bot 0.84801f
C5373 a_35770_36972# a_36152_36806# 0.01012f
C5374 sar_ctrl_async_phys_0.sg13g2_a21oi_1$1_6.B1 sar_ctrl_async_phys_0.sg13g2_a21oi_1$1_3.B1 0.03181f
C5375 sar_ctrl_async_phys_0.sg13g2_nor2b_1$1_0.A a_34904_38224# 0.35057f
C5376 sar_ctrl_async_phys_0.dac_code_n[4] oa_sar8_acore18_opt_0.sw_bitcell_opt_term_0.trkb 2.02553f
C5377 sar_ctrl_async_phys_0.sg13g2_dlygate4sd3_1$1_3.A a_28968_42013# 0.41585f
C5378 sar_ctrl_async_phys_0.sg13g2_and2_1$1_3.X a_27206_39326# 0.09153f
C5379 sar_ctrl_async_phys_0.sg13g2_and2_1$1_3.X a_26270_39215# 0.05694f
C5380 sar_ctrl_async_phys_0.dac_code_n[4] sar_ctrl_async_phys_0.cmp_n 0.0682f
C5381 sar_ctrl_async_phys_0.sg13g2_dfrbpq_1$1_0.CLK a_33658_35460# 0.01255f
C5382 sar_ctrl_async_phys_0.sg13g2_and2_1$1_0.A a_27120_37522# 0.01277f
C5383 sar_ctrl_async_phys_0.sg13g2_buf_1$1_14.A a_34308_37400# 0.29563f
C5384 sar_ctrl_async_phys_0.sg13g2_nand2b_1$1_5.A_N a_34040_45082# 0.03029f
C5385 vinn VSS 4.87544f
C5386 vinp VSS 1.35533f
C5387 vcm VSS 5.66386f
C5388 result[1] VSS 0.54981f
C5389 result[0] VSS 1.42992f
C5390 result[3] VSS 1.02017f
C5391 result[2] VSS 0.46689f
C5392 result[6] VSS 0.66201f
C5393 busy VSS 0.4842f
C5394 done VSS 0.64653f
C5395 result[7] VSS 0.45945f
C5396 result[5] VSS 0.63758f
C5397 result[4] VSS 0.68075f
C5398 VDD VSS 0.38921p
C5399 m3_60844_n2380# VSS 0.11538f ; **FLOATING
C5400 m3_57896_n2380# VSS 0.1082f ; **FLOATING
C5401 m3_54868_n2380# VSS 0.11186f ; **FLOATING
C5402 m3_51760_n2380# VSS 0.11552f ; **FLOATING
C5403 m3_48572_n2380# VSS 0.11918f ; **FLOATING
C5404 m3_45264_n2380# VSS 0.12467f ; **FLOATING
C5405 m3_41836_n2380# VSS 0.13016f ; **FLOATING
C5406 m3_38288_n2380# VSS 0.13565f ; **FLOATING
C5407 m3_34580_n2380# VSS 0.15298f ; **FLOATING
C5408 a_35948_n9612# VSS 24.28825f
C5409 a_35028_n9612# VSS 2.29565f
C5410 a_21332_n9711# VSS 2.2786f
C5411 a_20412_n9612# VSS 22.56145f
C5412 oa_sar8_acore18_opt_0.sw_bitcell_opt_term_0.gb VSS 54.20869f
C5413 oa_sar8_acore18_opt_0.sw_bitcell_opt_term_0.VSS VSS 59.13996f
C5414 oa_sar8_acore18_opt_0.sw_bitcell_opt_b7_1.VSS VSS 72.49602f
C5415 oa_sar8_acore18_opt_0.sw_bitcell_opt_term_0.bot VSS 27.46097f
C5416 oa_sar8_acore18_opt_0.sw_bitcell_opt_b0_0.bot VSS 22.89177f
C5417 oa_sar8_acore18_opt_0.sw_bitcell_opt_b1_0.bot VSS 22.1171f
C5418 oa_sar8_acore18_opt_0.sw_bitcell_opt_b2_0.bot VSS 21.44351f
C5419 oa_sar8_acore18_opt_0.sw_bitcell_opt_b3_0.bot VSS 21.25576f
C5420 oa_sar8_acore18_opt_0.sw_bitcell_opt_b4_0.bot VSS 24.83547f
C5421 oa_sar8_acore18_opt_0.sw_bitcell_opt_b5_0.bot VSS 22.13729f
C5422 oa_sar8_acore18_opt_0.sw_bitcell_opt_b6_0.bot VSS 24.46802f
C5423 oa_sar8_acore18_opt_0.sw_bitcell_opt_term_0.vin VSS 26.76735f
C5424 oa_sar8_acore18_opt_0.sw_bitcell_opt_b7_0.bot VSS 44.07689f
C5425 oa_sar8_acore18_opt_0.sw_bitcell_opt_b7_1.bot VSS 46.04301f
C5426 oa_sar8_acore18_opt_0.sw_bitcell_opt_b6_1.bot VSS 24.58449f
C5427 oa_sar8_acore18_opt_0.sw_bitcell_opt_b5_1.bot VSS 19.91135f
C5428 oa_sar8_acore18_opt_0.sw_bitcell_opt_b4_1.bot VSS 24.27217f
C5429 oa_sar8_acore18_opt_0.sw_bitcell_opt_b3_1.bot VSS 20.46672f
C5430 oa_sar8_acore18_opt_0.sw_bitcell_opt_b2_1.bot VSS 20.58735f
C5431 oa_sar8_acore18_opt_0.sw_bitcell_opt_b1_1.bot VSS 21.1447f
C5432 oa_sar8_acore18_opt_0.sw_bitcell_opt_b0_1.bot VSS 21.7302f
C5433 oa_sar8_acore18_opt_0.sw_bitcell_opt_term_0.trkb VSS 0.10425p
C5434 oa_sar8_acore18_opt_0.bstrap_opt_w2_c1200_1.out VSS 30.25455f
C5435 oa_sar8_acore18_opt_0.sw_bitcell_opt_term_1.bot VSS 26.27735f
C5436 a_30632_22281# VSS 1.43115f
C5437 oa_sar8_acore18_opt_0.sw_tg_opt_0.bot VSS 80.01213f
C5438 a_26184_21025# VSS 8.94944f
C5439 oa_sar8_acore18_opt_0.sw_tg_opt_1.bot VSS 80.94447f
C5440 a_28008_23477# VSS 2.45421f
C5441 a_35297_30703# VSS 0.11473f
C5442 a_34358_30639# VSS 0.02082f
C5443 a_34420_30639# VSS 0.05954f
C5444 a_35593_30941# VSS 0.19802f
C5445 a_33940_30626# VSS 0.25843f
C5446 a_34489_31017# VSS 0.98788f
C5447 a_33846_30626# VSS 0.60009f
C5448 a_34106_30849# VSS 0.08274f
C5449 a_33464_30664# VSS 0.13866f
C5450 a_30872_30758# VSS 0.10678f ; **FLOATING
C5451 a_35659_31435# VSS 0.79546f
C5452 a_36210_31826# VSS 0.3885f
C5453 a_35463_31435# VSS 0.60189f
C5454 a_35814_31813# VSS 14.88084f
C5455 a_35418_31668# VSS 0.33841f
C5456 a_32233_31511# VSS 0.10866f
C5457 a_34526_31826# VSS 0.33522f
C5458 a_32450_31826# VSS 0.23823f
C5459 a_31937_31749# VSS 0.17832f
C5460 a_33464_31388# VSS 0.07462f
C5461 a_31060_31813# VSS 0.79802f
C5462 a_30998_31813# VSS 0.761f
C5463 a_30384_31474# VSS 0.04075f ; **FLOATING
C5464 a_30772_31392# VSS 0.19525f
C5465 a_30580_31826# VSS 0.18354f
C5466 a_30486_31826# VSS 0.8102f
C5467 a_29912_31474# VSS 0.10632f ; **FLOATING
C5468 a_35166_32120# VSS 0.01811f
C5469 a_34319_32120# VSS 0.24022f
C5470 a_34895_32460# VSS 0.35085f
C5471 a_34319_32460# VSS 0.109f
C5472 a_33089_32215# VSS 0.31478f
C5473 a_32150_32151# VSS 0.80447f
C5474 a_32212_32151# VSS 0.93789f
C5475 a_33385_32453# VSS 0.21038f
C5476 sar_ctrl_async_phys_0.sg13g2_a22oi_1$1_0.B2 VSS 0.02761f
C5477 a_33850_32436# VSS 0.04137f
C5478 a_32281_32529# VSS 0.04137f
C5479 a_31638_32138# VSS 0.37232f
C5480 a_30497_32215# VSS 0.17985f
C5481 a_29558_32151# VSS 0.78703f
C5482 a_29620_32151# VSS 0.82476f
C5483 a_30793_32453# VSS 0.0704f
C5484 a_29689_32529# VSS 0.22519f
C5485 a_29332_32456# VSS 0.2606f
C5486 a_29046_32138# VSS 0.96609f
C5487 sar_ctrl_async_phys_0.sg13g2_inv_1$1_5.Y VSS 0.02373f
C5488 a_28856_32270# VSS 0.10337f ; **FLOATING
C5489 a_34489_32947# VSS 0.15481f
C5490 a_33359_32876# VSS 0.26741f
C5491 a_35810_33338# VSS 0.15568f
C5492 a_35297_33261# VSS 0.27311f
C5493 a_34420_33325# VSS 0.81926f
C5494 a_34358_33325# VSS 0.78103f
C5495 a_33168_32986# VSS 0.04159f ; **FLOATING
C5496 a_32687_32876# VSS 0.0654f
C5497 a_31823_32876# VSS 0.26813f
C5498 a_31247_32876# VSS 0.79827f
C5499 a_30671_32876# VSS 0.77798f
C5500 a_34132_32904# VSS 0.0952f
C5501 a_33940_33338# VSS 0.29967f
C5502 a_33846_33338# VSS 0.60832f
C5503 a_33630_33292# VSS 0.25971f
C5504 a_32687_33292# VSS 0.11312f
C5505 a_30480_32986# VSS 0.04082f ; **FLOATING
C5506 sar_ctrl_async_phys_0.sg13g2_a22oi_1$1_4.Y VSS 0.06376f
C5507 a_32094_33292# VSS 0.96984f
C5508 a_31823_33292# VSS 0.1111f
C5509 a_30942_33292# VSS 0.05323f
C5510 a_30671_33292# VSS 0.95116f
C5511 sar_ctrl_async_phys_0.bit_active[1] VSS 0.94182f
C5512 sar_ctrl_async_phys_0.sg13g2_a22oi_1$1_1.Y VSS 0.10646f
C5513 sar_ctrl_async_phys_0.sg13g2_buf_1$1_7.A VSS 0.21341f
C5514 a_30977_33727# VSS 0.17925f
C5515 a_30038_33663# VSS 0.95089f
C5516 a_30100_33663# VSS 0.98928f
C5517 a_31273_33965# VSS 0.07116f
C5518 a_29620_33650# VSS 0.37914f
C5519 a_29526_33650# VSS 0.64068f
C5520 sar_ctrl_async_phys_0.sg13g2_inv_1$1_6.Y VSS 0.14451f
C5521 a_29786_33873# VSS 0.04137f
C5522 a_34489_34459# VSS 0.92216f
C5523 a_35297_34773# VSS 0.2001f
C5524 a_34420_34837# VSS 0.14678f
C5525 a_34358_34837# VSS 1.2973f
C5526 a_34549_34423# VSS 0.16548f
C5527 a_34106_34380# VSS 0.10865f
C5528 a_33940_34850# VSS 0.48694f
C5529 a_33846_34850# VSS 0.69172f
C5530 a_31640_34498# VSS 0.07781f ; **FLOATING
C5531 a_25496_34412# VSS 3.4504f
C5532 sar_ctrl_async_phys_0.bit_active[4] VSS 1.03115f
C5533 a_35417_35208# VSS 0.08007f
C5534 sar_ctrl_async_phys_0.bit_active[3] VSS 0.74065f
C5535 sar_ctrl_async_phys_0.bit_active[2] VSS 1.02059f
C5536 a_33410_35162# VSS 0.14642f
C5537 sar_ctrl_async_phys_0.bit_active[0] VSS 0.49707f
C5538 a_32897_35239# VSS 0.43874f
C5539 a_31958_35175# VSS 0.07325f
C5540 a_32020_35175# VSS 0.32029f
C5541 a_31540_35162# VSS 0.80447f
C5542 a_30944_35166# VSS 0.47332f
C5543 a_32089_35553# VSS 0.75951f
C5544 a_31446_35162# VSS 0.43873f
C5545 a_31706_35385# VSS 0.04137f
C5546 a_31007_35460# VSS 0.45008f
C5547 a_30733_35460# VSS 0.06661f
C5548 a_30384_35294# VSS 0.03856f ; **FLOATING
C5549 a_30200_35294# VSS 0.10028f ; **FLOATING
C5550 a_30830_35166# VSS 0.89396f
C5551 a_36336_36010# VSS 0.08141f ; **FLOATING
C5552 a_34393_35971# VSS 0.88216f
C5553 a_35201_36285# VSS 0.19692f
C5554 a_34324_36349# VSS 0.1444f
C5555 a_33648_36010# VSS 0.05647f ; **FLOATING
C5556 a_32137_36047# VSS 0.16634f
C5557 a_34036_35928# VSS 0.09578f
C5558 a_34010_35892# VSS 0.08274f
C5559 a_33844_36362# VSS 2.43624f
C5560 a_33750_36362# VSS 1.41347f
C5561 a_31033_35971# VSS 0.98325f
C5562 a_32354_36362# VSS 0.52177f
C5563 a_31841_36285# VSS 0.17851f
C5564 a_30964_36349# VSS 0.12415f
C5565 a_30902_36349# VSS 0.88995f
C5566 a_30390_36362# VSS 0.24833f
C5567 a_27504_36010# VSS 0.06074f ; **FLOATING
C5568 a_28488_35965# VSS 0.10183f
C5569 a_36336_36806# VSS 0.07525f ; **FLOATING
C5570 a_36152_36806# VSS 0.08041f ; **FLOATING
C5571 a_35009_36751# VSS 1.07071f
C5572 a_34070_36687# VSS 0.08724f
C5573 a_34132_36687# VSS 0.22532f
C5574 a_33652_36674# VSS 0.29263f
C5575 a_34201_37065# VSS 0.76422f
C5576 a_33558_36674# VSS 0.4744f
C5577 a_32888_36806# VSS 0.08083f ; **FLOATING
C5578 a_32304_36806# VSS 0.04618f ; **FLOATING
C5579 a_31352_36806# VSS 0.08688f ; **FLOATING
C5580 a_29862_36682# VSS 0.19239f
C5581 a_29760_36682# VSS 0.4739f
C5582 sar_ctrl_async_phys_0.sg13g2_dlygate4sd3_1$1_0.A VSS 0.10174f
C5583 a_28026_36972# VSS 0.27127f
C5584 a_28862_36863# VSS 0.17268f
C5585 a_35211_37436# VSS 0.04534f
C5586 a_33289_37559# VSS 0.1803f
C5587 sar_ctrl_async_phys_0.bit_active[5] VSS 0.46932f
C5588 a_35801_37784# VSS 0.15447f
C5589 a_36056_37436# VSS 0.13071f
C5590 a_35313_37784# VSS 1.72053f
C5591 a_34833_37784# VSS 0.07597f
C5592 a_35664_37695# VSS 0.14741f
C5593 sar_ctrl_async_phys_0.sg13g2_and2_1$1_1.B VSS 0.07515f
C5594 a_32185_37483# VSS 0.0485f
C5595 a_33506_37874# VSS 0.19377f
C5596 a_32993_37797# VSS 0.37859f
C5597 a_32116_37861# VSS 1.01775f
C5598 a_32054_37861# VSS 0.98104f
C5599 a_31440_37522# VSS 0.03501f ; **FLOATING
C5600 a_31256_37522# VSS 0.09404f ; **FLOATING
C5601 a_29660_37436# VSS 0.06594f
C5602 a_29276_37436# VSS 0.02936f
C5603 a_28506_37436# VSS 0.23282f
C5604 a_31542_37874# VSS 0.37999f
C5605 sar_ctrl_async_phys_0.sg13g2_inv_1$1_7.A VSS 0.32808f
C5606 a_28272_37522# VSS 0.06002f ; **FLOATING
C5607 a_27354_37436# VSS 1.04628f
C5608 sar_ctrl_async_phys_0.sg13g2_nor2_1$1_7.A VSS 0.20335f
C5609 a_27120_37522# VSS 0.04261f ; **FLOATING
C5610 a_26630_37814# VSS 0.27454f
C5611 a_26160_37522# VSS 0.05963f ; **FLOATING
C5612 sar_ctrl_async_phys_0.bit_active[7] VSS 0.36703f
C5613 a_34266_38484# VSS 0.66118f
C5614 a_33882_38484# VSS 0.75866f
C5615 a_36056_38224# VSS 0.14703f
C5616 a_35672_38224# VSS 0.03027f
C5617 a_34520_38224# VSS 0.06356f
C5618 sar_ctrl_async_phys_0.sg13g2_nor2b_1$1_2.Y VSS 0.09424f
C5619 a_32120_38318# VSS 0.08748f ; **FLOATING
C5620 a_31355_38232# VSS 0.27636f
C5621 a_31064_38318# VSS 0.08854f ; **FLOATING
C5622 sar_ctrl_async_phys_0.sg13g2_nor2b_1$1_0.Y VSS 0.29337f
C5623 a_31261_38232# VSS 0.15358f
C5624 a_29084_38484# VSS 0.19569f
C5625 a_26681_38232# VSS 1.17176f
C5626 a_26352_38318# VSS 0.03868f ; **FLOATING
C5627 a_26168_38318# VSS 0.09823f ; **FLOATING
C5628 a_26544_38389# VSS 0.06262f
C5629 a_35402_39318# VSS 0.63349f
C5630 sar_ctrl_async_phys_0.bit_active[6] VSS 0.68055f
C5631 a_34800_39034# VSS 0.04744f ; **FLOATING
C5632 a_32156_38948# VSS 0.10254f
C5633 a_30697_39071# VSS 0.1408f
C5634 a_29593_38995# VSS 0.05066f
C5635 a_30914_39386# VSS 0.534f
C5636 a_30401_39309# VSS 0.32265f
C5637 a_29524_39373# VSS 0.87284f
C5638 a_29462_39373# VSS 0.7879f
C5639 a_29236_38952# VSS 0.02069f
C5640 a_29044_39386# VSS 1.39513f
C5641 a_28950_39386# VSS 0.79416f
C5642 a_28560_39034# VSS 0.03749f ; **FLOATING
C5643 a_28376_39034# VSS 0.10133f ; **FLOATING
C5644 a_27304_38928# VSS 0.34479f
C5645 a_27032_39034# VSS 0.08558f ; **FLOATING
C5646 a_25914_38948# VSS 0.21506f
C5647 a_27206_39326# VSS 0.22896f
C5648 a_26385_39214# VSS 0.07039f
C5649 a_25680_39034# VSS 0.0381f ; **FLOATING
C5650 a_25496_39034# VSS 0.11471f ; **FLOATING
C5651 a_26666_38912# VSS 0.08864f
C5652 a_36336_39830# VSS 0.08008f ; **FLOATING
C5653 a_36089_39744# VSS 0.22504f
C5654 sar_ctrl_async_phys_0.sg13g2_buf_1$1_14.A VSS 0.71942f
C5655 a_34721_39775# VSS 0.48326f
C5656 a_33844_39711# VSS 0.13516f
C5657 a_33364_39698# VSS 0.93607f
C5658 a_33913_40089# VSS 0.9021f
C5659 a_33270_39698# VSS 0.44667f
C5660 a_33168_39830# VSS 0.03437f ; **FLOATING
C5661 a_32984_39830# VSS 0.07994f ; **FLOATING
C5662 a_32354_39698# VSS 0.46889f
C5663 a_31841_39775# VSS 0.17922f
C5664 a_30902_39711# VSS 1.82181f
C5665 a_30964_39711# VSS 0.97037f
C5666 a_32137_40013# VSS 0.12163f
C5667 a_30129_39724# VSS 0.01147f
C5668 a_30390_39698# VSS 0.19863f
C5669 a_30027_39996# VSS 0.07081f
C5670 a_29808_39830# VSS 0.04073f ; **FLOATING
C5671 a_29562_39996# VSS 0.03458f
C5672 a_29328_39830# VSS 0.04154f ; **FLOATING
C5673 a_29144_39830# VSS 0.08264f ; **FLOATING
C5674 a_28853_39702# VSS 0.89932f
C5675 a_28176_39830# VSS 0.04246f ; **FLOATING
C5676 sar_ctrl_async_phys_0.sg13g2_nor2_1$1_6.Y VSS 0.10952f
C5677 a_25896_39706# VSS 0.04978f
C5678 a_25794_39706# VSS 0.37599f
C5679 a_27134_39887# VSS 0.11385f
C5680 sar_ctrl_async_phys_0.sg13g2_nand3_1$1_0.Y VSS 0.42178f
C5681 a_25496_39830# VSS 0.11788f ; **FLOATING
C5682 a_36336_40546# VSS 0.07864f ; **FLOATING
C5683 a_35595_40460# VSS 0.59039f
C5684 a_36074_40830# VSS 0.32593f
C5685 a_35697_40808# VSS 0.02179f
C5686 a_34896_40546# VSS 0.04079f ; **FLOATING
C5687 a_33577_40583# VSS 0.17851f
C5688 a_35053_40730# VSS 0.1476f
C5689 a_34596_40424# VSS 0.0383f
C5690 a_33281_40821# VSS 0.30346f
C5691 a_32404_40885# VSS 0.96846f
C5692 a_32342_40885# VSS 0.93175f
C5693 a_30985_40583# VSS 0.08303f
C5694 a_31924_40898# VSS 0.21327f
C5695 a_31830_40898# VSS 1.79596f
C5696 a_31202_40898# VSS 0.14513f
C5697 a_30689_40821# VSS 0.37488f
C5698 a_29812_40885# VSS 0.81334f
C5699 a_29750_40885# VSS 1.66336f
C5700 a_29048_40546# VSS 0.08222f ; **FLOATING
C5701 a_28578_40460# VSS 0.10483f
C5702 a_28236_40440# VSS 0.15745f
C5703 a_27738_40460# VSS 0.48747f
C5704 a_29524_40464# VSS 0.2477f
C5705 a_29332_40898# VSS 0.23219f
C5706 a_29238_40898# VSS 0.84783f
C5707 sar_ctrl_async_phys_0.sg13g2_nor2_1$1_11.Y VSS 0.03168f
C5708 a_28130_40838# VSS 0.74192f
C5709 sar_ctrl_async_phys_0.sg13g2_dlygate4sd3_1$1_6.A VSS 0.09585f
C5710 a_25488_40546# VSS 0.0801f ; **FLOATING
C5711 a_25878_40460# VSS 0.1868f
C5712 sar_ctrl_async_phys_0.sg13g2_nor2_1$1_14.A VSS 0.75418f
C5713 a_26954_40424# VSS 0.31544f
C5714 a_25990_40484# VSS 0.17354f
C5715 a_36336_41342# VSS 0.07926f ; **FLOATING
C5716 a_35330_41210# VSS 0.42182f
C5717 a_34817_41287# VSS 0.4986f
C5718 a_33878_41223# VSS 1.72029f
C5719 a_33940_41223# VSS 0.86845f
C5720 a_35113_41525# VSS 0.17804f
C5721 a_33366_41210# VSS 0.83543f
C5722 a_33114_41508# VSS 0.62186f
C5723 a_32792_41342# VSS 0.08164f ; **FLOATING
C5724 a_32049_41236# VSS 0.14696f
C5725 a_31947_41508# VSS 0.401f
C5726 a_31640_41342# VSS 0.09007f ; **FLOATING
C5727 a_27984_41342# VSS 0.0367f ; **FLOATING
C5728 a_27800_41342# VSS 0.10015f ; **FLOATING
C5729 a_26550_41214# VSS 0.08735f
C5730 sar_ctrl_async_phys_0.sg13g2_nor4_1$1_0.Y VSS 0.86261f
C5731 a_35327_42342# VSS 0.1419f
C5732 a_36056_41972# VSS 0.36938f
C5733 sar_ctrl_async_phys_0.dac_code_n[7] VSS 67.78639f
C5734 a_34224_42058# VSS 0.04147f ; **FLOATING
C5735 a_28760_42058# VSS 0.08984f ; **FLOATING
C5736 a_29238_41972# VSS 0.16507f
C5737 a_28968_42013# VSS 0.25585f
C5738 sar_ctrl_async_phys_0.sg13g2_dlygate4sd3_1$1_8.X VSS 0.14423f
C5739 a_26454_41972# VSS 0.30322f
C5740 a_35402_42726# VSS 0.07687f
C5741 a_35018_42726# VSS 0.07466f
C5742 a_34175_42726# VSS 0.23456f
C5743 a_33777_42748# VSS 0.50936f
C5744 a_33072_42854# VSS 0.04369f ; **FLOATING
C5745 a_32817_42748# VSS 0.01118f
C5746 a_31665_42748# VSS 0.01135f
C5747 a_32715_43020# VSS 0.20769f
C5748 a_36056_42760# VSS 0.03345f
C5749 sar_ctrl_async_phys_0.sg13g2_nand2_1$1_3.Y VSS 0.05088f
C5750 a_31563_43020# VSS 0.68315f
C5751 a_30480_42854# VSS 0.03886f ; **FLOATING
C5752 a_30296_42854# VSS 0.09837f ; **FLOATING
C5753 sar_ctrl_async_phys_0.sg13g2_dlygate4sd3_1$1_5.X VSS 0.04233f
C5754 a_25820_43020# VSS 0.60358f
C5755 a_25496_42854# VSS 0.11857f ; **FLOATING
C5756 a_36336_43570# VSS 0.07543f ; **FLOATING
C5757 a_36152_43570# VSS 0.07987f ; **FLOATING
C5758 a_35522_43922# VSS 0.26894f
C5759 a_35009_43845# VSS 0.54602f
C5760 a_35103_43845# VSS 0.08274f
C5761 a_34132_43909# VSS 0.82121f
C5762 a_34070_43909# VSS 0.78423f
C5763 a_33844_43488# VSS 0.1331f
C5764 a_33652_43922# VSS 0.7626f
C5765 a_33179_43832# VSS 0.37383f
C5766 a_32888_43570# VSS 0.07963f ; **FLOATING
C5767 a_32538_43484# VSS 0.54154f
C5768 a_33558_43922# VSS 0.99143f
C5769 sar_ctrl_async_phys_0.sg13g2_nor2_1$1_2.Y VSS 0.65584f
C5770 a_32027_43832# VSS 0.06951f
C5771 a_29977_43531# VSS 0.99178f
C5772 a_30785_43845# VSS 0.24828f
C5773 a_29908_43909# VSS 0.0385f
C5774 a_29232_43570# VSS 0.06361f ; **FLOATING
C5775 a_29620_43488# VSS 0.24757f
C5776 a_29334_43922# VSS 0.79542f
C5777 sar_ctrl_async_phys_0.sample VSS 0.36625f
C5778 a_36248_44366# VSS 0.12103f ; **FLOATING
C5779 a_35105_44311# VSS 0.41625f
C5780 a_34166_44247# VSS 0.88363f
C5781 a_34228_44247# VSS 0.92091f
C5782 a_35401_44549# VSS 0.0822f
C5783 a_33654_44234# VSS 0.82499f
C5784 a_33552_44366# VSS 0.03458f ; **FLOATING
C5785 a_33368_44366# VSS 0.07746f ; **FLOATING
C5786 a_32738_44234# VSS 0.2542f
C5787 a_32225_44311# VSS 0.095f
C5788 a_31286_44247# VSS 0.86942f
C5789 a_31348_44247# VSS 1.00337f
C5790 a_32521_44549# VSS 0.20961f
C5791 a_30868_44234# VSS 0.19352f
C5792 a_31417_44625# VSS 0.08274f
C5793 a_31060_44552# VSS 0.09056f
C5794 a_30774_44234# VSS 0.59497f
C5795 a_30584_44366# VSS 0.09017f ; **FLOATING
C5796 a_31034_44457# VSS 0.08274f
C5797 a_36336_45082# VSS 0.07525f ; **FLOATING
C5798 a_36152_45082# VSS 0.07709f ; **FLOATING
C5799 a_35807_45366# VSS 0.1234f
C5800 a_35327_45366# VSS 0.35206f
C5801 a_34847_45366# VSS 0.10787f
C5802 a_34224_45082# VSS 0.03578f ; **FLOATING
C5803 a_34040_45082# VSS 0.07765f ; **FLOATING
C5804 a_35725_45266# VSS 0.35828f
C5805 a_34765_45266# VSS 0.13622f
C5806 a_32897_45357# VSS 0.17779f
C5807 a_32020_45421# VSS 1.04282f
C5808 a_31958_45421# VSS 0.90981f
C5809 a_31732_45000# VSS 0.08913f
C5810 a_31540_45434# VSS 2.05896f
C5811 a_31446_45434# VSS 0.63561f
C5812 a_30872_45082# VSS 0.10148f ; **FLOATING
C5813 a_35327_45750# VSS 0.0145f
C5814 a_35000_45878# VSS 0.08575f ; **FLOATING
C5815 a_33857_45823# VSS 0.09495f
C5816 a_32980_45759# VSS 0.03671f
C5817 a_34153_46061# VSS 0.15619f
C5818 a_34208_45966# VSS 0.41694f
C5819 a_33049_46137# VSS 1.08226f
C5820 a_33211_45868# VSS 0.08274f
C5821 a_32406_45746# VSS 1.80786f
C5822 sar_ctrl_async_phys_0.sg13g2_nor2_1$1_0.Y VSS 0.87025f
C5823 sar_ctrl_async_phys_0.sg13g2_o21ai_1$1_1.B1 VSS 10.38681f
C5824 a_26160_45878# VSS 0.06157f ; **FLOATING
C5825 sar_ctrl_async_phys_0.sg13g2_buf_1$1_46.A VSS 0.54446f
C5826 a_35402_46878# VSS 0.55148f
C5827 sar_ctrl_async_phys_0.dac_code_n[3] VSS 0.03181f
C5828 sar_ctrl_async_phys_0.dac_code_n[1] VSS 82.23344f
C5829 a_33944_46594# VSS 0.10188f ; **FLOATING
C5830 a_32425_46631# VSS 0.23282f
C5831 a_34236_46472# VSS 0.19754f
C5832 a_31321_46555# VSS 0.83163f
C5833 a_32642_46946# VSS 0.11332f
C5834 a_32129_46869# VSS 0.31501f
C5835 sar_ctrl_async_phys_0.sg13g2_dfrbpq_1$1_0.CLK VSS 17.02187f
C5836 a_31252_46933# VSS 0.07809f
C5837 a_30576_46594# VSS 0.04589f ; **FLOATING
C5838 a_30964_46512# VSS 0.02069f
C5839 a_30678_46946# VSS 0.19316f
C5840 sar_ctrl_async_phys_0.dac_code_n[2] VSS 0.44423f
C5841 sar_ctrl_async_phys_0.cmp_valid VSS 0.46777f
C5842 sar_ctrl_async_phys_0.cmp_fault VSS 2.34814f
C5843 a_33944_47390# VSS 0.10581f ; **FLOATING
C5844 a_35288_47296# VSS 0.16795f
C5845 sar_ctrl_async_phys_0.sg13g2_buf_1$1_42.A VSS 0.12616f
C5846 w_39600_n9960# VSS 2.35291f
C5847 sar_ctrl_async_phys_0.sg13g2_dfrbpq_1$1_0.CLK.n0 VSS 1.79313f
C5848 sar_ctrl_async_phys_0.sg13g2_dfrbpq_1$1_0.CLK.n1 VSS 2.50749f
C5849 sar_ctrl_async_phys_0.sg13g2_dfrbpq_1$1_0.CLK.n2 VSS 1.75036f
C5850 sar_ctrl_async_phys_0.sg13g2_dfrbpq_1$1_0.CLK.n3 VSS 1.17593f
C5851 sar_ctrl_async_phys_0.sg13g2_dfrbpq_1$1_0.CLK.n4 VSS 1.67003f
C5852 sar_ctrl_async_phys_0.sg13g2_dfrbpq_1$1_0.CLK.n5 VSS 1.43468f
C5853 sar_ctrl_async_phys_0.sg13g2_dfrbpq_1$1_0.CLK.n6 VSS 1.57977f
C5854 sar_ctrl_async_phys_0.sg13g2_dfrbpq_1$1_0.CLK.n7 VSS 1.62442f
C5855 sar_ctrl_async_phys_0.sg13g2_dfrbpq_1$1_0.CLK.n8 VSS 1.29064f
C5856 sar_ctrl_async_phys_0.sg13g2_dfrbpq_1$1_0.CLK.n9 VSS 1.02573f
C5857 sar_ctrl_async_phys_0.sg13g2_dfrbpq_1$1_0.CLK.n10 VSS 1.04596f
C5858 sar_ctrl_async_phys_0.sg13g2_dfrbpq_1$1_0.CLK.n11 VSS 1.73005f
C5859 sar_ctrl_async_phys_0.sg13g2_dfrbpq_1$1_0.CLK.n12 VSS 1.19777f
C5860 sar_ctrl_async_phys_0.sg13g2_dfrbpq_1$1_0.CLK.n13 VSS 1.8473f
C5861 sar_ctrl_async_phys_0.sg13g2_dfrbpq_1$1_0.CLK.n14 VSS 1.43936f
C5862 sar_ctrl_async_phys_0.sg13g2_dfrbpq_1$1_0.CLK.n15 VSS 0.98484f
C5863 sar_ctrl_async_phys_0.sg13g2_dfrbpq_1$1_0.CLK.n16 VSS 0.94824f
C5864 sar_ctrl_async_phys_0.sg13g2_dfrbpq_1$1_0.CLK.n17 VSS 1.58309f
C5865 sar_ctrl_async_phys_0.sg13g2_dfrbpq_1$1_0.CLK.n18 VSS 1.38445f
C5866 sar_ctrl_async_phys_0.sg13g2_dfrbpq_1$1_0.CLK.n19 VSS 1.57328f
C5867 sar_ctrl_async_phys_0.sg13g2_dfrbpq_1$1_0.CLK.n20 VSS 1.66843f
C5868 sar_ctrl_async_phys_0.sg13g2_dfrbpq_1$1_0.CLK.n21 VSS 1.19057f
C5869 sar_ctrl_async_phys_0.sg13g2_dfrbpq_1$1_0.CLK.n22 VSS 2.2361f
C5870 sar_ctrl_async_phys_0.sg13g2_dfrbpq_1$1_0.CLK.n23 VSS 1.50415f
C5871 sar_ctrl_async_phys_0.sg13g2_dfrbpq_1$1_0.CLK.n24 VSS 1.2823f
C5872 sar_ctrl_async_phys_0.sg13g2_dfrbpq_1$1_0.CLK.n25 VSS 1.3813f
C5873 sar_ctrl_async_phys_0.sg13g2_dfrbpq_1$1_0.CLK.n26 VSS 1.36949f
C5874 sar_ctrl_async_phys_0.sg13g2_dfrbpq_1$1_0.CLK.t0 VSS 0.52017f
C5875 sar_ctrl_async_phys_0.dac_code_n[1].n0 VSS 2.34617f
C5876 sar_ctrl_async_phys_0.dac_code_n[1].t0 VSS 0.13653f
C5877 sar_ctrl_async_phys_0.sg13g2_o21ai_1$1_1.B1.n0 VSS 3.02254f
C5878 sar_ctrl_async_phys_0.sg13g2_o21ai_1$1_1.B1.n1 VSS 1.5229f
C5879 sar_ctrl_async_phys_0.sg13g2_o21ai_1$1_1.B1.n2 VSS 1.95002f
C5880 sar_ctrl_async_phys_0.sg13g2_o21ai_1$1_1.B1.n3 VSS 1.17557f
C5881 sar_ctrl_async_phys_0.sg13g2_o21ai_1$1_1.B1.n4 VSS 1.19828f
C5882 sar_ctrl_async_phys_0.sg13g2_o21ai_1$1_1.B1.n5 VSS 4.82232f
C5883 sar_ctrl_async_phys_0.sg13g2_o21ai_1$1_1.B1.t0 VSS 0.89891f
C5884 sar_ctrl_async_phys_0.dac_code_n[7].n0 VSS 2.34252f
C5885 sar_ctrl_async_phys_0.dac_code_n[7].t0 VSS 0.29637f
C5886 sar_ctrl_async_phys_0.sg13g2_buf_1$1_2.X.t0 VSS 2.35948f
C5887 sar_ctrl_async_phys_0.sg13g2_nand3b_1$1_0.B VSS 0.24308f
C5888 sar_ctrl_async_phys_0.sg13g2_nand2_1$1_1.A VSS 0.45954f
C5889 sar_ctrl_async_phys_0.sg13g2_dfrbpq_1$1_21.RESET_B VSS 0.65699f
C5890 sar_ctrl_async_phys_0.sg13g2_dfrbpq_1$1_2.RESET_B VSS 0.51317f
C5891 sar_ctrl_async_phys_0.sg13g2_buf_1$1_2.X.t1 VSS 0.38734f
C5892 sar_ctrl_async_phys_0.sg13g2_buf_1$1_2.X.n0 VSS 1.52756f
C5893 sar_ctrl_async_phys_0.sg13g2_buf_1$1_2.X.n1 VSS 1.32632f
C5894 sar_ctrl_async_phys_0.sg13g2_buf_1$1_2.X.n2 VSS 2.24641f
C5895 sar_ctrl_async_phys_0.sg13g2_buf_1$1_2.X.n3 VSS 0.88473f
C5896 sar_ctrl_async_phys_0.sg13g2_buf_1$1_2.X.n4 VSS 1.23911f
C5897 sar_ctrl_async_phys_0.sg13g2_buf_1$1_2.X.n5 VSS 1.45239f
C5898 sar_ctrl_async_phys_0.sg13g2_buf_1$1_6.X.t0 VSS 0.47278f
C5899 sar_ctrl_async_phys_0.sg13g2_buf_1$1_6.X.n0 VSS 1.74508f
C5900 sar_ctrl_async_phys_0.sg13g2_buf_1$1_6.X.n1 VSS 1.15671f
C5901 sar_ctrl_async_phys_0.sg13g2_buf_1$1_6.X.n2 VSS 1.86835f
C5902 sar_ctrl_async_phys_0.sg13g2_buf_1$1_6.X.n3 VSS 1.57142f
C5903 sar_ctrl_async_phys_0.sg13g2_buf_1$1_6.X.n4 VSS 2.64534f
C5904 sar_ctrl_async_phys_0.sg13g2_buf_1$1_6.X.n5 VSS 1.01993f
C5905 sar_ctrl_async_phys_0.sg13g2_buf_1$1_6.X.n6 VSS 1.48074f
C5906 oa_sar8_acore18_opt_0.sw_tg_opt_1.bot.t1 VSS 1.15887f
C5907 oa_sar8_acore18_opt_0.sw_tg_opt_1.bot.t0 VSS 0.1877f
C5908 oa_sar8_acore18_opt_0.sw_tg_opt_0.bot.t1 VSS 1.16455f
C5909 oa_sar8_acore18_opt_0.sw_tg_opt_0.bot.t0 VSS 0.20616f
C5910 oa_sar8_acore18_opt_0.sw_bitcell_opt_term_1.bot.t3 VSS 0.62617f
C5911 oa_sar8_acore18_opt_0.sw_bitcell_opt_term_1.bot.t0 VSS 3.49716f
C5912 oa_sar8_acore18_opt_0.sw_bitcell_opt_term_1.bot.t1 VSS 2.36664f
C5913 oa_sar8_acore18_opt_0.sw_bitcell_opt_term_1.bot.n0 VSS 23.9513f
C5914 oa_sar8_acore18_opt_0.sw_bitcell_opt_term_0.trkb.n0 VSS 4.37762f
C5915 oa_sar8_acore18_opt_0.sw_bitcell_opt_term_0.trkb.t1 VSS 1.1642f
C5916 oa_sar8_acore18_opt_0.sw_bitcell_opt_term_0.trkb.t0 VSS 19.22205f
C5917 oa_sar8_acore18_opt_0.sw_bitcell_opt_term_0.trkb.n1 VSS 4.42405f
C5918 oa_sar8_acore18_opt_0.sw_bitcell_opt_term_0.trkb.n2 VSS 6.3393f
C5919 oa_sar8_acore18_opt_0.sw_bitcell_opt_term_0.trkb.n3 VSS 11.8898f
C5920 oa_sar8_acore18_opt_0.sw_bitcell_opt_term_0.trkb.n4 VSS 1.09146f
C5921 oa_sar8_acore18_opt_0.sw_bitcell_opt_term_0.trkb.n5 VSS 1.56951f
C5922 oa_sar8_acore18_opt_0.sw_bitcell_opt_term_0.trkb.n6 VSS 4.42403f
C5923 oa_sar8_acore18_opt_0.sw_bitcell_opt_b0_1.bot.t1 VSS 11.24963f
C5924 oa_sar8_acore18_opt_0.sw_bitcell_opt_b0_1.bot.t0 VSS 4.01129f
C5925 oa_sar8_acore18_opt_0.sw_bitcell_opt_b0_1.bot.t2 VSS 4.57703f
C5926 oa_sar8_acore18_opt_0.sw_bitcell_opt_b0_1.bot.n0 VSS 29.1037f
C5927 oa_sar8_acore18_opt_0.sw_bitcell_opt_b1_1.bot.t1 VSS 1.61835f
C5928 oa_sar8_acore18_opt_0.sw_bitcell_opt_b1_1.bot.t0 VSS 5.01222f
C5929 oa_sar8_acore18_opt_0.sw_bitcell_opt_b1_1.bot.t4 VSS 3.46333f
C5930 oa_sar8_acore18_opt_0.sw_bitcell_opt_b1_1.bot.t2 VSS 2.12381f
C5931 oa_sar8_acore18_opt_0.sw_bitcell_opt_b1_1.bot.n0 VSS 9.27531f
C5932 oa_sar8_acore18_opt_0.sw_bitcell_opt_b1_1.bot.n1 VSS 19.2932f
C5933 oa_sar8_acore18_opt_0.sw_bitcell_opt_b2_1.bot.n0 VSS 5.17708f
C5934 oa_sar8_acore18_opt_0.sw_bitcell_opt_b2_1.bot.t1 VSS 7.5294f
C5935 oa_sar8_acore18_opt_0.sw_bitcell_opt_b2_1.bot.t0 VSS 14.82887f
C5936 oa_sar8_acore18_opt_0.sw_bitcell_opt_b2_1.bot.t6 VSS 2.00457f
C5937 oa_sar8_acore18_opt_0.sw_bitcell_opt_b2_1.bot.t8 VSS 1.95963f
C5938 oa_sar8_acore18_opt_0.sw_bitcell_opt_b2_1.bot.n1 VSS 4.62373f
C5939 oa_sar8_acore18_opt_0.sw_bitcell_opt_b2_1.bot.t2 VSS 2.10612f
C5940 oa_sar8_acore18_opt_0.sw_bitcell_opt_b2_1.bot.t4 VSS 2.10612f
C5941 oa_sar8_acore18_opt_0.sw_bitcell_opt_b2_1.bot.n2 VSS 17.9364f
C5942 oa_sar8_acore18_opt_0.sw_bitcell_opt_b3_1.bot.n0 VSS 1.02134f
C5943 oa_sar8_acore18_opt_0.sw_bitcell_opt_b3_1.bot.n1 VSS 1.15128f
C5944 oa_sar8_acore18_opt_0.sw_bitcell_opt_b3_1.bot.n2 VSS 3.64965f
C5945 oa_sar8_acore18_opt_0.sw_bitcell_opt_b3_1.bot.t17 VSS 0.67607f
C5946 oa_sar8_acore18_opt_0.sw_bitcell_opt_b3_1.bot.t0 VSS 14.37357f
C5947 oa_sar8_acore18_opt_0.sw_bitcell_opt_b3_1.bot.t9 VSS 1.72328f
C5948 oa_sar8_acore18_opt_0.sw_bitcell_opt_b3_1.bot.t11 VSS 1.65421f
C5949 oa_sar8_acore18_opt_0.sw_bitcell_opt_b3_1.bot.t13 VSS 1.65421f
C5950 oa_sar8_acore18_opt_0.sw_bitcell_opt_b3_1.bot.t15 VSS 1.65421f
C5951 oa_sar8_acore18_opt_0.sw_bitcell_opt_b3_1.bot.t1 VSS 1.98132f
C5952 oa_sar8_acore18_opt_0.sw_bitcell_opt_b3_1.bot.t3 VSS 1.98132f
C5953 oa_sar8_acore18_opt_0.sw_bitcell_opt_b3_1.bot.t5 VSS 0.12488p
C5954 oa_sar8_acore18_opt_0.sw_bitcell_opt_b3_1.bot.t7 VSS 1.98132f
C5955 oa_sar8_acore18_opt_0.sw_bitcell_opt_b3_1.bot.n3 VSS 2.6684f
C5956 oa_sar8_acore18_opt_0.sw_bitcell_opt_b3_1.bot.n4 VSS 16.1232f
C5957 oa_sar8_acore18_opt_0.sw_bitcell_opt_b4_1.bot.n0 VSS 0.9214f
C5958 oa_sar8_acore18_opt_0.sw_bitcell_opt_b4_1.bot.n1 VSS 1.43942f
C5959 oa_sar8_acore18_opt_0.sw_bitcell_opt_b4_1.bot.n2 VSS 0.88671f
C5960 oa_sar8_acore18_opt_0.sw_bitcell_opt_b4_1.bot.n3 VSS 1.63887f
C5961 oa_sar8_acore18_opt_0.sw_bitcell_opt_b4_1.bot.n4 VSS 0.88671f
C5962 oa_sar8_acore18_opt_0.sw_bitcell_opt_b4_1.bot.n5 VSS 0.9214f
C5963 oa_sar8_acore18_opt_0.sw_bitcell_opt_b4_1.bot.n6 VSS 1.19449f
C5964 oa_sar8_acore18_opt_0.sw_bitcell_opt_b4_1.bot.t1 VSS 0.57273f
C5965 oa_sar8_acore18_opt_0.sw_bitcell_opt_b4_1.bot.t0 VSS 9.90832f
C5966 oa_sar8_acore18_opt_0.sw_bitcell_opt_b4_1.bot.t2 VSS 1.6522f
C5967 oa_sar8_acore18_opt_0.sw_bitcell_opt_b4_1.bot.t4 VSS 1.64505f
C5968 oa_sar8_acore18_opt_0.sw_bitcell_opt_b4_1.bot.t6 VSS 1.64505f
C5969 oa_sar8_acore18_opt_0.sw_bitcell_opt_b4_1.bot.t8 VSS 1.64505f
C5970 oa_sar8_acore18_opt_0.sw_bitcell_opt_b4_1.bot.t10 VSS 1.64505f
C5971 oa_sar8_acore18_opt_0.sw_bitcell_opt_b4_1.bot.t12 VSS 1.64505f
C5972 oa_sar8_acore18_opt_0.sw_bitcell_opt_b4_1.bot.t14 VSS 1.64505f
C5973 oa_sar8_acore18_opt_0.sw_bitcell_opt_b4_1.bot.t16 VSS 1.64505f
C5974 oa_sar8_acore18_opt_0.sw_bitcell_opt_b4_1.bot.t18 VSS 1.2307f
C5975 oa_sar8_acore18_opt_0.sw_bitcell_opt_b4_1.bot.t20 VSS 1.2307f
C5976 oa_sar8_acore18_opt_0.sw_bitcell_opt_b4_1.bot.t22 VSS 1.2307f
C5977 oa_sar8_acore18_opt_0.sw_bitcell_opt_b4_1.bot.t24 VSS 1.2307f
C5978 oa_sar8_acore18_opt_0.sw_bitcell_opt_b4_1.bot.t26 VSS 1.2307f
C5979 oa_sar8_acore18_opt_0.sw_bitcell_opt_b4_1.bot.t28 VSS 1.2307f
C5980 oa_sar8_acore18_opt_0.sw_bitcell_opt_b4_1.bot.t30 VSS 1.2307f
C5981 oa_sar8_acore18_opt_0.sw_bitcell_opt_b4_1.bot.t32 VSS 1.2307f
C5982 oa_sar8_acore18_opt_0.sw_bitcell_opt_b4_1.bot.n7 VSS 11.6306f
C5983 oa_sar8_acore18_opt_0.sw_bitcell_opt_b5_1.bot.t22 VSS 6.00175f
C5984 oa_sar8_acore18_opt_0.sw_bitcell_opt_b5_1.bot.t2 VSS 6.00175f
C5985 oa_sar8_acore18_opt_0.sw_bitcell_opt_b5_1.bot.t1 VSS 6.90691f
C5986 oa_sar8_acore18_opt_0.sw_bitcell_opt_b5_1.bot.t0 VSS 2.74428f
C5987 oa_sar8_acore18_opt_0.sw_bitcell_opt_b5_1.bot.t15 VSS 4.45501f
C5988 oa_sar8_acore18_opt_0.sw_bitcell_opt_b5_1.bot.t20 VSS 4.24218f
C5989 oa_sar8_acore18_opt_0.sw_bitcell_opt_b5_1.bot.t10 VSS 4.45501f
C5990 oa_sar8_acore18_opt_0.sw_bitcell_opt_b5_1.bot.n0 VSS 3.37994f
C5991 oa_sar8_acore18_opt_0.sw_bitcell_opt_b5_1.bot.t35 VSS 4.45501f
C5992 oa_sar8_acore18_opt_0.sw_bitcell_opt_b5_1.bot.t40 VSS 4.24218f
C5993 oa_sar8_acore18_opt_0.sw_bitcell_opt_b5_1.bot.t30 VSS 4.45501f
C5994 oa_sar8_acore18_opt_0.sw_bitcell_opt_b5_1.bot.n1 VSS 6.59357f
C5995 oa_sar8_acore18_opt_0.sw_bitcell_opt_b6_1.bot.t62 VSS 4.61805f
C5996 oa_sar8_acore18_opt_0.sw_bitcell_opt_b6_1.bot.t42 VSS 4.61805f
C5997 oa_sar8_acore18_opt_0.sw_bitcell_opt_b6_1.bot.t22 VSS 4.61805f
C5998 oa_sar8_acore18_opt_0.sw_bitcell_opt_b6_1.bot.t2 VSS 4.61805f
C5999 oa_sar8_acore18_opt_0.sw_bitcell_opt_b6_1.bot.n0 VSS 5.28407f
C6000 oa_sar8_acore18_opt_0.sw_bitcell_opt_b6_1.bot.n1 VSS 3.39319f
C6001 oa_sar8_acore18_opt_0.sw_bitcell_opt_b6_1.bot.t1 VSS 0.40244f
C6002 oa_sar8_acore18_opt_0.sw_bitcell_opt_b6_1.bot.t0 VSS 8.76674f
C6003 oa_sar8_acore18_opt_0.sw_bitcell_opt_b6_1.bot.t15 VSS 3.42791f
C6004 oa_sar8_acore18_opt_0.sw_bitcell_opt_b6_1.bot.t20 VSS 3.38536f
C6005 oa_sar8_acore18_opt_0.sw_bitcell_opt_b6_1.bot.t10 VSS 3.42791f
C6006 oa_sar8_acore18_opt_0.sw_bitcell_opt_b6_1.bot.t35 VSS 3.42791f
C6007 oa_sar8_acore18_opt_0.sw_bitcell_opt_b6_1.bot.t40 VSS 3.38536f
C6008 oa_sar8_acore18_opt_0.sw_bitcell_opt_b6_1.bot.t30 VSS 3.42791f
C6009 oa_sar8_acore18_opt_0.sw_bitcell_opt_b6_1.bot.t55 VSS 3.42791f
C6010 oa_sar8_acore18_opt_0.sw_bitcell_opt_b6_1.bot.t60 VSS 3.38536f
C6011 oa_sar8_acore18_opt_0.sw_bitcell_opt_b6_1.bot.t50 VSS 3.42791f
C6012 oa_sar8_acore18_opt_0.sw_bitcell_opt_b6_1.bot.t75 VSS 3.42791f
C6013 oa_sar8_acore18_opt_0.sw_bitcell_opt_b6_1.bot.t80 VSS 3.38536f
C6014 oa_sar8_acore18_opt_0.sw_bitcell_opt_b6_1.bot.t70 VSS 3.42791f
C6015 oa_sar8_acore18_opt_0.sw_bitcell_opt_b7_1.bot.t1 VSS 1.5789f
C6016 oa_sar8_acore18_opt_0.sw_bitcell_opt_b7_1.bot.t0 VSS 2.94447f
C6017 oa_sar8_acore18_opt_0.sw_bitcell_opt_b7_1.bot.t36 VSS 2.67113f
C6018 oa_sar8_acore18_opt_0.sw_bitcell_opt_b7_1.bot.t41 VSS 2.73068f
C6019 oa_sar8_acore18_opt_0.sw_bitcell_opt_b7_1.bot.t31 VSS 2.67113f
C6020 oa_sar8_acore18_opt_0.sw_bitcell_opt_b7_1.bot.t26 VSS 2.33724f
C6021 oa_sar8_acore18_opt_0.sw_bitcell_opt_b7_1.bot.t22 VSS 1.26128f
C6022 oa_sar8_acore18_opt_0.sw_bitcell_opt_b7_1.bot.n0 VSS 0.51124f
C6023 oa_sar8_acore18_opt_0.sw_bitcell_opt_b7_1.bot.t15 VSS 2.67113f
C6024 oa_sar8_acore18_opt_0.sw_bitcell_opt_b7_1.bot.t20 VSS 2.73068f
C6025 oa_sar8_acore18_opt_0.sw_bitcell_opt_b7_1.bot.t10 VSS 6.464f
C6026 oa_sar8_acore18_opt_0.sw_bitcell_opt_b7_1.bot.t5 VSS 2.33724f
C6027 oa_sar8_acore18_opt_0.sw_bitcell_opt_b7_1.bot.t2 VSS 1.26128f
C6028 oa_sar8_acore18_opt_0.sw_bitcell_opt_b7_1.bot.n1 VSS 0.6195f
C6029 oa_sar8_acore18_opt_0.sw_bitcell_opt_b7_1.bot.t58 VSS 2.67113f
C6030 oa_sar8_acore18_opt_0.sw_bitcell_opt_b7_1.bot.t63 VSS 2.73068f
C6031 oa_sar8_acore18_opt_0.sw_bitcell_opt_b7_1.bot.t53 VSS 2.67113f
C6032 oa_sar8_acore18_opt_0.sw_bitcell_opt_b7_1.bot.t48 VSS 2.33724f
C6033 oa_sar8_acore18_opt_0.sw_bitcell_opt_b7_1.bot.t44 VSS 1.26128f
C6034 oa_sar8_acore18_opt_0.sw_bitcell_opt_b7_1.bot.n2 VSS 0.6195f
C6035 oa_sar8_acore18_opt_0.sw_bitcell_opt_b7_1.bot.t79 VSS 2.67113f
C6036 oa_sar8_acore18_opt_0.sw_bitcell_opt_b7_1.bot.t84 VSS 2.73068f
C6037 oa_sar8_acore18_opt_0.sw_bitcell_opt_b7_1.bot.t74 VSS 2.67113f
C6038 oa_sar8_acore18_opt_0.sw_bitcell_opt_b7_1.bot.t69 VSS 2.33724f
C6039 oa_sar8_acore18_opt_0.sw_bitcell_opt_b7_1.bot.t65 VSS 1.26128f
C6040 oa_sar8_acore18_opt_0.sw_bitcell_opt_b7_1.bot.n3 VSS 2.18335f
C6041 oa_sar8_acore18_opt_0.sw_bitcell_opt_b7_1.bot.t100 VSS 2.67113f
C6042 oa_sar8_acore18_opt_0.sw_bitcell_opt_b7_1.bot.t105 VSS 2.73068f
C6043 oa_sar8_acore18_opt_0.sw_bitcell_opt_b7_1.bot.t95 VSS 2.67113f
C6044 oa_sar8_acore18_opt_0.sw_bitcell_opt_b7_1.bot.t90 VSS 2.33724f
C6045 oa_sar8_acore18_opt_0.sw_bitcell_opt_b7_1.bot.t86 VSS 1.26128f
C6046 oa_sar8_acore18_opt_0.sw_bitcell_opt_b7_1.bot.n4 VSS 2.18335f
C6047 oa_sar8_acore18_opt_0.sw_bitcell_opt_b7_1.bot.t121 VSS 2.67113f
C6048 oa_sar8_acore18_opt_0.sw_bitcell_opt_b7_1.bot.t126 VSS 2.73068f
C6049 oa_sar8_acore18_opt_0.sw_bitcell_opt_b7_1.bot.t116 VSS 2.67113f
C6050 oa_sar8_acore18_opt_0.sw_bitcell_opt_b7_1.bot.t111 VSS 2.33724f
C6051 oa_sar8_acore18_opt_0.sw_bitcell_opt_b7_1.bot.t107 VSS 1.26128f
C6052 oa_sar8_acore18_opt_0.sw_bitcell_opt_b7_1.bot.n5 VSS 0.6195f
C6053 oa_sar8_acore18_opt_0.sw_bitcell_opt_b7_1.bot.t142 VSS 2.67113f
C6054 oa_sar8_acore18_opt_0.sw_bitcell_opt_b7_1.bot.t147 VSS 2.73068f
C6055 oa_sar8_acore18_opt_0.sw_bitcell_opt_b7_1.bot.t137 VSS 2.67113f
C6056 oa_sar8_acore18_opt_0.sw_bitcell_opt_b7_1.bot.t132 VSS 2.33724f
C6057 oa_sar8_acore18_opt_0.sw_bitcell_opt_b7_1.bot.t128 VSS 1.26128f
C6058 oa_sar8_acore18_opt_0.sw_bitcell_opt_b7_1.bot.n6 VSS 0.6195f
C6059 oa_sar8_acore18_opt_0.sw_bitcell_opt_b7_1.bot.t163 VSS 2.67113f
C6060 oa_sar8_acore18_opt_0.sw_bitcell_opt_b7_1.bot.t168 VSS 10.16738f
C6061 oa_sar8_acore18_opt_0.sw_bitcell_opt_b7_1.bot.t158 VSS 2.67113f
C6062 oa_sar8_acore18_opt_0.sw_bitcell_opt_b7_1.bot.t153 VSS 2.33724f
C6063 oa_sar8_acore18_opt_0.sw_bitcell_opt_b7_1.bot.t149 VSS 1.26128f
C6064 oa_sar8_acore18_opt_0.sw_bitcell_opt_b7_1.bot.n7 VSS 1.21048f
C6065 oa_sar8_acore18_opt_0.sw_bitcell_opt_b7_1.bot.n8 VSS 0.5584f
C6066 oa_sar8_acore18_opt_0.sw_bitcell_opt_b7_0.bot.t0 VSS 0.48285f
C6067 oa_sar8_acore18_opt_0.sw_bitcell_opt_b7_0.bot.t1 VSS 18.32575f
C6068 oa_sar8_acore18_opt_0.sw_bitcell_opt_b7_0.bot.t35 VSS 2.87971f
C6069 oa_sar8_acore18_opt_0.sw_bitcell_opt_b7_0.bot.t40 VSS 1.55402f
C6070 oa_sar8_acore18_opt_0.sw_bitcell_opt_b7_0.bot.t30 VSS 3.29109f
C6071 oa_sar8_acore18_opt_0.sw_bitcell_opt_b7_0.bot.t25 VSS 3.29109f
C6072 oa_sar8_acore18_opt_0.sw_bitcell_opt_b7_0.bot.t22 VSS 3.36446f
C6073 oa_sar8_acore18_opt_0.sw_bitcell_opt_b7_0.bot.n0 VSS 0.6299f
C6074 oa_sar8_acore18_opt_0.sw_bitcell_opt_b7_0.bot.t15 VSS 7.04558f
C6075 oa_sar8_acore18_opt_0.sw_bitcell_opt_b7_0.bot.t20 VSS 1.55402f
C6076 oa_sar8_acore18_opt_0.sw_bitcell_opt_b7_0.bot.t10 VSS 3.29109f
C6077 oa_sar8_acore18_opt_0.sw_bitcell_opt_b7_0.bot.t5 VSS 3.29109f
C6078 oa_sar8_acore18_opt_0.sw_bitcell_opt_b7_0.bot.t2 VSS 3.36446f
C6079 oa_sar8_acore18_opt_0.sw_bitcell_opt_b7_0.bot.n1 VSS 0.76328f
C6080 oa_sar8_acore18_opt_0.sw_bitcell_opt_b7_0.bot.t57 VSS 2.87971f
C6081 oa_sar8_acore18_opt_0.sw_bitcell_opt_b7_0.bot.t62 VSS 1.55402f
C6082 oa_sar8_acore18_opt_0.sw_bitcell_opt_b7_0.bot.t52 VSS 3.29109f
C6083 oa_sar8_acore18_opt_0.sw_bitcell_opt_b7_0.bot.t47 VSS 3.29109f
C6084 oa_sar8_acore18_opt_0.sw_bitcell_opt_b7_0.bot.t44 VSS 3.36446f
C6085 oa_sar8_acore18_opt_0.sw_bitcell_opt_b7_0.bot.n2 VSS 0.76328f
C6086 oa_sar8_acore18_opt_0.sw_bitcell_opt_b7_0.bot.t78 VSS 2.87971f
C6087 oa_sar8_acore18_opt_0.sw_bitcell_opt_b7_0.bot.t83 VSS 1.55402f
C6088 oa_sar8_acore18_opt_0.sw_bitcell_opt_b7_0.bot.t73 VSS 3.29109f
C6089 oa_sar8_acore18_opt_0.sw_bitcell_opt_b7_0.bot.t68 VSS 3.29109f
C6090 oa_sar8_acore18_opt_0.sw_bitcell_opt_b7_0.bot.t65 VSS 3.36446f
C6091 oa_sar8_acore18_opt_0.sw_bitcell_opt_b7_0.bot.n3 VSS 2.6901f
C6092 oa_sar8_acore18_opt_0.sw_bitcell_opt_b7_0.bot.t99 VSS 2.87971f
C6093 oa_sar8_acore18_opt_0.sw_bitcell_opt_b7_0.bot.t104 VSS 1.55402f
C6094 oa_sar8_acore18_opt_0.sw_bitcell_opt_b7_0.bot.t94 VSS 0.13847p
C6095 oa_sar8_acore18_opt_0.sw_bitcell_opt_b7_0.bot.t89 VSS 3.29109f
C6096 oa_sar8_acore18_opt_0.sw_bitcell_opt_b7_0.bot.t86 VSS 3.36446f
C6097 oa_sar8_acore18_opt_0.sw_bitcell_opt_b7_0.bot.n4 VSS 2.6901f
C6098 oa_sar8_acore18_opt_0.sw_bitcell_opt_b7_0.bot.t120 VSS 2.87971f
C6099 oa_sar8_acore18_opt_0.sw_bitcell_opt_b7_0.bot.t125 VSS 1.55402f
C6100 oa_sar8_acore18_opt_0.sw_bitcell_opt_b7_0.bot.t115 VSS 3.29109f
C6101 oa_sar8_acore18_opt_0.sw_bitcell_opt_b7_0.bot.t110 VSS 3.29109f
C6102 oa_sar8_acore18_opt_0.sw_bitcell_opt_b7_0.bot.t107 VSS 3.36446f
C6103 oa_sar8_acore18_opt_0.sw_bitcell_opt_b7_0.bot.n5 VSS 0.76328f
C6104 oa_sar8_acore18_opt_0.sw_bitcell_opt_b7_0.bot.t141 VSS 2.87971f
C6105 oa_sar8_acore18_opt_0.sw_bitcell_opt_b7_0.bot.t146 VSS 1.55402f
C6106 oa_sar8_acore18_opt_0.sw_bitcell_opt_b7_0.bot.t136 VSS 3.29109f
C6107 oa_sar8_acore18_opt_0.sw_bitcell_opt_b7_0.bot.t131 VSS 3.29109f
C6108 oa_sar8_acore18_opt_0.sw_bitcell_opt_b7_0.bot.t128 VSS 3.36446f
C6109 oa_sar8_acore18_opt_0.sw_bitcell_opt_b7_0.bot.n6 VSS 0.76328f
C6110 oa_sar8_acore18_opt_0.sw_bitcell_opt_b7_0.bot.t162 VSS 2.87971f
C6111 oa_sar8_acore18_opt_0.sw_bitcell_opt_b7_0.bot.t167 VSS 1.55402f
C6112 oa_sar8_acore18_opt_0.sw_bitcell_opt_b7_0.bot.t157 VSS 3.29109f
C6113 oa_sar8_acore18_opt_0.sw_bitcell_opt_b7_0.bot.t152 VSS 11.16207f
C6114 oa_sar8_acore18_opt_0.sw_bitcell_opt_b7_0.bot.t149 VSS 3.36446f
C6115 oa_sar8_acore18_opt_0.sw_bitcell_opt_b7_0.bot.n7 VSS 1.41498f
C6116 oa_sar8_acore18_opt_0.sw_bitcell_opt_b7_0.bot.n8 VSS 0.73211f
C6117 oa_sar8_acore18_opt_0.sw_bitcell_opt_b6_0.bot.t74 VSS 5.91855f
C6118 oa_sar8_acore18_opt_0.sw_bitcell_opt_b6_0.bot.t54 VSS 5.91855f
C6119 oa_sar8_acore18_opt_0.sw_bitcell_opt_b6_0.bot.t34 VSS 5.91855f
C6120 oa_sar8_acore18_opt_0.sw_bitcell_opt_b6_0.bot.t14 VSS 5.91855f
C6121 oa_sar8_acore18_opt_0.sw_bitcell_opt_b6_0.bot.n0 VSS 6.7619f
C6122 oa_sar8_acore18_opt_0.sw_bitcell_opt_b6_0.bot.n1 VSS 4.34875f
C6123 oa_sar8_acore18_opt_0.sw_bitcell_opt_b6_0.bot.t81 VSS 0.51578f
C6124 oa_sar8_acore18_opt_0.sw_bitcell_opt_b6_0.bot.t0 VSS 13.44166f
C6125 oa_sar8_acore18_opt_0.sw_bitcell_opt_b6_0.bot.t9 VSS 4.39325f
C6126 oa_sar8_acore18_opt_0.sw_bitcell_opt_b6_0.bot.t4 VSS 4.39325f
C6127 oa_sar8_acore18_opt_0.sw_bitcell_opt_b6_0.bot.t1 VSS 4.33872f
C6128 oa_sar8_acore18_opt_0.sw_bitcell_opt_b6_0.bot.t29 VSS 4.39325f
C6129 oa_sar8_acore18_opt_0.sw_bitcell_opt_b6_0.bot.t24 VSS 4.39325f
C6130 oa_sar8_acore18_opt_0.sw_bitcell_opt_b6_0.bot.t21 VSS 4.33872f
C6131 oa_sar8_acore18_opt_0.sw_bitcell_opt_b6_0.bot.t49 VSS 4.39325f
C6132 oa_sar8_acore18_opt_0.sw_bitcell_opt_b6_0.bot.t44 VSS 4.39325f
C6133 oa_sar8_acore18_opt_0.sw_bitcell_opt_b6_0.bot.t41 VSS 4.33872f
C6134 oa_sar8_acore18_opt_0.sw_bitcell_opt_b6_0.bot.t69 VSS 4.39325f
C6135 oa_sar8_acore18_opt_0.sw_bitcell_opt_b6_0.bot.t64 VSS 4.39325f
C6136 oa_sar8_acore18_opt_0.sw_bitcell_opt_b6_0.bot.t61 VSS 4.33872f
C6137 oa_sar8_acore18_opt_0.sw_bitcell_opt_b5_0.bot.t35 VSS 7.0384f
C6138 oa_sar8_acore18_opt_0.sw_bitcell_opt_b5_0.bot.t15 VSS 7.0384f
C6139 oa_sar8_acore18_opt_0.sw_bitcell_opt_b5_0.bot.t0 VSS 8.253f
C6140 oa_sar8_acore18_opt_0.sw_bitcell_opt_b5_0.bot.t1 VSS 3.72251f
C6141 oa_sar8_acore18_opt_0.sw_bitcell_opt_b5_0.bot.t10 VSS 5.2245f
C6142 oa_sar8_acore18_opt_0.sw_bitcell_opt_b5_0.bot.t5 VSS 5.2245f
C6143 oa_sar8_acore18_opt_0.sw_bitcell_opt_b5_0.bot.t2 VSS 4.97491f
C6144 oa_sar8_acore18_opt_0.sw_bitcell_opt_b5_0.bot.n0 VSS 3.96375f
C6145 oa_sar8_acore18_opt_0.sw_bitcell_opt_b5_0.bot.t30 VSS 5.2245f
C6146 oa_sar8_acore18_opt_0.sw_bitcell_opt_b5_0.bot.t25 VSS 5.2245f
C6147 oa_sar8_acore18_opt_0.sw_bitcell_opt_b5_0.bot.t22 VSS 4.97491f
C6148 oa_sar8_acore18_opt_0.sw_bitcell_opt_b5_0.bot.n1 VSS 7.81767f
C6149 oa_sar8_acore18_opt_0.sw_bitcell_opt_b4_0.bot.n0 VSS 1.01916f
C6150 oa_sar8_acore18_opt_0.sw_bitcell_opt_b4_0.bot.n1 VSS 1.59213f
C6151 oa_sar8_acore18_opt_0.sw_bitcell_opt_b4_0.bot.n2 VSS 0.98079f
C6152 oa_sar8_acore18_opt_0.sw_bitcell_opt_b4_0.bot.n3 VSS 1.81275f
C6153 oa_sar8_acore18_opt_0.sw_bitcell_opt_b4_0.bot.n4 VSS 0.98079f
C6154 oa_sar8_acore18_opt_0.sw_bitcell_opt_b4_0.bot.n5 VSS 1.01916f
C6155 oa_sar8_acore18_opt_0.sw_bitcell_opt_b4_0.bot.n6 VSS 1.32122f
C6156 oa_sar8_acore18_opt_0.sw_bitcell_opt_b4_0.bot.t0 VSS 7.53956f
C6157 oa_sar8_acore18_opt_0.sw_bitcell_opt_b4_0.bot.t1 VSS 4.13957f
C6158 oa_sar8_acore18_opt_0.sw_bitcell_opt_b4_0.bot.t16 VSS 1.82749f
C6159 oa_sar8_acore18_opt_0.sw_bitcell_opt_b4_0.bot.t14 VSS 1.81959f
C6160 oa_sar8_acore18_opt_0.sw_bitcell_opt_b4_0.bot.t12 VSS 1.81959f
C6161 oa_sar8_acore18_opt_0.sw_bitcell_opt_b4_0.bot.t10 VSS 1.81959f
C6162 oa_sar8_acore18_opt_0.sw_bitcell_opt_b4_0.bot.t8 VSS 1.81959f
C6163 oa_sar8_acore18_opt_0.sw_bitcell_opt_b4_0.bot.t6 VSS 1.81959f
C6164 oa_sar8_acore18_opt_0.sw_bitcell_opt_b4_0.bot.t4 VSS 1.81959f
C6165 oa_sar8_acore18_opt_0.sw_bitcell_opt_b4_0.bot.t2 VSS 1.81959f
C6166 oa_sar8_acore18_opt_0.sw_bitcell_opt_b4_0.bot.t32 VSS 1.36127f
C6167 oa_sar8_acore18_opt_0.sw_bitcell_opt_b4_0.bot.t30 VSS 1.36127f
C6168 oa_sar8_acore18_opt_0.sw_bitcell_opt_b4_0.bot.t28 VSS 1.36127f
C6169 oa_sar8_acore18_opt_0.sw_bitcell_opt_b4_0.bot.t26 VSS 1.36127f
C6170 oa_sar8_acore18_opt_0.sw_bitcell_opt_b4_0.bot.t24 VSS 1.36127f
C6171 oa_sar8_acore18_opt_0.sw_bitcell_opt_b4_0.bot.t22 VSS 1.36127f
C6172 oa_sar8_acore18_opt_0.sw_bitcell_opt_b4_0.bot.t20 VSS 1.36127f
C6173 oa_sar8_acore18_opt_0.sw_bitcell_opt_b4_0.bot.t18 VSS 1.36127f
C6174 oa_sar8_acore18_opt_0.sw_bitcell_opt_b4_0.bot.n7 VSS 12.316f
C6175 oa_sar8_acore18_opt_0.sw_bitcell_opt_b3_0.bot.n0 VSS 1.20175f
C6176 oa_sar8_acore18_opt_0.sw_bitcell_opt_b3_0.bot.n1 VSS 1.35464f
C6177 oa_sar8_acore18_opt_0.sw_bitcell_opt_b3_0.bot.n2 VSS 4.29433f
C6178 oa_sar8_acore18_opt_0.sw_bitcell_opt_b3_0.bot.t0 VSS 7.64468f
C6179 oa_sar8_acore18_opt_0.sw_bitcell_opt_b3_0.bot.t1 VSS 4.86517f
C6180 oa_sar8_acore18_opt_0.sw_bitcell_opt_b3_0.bot.t16 VSS 2.02768f
C6181 oa_sar8_acore18_opt_0.sw_bitcell_opt_b3_0.bot.t14 VSS 1.94641f
C6182 oa_sar8_acore18_opt_0.sw_bitcell_opt_b3_0.bot.t12 VSS 1.94641f
C6183 oa_sar8_acore18_opt_0.sw_bitcell_opt_b3_0.bot.t10 VSS 1.94641f
C6184 oa_sar8_acore18_opt_0.sw_bitcell_opt_b3_0.bot.t8 VSS 2.3313f
C6185 oa_sar8_acore18_opt_0.sw_bitcell_opt_b3_0.bot.t6 VSS 2.3313f
C6186 oa_sar8_acore18_opt_0.sw_bitcell_opt_b3_0.bot.t4 VSS 2.3313f
C6187 oa_sar8_acore18_opt_0.sw_bitcell_opt_b3_0.bot.t2 VSS 2.3313f
C6188 oa_sar8_acore18_opt_0.sw_bitcell_opt_b3_0.bot.n3 VSS 3.13975f
C6189 oa_sar8_acore18_opt_0.sw_bitcell_opt_b3_0.bot.n4 VSS 18.0551f
C6190 oa_sar8_acore18_opt_0.sw_bitcell_opt_b2_0.bot.n0 VSS 6.14537f
C6191 oa_sar8_acore18_opt_0.sw_bitcell_opt_b2_0.bot.t0 VSS 8.04281f
C6192 oa_sar8_acore18_opt_0.sw_bitcell_opt_b2_0.bot.t1 VSS 5.16002f
C6193 oa_sar8_acore18_opt_0.sw_bitcell_opt_b2_0.bot.t8 VSS 2.37948f
C6194 oa_sar8_acore18_opt_0.sw_bitcell_opt_b2_0.bot.t6 VSS 2.32614f
C6195 oa_sar8_acore18_opt_0.sw_bitcell_opt_b2_0.bot.n1 VSS 5.48852f
C6196 oa_sar8_acore18_opt_0.sw_bitcell_opt_b2_0.bot.t4 VSS 2.50004f
C6197 oa_sar8_acore18_opt_0.sw_bitcell_opt_b2_0.bot.t2 VSS 2.50004f
C6198 oa_sar8_acore18_opt_0.sw_bitcell_opt_b2_0.bot.n2 VSS 20.0578f
C6199 oa_sar8_acore18_opt_0.sw_bitcell_opt_b1_0.bot.t5 VSS 8.93924f
C6200 oa_sar8_acore18_opt_0.sw_bitcell_opt_b1_0.bot.t4 VSS 5.3121f
C6201 oa_sar8_acore18_opt_0.sw_bitcell_opt_b1_0.bot.t2 VSS 4.21353f
C6202 oa_sar8_acore18_opt_0.sw_bitcell_opt_b1_0.bot.t0 VSS 2.58386f
C6203 oa_sar8_acore18_opt_0.sw_bitcell_opt_b1_0.bot.n0 VSS 11.2845f
C6204 oa_sar8_acore18_opt_0.sw_bitcell_opt_b1_0.bot.n1 VSS 21.9163f
C6205 oa_sar8_acore18_opt_0.sw_bitcell_opt_b0_0.bot.t3 VSS 9.6184f
C6206 oa_sar8_acore18_opt_0.sw_bitcell_opt_b0_0.bot.t2 VSS 5.57782f
C6207 oa_sar8_acore18_opt_0.sw_bitcell_opt_b0_0.bot.t0 VSS 5.70351f
C6208 oa_sar8_acore18_opt_0.sw_bitcell_opt_b0_0.bot.n0 VSS 34.3948f
C6209 oa_sar8_acore18_opt_0.sw_bitcell_opt_term_0.bot.t3 VSS 0.80428f
C6210 oa_sar8_acore18_opt_0.sw_bitcell_opt_term_0.bot.t0 VSS 5.31679f
C6211 oa_sar8_acore18_opt_0.sw_bitcell_opt_term_0.bot.t1 VSS 3.28844f
C6212 oa_sar8_acore18_opt_0.sw_bitcell_opt_term_0.bot.n0 VSS 31.445f
C6213 oa_sar8_acore18_opt_0.sw_bitcell_opt_term_0.gb.t1 VSS 1.57798f
C6214 VSS.t283 VSS 0.24823f
C6215 VSS.t26 VSS 0.33097f
C6216 VSS.t287 VSS 0.16548f
C6217 VSS.t895 VSS 0.49167f
C6218 VSS.t279 VSS 0.16548f
C6219 VSS.t10 VSS 0.16548f
C6220 VSS.t554 VSS 1.54688f
C6221 VSS.t901 VSS 0.05913f
C6222 VSS.t107 VSS 1.65103f
C6223 VSS.t519 VSS 0.16548f
C6224 VSS.t322 VSS 0.16548f
C6225 VSS.t448 VSS 0.38796f
C6226 VSS.t587 VSS 0.16548f
C6227 VSS.t293 VSS 0.16548f
C6228 VSS.t222 VSS 0.54356f
C6229 VSS.t672 VSS 0.24823f
C6230 VSS.t20 VSS 0.16548f
C6231 VSS.t175 VSS 0.08274f
C6232 VSS.t54 VSS 0.16548f
C6233 VSS.t1106 VSS 0.07694f
C6234 VSS.t1116 VSS 0.6685f
C6235 VSS.t372 VSS 0.14205f
C6236 VSS.t593 VSS 0.7438f
C6237 VSS.t534 VSS 0.7438f
C6238 VSS.t701 VSS 0.7438f
C6239 VSS.t698 VSS 0.7438f
C6240 VSS.t1120 VSS 0.32503f
C6241 VSS.t1122 VSS 0.18298f
C6242 VSS.t1125 VSS 0.61418f
C6243 VSS.t290 VSS 0.16548f
C6244 VSS.t311 VSS 0.44395f
C6245 VSS.t470 VSS 0.08284f
C6246 VSS.t309 VSS 16.24542f
C6247 VSS.t578 VSS 0.15598f
C6248 VSS.t178 VSS 0.15856f
C6249 VSS.t116 VSS 0.216f
C6250 VSS.t212 VSS 0.28472f
C6251 VSS.t449 VSS 0.31823f
C6252 VSS.t621 VSS 0.02373f
C6253 VSS.t17 VSS 0.17312f
C6254 VSS.t193 VSS 0.24823f
C6255 VSS.t225 VSS 0.2504f
C6256 VSS.t820 VSS 4.3909f
C6257 VSS.t819 VSS 12.47136f
C6258 VSS.t827 VSS 0.38854f
C6259 VSS.t831 VSS 0.12379f
C6260 VSS.t832 VSS 0.12379f
C6261 VSS.t834 VSS 0.08802f
C6262 VSS.t313 VSS 0.29947f
C6263 VSS.t216 VSS 0.06485f
C6264 VSS.t506 VSS 0.31728f
C6265 VSS.t152 VSS 0.34813f
C6266 VSS.t42 VSS 2.10154f
C6267 VSS.t118 VSS 1.74191f
C6268 VSS.t737 VSS 0.62924f
C6269 VSS.t739 VSS 0.5371f
C6270 VSS.t730 VSS 3.75132f
C6271 VSS.t433 VSS 1.11779f
C6272 VSS.t109 VSS 0.57004f
C6273 VSS.t7 VSS 0.08285f
C6274 VSS.t135 VSS 3.20817f
C6275 VSS.t172 VSS 0.68281f
C6276 VSS.t794 VSS 0.68281f
C6277 VSS.t792 VSS 0.42816f
C6278 VSS.t783 VSS 1.89553f
C6279 VSS.t780 VSS 0.47388f
C6280 VSS.t777 VSS 0.47388f
C6281 VSS.t333 VSS 3.41782f
C6282 VSS.t122 VSS 0.31782f
C6283 VSS.t38 VSS 0.30529f
C6284 VSS.t137 VSS 0.3826f
C6285 VSS.t128 VSS 0.6586f
C6286 VSS.t87 VSS 0.6586f
C6287 VSS.t113 VSS 0.09436f
C6288 VSS.t307 VSS 1.13958f
C6289 VSS.t428 VSS 0.27551f
C6290 VSS.t31 VSS 3.90805f
C6291 VSS.t85 VSS 0.13578f
C6292 VSS.t886 VSS 1.22681f
C6293 VSS.t539 VSS 0.2477f
C6294 VSS.t29 VSS 0.16144f
C6295 VSS.t575 VSS 0.08469f
C6296 VSS.t883 VSS 0.94678f
C6297 VSS.t51 VSS 0.38643f
C6298 VSS.t35 VSS 0.37019f
C6299 VSS.t240 VSS 0.01904f
C6300 VSS.t665 VSS 0.3641f
C6301 VSS.t208 VSS 0.3662f
C6302 VSS.t355 VSS 0.02223f
C6303 VSS.t199 VSS 0.15832f
C6304 VSS.t650 VSS 0.35379f
C6305 VSS.t899 VSS 0.58149f
C6306 VSS.t104 VSS 0.56766f
C6307 VSS.t272 VSS 0.90924f
C6308 VSS.t243 VSS 1.34754f
C6309 VSS.t351 VSS 0.62276f
C6310 VSS.t248 VSS 1.14842f
C6311 VSS.t907 VSS 0.05913f
C6312 VSS.t246 VSS 0.05913f
C6313 VSS.t906 VSS 0.05913f
C6314 VSS.t169 VSS 0.44505f
C6315 VSS.t498 VSS 0.61842f
C6316 VSS.t79 VSS 0.73436f
C6317 VSS.t102 VSS 3.06095f
C6318 VSS.t15 VSS 0.2836f
C6319 VSS.t401 VSS 0.06356f
C6320 VSS.t210 VSS 1.26144f
C6321 VSS.t114 VSS 0.1628f
C6322 VSS.t373 VSS 0.83116f
C6323 VSS.t277 VSS 0.35469f
C6324 VSS.t219 VSS 1.2973f
C6325 VSS.t431 VSS 0.59895f
C6326 VSS.t968 VSS 0.31545f
C6327 VSS.t252 VSS 1.00386f
C6328 VSS.t954 VSS 0.09699f
C6329 VSS.t583 VSS 1.1945f
C6330 VSS.t952 VSS 0.85774f
C6331 VSS.t62 VSS 0.31686f
C6332 VSS.t963 VSS 0.21302f
C6333 VSS.t941 VSS 2.20964f
C6334 VSS.t936 VSS 0.78571f
C6335 VSS.t44 VSS 0.163f
C6336 VSS.t979 VSS 2.44961f
C6337 VSS.t95 VSS 0.01048f
C6338 VSS.t1050 VSS 1.10891f
C6339 VSS.t1032 VSS 1.29298f
C6340 VSS.t1034 VSS 0.79459f
C6341 VSS.t1029 VSS 0.36806f
C6342 VSS.t1024 VSS 1.42457f
C6343 VSS.t1027 VSS 1.10417f
C6344 VSS.t1022 VSS 1.81807f
C6345 VSS.t1016 VSS 0.42877f
C6346 VSS.t1017 VSS 0.66713f
C6347 VSS.t1012 VSS 1.06163f
C6348 VSS.t1007 VSS 2.19319f
C6349 VSS.t1081 VSS 2.26116f
C6350 VSS.t1080 VSS 1.96233f
C6351 VSS.t1101 VSS 0.35791f
C6352 VSS.t1083 VSS 0.29883f
C6353 VSS.t1054 VSS 0.82119f
C6354 VSS.t1053 VSS 0.06117f
C6355 VSS.t1059 VSS 0.69227f
C6356 VSS.t532 VSS 0.16548f
C6357 VSS.t23 VSS 0.04137f
C6358 VSS.t48 VSS 1.10891f
C6359 VSS.t194 VSS 2.31777f
C6360 VSS.t260 VSS 2.47977f
C6361 VSS.t654 VSS 0.09547f
C6362 VSS.t92 VSS 0.35698f
C6363 VSS.t635 VSS 0.10967f
C6364 VSS.t33 VSS 0.28566f
C6365 VSS.t13 VSS 0.93733f
C6366 VSS.t206 VSS 0.08274f
C6367 VSS.t943 VSS 0.73654f
C6368 VSS.t946 VSS 1.53347f
C6369 VSS.t948 VSS 0.51116f
C6370 VSS.t75 VSS 0.73426f
C6371 VSS.t341 VSS 0.38845f
C6372 VSS.t1204 VSS 0.73603f
C6373 VSS.t383 VSS 0.76998f
C6374 VSS.t898 VSS 3.90805f
C6375 VSS.t721 VSS 0.25986f
C6376 VSS.t331 VSS 0.14776f
C6377 VSS.t514 VSS 0.24256f
C6378 VSS.t511 VSS 13.67576f
C6379 VSS.t82 VSS 0.16548f
C6380 VSS.t393 VSS 1.10114f
C6381 VSS.t390 VSS 10.3548f
C6382 VSS.t1108 VSS 0.07694f
C6383 VDD.n0 VSS 0.32256f
C6384 VDD.n1 VSS 0.1013f
C6385 VDD.n2 VSS 0.06824f
C6386 VDD.n3 VSS 0.32868f
C6387 VDD.n4 VSS 0.0133f
C6388 VDD.n5 VSS 0.29251f
C6389 VDD.n6 VSS 0.01959f
C6390 VDD.n7 VSS 0.02553f
C6391 VDD.n8 VSS 0.02378f
C6392 VDD.n9 VSS 0.02651f
C6393 VDD.n10 VSS 0.01987f
C6394 VDD.n11 VSS 0.01412f
C6395 VDD.n12 VSS 0.22839f
C6396 VDD.n13 VSS 0.02651f
C6397 VDD.n14 VSS 0.01987f
C6398 VDD.n15 VSS 0.01412f
C6399 VDD.n16 VSS 0.22839f
C6400 VDD.n17 VSS 0.08734f
C6401 VDD.n18 VSS 0.0139f
C6402 VDD.n19 VSS 0.08641f
C6403 VDD.n20 VSS 0.10229f
C6404 VDD.n21 VSS 0.24145f
C6405 VDD.n22 VSS 0.08734f
C6406 VDD.n23 VSS 0.0139f
C6407 VDD.n24 VSS 0.16798f
C6408 VDD.n25 VSS 0.10229f
C6409 VDD.n26 VSS 0.24145f
C6410 VDD.n27 VSS 0.09334f
C6411 VDD.n28 VSS 0.05202f
C6412 VDD.n30 VSS 0.03267f
C6413 VDD.n31 VSS 0.02613f
C6414 VDD.n34 VSS 0.04331f
C6415 VDD.n37 VSS 0.05189f
C6416 VDD.n38 VSS 0.0229f
C6417 VDD.n39 VSS 0.31738f
C6418 VDD.n40 VSS 0.17923f
C6419 VDD.n43 VSS 0.05264f
C6420 VDD.n44 VSS 0.02978f
C6421 VDD.n45 VSS 0.18872f
C6422 VDD.n46 VSS 0.01844f
C6423 VDD.n48 VSS 0.24024f
C6424 VDD.n49 VSS 0.0392f
C6425 VDD.n50 VSS 0.02274f
C6426 VDD.n51 VSS 0.03948f
C6427 VDD.n52 VSS 0.09338f
C6428 VDD.n53 VSS 0.3087f
C6429 VDD.n54 VSS 0.03845f
C6430 VDD.n55 VSS 0.01583f
C6431 VDD.n56 VSS 0.28719f
C6432 VDD.n57 VSS 0.16546f
C6433 VDD.n58 VSS 0.10379f
C6434 VDD.n59 VSS 0.07596f
C6435 VDD.n60 VSS 0.08405f
C6436 VDD.n61 VSS 0.03237f
C6437 VDD.n62 VSS 0.03248f
C6438 VDD.n64 VSS 0.0329f
C6439 VDD.n65 VSS 0.08097f
C6440 VDD.n66 VSS 0.03299f
C6441 VDD.n67 VSS 0.02212f
C6442 VDD.n68 VSS 0.1029f
C6443 VDD.n70 VSS 0.22181f
C6444 VDD.n71 VSS 0.01988f
C6445 VDD.n72 VSS 0.24169f
C6446 VDD.n73 VSS 0.12229f
C6447 VDD.n75 VSS 0.24169f
C6448 VDD.n76 VSS 0.12229f
C6449 VDD.n79 VSS 0.03309f
C6450 VDD.n80 VSS 0.0164f
C6451 VDD.n81 VSS 0.14541f
C6452 VDD.n82 VSS 0.08302f
C6453 VDD.n83 VSS 0.07775f
C6454 VDD.n85 VSS 0.24169f
C6455 VDD.n86 VSS 0.12229f
C6456 VDD.n88 VSS 0.24169f
C6457 VDD.n89 VSS 0.12229f
C6458 VDD.n92 VSS 0.03267f
C6459 VDD.n93 VSS 0.08197f
C6460 VDD.n94 VSS 0.26316f
C6461 VDD.n95 VSS 0.04685f
C6462 VDD.n96 VSS 0.08518f
C6463 VDD.n98 VSS 0.25447f
C6464 VDD.n99 VSS 0.03957f
C6465 VDD.n100 VSS 0.01864f
C6466 VDD.n101 VSS 0.21518f
C6467 VDD.n102 VSS 0.10965f
C6468 VDD.n103 VSS 0.02651f
C6469 VDD.n106 VSS 0.03309f
C6470 VDD.n107 VSS 0.01859f
C6471 VDD.n108 VSS 0.33054f
C6472 VDD.n109 VSS 0.20318f
C6473 VDD.n110 VSS 0.14965f
C6474 VDD.n112 VSS 0.22843f
C6475 VDD.n113 VSS 0.11589f
C6476 VDD.n114 VSS 0.01988f
C6477 VDD.n116 VSS 0.14541f
C6478 VDD.n117 VSS 0.08302f
C6479 VDD.n118 VSS 0.28719f
C6480 VDD.n119 VSS 0.03948f
C6481 VDD.n120 VSS 0.30459f
C6482 VDD.n121 VSS 0.03248f
C6483 VDD.n122 VSS 0.25984f
C6484 VDD.n123 VSS 0.13476f
C6485 VDD.n124 VSS 0.21518f
C6486 VDD.n128 VSS 0.0532f
C6487 VDD.n129 VSS 0.02358f
C6488 VDD.t388 VSS 0.1209f
C6489 VDD.t10 VSS 15.16412f
C6490 VDD.t16 VSS 15.7856f
C6491 VDD.n130 VSS 0.14068f
C6492 VDD.n131 VSS 0.26885f
C6493 VDD.n132 VSS 0.14351f
C6494 VDD.n133 VSS 0.13047f
C6495 VDD.n135 VSS 0.14541f
C6496 VDD.n136 VSS 0.08302f
C6497 VDD.n137 VSS 0.06487f
C6498 VDD.n138 VSS 0.09105f
C6499 VDD.n141 VSS 0.0455f
C6500 VDD.n142 VSS 0.09402f
C6501 VDD.n143 VSS 0.16274f
C6502 VDD.n144 VSS 0.17172f
C6503 VDD.n146 VSS 0.17027f
C6504 VDD.n147 VSS 0.29144f
C6505 VDD.n148 VSS 0.17834f
C6506 VDD.n149 VSS 0.1148f
C6507 VDD.n150 VSS 5.40096f
C6508 VDD.n152 VSS 0.03897f
C6509 VDD.n153 VSS 0.0325f
C6510 VDD.n154 VSS 0.0455f
C6511 VDD.n155 VSS 0.03285f
C6512 VDD.n156 VSS 0.10953f
C6513 VDD.n157 VSS 0.08978f
C6514 VDD.n158 VSS 0.02651f
C6515 VDD.n159 VSS 0.22181f
C6516 VDD.n161 VSS 0.01602f
C6517 VDD.n162 VSS 0.0385f
C6518 VDD.n163 VSS 0.02159f
C6519 VDD.n164 VSS 0.01859f
C6520 VDD.n165 VSS 0.09002f
C6521 VDD.n166 VSS 0.09652f
C6522 VDD.n167 VSS 0.04018f
C6523 VDD.n168 VSS 0.04889f
C6524 VDD.n169 VSS 0.02651f
C6525 VDD.n170 VSS 0.01316f
C6526 VDD.n171 VSS 0.2611f
C6527 VDD.n173 VSS 0.22843f
C6528 VDD.n174 VSS 0.11315f
C6529 VDD.n175 VSS 0.11862f
C6530 VDD.n176 VSS 0.10953f
C6531 VDD.n177 VSS 0.08978f
C6532 VDD.n178 VSS 0.07775f
C6533 VDD.t29 VSS 8.4871f
C6534 VDD.t147 VSS 10.06062f
C6535 VDD.t322 VSS 4.34615f
C6536 VDD.n181 VSS 0.26666f
C6537 VDD.n182 VSS 0.14541f
C6538 VDD.n183 VSS 0.14541f
C6539 VDD.n184 VSS 0.01979f
C6540 VDD.n186 VSS 0.01946f
C6541 VDD.n189 VSS 0.01988f
C6542 VDD.n190 VSS 0.07381f
C6543 VDD.n191 VSS 0.18653f
C6544 VDD.n192 VSS 0.24388f
C6545 VDD.n193 VSS 0.01318f
C6546 VDD.t42 VSS 8.7506f
C6547 VDD.n194 VSS 0.62624f
C6548 VDD.n195 VSS 0.04232f
C6549 VDD.n196 VSS 0.01178f
C6550 VDD.n198 VSS 0.02613f
C6551 VDD.n199 VSS 0.01307f
C6552 VDD.n200 VSS 0.01307f
C6553 VDD.n201 VSS 0.03931f
C6554 VDD.n202 VSS 0.14541f
C6555 VDD.n204 VSS 0.01983f
C6556 VDD.n205 VSS 0.08402f
C6557 VDD.n206 VSS 0.08965f
C6558 VDD.n208 VSS 0.08746f
C6559 VDD.n209 VSS 0.04048f
C6560 VDD.n210 VSS 0.03971f
C6561 VDD.n211 VSS 0.12904f
C6562 VDD.n214 VSS 0.01983f
C6563 VDD.n215 VSS 0.01325f
C6564 VDD.n216 VSS 0.01325f
C6565 VDD.n217 VSS 0.06638f
C6566 VDD.n219 VSS 0.08006f
C6567 VDD.n220 VSS 0.01412f
C6568 VDD.n221 VSS 0.04226f
C6569 VDD.n222 VSS 0.02007f
C6570 VDD.n225 VSS 0.03931f
C6571 VDD.n226 VSS 0.14541f
C6572 VDD.n228 VSS 0.01983f
C6573 VDD.n229 VSS 0.03976f
C6574 VDD.n230 VSS 0.07417f
C6575 VDD.n231 VSS 0.01843f
C6576 VDD.n232 VSS 0.01983f
C6577 VDD.n233 VSS 0.01946f
C6578 VDD.n235 VSS 0.01283f
C6579 VDD.n236 VSS 0.01279f
C6580 VDD.n238 VSS 0.01283f
C6581 VDD.n239 VSS 0.11402f
C6582 VDD.n240 VSS 0.0734f
C6583 VDD.n241 VSS 0.01633f
C6584 VDD.n242 VSS 0.02646f
C6585 VDD.n244 VSS 0.07003f
C6586 VDD.n245 VSS 0.02214f
C6587 VDD.n246 VSS 0.01166f
C6588 VDD.n247 VSS 0.02599f
C6589 VDD.n248 VSS 0.01297f
C6590 VDD.n251 VSS 0.01983f
C6591 VDD.n252 VSS 0.01325f
C6592 VDD.n253 VSS 0.12539f
C6593 VDD.n254 VSS 0.07245f
C6594 VDD.n255 VSS 0.01988f
C6595 VDD.n257 VSS 0.01946f
C6596 VDD.n258 VSS 0.01297f
C6597 VDD.n259 VSS 0.07472f
C6598 VDD.n261 VSS 0.02679f
C6599 VDD.n262 VSS 0.03108f
C6600 VDD.n263 VSS 0.01433f
C6601 VDD.n264 VSS 0.02011f
C6602 VDD.n265 VSS 0.08901f
C6603 VDD.n267 VSS 0.01983f
C6604 VDD.n268 VSS 0.01325f
C6605 VDD.n269 VSS 0.01321f
C6606 VDD.n270 VSS 0.01979f
C6607 VDD.n271 VSS 0.07238f
C6608 VDD.n272 VSS 0.07003f
C6609 VDD.n273 VSS 0.02214f
C6610 VDD.n274 VSS 0.12854f
C6611 VDD.n275 VSS 0.04232f
C6612 VDD.n277 VSS 0.01983f
C6613 VDD.n278 VSS 0.01325f
C6614 VDD.n280 VSS 0.01983f
C6615 VDD.n281 VSS 0.01325f
C6616 VDD.n282 VSS 0.11133f
C6617 VDD.n283 VSS 0.05134f
C6618 VDD.t380 VSS 1.49894f
C6619 VDD.n284 VSS 0.04884f
C6620 VDD.n285 VSS 0.14952f
C6621 VDD.t443 VSS 1.09546f
C6622 VDD.t445 VSS 1.09546f
C6623 VDD.n286 VSS 0.10379f
C6624 VDD.n288 VSS 0.08767f
C6625 VDD.t76 VSS 15.07011f
C6626 VDD.n289 VSS 0.22961f
C6627 VDD.n290 VSS 0.32965f
C6628 VDD.t19 VSS 0.06222f
C6629 VDD.n291 VSS 0.02694f
C6630 VDD.n292 VSS 0.27971f
C6631 VDD.n293 VSS 0.10673f
C6632 VDD.n294 VSS 0.02677f
C6633 VDD.t375 VSS 0.611f
C6634 VDD.t317 VSS 18.19086f
C6635 VDD.t5 VSS 15.00886f
C6636 VDD.n297 VSS 0.13654f
C6637 VDD.n298 VSS 1.06752f
C6638 VDD.t331 VSS 0.27032f
C6639 VDD.n299 VSS 0.22406f
C6640 VDD.t59 VSS 0.35791f
C6641 VDD.t79 VSS 0.6685f
C6642 VDD.n300 VSS 0.83224f
C6643 VDD.t4 VSS 1.79939f
C6644 VDD.n301 VSS 0.27504f
C6645 VDD.t603 VSS 0.83547f
C6646 VDD.t592 VSS 1.31214f
C6647 VDD.n302 VSS 0.13608f
C6648 VDD.n303 VSS 1.06752f
C6649 VDD.t202 VSS 18.40398f
C6650 VDD.t513 VSS 0.4493f
C6651 VDD.t728 VSS 0.19045f
C6652 VDD.t419 VSS 0.91283f
C6653 VDD.t372 VSS 1.66396f
C6654 VDD.n304 VSS 0.70035f
C6655 VDD.n305 VSS 0.88005f
C6656 VDD.t148 VSS 0.85065f
C6657 VDD.n306 VSS 0.16291f
C6658 VDD.t309 VSS 2.04928f
C6659 VDD.n307 VSS 1.06752f
C6660 VDD.t146 VSS 2.16815f
C6661 VDD.n308 VSS 0.01083f
C6662 VDD.t18 VSS 0.0485f
C6663 VDD.n309 VSS 0.73236f
C6664 VDD.t362 VSS 1.00961f
C6665 VDD.t320 VSS 1.27106f
C6666 VDD.t649 VSS 0.45439f
C6667 VDD.n310 VSS 1.06752f
C6668 VDD.t485 VSS 0.14596f
C6669 VDD.t392 VSS 1.76714f
C6670 VDD.t326 VSS 1.86845f
C6671 VDD.n311 VSS 0.17037f
C6672 VDD.t452 VSS 0.31077f
C6673 VDD.t361 VSS 0.75941f
C6674 VDD.n312 VSS 0.06956f
C6675 VDD.t721 VSS 0.77038f
C6676 VDD.t325 VSS 0.69105f
C6677 VDD.t340 VSS 0.82995f
C6678 VDD.t328 VSS 2.04863f
C6679 VDD.n313 VSS 1.06752f
C6680 VDD.n314 VSS 0.34656f
C6681 VDD.n315 VSS 0.23895f
C6682 VDD.t330 VSS 1.05617f
C6683 VDD.n316 VSS 0.19213f
C6684 VDD.t359 VSS 0.46171f
C6685 VDD.t219 VSS 0.03154f
C6686 VDD.t218 VSS 0.82377f
C6687 VDD.t33 VSS 0.08678f
C6688 VDD.t175 VSS 5.31558f
C6689 VDD.t416 VSS 2.12567f
C6690 VDD.t390 VSS 1.48471f
C6691 VDD.t177 VSS 0.19754f
C6692 VDD.n317 VSS 0.82136f
C6693 VDD.t176 VSS 1.37348f
C6694 VDD.n318 VSS 0.96193f
C6695 VDD.t11 VSS 2.90413f
C6696 VDD.t130 VSS 0.02119f
C6697 VDD.t132 VSS 1.79466f
C6698 VDD.n319 VSS 0.14501f
C6699 VDD.t424 VSS 0.36824f
C6700 VDD.n320 VSS 1.04656f
C6701 VDD.n321 VSS 1.72589f
C6702 VDD.n322 VSS 0.66844f
C6703 VDD.n323 VSS 1.72589f
C6704 VDD.t408 VSS 0.218f
C6705 VDD.t692 VSS 0.18469f
C6706 VDD.t407 VSS 1.42787f
C6707 VDD.t349 VSS 1.87512f
C6708 VDD.n324 VSS 0.12615f
C6709 VDD.t6 VSS 0.64822f
C6710 VDD.t13 VSS 2.17062f
C6711 VDD.n325 VSS 1.06752f
C6712 VDD.n326 VSS 1.06752f
C6713 VDD.n327 VSS 1.06752f
C6714 VDD.t71 VSS 0.95474f
C6715 VDD.t68 VSS 1.15614f
C6716 VDD.t157 VSS 0.90751f
C6717 VDD.t562 VSS 1.74059f
C6718 VDD.t163 VSS 0.14251f
C6719 VDD.t501 VSS 1.61689f
C6720 VDD.t114 VSS 0.3855f
C6721 VDD.n328 VSS 0.14368f
C6722 VDD.t100 VSS 1.22863f
C6723 VDD.t2 VSS 1.54589f
C6724 VDD.t1 VSS 1.14511f
C6725 VDD.t156 VSS 1.60127f
C6726 VDD.t154 VSS 0.86768f
C6727 VDD.t0 VSS 14.72805f
C6728 VDD.n329 VSS 1.06752f
C6729 VDD.n330 VSS 1.06752f
C6730 VDD.n331 VSS 1.06752f
C6731 VDD.t858 VSS 0.32479f
C6732 VDD.n332 VSS 0.02363f
C6733 VDD.t231 VSS 0.07313f
C6734 VDD.t259 VSS 0.07161f
C6735 VDD.n334 VSS 0.0315f
C6736 VDD.t1058 VSS 0.12712f
C6737 VDD.t230 VSS 0.02065f
C6738 VDD.n336 VSS 0.02784f
C6739 VDD.n337 VSS 0.03053f
C6740 VDD.t431 VSS 0.69673f
C6741 VDD.t478 VSS 0.02474f
C6742 VDD.n339 VSS 0.04893f
C6743 VDD.n340 VSS 0.01348f
C6744 VDD.t705 VSS 0.02317f
C6745 VDD.n341 VSS 0.03667f
C6746 VDD.t475 VSS 0.39747f
C6747 VDD.n343 VSS 0.01624f
C6748 VDD.t376 VSS 0.02317f
C6749 VDD.n345 VSS 0.03667f
C6750 VDD.n346 VSS 0.01148f
C6751 VDD.t678 VSS 0.34163f
C6752 VDD.t558 VSS 0.11858f
C6753 VDD.n347 VSS 0.05208f
C6754 VDD.t261 VSS 0.01983f
C6755 VDD.n348 VSS 0.05596f
C6756 VDD.t833 VSS 0.12888f
C6757 VDD.n349 VSS 0.06163f
C6758 VDD.t260 VSS 0.02064f
C6759 VDD.n350 VSS 0.03233f
C6760 VDD.n351 VSS 0.01027f
C6761 VDD.t243 VSS 0.02078f
C6762 VDD.t255 VSS 0.06695f
C6763 VDD.n352 VSS 0.05595f
C6764 VDD.n353 VSS 0.06266f
C6765 VDD.n354 VSS 0.01027f
C6766 VDD.t926 VSS 0.16493f
C6767 VDD.t82 VSS 3.18395f
C6768 VDD.n357 VSS 0.15729f
C6769 VDD.t85 VSS 0.35098f
C6770 VDD.t120 VSS 4.67991f
C6771 VDD.n358 VSS 0.43591f
C6772 VDD.t948 VSS 0.02432f
C6773 VDD.t103 VSS 0.02065f
C6774 VDD.n360 VSS 0.03013f
C6775 VDD.t104 VSS 0.02217f
C6776 VDD.n361 VSS 0.09334f
C6777 VDD.t251 VSS 1.6693f
C6778 VDD.n362 VSS 0.07559f
C6779 VDD.t252 VSS 2.19423f
C6780 VDD.n364 VSS 0.08687f
C6781 VDD.n365 VSS 0.03235f
C6782 VDD.t507 VSS 0.02064f
C6783 VDD.n366 VSS 0.03086f
C6784 VDD.t262 VSS 0.02065f
C6785 VDD.n368 VSS 0.0259f
C6786 VDD.n369 VSS 0.01078f
C6787 VDD.t253 VSS 0.54417f
C6788 VDD.n370 VSS 0.0315f
C6789 VDD.t242 VSS 0.02217f
C6790 VDD.n371 VSS 0.08687f
C6791 VDD.t254 VSS 0.06776f
C6792 VDD.n372 VSS 0.0264f
C6793 VDD.n373 VSS 0.03261f
C6794 VDD.t611 VSS 0.81219f
C6795 VDD.t435 VSS 0.126f
C6796 VDD.n375 VSS 0.06171f
C6797 VDD.n376 VSS 0.06103f
C6798 VDD.n377 VSS 1.06752f
C6799 VDD.n378 VSS 1.06752f
C6800 VDD.t553 VSS 0.44129f
C6801 VDD.n379 VSS 1.06752f
C6802 VDD.t289 VSS 0.10183f
C6803 VDD.t258 VSS 0.17369f
C6804 VDD.t201 VSS 0.91948f
C6805 VDD.t319 VSS 2.62807f
C6806 VDD.n380 VSS 1.06752f
C6807 VDD.n381 VSS 1.06752f
C6808 VDD.n382 VSS 0.4082f
C6809 VDD.t233 VSS 0.85065f
C6810 VDD.n383 VSS 1.06752f
C6811 VDD.t394 VSS 1.18124f
C6812 VDD.t343 VSS 0.36426f
C6813 VDD.n384 VSS 0.15546f
C6814 VDD.t561 VSS 0.36375f
C6815 VDD.t342 VSS 0.41245f
C6816 VDD.t345 VSS 1.05773f
C6817 VDD.t150 VSS 0.14451f
C6818 VDD.t77 VSS 0.0744f
C6819 VDD.t97 VSS 0.0744f
C6820 VDD.t121 VSS 7.59884f
C6821 VDD.n385 VSS 2.15518f
C6822 VDD.t329 VSS 1.63313f
C6823 VDD.t3 VSS 14.92645f
C6824 VDD.n386 VSS 18.1775f
C6825 VDD.t582 VSS 1.49894f
C6826 VDD.n387 VSS 0.11312f
C6827 VDD.t951 VSS 1.24227f
C6828 VDD.n388 VSS 0.10251f
C6829 VDD.n389 VSS 0.10024f
C6830 VDD.n390 VSS 0.02404f
C6831 VDD.t716 VSS 1.60161f
C6832 VDD.n391 VSS 0.11576f
C6833 VDD.n392 VSS 0.07021f
C6834 VDD.t609 VSS 1.24227f
C6835 VDD.n393 VSS 0.1068f
C6836 VDD.n394 VSS 0.08703f
C6837 VDD.t635 VSS 1.70428f
C6838 VDD.n395 VSS 0.12473f
C6839 VDD.n396 VSS 0.03964f
C6840 VDD.n397 VSS 0.02646f
C6841 VDD.t608 VSS 1.24227f
C6842 VDD.n398 VSS 0.0962f
C6843 VDD.n399 VSS 0.08418f
C6844 VDD.t990 VSS 1.80694f
C6845 VDD.n400 VSS 0.11092f
C6846 VDD.t953 VSS 1.59795f
C6847 VDD.t698 VSS 1.96094f
C6848 VDD.n401 VSS 0.12494f
C6849 VDD.t780 VSS 1.24227f
C6850 VDD.n402 VSS 0.10606f
C6851 VDD.n403 VSS 0.07811f
C6852 VDD.n404 VSS 0.02779f
C6853 VDD.t383 VSS 2.11494f
C6854 VDD.n405 VSS 0.12792f
C6855 VDD.n406 VSS 0.01414f
C6856 VDD.n407 VSS 0.02646f
C6857 VDD.t518 VSS 1.24227f
C6858 VDD.n408 VSS 0.10655f
C6859 VDD.t756 VSS 2.26895f
C6860 VDD.n409 VSS 0.13617f
C6861 VDD.n410 VSS 0.1288f
C6862 VDD.n411 VSS 0.07021f
C6863 VDD.t778 VSS 1.24227f
C6864 VDD.n412 VSS 0.1068f
C6865 VDD.n413 VSS 0.02585f
C6866 VDD.t685 VSS 2.47428f
C6867 VDD.n414 VSS 0.12102f
C6868 VDD.t779 VSS 1.24227f
C6869 VDD.n415 VSS 0.10251f
C6870 VDD.n416 VSS 0.10024f
C6871 VDD.n417 VSS 0.01946f
C6872 VDD.n418 VSS 0.03222f
C6873 VDD.t337 VSS 2.47428f
C6874 VDD.n419 VSS 0.12045f
C6875 VDD.t519 VSS 1.24227f
C6876 VDD.n420 VSS 0.10528f
C6877 VDD.n421 VSS 0.08396f
C6878 VDD.n422 VSS 0.02129f
C6879 VDD.n423 VSS 0.02124f
C6880 VDD.t955 VSS 2.26895f
C6881 VDD.n424 VSS 0.12273f
C6882 VDD.t670 VSS 1.59818f
C6883 VDD.n425 VSS 0.01379f
C6884 VDD.n426 VSS 0.02595f
C6885 VDD.n427 VSS 0.03614f
C6886 VDD.t467 VSS 2.11494f
C6887 VDD.n428 VSS 0.11664f
C6888 VDD.t882 VSS 1.24227f
C6889 VDD.n429 VSS 0.10163f
C6890 VDD.n430 VSS 0.01974f
C6891 VDD.n431 VSS 0.03052f
C6892 VDD.t495 VSS 1.96094f
C6893 VDD.n432 VSS 0.12075f
C6894 VDD.t881 VSS 1.24227f
C6895 VDD.n433 VSS 0.09799f
C6896 VDD.n434 VSS 0.08195f
C6897 VDD.n435 VSS 0.01212f
C6898 VDD.n436 VSS 0.02011f
C6899 VDD.n437 VSS 0.02668f
C6900 VDD.t540 VSS 1.80694f
C6901 VDD.n438 VSS 0.11202f
C6902 VDD.n439 VSS 0.09493f
C6903 VDD.n440 VSS 0.01983f
C6904 VDD.t610 VSS 1.24227f
C6905 VDD.n441 VSS 0.09064f
C6906 VDD.n442 VSS 0.08195f
C6907 VDD.n443 VSS 0.01993f
C6908 VDD.n444 VSS 0.08653f
C6909 VDD.t456 VSS 1.70428f
C6910 VDD.n445 VSS 0.12261f
C6911 VDD.n446 VSS 0.01546f
C6912 VDD.t777 VSS 1.24227f
C6913 VDD.n447 VSS 0.10431f
C6914 VDD.t1008 VSS 1.60161f
C6915 VDD.n448 VSS 0.07689f
C6916 VDD.n449 VSS 0.02052f
C6917 VDD.n451 VSS 0.10593f
C6918 VDD.t952 VSS 1.24227f
C6919 VDD.n452 VSS 0.09253f
C6920 VDD.n453 VSS 0.08856f
C6921 VDD.t968 VSS 1.49894f
C6922 VDD.n454 VSS 0.11819f
C6923 VDD.t781 VSS 1.24227f
C6924 VDD.n455 VSS 0.09799f
C6925 VDD.n456 VSS 0.08195f
C6926 VDD.n457 VSS 0.07035f
C6927 VDD.n458 VSS 0.0174f
C6928 VDD.t901 VSS 1.49894f
C6929 VDD.n459 VSS 0.11208f
C6930 VDD.n460 VSS 0.01414f
C6931 VDD.n461 VSS 0.02646f
C6932 VDD.t517 VSS 1.24227f
C6933 VDD.n462 VSS 0.09064f
C6934 VDD.n463 VSS 0.30141f
C6935 VDD.t902 VSS 0.25712f
C6936 VDD.t909 VSS 0.09164f
C6937 VDD.n464 VSS 0.20963f
C6938 VDD.n465 VSS 0.22162f
C6939 VDD.n466 VSS 0.04328f
C6940 VDD.n467 VSS 0.56503f
C6941 VDD.n468 VSS 0.23955f
C6942 VDD.n469 VSS 0.23963f
C6943 VDD.t969 VSS 8.97962f
C6944 VDD.t970 VSS 0.09164f
C6945 VDD.n470 VSS 0.20963f
C6946 VDD.n471 VSS 0.1356f
C6947 VDD.n472 VSS 0.14522f
C6948 VDD.n473 VSS 0.26965f
C6949 VDD.t1009 VSS 8.28118f
C6950 VDD.t1010 VSS 0.10559f
C6951 VDD.n474 VSS 0.2211f
C6952 VDD.n475 VSS 0.1426f
C6953 VDD.n476 VSS 0.14522f
C6954 VDD.n477 VSS 0.27665f
C6955 VDD.t457 VSS 7.39175f
C6956 VDD.t458 VSS 0.12195f
C6957 VDD.n478 VSS 0.22787f
C6958 VDD.n479 VSS 0.1496f
C6959 VDD.n480 VSS 0.14522f
C6960 VDD.n481 VSS 0.28365f
C6961 VDD.t541 VSS 0.1324f
C6962 VDD.t542 VSS 7.04175f
C6963 VDD.n482 VSS 0.23575f
C6964 VDD.n483 VSS 0.1566f
C6965 VDD.n484 VSS 0.14522f
C6966 VDD.n485 VSS 0.29415f
C6967 VDD.t496 VSS 7.07499f
C6968 VDD.t497 VSS 0.1614f
C6969 VDD.n486 VSS 0.24716f
C6970 VDD.n487 VSS 0.1671f
C6971 VDD.n488 VSS 0.14522f
C6972 VDD.n489 VSS 0.30465f
C6973 VDD.t468 VSS 7.70074f
C6974 VDD.t469 VSS 0.35642f
C6975 VDD.n490 VSS 0.25919f
C6976 VDD.n491 VSS 0.1776f
C6977 VDD.n492 VSS 0.14522f
C6978 VDD.n493 VSS 0.54304f
C6979 VDD.t956 VSS 0.20328f
C6980 VDD.t957 VSS 0.21067f
C6981 VDD.n494 VSS 0.26605f
C6982 VDD.n495 VSS 0.1881f
C6983 VDD.n496 VSS 0.14522f
C6984 VDD.n497 VSS 0.32915f
C6985 VDD.t338 VSS 0.28716f
C6986 VDD.t339 VSS 0.24471f
C6987 VDD.n498 VSS 0.27623f
C6988 VDD.n499 VSS 0.2021f
C6989 VDD.n500 VSS 0.26379f
C6990 VDD.t776 VSS 2.40785f
C6991 VDD.n501 VSS 3.894f
C6992 VDD.n502 VSS 0.01414f
C6993 VDD.n503 VSS 0.02646f
C6994 VDD.t883 VSS 1.24227f
C6995 VDD.n504 VSS 0.09064f
C6996 VDD.n505 VSS 0.08418f
C6997 VDD.n506 VSS 0.07021f
C6998 VDD.t669 VSS 1.24227f
C6999 VDD.n507 VSS 0.1068f
C7000 VDD.n508 VSS 0.07021f
C7001 VDD.t880 VSS 1.24227f
C7002 VDD.n509 VSS 0.1068f
C7003 VDD.t618 VSS 1.24227f
C7004 VDD.n510 VSS 0.10748f
C7005 VDD.t427 VSS 0.81779f
C7006 VDD.n511 VSS 3.66961f
C7007 VDD.n512 VSS 0.36845f
C7008 VDD.t619 VSS 0.05567f
C7009 VDD.t620 VSS 0.05756f
C7010 VDD.n513 VSS 0.17944f
C7011 VDD.n514 VSS 0.1181f
C7012 VDD.n515 VSS 0.3687f
C7013 VDD.n516 VSS 0.51649f
C7014 VDD.n517 VSS 0.34122f
C7015 VDD.n518 VSS 1.00187f
C7016 VDD.n519 VSS 1.34602f
C7017 VDD.t441 VSS 1.44606f
C7018 VDD.t439 VSS 1.44606f
C7019 VDD.n520 VSS 0.05644f
C7020 VDD.n521 VSS 0.07223f
C7021 VDD.t594 VSS 1.93355f
C7022 VDD.n522 VSS 0.01597f
C7023 VDD.n523 VSS 0.01597f
C7024 VDD.t446 VSS 7.01185f
C7025 VDD.n524 VSS 0.35816f
C7026 VDD.n525 VSS 0.13426f
C7027 VDD.t444 VSS 0.132f
C7028 VDD.n526 VSS 0.17904f
C7029 VDD.n527 VSS 0.34555f
C7030 VDD.t597 VSS 0.08822f
C7031 VDD.t595 VSS 0.09149f
C7032 VDD.n528 VSS 0.21506f
C7033 VDD.n529 VSS 0.33079f
C7034 VDD.t382 VSS 0.08822f
C7035 VDD.t381 VSS 0.1334f
C7036 VDD.n530 VSS 0.21505f
C7037 VDD.n531 VSS 0.33079f
C7038 VDD.n532 VSS 0.11975f
C7039 VDD.t440 VSS 0.132f
C7040 VDD.n533 VSS 0.17904f
C7041 VDD.n534 VSS 0.33102f
C7042 VDD.t442 VSS 0.29964f
C7043 VDD.n535 VSS 0.16504f
C7044 VDD.n536 VSS 1.69155f
C7045 VDD.n537 VSS 2.12303f
C7046 VDD.n538 VSS 0.33064f
C7047 VDD.t686 VSS 1.46463f
C7048 VDD.t687 VSS 0.24471f
C7049 VDD.n539 VSS 0.27623f
C7050 VDD.n540 VSS 0.2021f
C7051 VDD.n541 VSS 0.14522f
C7052 VDD.n542 VSS 0.31515f
C7053 VDD.t757 VSS 0.20328f
C7054 VDD.t758 VSS 0.21102f
C7055 VDD.n543 VSS 0.26571f
C7056 VDD.n544 VSS 0.1881f
C7057 VDD.n545 VSS 0.14522f
C7058 VDD.n546 VSS 0.30465f
C7059 VDD.t384 VSS 6.60859f
C7060 VDD.t385 VSS 0.18507f
C7061 VDD.n547 VSS 0.25887f
C7062 VDD.n548 VSS 0.1776f
C7063 VDD.n549 VSS 0.14522f
C7064 VDD.n550 VSS 0.29415f
C7065 VDD.t699 VSS 0.16762f
C7066 VDD.t700 VSS 0.16168f
C7067 VDD.n551 VSS 0.24688f
C7068 VDD.n552 VSS 0.1671f
C7069 VDD.n553 VSS 0.14522f
C7070 VDD.n554 VSS 0.51178f
C7071 VDD.t991 VSS 0.17915f
C7072 VDD.t992 VSS 0.13778f
C7073 VDD.n555 VSS 0.23552f
C7074 VDD.n556 VSS 0.1566f
C7075 VDD.n557 VSS 0.14522f
C7076 VDD.n558 VSS 0.27665f
C7077 VDD.t636 VSS 6.94315f
C7078 VDD.t637 VSS 0.17839f
C7079 VDD.n559 VSS 0.22766f
C7080 VDD.n560 VSS 0.1496f
C7081 VDD.n561 VSS 0.14522f
C7082 VDD.n562 VSS 0.26965f
C7083 VDD.t717 VSS 1.09554f
C7084 VDD.t718 VSS 0.10577f
C7085 VDD.n563 VSS 0.22093f
C7086 VDD.n564 VSS 0.1426f
C7087 VDD.n565 VSS 0.14522f
C7088 VDD.n566 VSS 0.26265f
C7089 VDD.t583 VSS 10.75444f
C7090 VDD.t584 VSS 0.09178f
C7091 VDD.n567 VSS 0.20949f
C7092 VDD.n568 VSS 0.1356f
C7093 VDD.n569 VSS 0.04101f
C7094 VDD.t671 VSS 1.59806f
C7095 VDD.n570 VSS 0.05138f
C7096 VDD.n571 VSS 0.0196f
C7097 VDD.t904 VSS 1.49894f
C7098 VDD.n572 VSS 0.09844f
C7099 VDD.n573 VSS 0.09044f
C7100 VDD.n574 VSS 0.52125f
C7101 VDD.n575 VSS 0.28785f
C7102 VDD.t905 VSS 0.25712f
C7103 VDD.t907 VSS 0.09178f
C7104 VDD.n576 VSS 0.20949f
C7105 VDD.n577 VSS 0.1356f
C7106 VDD.n578 VSS 0.46967f
C7107 VDD.n579 VSS 2.60513f
C7108 VDD.n580 VSS 67.4524f
.ends
