* PEX produced on Thu Aug 20 07:56:52 PM CEST 2026 using /foss/tools/sak/sak-pex.sh with m=3 and s=1 (extresist threshold=10000 mOhm, minres=1000 mOhm, mindelay=1 ps)
* NGSPICE file created from oa_sar8_core18_final.ext - technology: ihp-sg13g2

.subckt oa_sar8_core18_final track rst_n result[0] result[1] result[2] result[3] result[4]
+ result[5] result[6] result[7] done busy vinp vinn vcm VDD VSS
X0 a_26364_45710# sar_ctrl_async_phys_0.sg13g2_buf_1_13.X.t2 VSS.t231 VSS.t230 sg13_lv_nmos ad=0.187p pd=1.78u as=0.14875p ps=1.16u w=0.55u l=0.13u
X1 oa_sar8_acore18_opt_0.sw_bitcell_opt_b3_1.bot.t0 sar_ctrl_async_phys_0.dac_code_n[3] oa_sar8_acore18_opt_0.sw_bitcell_opt_b7_1.VSS VSS.t389 sg13_lv_nmos ad=0.4095p pd=2.49u as=0.735p ps=4.9u w=2.1u l=0.13u
X2 result[3] a_33464_31388# VDD.t489 VDD.t39 sg13_lv_pmos ad=0.42p pd=2.99u as=0.2114p ps=1.54u w=1.12u l=0.13u
X3 VSS.t22 sar_ctrl_async_phys_0.sg13g2_dfrbpq_1_9.RESET_B a_31540_45434# VSS.t310 sg13_lv_nmos ad=0.1626p pd=1.415u as=60.89999f ps=0.71u w=0.42u l=0.13u
X4 VSS.t60 sar_ctrl_async_phys_0.sg13g2_o21ai_1_1.A2 a_28130_40838# VSS.t1121 sg13_lv_nmos ad=0.1406p pd=1.12u as=0.1406p ps=1.12u w=0.74u l=0.15u
X5 VSS.t343 a_30848_32358# a_30497_32215# VSS.t454 sg13_lv_nmos ad=79.8f pd=0.8u as=0.1428p ps=1.52u w=0.42u l=0.13u
X6 a_31716_38912# sar_ctrl_async_phys_0.sg13g2_buf_1_22.A VDD.t165 VDD.t162 sg13_lv_pmos ad=0.2856p pd=2.36u as=0.2618p ps=1.63u w=0.84u l=0.13u
X7 a_26270_39215# a_26385_39214# VDD.t351 VDD.t162 sg13_lv_pmos ad=0.34p pd=2.68u as=0.2254p ps=1.53u w=1u l=0.5u
X8 oa_sar8_acore18_opt_0.sw_tg_opt_0.bot.t3 oa_sar8_acore18_opt_0.sw_bitcell_opt_b7_0.bot.t94 cap_cmim l=2.14u w=2.14u
X9 VSS.t237 a_26270_39215# sar_ctrl_async_phys_0.sg13g2_dlygate4sd3_1_5.A VSS.t89 sg13_lv_nmos ad=0.1426p pd=1.16u as=0.2516p ps=2.16u w=0.74u l=0.13u
X10 oa_sar8_acore18_opt_0.sw_tg_opt_1.bot.t3 oa_sar8_acore18_opt_0.sw_bitcell_opt_b3_1.bot.t6 cap_cmim l=2.14u w=2.14u
X11 a_31033_35971# a_30676_35928# VDD.t185 VDD.t37 sg13_lv_pmos ad=63f pd=0.72u as=0.1563p ps=1.22u w=0.42u l=0.13u
X12 VSS.t832 VDD.t8 VSS.t66 VSS.t831 sg13_lv_nmos ad=0.1428p pd=1.52u as=0 ps=0 w=0.42u l=1u
X13 a_27354_37436# sar_ctrl_async_phys_0.sg13g2_nor2_1_3.A VDD.t191 VDD.t13 sg13_lv_pmos ad=0.1176p pd=1.33u as=0.4032p ps=2.96u w=1.12u l=0.13u
X14 a_35391_30703# a_34549_30605# a_34132_30944# VDD.t39 sg13_lv_pmos ad=0.2048p pd=1.63u as=0.34p ps=2.68u w=1u l=0.13u
X15 a_31093_39677# sar_ctrl_async_phys_0.sg13g2_dfrbpq_1_0.CLK.t18 VSS.t94 VSS.t294 sg13_lv_nmos ad=0.2516p pd=2.16u as=4.48835p ps=28.62u w=0.74u l=0.13u
X16 sar_ctrl_async_phys_0.cmp_p sar_ctrl_async_phys_0.cmp_n a_26184_21025# VSS.t1170 sg13_lv_nmos ad=0.39p pd=2.39u as=0.7p ps=4.7u w=2u l=0.13u
X17 a_28950_39386# a_29755_38959# a_29210_38916# VDD.t162 sg13_lv_pmos ad=0.1428p pd=1.52u as=79.8f ps=0.8u w=0.42u l=0.13u
X18 a_25820_43020# sar_ctrl_async_phys_0.sg13g2_inv_1_9.Y sar_ctrl_async_phys_0.sg13g2_nor2_1_13.Y VDD.t0 sg13_lv_pmos ad=0.1176p pd=1.33u as=0.3808p ps=2.92u w=1.12u l=0.13u
X19 oa_sar8_acore18_opt_0.sw_tg_opt_1.bot.t3 oa_sar8_acore18_opt_0.sw_bitcell_opt_b7_1.bot.t43 cap_cmim l=2.14u w=2.14u
X20 a_29306_32361# a_29749_32117# a_29689_32529# VDD.t118 sg13_lv_pmos ad=79.8f pd=0.8u as=63f ps=0.72u w=0.42u l=0.13u
X21 oa_sar8_acore18_opt_0.sw_tg_opt_0.bot.t3 oa_sar8_acore18_opt_0.sw_bitcell_opt_b4_0.bot.t14 cap_cmim l=2.14u w=2.14u
X22 a_33652_41528# a_33626_41433# VSS.t20 VSS.t633 sg13_lv_nmos ad=0.2516p pd=2.16u as=0.1626p ps=1.415u w=0.74u l=0.13u
X23 VDD.t114 sar_ctrl_async_phys_0.sg13g2_dfrbpq_1_9.RESET_B a_30678_46946# VDD.t29 sg13_lv_pmos ad=0.36237p pd=2.605u as=79.8f ps=0.8u w=0.42u l=0.13u
X24 VSS.t172 sar_ctrl_async_phys_0.sg13g2_a22oi_1_0.A2 sar_ctrl_async_phys_0.sg13g2_nor2_1_1.Y VSS.t87 sg13_lv_nmos ad=0.2516p pd=2.16u as=0.1406p ps=1.12u w=0.74u l=0.13u
X25 oa_sar8_acore18_opt_0.sw_tg_opt_1.bot.t3 oa_sar8_acore18_opt_0.sw_bitcell_opt_b6_1.bot.t9 cap_cmim l=2.14u w=2.14u
X26 a_29594_43452# a_30037_43495# a_29977_43531# VDD.t0 sg13_lv_pmos ad=79.8f pd=0.8u as=63f ps=0.72u w=0.42u l=0.13u
X27 a_33289_37559# a_32347_37447# a_33087_37797# VDD.t13 sg13_lv_pmos ad=93.45f pd=0.865u as=0.2048p ps=1.63u w=0.42u l=0.13u
X28 VSS.t9 sar_ctrl_async_phys_0.sg13g2_buf_1_2.X a_35814_31813# VSS.t461 sg13_lv_nmos ad=0.1701p pd=1.65u as=37.8f ps=0.6u w=0.42u l=0.13u
X29 a_33248_35382# a_32991_35239# a_33410_35162# VSS.t621 sg13_lv_nmos ad=0.1428p pd=1.52u as=37.8f ps=0.6u w=0.42u l=0.13u
X30 oa_sar8_acore18_opt_0.bstrap_opt_w2_c1200_1.out oa_sar8_acore18_opt_0.bstrap_opt_w2_c1200_1.gb oa_sar8_acore18_opt_0.sw_bitcell_opt_b2_1.bot.t0 VSS.t1092 sg13_lv_nmos ad=0.35p pd=2.7u as=0.195p ps=1.39u w=1u l=0.13u
X31 VSS.t129 VDD.t22 VSS.t129 VSS.t61 sg13_lv_nmos ad=0.1428p pd=1.52u as=0 ps=0 w=0.42u l=1u
X32 oa_sar8_acore18_opt_0.sw_tg_opt_0.bot.t3 oa_sar8_acore18_opt_0.sw_bitcell_opt_b6_0.bot.t15 cap_cmim l=2.14u w=2.14u
X33 oa_sar8_acore18_opt_0.sw_bitcell_opt_b7_0.bot.t0 sar_ctrl_async_phys_0.dac_code[7] oa_sar8_acore18_opt_0.sw_bitcell_opt_term_0.VSS VSS.t121 sg13_lv_nmos ad=0.663p pd=3.79u as=1.19p ps=7.5u w=3.4u l=0.13u
X34 oa_sar8_acore18_opt_0.sw_tg_opt_1.bot.t3 oa_sar8_acore18_opt_0.sw_bitcell_opt_b6_1.bot.t41 cap_cmim l=2.14u w=2.14u
X35 VDD.t339 sar_ctrl_async_phys_0.sg13g2_and2_1_2.X sar_ctrl_async_phys_0.sg13g2_nand3_1_0.Y VDD.t311 sg13_lv_pmos ad=0.2128p pd=1.5u as=0.2128p ps=1.5u w=1.12u l=0.13u
X36 sar_ctrl_async_phys_0.sg13g2_dfrbpq_1_22.D sar_ctrl_async_phys_0.sg13g2_nor2b_1_0.A VSS.t190 VSS.t548 sg13_lv_nmos ad=0.1406p pd=1.12u as=0.2516p ps=2.16u w=0.74u l=0.13u
X37 a_34358_34837# sar_ctrl_async_phys_0.sg13g2_buf_1_2.A VSS.t5 VSS.t458 sg13_lv_nmos ad=37.8f pd=0.6u as=0.1701p ps=1.65u w=0.42u l=0.13u
X38 oa_sar8_acore18_opt_0.sw_tg_opt_1.bot.t3 oa_sar8_acore18_opt_0.sw_bitcell_opt_b7_1.bot.t120 cap_cmim l=2.14u w=2.14u
X39 oa_sar8_acore18_opt_0.sw_bitcell_opt_term_0.gb.t0 VDD.t1090 a_35028_n9612# VSS.t1078 sg13_lv_nmos ad=0.19p pd=1.38u as=0.345p ps=2.69u w=1u l=0.15u
X40 a_35648_33142# a_35391_33261# a_35810_33338# VSS.t152 sg13_lv_nmos ad=0.1428p pd=1.52u as=37.8f ps=0.6u w=0.42u l=0.13u
X41 VSS.t7 a_31328_33870# a_30977_33727# VSS.t126 sg13_lv_nmos ad=79.8f pd=0.8u as=0.1428p ps=1.52u w=0.42u l=0.13u
X42 VDD.t68 VSS.t672 VDD.t68 VDD.t29 sg13_lv_pmos ad=0.19p pd=1.38u as=0 ps=0 w=1u l=1u
X43 a_31348_44247# a_31579_44356# a_31034_44457# VSS.t351 sg13_lv_nmos ad=0.2373p pd=1.97u as=79.8f ps=0.8u w=0.42u l=0.13u
X44 a_30676_40016# a_30650_39921# VSS.t37 VSS.t1289 sg13_lv_nmos ad=0.2516p pd=2.16u as=0.1626p ps=1.415u w=0.74u l=0.13u
X45 oa_sar8_acore18_opt_0.sw_tg_opt_1.bot.t3 oa_sar8_acore18_opt_0.sw_bitcell_opt_b4_1.bot.t17 cap_cmim l=2.14u w=2.14u
X46 a_30650_35892# a_31093_35935# a_31033_35971# VDD.t37 sg13_lv_pmos ad=79.8f pd=0.8u as=63f ps=0.72u w=0.42u l=0.13u
X47 oa_sar8_acore18_opt_0.sw_tg_opt_0.bot.t3 oa_sar8_acore18_opt_0.sw_bitcell_opt_b7_0.bot.t57 cap_cmim l=2.14u w=2.14u
X48 sar_ctrl_async_phys_0.sg13g2_a22oi_1_3.A2 sar_ctrl_async_phys_0.sg13g2_a21oi_1_5.B1 VSS.t123 VSS.t1212 sg13_lv_nmos ad=0.1406p pd=1.12u as=0.2516p ps=2.16u w=0.74u l=0.13u
X49 oa_sar8_acore18_opt_0.sw_tg_opt_1.bot.t3 oa_sar8_acore18_opt_0.sw_bitcell_opt_b5_1.bot.t14 cap_cmim l=2.14u w=2.14u
X50 VDD.t681 sar_ctrl_async_phys_0.dac_code[0] oa_sar8_acore18_opt_0.sw_bitcell_opt_b0_0.bot.t1 VDD.t680 sg13_lv_pmos ad=1.05p pd=6.7u as=0.585p ps=3.39u w=3u l=0.13u
X51 a_31060_44552# a_31579_44356# a_32319_44311# VSS.t352 sg13_lv_nmos ad=0.3473p pd=2.71u as=0.12665p ps=1.145u w=0.74u l=0.13u
X52 VDD.t479 sar_ctrl_async_phys_0.dac_code[2] oa_sar8_acore18_opt_0.sw_bitcell_opt_b2_0.bot.t1 VDD.t478 sg13_lv_pmos ad=1.33p pd=8.3u as=0.741p ps=4.19u w=3.8u l=0.13u
X53 VDD.t230 VSS.t979 VDD.t205 VDD.t118 sg13_lv_pmos ad=0.19p pd=1.38u as=0 ps=0 w=1u l=1u
X54 VDD.t46 VSS.t920 VDD.t46 VDD.t37 sg13_lv_pmos ad=0.34p pd=2.68u as=0 ps=0 w=1u l=1u
X55 a_34069_41189# sar_ctrl_async_phys_0.sg13g2_dfrbpq_1_0.CLK.t22 VDD.t325 VDD.t5 sg13_lv_pmos ad=0.4088p pd=2.97u as=3.62845p ps=23.965u w=1.12u l=0.13u
X56 VSS.t346 VDD.t366 VSS.t346 VSS.t811 sg13_lv_nmos ad=79.8f pd=0.8u as=0 ps=0 w=0.42u l=1u
X57 a_36089_39744# sar_ctrl_async_phys_0.sg13g2_a21oi_1_3.A2 VSS.t166 VSS.t261 sg13_lv_nmos ad=0.1216p pd=1.02u as=0.1331p ps=1.12u w=0.64u l=0.13u
X58 a_29701_36874# sar_ctrl_async_phys_0.sg13g2_nor2_1_7.A VSS.t111 VSS.t155 sg13_lv_nmos ad=0.187p pd=1.78u as=0.18575p ps=1.26u w=0.55u l=0.13u
X59 a_32233_31511# a_31291_31399# a_32031_31749# VDD.t39 sg13_lv_pmos ad=93.45f pd=0.865u as=0.2048p ps=1.63u w=0.42u l=0.13u
X60 VSS.t7 sar_ctrl_async_phys_0.sg13g2_inv_1_5.A sar_ctrl_async_phys_0.sg13g2_inv_1_5.Y VSS.t141 sg13_lv_nmos ad=0.2516p pd=2.16u as=0.2516p ps=2.16u w=0.74u l=0.13u
X61 a_35245_45266# sar_ctrl_async_phys_0.sg13g2_nand2_1_2.B VSS.t174 VSS.t179 sg13_lv_nmos ad=0.187p pd=1.78u as=0.14505p ps=1.15u w=0.55u l=0.13u
X62 a_32319_44311# a_31477_44213# a_31060_44552# VDD.t69 sg13_lv_pmos ad=0.2048p pd=1.63u as=0.34p ps=2.68u w=1u l=0.13u
X63 a_35313_37784# sar_ctrl_async_phys_0.sg13g2_a21oi_1_0.A1.t1 sar_ctrl_async_phys_0.sg13g2_a22oi_1_0.A2 VSS.t118 sg13_lv_nmos ad=0.1406p pd=1.12u as=0.1406p ps=1.12u w=0.74u l=0.13u
X64 VDD.t39 a_35648_30846# a_35593_30941# VDD.t39 sg13_lv_pmos ad=1.96315p pd=12.675u as=93.45f ps=0.865u w=0.42u l=0.13u
X65 VDD.t328 sar_ctrl_async_phys_0.sg13g2_o21ai_1_1.B1 a_31830_40898# VDD.t311 sg13_lv_pmos ad=0.36237p pd=2.605u as=79.8f ps=0.8u w=0.42u l=0.13u
X66 a_31098_43020# sar_ctrl_async_phys_0.sg13g2_nor2b_1_0.A sar_ctrl_async_phys_0.sg13g2_nor2_1_11.A VDD.t0 sg13_lv_pmos ad=0.1176p pd=1.33u as=0.3808p ps=2.92u w=1.12u l=0.13u
X67 VDD.t196 VSS.t160 VDD.t196 VDD.t162 sg13_lv_pmos ad=0.34p pd=2.68u as=0 ps=0 w=1u l=1u
X68 oa_sar8_acore18_opt_0.sw_bitcell_opt_term_0.vin oa_sar8_acore18_opt_0.sw_bitcell_opt_term_0.gb.t7 oa_sar8_acore18_opt_0.sw_bitcell_opt_b2_0.bot.t0 VSS.t209 sg13_lv_nmos ad=0.35p pd=2.7u as=0.195p ps=1.39u w=1u l=0.13u
X69 VDD.t101 a_25596_47222# sar_ctrl_async_phys_0.hold_req VDD.t15 sg13_lv_pmos ad=0.2114p pd=1.54u as=0.42p ps=2.99u w=1.12u l=0.13u
X70 sar_ctrl_async_phys_0.bit_active[6] a_34904_38948# VSS.t50 VSS.t670 sg13_lv_nmos ad=0.2886p pd=2.26u as=0.14875p ps=1.16u w=0.74u l=0.13u
X71 oa_sar8_acore18_opt_0.sw_tg_opt_1.bot.t3 oa_sar8_acore18_opt_0.sw_bitcell_opt_b3_1.bot.t16 cap_cmim l=2.14u w=2.14u
X72 oa_sar8_acore18_opt_0.sw_tg_opt_0.bot.t3 oa_sar8_acore18_opt_0.sw_bitcell_opt_b6_0.bot.t62 cap_cmim l=2.14u w=2.14u
X73 a_35103_43845# a_34261_43495# a_35009_43845# VSS.t537 sg13_lv_nmos ad=0.12665p pd=1.145u as=0.1428p ps=1.52u w=0.42u l=0.13u
X74 oa_sar8_acore18_opt_0.sw_tg_opt_1.bot.t3 oa_sar8_acore18_opt_0.sw_bitcell_opt_b6_1.bot.t74 cap_cmim l=2.14u w=2.14u
X75 VSS.t1049 VDD.t62 VSS.t1048 VSS.t1047 sg13_lv_nmos ad=0.1428p pd=1.52u as=0 ps=0 w=0.42u l=1u
X76 a_35360_43726# sar_ctrl_async_phys_0.sg13g2_dfrbpq_1_9.RESET_B VDD.t485 VDD.t0 sg13_lv_pmos ad=79.8f pd=0.8u as=2.2076p ps=14.4u w=0.42u l=0.13u
X77 oa_sar8_acore18_opt_0.sw_tg_opt_1.bot.t4 oa_sar8_acore18_opt_0.sw_bitcell_opt_b7_1.bot.t9 cap_cmim l=2.14u w=2.14u
X78 VSS.t957 VDD.t254 VSS.t959 VSS.t958 sg13_lv_nmos ad=79.8f pd=0.8u as=0 ps=0 w=0.42u l=1u
X79 a_35280_35365# sar_ctrl_async_phys_0.sg13g2_and2_1_0.B VDD.t447 VDD.t37 sg13_lv_pmos ad=0.1596p pd=1.22u as=0.1918p ps=1.5u w=0.84u l=0.13u
X80 VSS.t672 VDD.t68 VSS.t672 VSS.t700 sg13_lv_nmos ad=0.1428p pd=1.52u as=0 ps=0 w=0.42u l=1u
X81 a_34266_38484# sar_ctrl_async_phys_0.sg13g2_nor2_1_2.A VDD.t247 VDD.t162 sg13_lv_pmos ad=0.1176p pd=1.33u as=0.4032p ps=2.96u w=1.12u l=0.13u
X82 oa_sar8_acore18_opt_0.sw_tg_opt_0.bot.t3 oa_sar8_acore18_opt_0.sw_bitcell_opt_b6_0.bot.t25 cap_cmim l=2.14u w=2.14u
X83 a_32533_40471# sar_ctrl_async_phys_0.sg13g2_dfrbpq_1_0.CLK.t19 VSS.t331 VSS.t1235 sg13_lv_nmos ad=0.2516p pd=2.16u as=4.20675p ps=26.86u w=0.74u l=0.13u
X84 a_31935_39775# a_31093_39677# a_30676_40016# VDD.t311 sg13_lv_pmos ad=0.2048p pd=1.63u as=0.34p ps=2.68u w=1u l=0.13u
X85 oa_sar8_acore18_opt_0.sw_tg_opt_0.bot.t4 oa_sar8_acore18_opt_0.sw_bitcell_opt_b7_0.bot.t15 cap_cmim l=2.14u w=2.14u
X86 sar_ctrl_async_phys_0.dac_code[7] a_36056_38224# VDD.t350 VDD.t162 sg13_lv_pmos ad=0.42p pd=2.99u as=0.2114p ps=1.54u w=1.12u l=0.13u
X87 a_29238_40898# a_30043_40471# a_29498_40428# VDD.t311 sg13_lv_pmos ad=0.1428p pd=1.52u as=79.8f ps=0.8u w=0.42u l=0.13u
X88 VDD.t32 VSS.t129 VDD.t32 VDD.t29 sg13_lv_pmos ad=0.34p pd=2.68u as=0 ps=0 w=1u l=1u
X89 a_35295_36285# a_34453_35935# a_34036_35928# VDD.t37 sg13_lv_pmos ad=0.2048p pd=1.63u as=0.34p ps=2.68u w=1u l=0.13u
X90 VDD.t605 sar_ctrl_async_phys_0.sg13g2_buf_1_6.A a_35952_39901# VDD.t311 sg13_lv_pmos ad=0.2856p pd=2.36u as=0.1596p ps=1.22u w=0.84u l=0.13u
X91 a_29812_40885# a_29524_40464# a_29750_40885# VSS.t290 sg13_lv_nmos ad=0.1428p pd=1.52u as=37.8f ps=0.6u w=0.42u l=0.13u
X92 oa_sar8_acore18_opt_0.sw_tg_opt_0.bot.t3 oa_sar8_acore18_opt_0.sw_bitcell_opt_b7_0.bot.t65 cap_cmim l=2.14u w=2.14u
X93 sar_ctrl_async_phys_0.sg13g2_nor2_1_15.Y sar_ctrl_async_phys_0.sg13g2_nor2b_1_3.Y VSS.t20 VSS.t1214 sg13_lv_nmos ad=0.1406p pd=1.12u as=0.2516p ps=2.16u w=0.74u l=0.13u
X94 VSS.t346 VDD.t36 VSS.t346 VSS.t820 sg13_lv_nmos ad=79.8f pd=0.8u as=0 ps=0 w=0.42u l=1u
X95 oa_sar8_acore18_opt_0.sw_tg_opt_1.bot.t3 oa_sar8_acore18_opt_0.sw_bitcell_opt_b7_1.bot.t78 cap_cmim l=2.14u w=2.14u
X96 result[6] a_36056_32176# VSS.t434 VSS.t1084 sg13_lv_nmos ad=0.2886p pd=2.26u as=0.14875p ps=1.16u w=0.74u l=0.13u
X97 a_34549_32911# sar_ctrl_async_phys_0.sg13g2_dfrbpq_1_0.CLK.t6 VSS.t151 VSS.t555 sg13_lv_nmos ad=0.2516p pd=2.16u as=4.49817p ps=29.795u w=0.74u l=0.13u
X98 a_36156_45710# sar_ctrl_async_phys_0.sg13g2_buf_1_35.A VSS.t174 VSS.t173 sg13_lv_nmos ad=0.187p pd=1.78u as=0.14875p ps=1.16u w=0.55u l=0.13u
X99 oa_sar8_acore18_opt_0.sw_tg_opt_0.bot.t3 oa_sar8_acore18_opt_0.sw_bitcell_opt_b7_0.bot.t107 cap_cmim l=2.14u w=2.14u
X100 VDD.t596 sar_ctrl_async_phys_0.dac_code_n[2] oa_sar8_acore18_opt_0.sw_bitcell_opt_b2_1.bot.t1 VDD.t595 sg13_lv_pmos ad=1.33p pd=8.3u as=0.741p ps=4.19u w=3.8u l=0.13u
X101 oa_sar8_acore18_opt_0.sw_tg_opt_0.bot.t3 oa_sar8_acore18_opt_0.sw_bitcell_opt_b4_0.bot.t2 cap_cmim l=2.14u w=2.14u
X102 VSS.t277 a_28368_36877# sar_ctrl_async_phys_0.sg13g2_nor2_1_7.A VSS.t1136 sg13_lv_nmos ad=0.1331p pd=1.12u as=0.2516p ps=2.16u w=0.74u l=0.13u
X103 oa_sar8_acore18_opt_0.sw_tg_opt_1.bot.t3 oa_sar8_acore18_opt_0.sw_bitcell_opt_b5_1.bot.t1 cap_cmim l=2.14u w=2.14u
X104 VDD.t205 sar_ctrl_async_phys_0.sg13g2_a22oi_1_5.A2 a_30671_32876# VDD.t118 sg13_lv_pmos ad=0.3808p pd=2.92u as=0.2744p ps=1.61u w=1.12u l=0.13u
X105 sar_ctrl_async_phys_0.sg13g2_nor2_1_15.Y sar_ctrl_async_phys_0.sg13g2_a22oi_1_2.A2 a_33114_41508# VDD.t5 sg13_lv_pmos ad=0.3808p pd=2.92u as=0.1176p ps=1.33u w=1.12u l=0.13u
X106 a_30676_40016# a_30650_39921# VDD.t312 VDD.t311 sg13_lv_pmos ad=0.34p pd=2.68u as=0.36237p ps=2.605u w=1u l=0.13u
X107 a_32149_45007# sar_ctrl_async_phys_0.sg13g2_dfrbpq_1_0.CLK VDD.t346 VDD.t69 sg13_lv_pmos ad=0.4088p pd=2.97u as=1.79957p ps=11.62u w=1.12u l=0.13u
X108 a_26454_39702# a_26184_39702# VSS.t237 VSS.t89 sg13_lv_nmos ad=0.1428p pd=1.52u as=79.8f ps=0.8u w=0.42u l=0.5u
X109 VDD.t351 VSS.t144 VDD.t351 VDD.t162 sg13_lv_pmos ad=0.34p pd=2.68u as=0 ps=0 w=1u l=1u
X110 oa_sar8_acore18_opt_0.sw_tg_opt_1.bot.t2 oa_sar8_acore18_opt_0.sw_bitcell_opt_b7_1.bot.t167 cap_cmim l=2.14u w=2.14u
X111 oa_sar8_acore18_opt_0.sw_tg_opt_1.bot.t3 oa_sar8_acore18_opt_0.sw_bitcell_opt_b7_1.bot.t35 cap_cmim l=2.14u w=2.14u
X112 oa_sar8_acore18_opt_0.sw_bitcell_opt_term_1.bot.t0 oa_sar8_acore18_opt_0.sw_bitcell_opt_term_0.trkb.t30 oa_sar8_acore18_opt_0.bstrap_opt_w2_c1200_1.out VDD.t708 sg13_lv_pmos ad=0.39p pd=2.39u as=0.7p ps=4.7u w=2u l=0.13u
X113 sar_ctrl_async_phys_0.sg13g2_dfrbpq_1_1.D a_30830_35166# VSS.t115 VSS.t114 sg13_lv_nmos ad=0.4033p pd=2.57u as=0.148p ps=1.14u w=0.74u l=0.13u
X114 VDD.t139 VSS.t137 VDD.t137 VDD.t0 sg13_lv_pmos ad=0.34p pd=2.68u as=0 ps=0 w=1u l=1u
X115 a_33846_33338# a_34651_32911# a_34106_32868# VDD.t118 sg13_lv_pmos ad=0.1428p pd=1.52u as=79.8f ps=0.8u w=0.42u l=0.13u
X116 VDD.t342 sar_ctrl_async_phys_0.sg13g2_buf_1_2.X a_33846_33338# VDD.t118 sg13_lv_pmos ad=0.36237p pd=2.605u as=79.8f ps=0.8u w=0.42u l=0.13u
X117 VDD.t247 VSS.t857 VDD.t247 VDD.t162 sg13_lv_pmos ad=0.34p pd=2.68u as=0 ps=0 w=1u l=1u
X118 a_30671_33292# sar_ctrl_async_phys_0.sg13g2_a22oi_1_0.B1 VSS.t7 VSS.t10 sg13_lv_nmos ad=0.13875p pd=1.115u as=0.2553p ps=2.17u w=0.74u l=0.13u
X119 a_35360_36894# sar_ctrl_async_phys_0.sg13g2_buf_1_2.A.t2 VDD.t13 VDD.t13 sg13_lv_pmos ad=79.8f pd=0.8u as=2.2076p ps=14.4u w=0.42u l=0.13u
X120 a_29620_32151# a_29332_32456# a_29558_32151# VSS.t1152 sg13_lv_nmos ad=0.1428p pd=1.52u as=37.8f ps=0.6u w=0.42u l=0.13u
X121 oa_sar8_acore18_opt_0.sw_tg_opt_0.bot.t2 oa_sar8_acore18_opt_0.sw_bitcell_opt_b7_0.bot.t152 cap_cmim l=2.14u w=2.14u
X122 VDD.t198 sar_ctrl_async_phys_0.sg13g2_a22oi_1_2.B1 a_31832_34412# VDD.t54 sg13_lv_pmos ad=0.2114p pd=1.54u as=0.2856p ps=2.36u w=0.84u l=0.13u
X123 VSS.t413 oa_sar8_acore18_opt_0.sw_bitcell_opt_term_0.trkb.t8 a_21332_n9711# VSS.t412 sg13_lv_nmos ad=0.345p pd=2.69u as=0.19p ps=1.38u w=1u l=0.15u
X124 oa_sar8_acore18_opt_0.sw_tg_opt_0.bot.t3 oa_sar8_acore18_opt_0.sw_bitcell_opt_b7_0.bot.t47 cap_cmim l=2.14u w=2.14u
X125 a_35402_46878# sar_ctrl_async_phys_0.sg13g2_dfrbpq_1_9.Q VSS.t62 VSS.t91 sg13_lv_nmos ad=0.1406p pd=1.12u as=0.2516p ps=2.16u w=0.74u l=0.13u
X126 VSS.t115 VDD.t38 VSS.t931 VSS.t114 sg13_lv_nmos ad=0.1428p pd=1.52u as=0 ps=0 w=0.42u l=1u
X127 a_35360_43726# a_35103_43845# a_35522_43922# VSS.t321 sg13_lv_nmos ad=0.1428p pd=1.52u as=37.8f ps=0.6u w=0.42u l=0.13u
X128 VDD.t363 a_27134_39887# sar_ctrl_async_phys_0.sg13g2_dlygate4sd3_1_4.X VDD.t311 sg13_lv_pmos ad=0.2254p pd=1.53u as=0.4256p ps=3u w=1.12u l=0.13u
X129 a_31563_43020# sar_ctrl_async_phys_0.sg13g2_a21oi_1_4.B1 sar_ctrl_async_phys_0.sg13g2_a22oi_1_5.A2 VDD.t0 sg13_lv_pmos ad=0.2128p pd=1.5u as=0.3808p ps=2.92u w=1.12u l=0.13u
X130 sar_ctrl_async_phys_0.sg13g2_nand2_1_0.Y sar_ctrl_async_phys_0.sg13g2_nand2_1_0.B VDD.t766 VDD.t13 sg13_lv_pmos ad=0.2128p pd=1.5u as=0.3808p ps=2.92u w=1.12u l=0.13u
X131 a_35391_34773# a_34549_34423# a_34132_34416# VDD.t54 sg13_lv_pmos ad=0.2048p pd=1.63u as=0.34p ps=2.68u w=1u l=0.13u
X132 a_28026_36972# sar_ctrl_async_phys_0.sg13g2_nor2_1_3.Y VDD.t361 VDD.t13 sg13_lv_pmos ad=0.1176p pd=1.33u as=0.4032p ps=2.96u w=1.12u l=0.13u
X133 sar_ctrl_async_phys_0.sg13g2_dlygate4sd3_1_0.X a_28870_35948# VSS.t84 VSS.t634 sg13_lv_nmos ad=0.2516p pd=2.16u as=0.1426p ps=1.16u w=0.74u l=0.13u
X134 oa_sar8_acore18_opt_0.sw_tg_opt_1.bot.t3 oa_sar8_acore18_opt_0.sw_bitcell_opt_b5_1.bot.t1 cap_cmim l=2.14u w=2.14u
X135 sar_ctrl_async_phys_0.sg13g2_a22oi_1_0.Y sar_ctrl_async_phys_0.sg13g2_a22oi_1_0.B1 a_34895_32460# VDD.t118 sg13_lv_pmos ad=0.2128p pd=1.5u as=0.2716p ps=1.605u w=1.12u l=0.13u
X136 sar_ctrl_async_phys_0.dac_code_n[2] a_35288_47296# VDD.t345 VDD.t15 sg13_lv_pmos ad=0.42p pd=2.99u as=0.2114p ps=1.54u w=1.12u l=0.13u
X137 VDD.t415 sar_ctrl_async_phys_0.sg13g2_dfrbpq_1_9.RESET_B a_33654_44234# VDD.t69 sg13_lv_pmos ad=0.36237p pd=2.605u as=79.8f ps=0.8u w=0.42u l=0.13u
X138 VDD.t230 VSS.t1008 VDD.t229 VDD.t118 sg13_lv_pmos ad=0.34p pd=2.68u as=0 ps=0 w=1u l=1u
X139 a_31348_44247# a_31060_44552# a_31286_44247# VSS.t142 sg13_lv_nmos ad=0.1428p pd=1.52u as=37.8f ps=0.6u w=0.42u l=0.13u
X140 a_33440_32358# sar_ctrl_async_phys_0.sg13g2_buf_1_2.X.t0 VDD.t340 VDD.t118 sg13_lv_pmos ad=79.8f pd=0.8u as=1.79957p ps=11.62u w=0.42u l=0.13u
X141 VDD.t46 VSS.t920 VDD.t46 VDD.t37 sg13_lv_pmos ad=0.19p pd=1.38u as=0 ps=0 w=1u l=1u
X142 VDD.t415 sar_ctrl_async_phys_0.sg13g2_nand2_1_3.A sar_ctrl_async_phys_0.sg13g2_a21oi_1_1.B1 VDD.t69 sg13_lv_pmos ad=0.2198p pd=1.53u as=0.2128p ps=1.5u w=1.12u l=0.13u
X143 oa_sar8_acore18_opt_0.sw_tg_opt_0.bot.t3 oa_sar8_acore18_opt_0.sw_bitcell_opt_b6_0.bot.t55 cap_cmim l=2.14u w=2.14u
X144 VDD.t46 VSS.t894 VDD.t46 VDD.t37 sg13_lv_pmos ad=0.19p pd=1.38u as=0 ps=0 w=1u l=1u
X145 oa_sar8_acore18_opt_0.sw_bitcell_opt_b3_0.bot.t1 sar_ctrl_async_phys_0.dac_code[3] VDD.t634 VDD.t632 sg13_lv_pmos ad=0.819p pd=4.59u as=1.47p ps=9.1u w=4.2u l=0.13u
X146 VDD.t547 a_35391_30703# a_36058_30924# VDD.t39 sg13_lv_pmos ad=0.2128p pd=1.5u as=0.3864p ps=2.93u w=1.12u l=0.13u
X147 a_34132_34416# a_34106_34380# VSS.t5 VSS.t1221 sg13_lv_nmos ad=0.2516p pd=2.16u as=0.1626p ps=1.415u w=0.74u l=0.13u
X148 VSS.t887 VDD.t46 VSS.t886 VSS.t885 sg13_lv_nmos ad=0.1428p pd=1.52u as=0 ps=0 w=0.42u l=1u
X149 VDD.t79 VSS.t727 VDD.t97 VDD.t69 sg13_lv_pmos ad=0.34p pd=2.68u as=0 ps=0 w=1u l=1u
X150 sar_ctrl_async_phys_0.sg13g2_nand2b_1_0.A_N sar_ctrl_async_phys_0.sg13g2_nor2_1_12.B a_27738_40460# VDD.t311 sg13_lv_pmos ad=0.3808p pd=2.92u as=0.1176p ps=1.33u w=1.12u l=0.13u
X151 VSS.t182 VDD.t14 VSS.t902 VSS.t901 sg13_lv_nmos ad=0.1428p pd=1.52u as=0 ps=0 w=0.42u l=1u
X152 a_34911_41287# a_34069_41189# a_34817_41287# VSS.t267 sg13_lv_nmos ad=0.12665p pd=1.145u as=0.1428p ps=1.52u w=0.42u l=0.13u
X153 a_33577_40583# a_32635_40471# a_33375_40821# VDD.t311 sg13_lv_pmos ad=93.45f pd=0.865u as=0.2048p ps=1.63u w=0.42u l=0.13u
X154 VSS.t417 a_32192_36166# a_31841_36285# VSS.t371 sg13_lv_nmos ad=79.8f pd=0.8u as=0.1428p ps=1.52u w=0.42u l=0.13u
X155 VDD.t16 VSS.t677 VDD.t16 VDD.t15 sg13_lv_pmos ad=0.34p pd=2.68u as=0 ps=0 w=1u l=1u
X156 a_29332_40898# sar_ctrl_async_phys_0.sg13g2_nor2_1_10.Y a_29238_40898# VSS.t16 sg13_lv_nmos ad=60.89999f pd=0.71u as=0.1428p ps=1.52u w=0.42u l=0.13u
X157 a_29760_36682# a_29701_36874# sar_ctrl_async_phys_0.sg13g2_nand3b_1_0.Y VSS.t379 sg13_lv_nmos ad=0.1406p pd=1.12u as=0.3404p ps=2.4u w=0.74u l=0.13u
X158 oa_sar8_acore18_opt_0.sw_tg_opt_1.bot.t3 oa_sar8_acore18_opt_0.sw_bitcell_opt_b7_1.bot.t131 cap_cmim l=2.14u w=2.14u
X159 VSS.t369 a_31935_39775# a_32602_39996# VSS.t30 sg13_lv_nmos ad=0.1406p pd=1.12u as=0.2516p ps=2.16u w=0.74u l=0.13u
X160 oa_sar8_acore18_opt_0.sw_tg_opt_1.bot.t3 oa_sar8_acore18_opt_0.sw_bitcell_opt_b5_1.bot.t21 cap_cmim l=2.14u w=2.14u
X161 VSS.t62 sar_ctrl_async_phys_0.sg13g2_a21oi_1_1.B1 a_35288_47296# VSS.t61 sg13_lv_nmos ad=0.14875p pd=1.16u as=0.187p ps=1.78u w=0.55u l=0.13u
X162 VSS.t733 VDD.t79 VSS.t733 VSS.t758 sg13_lv_nmos ad=79.8f pd=0.8u as=0 ps=0 w=0.42u l=1u
X163 oa_sar8_acore18_opt_0.sw_tg_opt_1.bot.t3 oa_sar8_acore18_opt_0.sw_bitcell_opt_b7_1.bot.t94 cap_cmim l=2.14u w=2.14u
X164 VSS.t253 a_35456_44454# a_35105_44311# VSS.t252 sg13_lv_nmos ad=79.8f pd=0.8u as=0.1428p ps=1.52u w=0.42u l=0.13u
X165 oa_sar8_acore18_opt_0.sw_tg_opt_0.bot.t4 oa_sar8_acore18_opt_0.sw_bitcell_opt_b7_0.bot.t10 cap_cmim l=2.14u w=2.14u
X166 VSS.t767 VDD.t70 VSS.t768 VSS.t185 sg13_lv_nmos ad=79.8f pd=0.8u as=0 ps=0 w=0.42u l=1u
X167 a_34093_42912# sar_ctrl_async_phys_0.sg13g2_nand2_1_3.B VSS.t123 VSS.t506 sg13_lv_nmos ad=0.187p pd=1.78u as=0.14505p ps=1.15u w=0.55u l=0.13u
X168 oa_sar8_acore18_opt_0.sw_tg_opt_1.bot.t3 oa_sar8_acore18_opt_0.sw_bitcell_opt_b7_1.bot.t25 cap_cmim l=2.14u w=2.14u
X169 a_32192_36166# a_31935_36285# a_32354_36362# VSS.t371 sg13_lv_nmos ad=0.1428p pd=1.52u as=37.8f ps=0.6u w=0.42u l=0.13u
X170 VSS.t845 VDD.t36 VSS.t45 VSS.t628 sg13_lv_nmos ad=79.8f pd=0.8u as=0 ps=0 w=0.42u l=1u
X171 oa_sar8_acore18_opt_0.sw_tg_opt_0.bot.t3 oa_sar8_acore18_opt_0.sw_bitcell_opt_b5_0.bot.t15 cap_cmim l=2.14u w=2.14u
X172 vcm oa_sar8_acore18_opt_0.sw_bitcell_opt_term_0.trkb.t11 oa_sar8_acore18_opt_0.sw_tg_opt_0.bot.t0 VDD.t970 sg13_lv_pmos ad=0.7p pd=4.7u as=0.39p ps=2.39u w=2u l=0.13u
X173 VDD.t244 VSS.t926 VDD.t299 VDD.t54 sg13_lv_pmos ad=0.34p pd=2.68u as=0 ps=0 w=1u l=1u
X174 VSS.t277 sar_ctrl_async_phys_0.sg13g2_dlygate4sd3_1_0.A a_28488_35965# VSS.t302 sg13_lv_nmos ad=79.8f pd=0.8u as=0.1428p ps=1.52u w=0.42u l=0.13u
X175 VSS.t672 VDD.t68 VSS.t672 VSS.t699 sg13_lv_nmos ad=79.8f pd=0.8u as=0 ps=0 w=0.42u l=1u
X176 a_29881_40507# a_29524_40464# VDD.t312 VDD.t311 sg13_lv_pmos ad=63f pd=0.72u as=0.1563p ps=1.22u w=0.42u l=0.13u
X177 sar_ctrl_async_phys_0.sg13g2_nor2b_1_0.A.t0 a_34520_38224# VDD.t350 VDD.t162 sg13_lv_pmos ad=0.42p pd=2.99u as=0.2114p ps=1.54u w=1.12u l=0.13u
X178 a_31828_37440# a_32347_37447# a_33087_37797# VSS.t118 sg13_lv_nmos ad=0.3473p pd=2.71u as=0.12665p ps=1.145u w=0.74u l=0.13u
X179 a_30964_46512# a_31483_46519# a_32223_46869# VSS.t91 sg13_lv_nmos ad=0.3473p pd=2.71u as=0.12665p ps=1.145u w=0.74u l=0.13u
X180 VDD.t191 VSS.t896 VDD.t191 VDD.t13 sg13_lv_pmos ad=0.34p pd=2.68u as=0 ps=0 w=1u l=1u
X181 VSS.t718 VDD.t68 VSS.t717 VSS.t716 sg13_lv_nmos ad=0.1428p pd=1.52u as=0 ps=0 w=0.42u l=1u
X182 a_26184_21025# sar_ctrl_async_phys_0.cmp_n sar_ctrl_async_phys_0.cmp_p VSS.t1170 sg13_lv_nmos ad=0.7p pd=4.7u as=0.39p ps=2.39u w=2u l=0.13u
X183 VSS.t273 sar_ctrl_async_phys_0.sg13g2_buf_1_33.A a_36056_42760# VSS.t400 sg13_lv_nmos ad=0.14875p pd=1.16u as=0.187p ps=1.78u w=0.55u l=0.13u
X184 sar_ctrl_async_phys_0.sg13g2_nor2_1_0.Y sar_ctrl_async_phys_0.sg13g2_nor2_1_0.A VSS.t172 VSS.t1119 sg13_lv_nmos ad=0.1406p pd=1.12u as=0.2516p ps=2.16u w=0.74u l=0.13u
X185 VSS.t403 sar_ctrl_async_phys_0.sg13g2_buf_1_2.A.t3 a_33652_36674# VSS.t402 sg13_lv_nmos ad=0.1626p pd=1.415u as=60.89999f ps=0.71u w=0.42u l=0.13u
X186 a_26394_37436# sar_ctrl_async_phys_0.sg13g2_nor2_1_3.A VDD.t191 VDD.t13 sg13_lv_pmos ad=0.1176p pd=1.33u as=0.4032p ps=2.96u w=1.12u l=0.13u
X187 VSS.t78 a_31477_44213# a_31579_44356# VSS.t77 sg13_lv_nmos ad=4.3785p pd=27.07u as=0.2516p ps=2.16u w=0.74u l=0.13u
X188 VDD.t196 VSS.t144 VDD.t196 VDD.t162 sg13_lv_pmos ad=0.34p pd=2.68u as=0 ps=0 w=1u l=1u
X189 VDD.t343 sar_ctrl_async_phys_0.sg13g2_a21oi_1_7.Y a_31247_32876# VDD.t118 sg13_lv_pmos ad=0.3808p pd=2.92u as=0.2744p ps=1.61u w=1.12u l=0.13u
X190 VSS.t72 VDD.t1 VSS.t72 VSS.t799 sg13_lv_nmos ad=79.8f pd=0.8u as=0 ps=0 w=0.42u l=1u
X191 oa_sar8_acore18_opt_0.sw_tg_opt_1.bot.t3 oa_sar8_acore18_opt_0.sw_bitcell_opt_b7_1.bot.t94 cap_cmim l=2.14u w=2.14u
X192 VDD.t205 VSS.t984 VDD.t205 VDD.t118 sg13_lv_pmos ad=0.19p pd=1.38u as=0 ps=0 w=1u l=1u
X193 a_32406_45746# sar_ctrl_async_phys_0.sg13g2_nor2_1_0.Y VDD.t169 VDD.t29 sg13_lv_pmos ad=79.8f pd=0.8u as=0.1428p ps=1.52u w=0.42u l=0.13u
X194 oa_sar8_acore18_opt_0.sw_tg_opt_1.bot.t3 oa_sar8_acore18_opt_0.sw_bitcell_opt_b6_1.bot.t29 cap_cmim l=2.14u w=2.14u
X195 VDD.t78 VSS.t677 VDD.t128 VDD.t29 sg13_lv_pmos ad=0.19p pd=1.38u as=0 ps=0 w=1u l=1u
X196 a_31247_33292# sar_ctrl_async_phys_0.sg13g2_a22oi_1_0.B1 VSS.t7 VSS.t6 sg13_lv_nmos ad=0.13875p pd=1.115u as=0.2553p ps=2.17u w=0.74u l=0.13u
X197 a_26184_21025# oa_sar8_acore18_opt_0.sw_tg_opt_1.bot.t5 a_28008_23477# VSS.t546 sg13_lv_nmos ad=0.19p pd=1.38u as=0.345p ps=2.69u w=1u l=0.15u
X198 VDD.t77 VSS.t730 VDD.t78 VDD.t29 sg13_lv_pmos ad=0.34p pd=2.68u as=0 ps=0 w=1u l=1u
X199 oa_sar8_acore18_opt_0.sw_tg_opt_0.bot.t3 oa_sar8_acore18_opt_0.sw_bitcell_opt_b6_0.bot.t35 cap_cmim l=2.14u w=2.14u
X200 a_35593_33023# a_34651_32911# a_35391_33261# VDD.t118 sg13_lv_pmos ad=93.45f pd=0.865u as=0.2048p ps=1.63u w=0.42u l=0.13u
X201 oa_sar8_acore18_opt_0.sw_tg_opt_0.bot.t3 oa_sar8_acore18_opt_0.sw_bitcell_opt_b5_0.bot.t25 cap_cmim l=2.14u w=2.14u
X202 a_33675_43020# sar_ctrl_async_phys_0.sg13g2_a21oi_1_5.B1 sar_ctrl_async_phys_0.sg13g2_a22oi_1_3.A2 VDD.t0 sg13_lv_pmos ad=0.2128p pd=1.5u as=0.3808p ps=2.92u w=1.12u l=0.13u
X203 VSS.t606 a_32245_37447# a_32347_37447# VSS.t1168 sg13_lv_nmos ad=9.86937p pd=64.34499u as=0.2516p ps=2.16u w=0.74u l=0.13u
X204 oa_sar8_acore18_opt_0.bstrap_opt_w2_c1200_1.out oa_sar8_acore18_opt_0.bstrap_opt_w2_c1200_1.gb oa_sar8_acore18_opt_0.sw_bitcell_opt_b4_1.bot.t0 VSS.t1094 sg13_lv_nmos ad=0.35p pd=2.7u as=0.195p ps=1.39u w=1u l=0.13u
X205 oa_sar8_acore18_opt_0.sw_bitcell_opt_b0_0.bot.t1 sar_ctrl_async_phys_0.dac_code[0] VDD.t682 VDD.t680 sg13_lv_pmos ad=0.585p pd=3.39u as=1.05p ps=6.7u w=3u l=0.13u
X206 sar_ctrl_async_phys_0.sg13g2_a22oi_1_1.A2 sar_ctrl_async_phys_0.sg13g2_a21oi_1_6.B1 VSS.t346 VSS.t345 sg13_lv_nmos ad=0.1406p pd=1.12u as=0.2516p ps=2.16u w=0.74u l=0.13u
X207 oa_sar8_acore18_opt_0.sw_tg_opt_0.bot.t3 oa_sar8_acore18_opt_0.sw_bitcell_opt_b1_0.bot.t2 cap_cmim l=2.14u w=2.14u
X208 a_21332_n9711# oa_sar8_acore18_opt_0.sw_bitcell_opt_term_0.trkb.t8 VSS.t413 VSS.t412 sg13_lv_nmos ad=0.19p pd=1.38u as=0.345p ps=2.69u w=1u l=0.15u
X209 a_29046_32138# a_29851_32260# a_29306_32361# VDD.t118 sg13_lv_pmos ad=0.1428p pd=1.52u as=79.8f ps=0.8u w=0.42u l=0.13u
X210 oa_sar8_acore18_opt_0.sw_tg_opt_0.bot.t3 oa_sar8_acore18_opt_0.sw_bitcell_opt_b7_0.bot.t78 cap_cmim l=2.14u w=2.14u
X211 oa_sar8_acore18_opt_0.sw_bitcell_opt_b2_0.bot.t1 sar_ctrl_async_phys_0.dac_code[2] VDD.t480 VDD.t478 sg13_lv_pmos ad=0.741p pd=4.19u as=1.33p ps=8.3u w=3.8u l=0.13u
X212 VSS.t69 a_29749_32117# a_29851_32260# VSS.t68 sg13_lv_nmos ad=4.0265p pd=25.31u as=0.2516p ps=2.16u w=0.74u l=0.13u
X213 oa_sar8_acore18_opt_0.sw_tg_opt_1.bot.t3 oa_sar8_acore18_opt_0.sw_bitcell_opt_b1_1.bot.t1 cap_cmim l=2.14u w=2.14u
X214 VSS.t5 sar_ctrl_async_phys_0.sg13g2_a22oi_1_0.B1 sar_ctrl_async_phys_0.sg13g2_buf_1_16.A VSS.t4 sg13_lv_nmos ad=0.2516p pd=2.16u as=0.2516p ps=2.16u w=0.74u l=0.13u
X215 VSS.t94 a_31093_39677# a_31195_39820# VSS.t1087 sg13_lv_nmos ad=5.61045p pd=35.775u as=0.2516p ps=2.16u w=0.74u l=0.13u
X216 sar_ctrl_async_phys_0.dac_code[5] a_36056_38948# VDD.t350 VDD.t162 sg13_lv_pmos ad=0.42p pd=2.99u as=0.2114p ps=1.54u w=1.12u l=0.13u
X217 a_32049_41236# sar_ctrl_async_phys_0.sg13g2_a21oi_1_0.A1 sar_ctrl_async_phys_0.sg13g2_a21oi_1_7.Y VSS.t556 sg13_lv_nmos ad=0.1406p pd=1.12u as=0.1406p ps=1.12u w=0.74u l=0.13u
X218 oa_sar8_acore18_opt_0.sw_tg_opt_0.bot.t3 oa_sar8_acore18_opt_0.sw_bitcell_opt_b7_0.bot.t30 cap_cmim l=2.14u w=2.14u
X219 oa_sar8_acore18_opt_0.sw_tg_opt_1.bot.t3 oa_sar8_acore18_opt_0.sw_bitcell_opt_b6_1.bot.t14 cap_cmim l=2.14u w=2.14u
X220 VSS.t184 sar_ctrl_async_phys_0.sg13g2_buf_1_2.A a_33844_36362# VSS.t450 sg13_lv_nmos ad=0.1626p pd=1.415u as=60.89999f ps=0.71u w=0.42u l=0.13u
X221 a_34093_42912# sar_ctrl_async_phys_0.sg13g2_nand2_1_3.B VDD.t389 VDD.t0 sg13_lv_pmos ad=0.2856p pd=2.36u as=0.2198p ps=1.53u w=0.84u l=0.13u
X222 sar_ctrl_async_phys_0.sg13g2_buf_1_2.X a_35384_32176# VDD.t342 VDD.t118 sg13_lv_pmos ad=0.42p pd=2.99u as=0.2114p ps=1.54u w=1.12u l=0.13u
X223 oa_sar8_acore18_opt_0.sw_tg_opt_1.bot.t3 oa_sar8_acore18_opt_0.sw_bitcell_opt_b6_1.bot.t54 cap_cmim l=2.14u w=2.14u
X224 VDD.t346 a_31477_44213# a_31579_44356# VDD.t69 sg13_lv_pmos ad=1.96315p pd=12.675u as=0.3864p ps=2.93u w=1.12u l=0.13u
X225 VSS.t18 sar_ctrl_async_phys_0.cmp_p a_25496_31388# VSS.t17 sg13_lv_nmos ad=0.14875p pd=1.16u as=0.187p ps=1.78u w=0.55u l=0.13u
X226 VDD.t338 a_35391_34773# a_36058_34412# VDD.t54 sg13_lv_pmos ad=0.2128p pd=1.5u as=0.3864p ps=2.93u w=1.12u l=0.13u
X227 VDD.t312 sar_ctrl_async_phys_0.sg13g2_a21oi_1_0.A1 a_30027_39996# VDD.t311 sg13_lv_pmos ad=0.2128p pd=1.5u as=0.2128p ps=1.5u w=1.12u l=0.13u
X228 oa_sar8_acore18_opt_0.sw_tg_opt_1.bot.t3 oa_sar8_acore18_opt_0.sw_bitcell_opt_b7_1.bot.t52 cap_cmim l=2.14u w=2.14u
X229 VSS.t972 VDD.t227 VSS.t971 VSS.t970 sg13_lv_nmos ad=0.1428p pd=1.52u as=0 ps=0 w=0.42u l=1u
X230 a_33777_42748# sar_ctrl_async_phys_0.sg13g2_a21oi_1_0.A1.t4 sar_ctrl_async_phys_0.sg13g2_a22oi_1_3.A2 VSS.t526 sg13_lv_nmos ad=0.1406p pd=1.12u as=0.1406p ps=1.12u w=0.74u l=0.13u
X231 oa_sar8_acore18_opt_0.sw_tg_opt_0.bot.t3 oa_sar8_acore18_opt_0.sw_bitcell_opt_b5_0.bot.t5 cap_cmim l=2.14u w=2.14u
X232 VSS.t9 sar_ctrl_async_phys_0.sg13g2_buf_1_2.A a_35384_32176# VSS.t1111 sg13_lv_nmos ad=0.14875p pd=1.16u as=0.187p ps=1.78u w=0.55u l=0.13u
X233 oa_sar8_acore18_opt_0.sw_tg_opt_0.bot.t3 oa_sar8_acore18_opt_0.sw_bitcell_opt_b7_0.bot.t62 cap_cmim l=2.14u w=2.14u
X234 VDD.t14 sar_ctrl_async_phys_0.sg13g2_buf_1_13.X sar_ctrl_async_phys_0.sg13g2_nand3b_1_0.Y VDD.t13 sg13_lv_pmos ad=0.2198p pd=1.53u as=0.2128p ps=1.5u w=1.12u l=0.13u
X235 VDD.t14 sar_ctrl_async_phys_0.sg13g2_buf_1_2.A.t6 a_31802_37404# VDD.t13 sg13_lv_pmos ad=0.1563p pd=1.22u as=0.147p ps=1.54u w=0.42u l=0.13u
X236 a_34615_31475# a_34767_31359# VDD.t39 VDD.t39 sg13_lv_pmos ad=0.3864p pd=2.93u as=1.96315p ps=12.675u w=1.12u l=0.13u
X237 VDD.t342 sar_ctrl_async_phys_0.sg13g2_a22oi_1_2.A2 a_33359_32876# VDD.t118 sg13_lv_pmos ad=0.3808p pd=2.92u as=0.2744p ps=1.61u w=1.12u l=0.13u
X238 VDD.t818 a_30495_39309# a_31162_38948# VDD.t162 sg13_lv_pmos ad=0.2128p pd=1.5u as=0.3864p ps=2.93u w=1.12u l=0.13u
X239 VDD.t325 a_34069_41189# a_34171_41332# VDD.t5 sg13_lv_pmos ad=3.62845p pd=23.965u as=0.3864p ps=2.93u w=1.12u l=0.13u
X240 VSS.t123 sar_ctrl_async_phys_0.sg13g2_buf_1_32.A a_34520_42760# VSS.t612 sg13_lv_nmos ad=0.14875p pd=1.16u as=0.187p ps=1.78u w=0.55u l=0.13u
X241 oa_sar8_acore18_opt_0.sw_bitcell_opt_b2_1.bot.t1 sar_ctrl_async_phys_0.dac_code_n[2] VDD.t597 VDD.t595 sg13_lv_pmos ad=0.741p pd=4.19u as=1.33p ps=8.3u w=3.8u l=0.13u
X242 a_31247_32876# sar_ctrl_async_phys_0.sg13g2_buf_1_5.A sar_ctrl_async_phys_0.sg13g2_inv_1_5.A VDD.t118 sg13_lv_pmos ad=0.2744p pd=1.61u as=0.2128p ps=1.5u w=1.12u l=0.13u
X243 a_31830_40898# a_32635_40471# a_32090_40428# VDD.t311 sg13_lv_pmos ad=0.1428p pd=1.52u as=79.8f ps=0.8u w=0.42u l=0.13u
X244 VSS.t626 VDD.t163 VSS.t626 VSS.t871 sg13_lv_nmos ad=0.1428p pd=1.52u as=0 ps=0 w=0.42u l=1u
X245 oa_sar8_acore18_opt_0.sw_tg_opt_0.bot.t3 oa_sar8_acore18_opt_0.sw_bitcell_opt_b7_0.bot.t141 cap_cmim l=2.14u w=2.14u
X246 sar_ctrl_async_phys_0.sg13g2_nor2_1_11.A sar_ctrl_async_phys_0.sg13g2_nor2b_1_0.A VSS.t346 VSS.t547 sg13_lv_nmos ad=0.1406p pd=1.12u as=0.2516p ps=2.16u w=0.74u l=0.13u
X247 a_33948_41936# sar_ctrl_async_phys_0.sg13g2_buf_1_3.A.t2 VDD.t209 VDD.t5 sg13_lv_pmos ad=0.2856p pd=2.36u as=0.2114p ps=1.54u w=0.84u l=0.13u
X248 a_31947_41508# sar_ctrl_async_phys_0.sg13g2_a21oi_1_7.A2 VDD.t209 VDD.t5 sg13_lv_pmos ad=0.3808p pd=2.92u as=0.2128p ps=1.5u w=1.12u l=0.13u
X249 oa_sar8_acore18_opt_0.sw_tg_opt_1.bot.t3 oa_sar8_acore18_opt_0.sw_bitcell_opt_b4_1.bot.t25 cap_cmim l=2.14u w=2.14u
X250 VDD.t42 a_31935_36285# a_32602_35924# VDD.t37 sg13_lv_pmos ad=0.2128p pd=1.5u as=0.3864p ps=2.93u w=1.12u l=0.13u
X251 VDD.t35 sar_ctrl_async_phys_0.sg13g2_nand2_1_2.A sar_ctrl_async_phys_0.sg13g2_buf_1_44.A VDD.t29 sg13_lv_pmos ad=0.3808p pd=2.92u as=0.2128p ps=1.5u w=1.12u l=0.13u
X252 a_33359_33292# sar_ctrl_async_phys_0.sg13g2_a22oi_1_2.B1 VSS.t11 VSS.t6 sg13_lv_nmos ad=0.13875p pd=1.115u as=0.2553p ps=2.17u w=0.74u l=0.13u
X253 VSS.t137 a_29238_41972# a_29350_41996# VSS.t1194 sg13_lv_nmos ad=0.1426p pd=1.16u as=0.1428p ps=1.52u w=0.42u l=0.5u
X254 a_32538_36972# sar_ctrl_async_phys_0.sg13g2_nor2b_1_0.A.t3 sar_ctrl_async_phys_0.sg13g2_nor2_1_0.A VDD.t13 sg13_lv_pmos ad=0.1176p pd=1.33u as=0.3808p ps=2.92u w=1.12u l=0.13u
X255 VDD.t340 a_29749_32117# a_29851_32260# VDD.t118 sg13_lv_pmos ad=1.96315p pd=12.675u as=0.3864p ps=2.93u w=1.12u l=0.13u
X256 VSS.t769 VDD.t133 VSS.t770 VSS.t185 sg13_lv_nmos ad=79.8f pd=0.8u as=0 ps=0 w=0.42u l=1u
X257 a_29750_40885# sar_ctrl_async_phys_0.sg13g2_o21ai_1_1.B1 VSS.t42 VSS.t41 sg13_lv_nmos ad=37.8f pd=0.6u as=0.1701p ps=1.65u w=0.42u l=0.13u
X258 a_29941_40471# sar_ctrl_async_phys_0.sg13g2_dfrbpq_1_0.CLK.t20 VSS.t106 VSS.t105 sg13_lv_nmos ad=0.2516p pd=2.16u as=4.20675p ps=26.86u w=0.74u l=0.13u
X259 VSS.t897 VDD.t191 VSS.t896 VSS.t895 sg13_lv_nmos ad=0.1428p pd=1.52u as=0 ps=0 w=0.42u l=1u
X260 a_34268_31826# a_34055_31352# VDD.t39 VDD.t39 sg13_lv_pmos ad=79.8f pd=0.8u as=1.96315p ps=12.675u w=0.42u l=0.13u
X261 oa_sar8_acore18_opt_0.sw_tg_opt_1.bot.t3 oa_sar8_acore18_opt_0.sw_bitcell_opt_b7_1.bot.t106 cap_cmim l=2.14u w=2.14u
X262 oa_sar8_acore18_opt_0.sw_tg_opt_1.bot.t4 oa_sar8_acore18_opt_0.sw_bitcell_opt_b7_1.bot.t14 cap_cmim l=2.14u w=2.14u
X263 a_35391_34773# a_34549_34423# a_35297_34773# VSS.t199 sg13_lv_nmos ad=0.12665p pd=1.145u as=0.1428p ps=1.52u w=0.42u l=0.13u
X264 a_33530_39921# a_33973_39677# a_33270_39698# VSS.t1129 sg13_lv_nmos ad=79.8f pd=0.8u as=0.1296p ps=1.52u w=0.42u l=0.13u
X265 oa_sar8_acore18_opt_0.sw_tg_opt_0.bot.t3 oa_sar8_acore18_opt_0.sw_bitcell_opt_b6_0.bot.t75 cap_cmim l=2.14u w=2.14u
X266 vcm oa_sar8_acore18_opt_0.sw_bitcell_opt_term_0.trkb.t12 oa_sar8_acore18_opt_0.sw_tg_opt_1.bot.t0 VDD.t709 sg13_lv_pmos ad=0.7p pd=4.7u as=0.39p ps=2.39u w=2u l=0.13u
X267 a_35648_34654# sar_ctrl_async_phys_0.sg13g2_buf_1_2.A VDD.t54 VDD.t54 sg13_lv_pmos ad=79.8f pd=0.8u as=2.2076p ps=14.4u w=0.42u l=0.13u
X268 VSS.t724 VDD.t70 VSS.t722 VSS.t751 sg13_lv_nmos ad=0.1428p pd=1.52u as=0 ps=0 w=0.42u l=1u
X269 a_35072_39918# sar_ctrl_async_phys_0.sg13g2_o21ai_1_1.B1 VDD.t311 VDD.t311 sg13_lv_pmos ad=79.8f pd=0.8u as=1.55472p ps=9.945u w=0.42u l=0.13u
X270 VDD.t198 VSS.t5 VDD.t198 VDD.t54 sg13_lv_pmos ad=0.34p pd=2.68u as=0 ps=0 w=1u l=1u
X271 oa_sar8_acore18_opt_0.sw_tg_opt_1.bot.t3 oa_sar8_acore18_opt_0.sw_bitcell_opt_b6_1.bot.t1 cap_cmim l=2.14u w=2.14u
X272 oa_sar8_acore18_opt_0.sw_tg_opt_0.bot.t3 oa_sar8_acore18_opt_0.sw_bitcell_opt_b6_0.bot.t30 cap_cmim l=2.14u w=2.14u
X273 VDD.t192 VSS.t899 VDD.t192 VDD.t37 sg13_lv_pmos ad=0.19p pd=1.38u as=0 ps=0 w=1u l=1u
X274 VSS.t20 sar_ctrl_async_phys_0.sg13g2_a22oi_1_2.A2 sar_ctrl_async_phys_0.sg13g2_nor2_1_15.Y VSS.t286 sg13_lv_nmos ad=0.2516p pd=2.16u as=0.1406p ps=1.12u w=0.74u l=0.13u
X275 a_28008_23477# oa_sar8_acore18_opt_0.sw_tg_opt_1.bot.t5 a_26184_21025# VSS.t546 sg13_lv_nmos ad=0.345p pd=2.69u as=0.19p ps=1.38u w=1u l=0.15u
X276 VSS.t777 VDD.t100 VSS.t779 VSS.t185 sg13_lv_nmos ad=79.8f pd=0.8u as=0 ps=0 w=0.42u l=1u
X277 a_30879_43845# a_30037_43495# a_30785_43845# VSS.t376 sg13_lv_nmos ad=0.12665p pd=1.145u as=0.1428p ps=1.52u w=0.42u l=0.13u
X278 VSS.t926 VDD.t244 VSS.t926 VSS.t114 sg13_lv_nmos ad=79.8f pd=0.8u as=0 ps=0 w=0.42u l=1u
X279 oa_sar8_acore18_opt_0.sw_tg_opt_0.bot.t3 oa_sar8_acore18_opt_0.sw_bitcell_opt_b7_0.bot.t68 cap_cmim l=2.14u w=2.14u
X280 sar_ctrl_async_phys_0.sg13g2_nand2b_1_1.Y a_35053_40730# VDD.t314 VDD.t311 sg13_lv_pmos ad=0.2128p pd=1.5u as=0.3808p ps=2.92u w=1.12u l=0.13u
X281 VSS.t144 VDD.t354 VSS.t144 VSS.t864 sg13_lv_nmos ad=79.8f pd=0.8u as=0 ps=0 w=0.42u l=1u
X282 a_33183_32215# a_32341_32117# a_33089_32215# VSS.t8 sg13_lv_nmos ad=0.12665p pd=1.145u as=0.1428p ps=1.52u w=0.42u l=0.13u
X283 VSS.t733 VDD.t79 VSS.t730 VSS.t757 sg13_lv_nmos ad=0.1428p pd=1.52u as=0 ps=0 w=0.42u l=1u
X284 VDD.t38 VSS.t926 VDD.t38 VDD.t37 sg13_lv_pmos ad=0.19p pd=1.38u as=0 ps=0 w=1u l=1u
X285 VSS.t770 VDD.t70 VSS.t771 VSS.t185 sg13_lv_nmos ad=79.8f pd=0.8u as=0 ps=0 w=0.42u l=1u
X286 VDD.t44 sar_ctrl_async_phys_0.sg13g2_a22oi_1_5.Y sar_ctrl_async_phys_0.sg13g2_inv_1_6.Y VDD.t39 sg13_lv_pmos ad=0.3808p pd=2.92u as=0.3808p ps=2.92u w=1.12u l=0.13u
X287 a_33652_41528# a_34171_41332# a_34911_41287# VSS.t1103 sg13_lv_nmos ad=0.3473p pd=2.71u as=0.12665p ps=1.145u w=0.74u l=0.13u
X288 a_29977_43531# a_29620_43488# VDD.t139 VDD.t0 sg13_lv_pmos ad=63f pd=0.72u as=0.1563p ps=1.22u w=0.42u l=0.13u
X289 VDD.t622 sar_ctrl_async_phys_0.dac_code[4] oa_sar8_acore18_opt_0.sw_bitcell_opt_b4_0.bot.t1 VDD.t621 sg13_lv_pmos ad=1.68p pd=10.3u as=0.936p ps=5.19u w=4.8u l=0.13u
X290 VDD.t161 VSS.t776 VDD.t146 VDD.t0 sg13_lv_pmos ad=0.19p pd=1.38u as=0 ps=0 w=1u l=1u
X291 VSS.t88 a_35664_37695# sar_ctrl_async_phys_0.sg13g2_buf_1_4.A VSS.t118 sg13_lv_nmos ad=0.1331p pd=1.12u as=0.2516p ps=2.16u w=0.74u l=0.13u
X292 VDD.t38 a_28758_35924# a_28870_35948# VDD.t37 sg13_lv_pmos ad=0.2254p pd=1.53u as=0.34p ps=2.68u w=1u l=0.5u
X293 VDD.t192 sar_ctrl_async_phys_0.sg13g2_dfrbpq_1_0.CLK.t12 a_27624_35965# VDD.t37 sg13_lv_pmos ad=0.1523p pd=1.38u as=0.1428p ps=1.52u w=0.42u l=0.13u
X294 VDD.t14 sar_ctrl_async_phys_0.sg13g2_buf_1_2.A.t6 a_31542_37874# VDD.t13 sg13_lv_pmos ad=0.36237p pd=2.605u as=79.8f ps=0.8u w=0.42u l=0.13u
X295 a_30746_31356# a_31189_31399# a_30486_31826# VSS.t588 sg13_lv_nmos ad=79.8f pd=0.8u as=0.1296p ps=1.52u w=0.42u l=0.13u
X296 a_29558_32151# sar_ctrl_async_phys_0.sg13g2_buf_1_2.X VSS.t464 VSS.t463 sg13_lv_nmos ad=37.8f pd=0.6u as=0.1701p ps=1.65u w=0.42u l=0.13u
X297 a_29812_33968# a_29786_33873# VDD.t55 VDD.t54 sg13_lv_pmos ad=0.34p pd=2.68u as=0.36237p ps=2.605u w=1u l=0.13u
X298 a_29334_43922# sar_ctrl_async_phys_0.sg13g2_nor2_1_11.A VDD.t528 VDD.t0 sg13_lv_pmos ad=79.8f pd=0.8u as=0.1428p ps=1.52u w=0.42u l=0.13u
X299 a_33844_43488# a_33818_43452# VSS.t205 VSS.t204 sg13_lv_nmos ad=0.2516p pd=2.16u as=0.1626p ps=1.415u w=0.74u l=0.13u
X300 oa_sar8_acore18_opt_0.sw_tg_opt_0.bot.t3 oa_sar8_acore18_opt_0.sw_bitcell_opt_b7_0.bot.t25 cap_cmim l=2.14u w=2.14u
X301 oa_sar8_acore18_opt_0.sw_tg_opt_1.bot.t3 oa_sar8_acore18_opt_0.sw_bitcell_opt_b6_1.bot.t61 cap_cmim l=2.14u w=2.14u
X302 a_32137_40013# a_31195_39820# a_31935_39775# VDD.t311 sg13_lv_pmos ad=93.45f pd=0.865u as=0.2048p ps=1.63u w=0.42u l=0.13u
X303 a_32991_45357# a_32149_45007# a_31732_45000# VDD.t69 sg13_lv_pmos ad=0.2048p pd=1.63u as=0.34p ps=2.68u w=1u l=0.13u
X304 sar_ctrl_async_phys_0.sg13g2_nand2b_1_2.Y a_35245_42242# VDD.t450 VDD.t5 sg13_lv_pmos ad=0.2128p pd=1.5u as=0.3808p ps=2.92u w=1.12u l=0.13u
X305 VSS.t54 sar_ctrl_async_phys_0.sg13g2_o21ai_1_1.B1 a_29044_39386# VSS.t53 sg13_lv_nmos ad=0.1626p pd=1.415u as=60.89999f ps=0.71u w=0.42u l=0.13u
X306 VDD.t191 VSS.t144 VDD.t191 VDD.t13 sg13_lv_pmos ad=0.34p pd=2.68u as=0 ps=0 w=1u l=1u
X307 VDD.t323 a_32223_46869# a_32480_46750# VDD.t29 sg13_lv_pmos ad=2.2076p pd=14.4u as=79.8f ps=0.8u w=0.42u l=0.13u
X308 sar_ctrl_async_phys_0.sg13g2_dlygate4sd3_1_0.A a_28006_35948# VDD.t192 VDD.t37 sg13_lv_pmos ad=0.4256p pd=3u as=0.2254p ps=1.53u w=1.12u l=0.13u
X309 VDD.t209 a_32400_41413# sar_ctrl_async_phys_0.sg13g2_and2_1_5.X VDD.t5 sg13_lv_pmos ad=0.1918p pd=1.5u as=0.3808p ps=2.92u w=1.12u l=0.13u
X310 sar_ctrl_async_phys_0.sg13g2_dfrbpq_1_1.D a_30830_35166# VDD.t185 VDD.t37 sg13_lv_pmos ad=0.6048p pd=3.32u as=0.2198p ps=1.52u w=1.12u l=0.13u
X311 sar_ctrl_async_phys_0.dac_code[3] a_36056_42760# VDD.t600 VDD.t0 sg13_lv_pmos ad=0.42p pd=2.99u as=0.2114p ps=1.54u w=1.12u l=0.13u
X312 a_35593_30941# a_34651_30748# a_35391_30703# VDD.t39 sg13_lv_pmos ad=93.45f pd=0.865u as=0.2048p ps=1.63u w=0.42u l=0.13u
X313 VDD.t205 VSS.t981 VDD.t205 VDD.t118 sg13_lv_pmos ad=0.34p pd=2.68u as=0 ps=0 w=1u l=1u
X314 a_31446_35162# sar_ctrl_async_phys_0.sg13g2_dfrbpq_1_1.D VDD.t185 VDD.t37 sg13_lv_pmos ad=79.8f pd=0.8u as=0.1428p ps=1.52u w=0.42u l=0.13u
X315 oa_sar8_acore18_opt_0.sw_tg_opt_0.bot.t3 oa_sar8_acore18_opt_0.sw_bitcell_opt_b7_0.bot.t110 cap_cmim l=2.14u w=2.14u
X316 a_31716_38912# sar_ctrl_async_phys_0.sg13g2_buf_1_22.A VSS.t190 VSS.t196 sg13_lv_nmos ad=0.187p pd=1.78u as=0.17255p ps=1.25u w=0.55u l=0.13u
X317 VDD.t625 sar_ctrl_async_phys_0.sg13g2_buf_1_2.A.t7 sar_ctrl_async_phys_0.sg13g2_nand2_1_0.Y VDD.t13 sg13_lv_pmos ad=0.3808p pd=2.92u as=0.2128p ps=1.5u w=1.12u l=0.13u
X318 oa_sar8_acore18_opt_0.sw_tg_opt_0.bot.t3 oa_sar8_acore18_opt_0.sw_bitcell_opt_b4_0.bot.t20 cap_cmim l=2.14u w=2.14u
X319 oa_sar8_acore18_opt_0.sw_tg_opt_0.bot.t0 oa_sar8_acore18_opt_0.sw_bitcell_opt_term_0.trkb.t11 vcm VDD.t970 sg13_lv_pmos ad=0.39p pd=2.39u as=0.7p ps=4.7u w=2u l=0.13u
X320 VDD.t51 VSS.t684 VDD.t67 VDD.t29 sg13_lv_pmos ad=0.19p pd=1.38u as=0 ps=0 w=1u l=1u
X321 oa_sar8_acore18_opt_0.sw_tg_opt_0.bot.t3 oa_sar8_acore18_opt_0.sw_bitcell_opt_b7_0.bot.t52 cap_cmim l=2.14u w=2.14u
X322 oa_sar8_acore18_opt_0.sw_tg_opt_1.bot.t4 oa_sar8_acore18_opt_0.sw_bitcell_opt_b7_1.bot.t4 cap_cmim l=2.14u w=2.14u
X323 oa_sar8_acore18_opt_0.sw_tg_opt_0.bot.t3 oa_sar8_acore18_opt_0.sw_bitcell_opt_b4_0.bot.t8 cap_cmim l=2.14u w=2.14u
X324 oa_sar8_acore18_opt_0.sw_bitcell_opt_term_0.VSS sar_ctrl_async_phys_0.dac_code[2] oa_sar8_acore18_opt_0.sw_bitcell_opt_b2_0.bot.t0 VSS.t255 sg13_lv_nmos ad=0.665p pd=4.5u as=0.3705p ps=2.29u w=1.9u l=0.13u
X325 a_33940_30626# sar_ctrl_async_phys_0.sg13g2_inv_1_3.Y a_33846_30626# VSS.t1151 sg13_lv_nmos ad=60.89999f pd=0.71u as=0.1428p ps=1.52u w=0.42u l=0.13u
X326 VDD.t350 sar_ctrl_async_phys_0.sg13g2_and2_1_5.X a_34904_38948# VDD.t162 sg13_lv_pmos ad=0.2114p pd=1.54u as=0.2856p ps=2.36u w=0.84u l=0.13u
X327 a_32031_31749# a_31189_31399# a_30772_31392# VDD.t39 sg13_lv_pmos ad=0.2048p pd=1.63u as=0.34p ps=2.68u w=1u l=0.13u
X328 a_33359_32876# sar_ctrl_async_phys_0.sg13g2_buf_1_7.A sar_ctrl_async_phys_0.sg13g2_inv_1_0.A VDD.t118 sg13_lv_pmos ad=0.2744p pd=1.61u as=0.2128p ps=1.5u w=1.12u l=0.13u
X329 VDD.t319 sar_ctrl_async_phys_0.sg13g2_inv_1_10.Y a_28236_40440# VDD.t311 sg13_lv_pmos ad=0.3808p pd=2.92u as=0.2128p ps=1.5u w=1.12u l=0.15u
X330 a_30848_32358# sar_ctrl_async_phys_0.sg13g2_buf_1_2.X VDD.t340 VDD.t118 sg13_lv_pmos ad=79.8f pd=0.8u as=1.79957p ps=11.62u w=0.42u l=0.13u
X331 VDD.t51 VSS.t733 VDD.t81 VDD.t29 sg13_lv_pmos ad=0.34p pd=2.68u as=0 ps=0 w=1u l=1u
X332 a_31823_32876# sar_ctrl_async_phys_0.sg13g2_a22oi_1_1.B2 sar_ctrl_async_phys_0.sg13g2_a22oi_1_1.Y VDD.t118 sg13_lv_pmos ad=0.2744p pd=1.61u as=0.2128p ps=1.5u w=1.12u l=0.13u
X333 a_35648_34654# a_35391_34773# a_35810_34850# VSS.t199 sg13_lv_nmos ad=0.1428p pd=1.52u as=37.8f ps=0.6u w=0.42u l=0.13u
X334 VDD.t312 sar_ctrl_async_phys_0.sg13g2_nand2b_1_0.A_N a_28651_39740# VDD.t311 sg13_lv_pmos ad=0.2198p pd=1.53u as=0.2856p ps=2.36u w=0.84u l=0.13u
X335 oa_sar8_acore18_opt_0.sw_tg_opt_0.bot.t3 oa_sar8_acore18_opt_0.sw_bitcell_opt_b6_0.bot.t10 cap_cmim l=2.14u w=2.14u
X336 a_35659_31435# a_34767_31359# a_35557_31435# VDD.t39 sg13_lv_pmos ad=63f pd=0.72u as=79.8f ps=0.8u w=0.42u l=0.13u
X337 VSS.t343 sar_ctrl_async_phys_0.sg13g2_buf_1_2.X a_30580_31826# VSS.t441 sg13_lv_nmos ad=0.1626p pd=1.415u as=60.89999f ps=0.71u w=0.42u l=0.13u
X338 a_33652_36674# sar_ctrl_async_phys_0.sg13g2_nor2_1_1.A a_33558_36674# VSS.t85 sg13_lv_nmos ad=60.89999f pd=0.71u as=0.1428p ps=1.52u w=0.42u l=0.13u
X339 sar_ctrl_async_phys_0.dac_code_n[5] a_36056_47296# VSS.t75 VSS.t61 sg13_lv_nmos ad=0.2886p pd=2.26u as=0.14875p ps=1.16u w=0.74u l=0.13u
X340 VSS.t784 VDD.t79 VSS.t784 VSS.t785 sg13_lv_nmos ad=0.1428p pd=1.52u as=0 ps=0 w=0.42u l=1u
X341 VDD.t350 sar_ctrl_async_phys_0.sg13g2_buf_1_22.A a_35672_38224# VDD.t162 sg13_lv_pmos ad=0.2114p pd=1.54u as=0.2856p ps=2.36u w=0.84u l=0.13u
X342 oa_sar8_acore18_opt_0.sw_bitcell_opt_term_0.trkb.t3 sar_ctrl_async_phys_0.sample VSS.t241 VSS.t240 sg13_lv_nmos ad=0.195p pd=1.39u as=0.35p ps=2.7u w=1u l=0.13u
X343 sar_ctrl_async_phys_0.sg13g2_nor2_1_2.A sar_ctrl_async_phys_0.sg13g2_a22oi_1_0.A1 VSS.t172 VSS.t118 sg13_lv_nmos ad=0.1406p pd=1.12u as=0.2516p ps=2.16u w=0.74u l=0.13u
X344 oa_sar8_acore18_opt_0.sw_tg_opt_1.bot.t3 oa_sar8_acore18_opt_0.sw_bitcell_opt_b7_1.bot.t141 cap_cmim l=2.14u w=2.14u
X345 a_34489_31017# a_34132_30944# VDD.t573 VDD.t39 sg13_lv_pmos ad=63f pd=0.72u as=0.1563p ps=1.22u w=0.42u l=0.13u
X346 a_31823_33292# sar_ctrl_async_phys_0.sg13g2_a22oi_1_0.B1 VSS.t12 VSS.t6 sg13_lv_nmos ad=0.13875p pd=1.115u as=0.2553p ps=2.17u w=0.74u l=0.13u
X347 VSS.t850 VDD.t196 VSS.t160 VSS.t89 sg13_lv_nmos ad=0.1428p pd=1.52u as=0 ps=0 w=0.42u l=1u
X348 a_32580_43448# sar_ctrl_async_phys_0.sg13g2_buf_1_20.A VDD.t366 VDD.t0 sg13_lv_pmos ad=0.2856p pd=2.36u as=0.2618p ps=1.63u w=0.84u l=0.13u
X349 VDD.t573 sar_ctrl_async_phys_0.sg13g2_buf_1_2.X a_33846_30626# VDD.t39 sg13_lv_pmos ad=0.36237p pd=2.605u as=79.8f ps=0.8u w=0.42u l=0.13u
X350 oa_sar8_acore18_opt_0.sw_tg_opt_0.bot.t3 oa_sar8_acore18_opt_0.sw_bitcell_opt_b6_0.bot.t70 cap_cmim l=2.14u w=2.14u
X351 a_30944_35166# sar_ctrl_async_phys_0.sg13g2_buf_1_0.A a_30830_35166# VSS.t114 sg13_lv_nmos ad=0.3367p pd=1.65u as=0.1628p ps=1.18u w=0.74u l=0.13u
X352 oa_sar8_acore18_opt_0.sw_tg_opt_1.bot.t3 oa_sar8_acore18_opt_0.sw_bitcell_opt_b5_1.bot.t9 cap_cmim l=2.14u w=2.14u
X353 oa_sar8_acore18_opt_0.sw_bitcell_opt_b7_1.VSS sar_ctrl_async_phys_0.hold_req VSS.t217 VSS.t218 sg13_lv_nmos ad=0.39p pd=2.39u as=0.7p ps=4.7u w=2u l=0.13u
X354 sar_ctrl_async_phys_0.sg13g2_dlygate4sd3_1_3.A a_28774_41278# VDD.t186 VDD.t5 sg13_lv_pmos ad=0.4256p pd=3u as=0.2254p ps=1.53u w=1.12u l=0.13u
X355 VSS.t982 VDD.t212 VSS.t984 VSS.t983 sg13_lv_nmos ad=79.8f pd=0.8u as=0 ps=0 w=0.42u l=1u
X356 oa_sar8_acore18_opt_0.sw_tg_opt_1.bot.t3 oa_sar8_acore18_opt_0.sw_bitcell_opt_b7_1.bot.t1 cap_cmim l=2.14u w=2.14u
X357 VSS.t346 VDD.t36 VSS.t346 VSS.t821 sg13_lv_nmos ad=0.1428p pd=1.52u as=0 ps=0 w=0.42u l=1u
X358 a_33558_43922# a_34363_43495# a_33818_43452# VDD.t0 sg13_lv_pmos ad=0.1428p pd=1.52u as=79.8f ps=0.8u w=0.42u l=0.13u
X359 a_32116_40464# a_32090_40428# VDD.t328 VDD.t311 sg13_lv_pmos ad=0.34p pd=2.68u as=0.36237p ps=2.605u w=1u l=0.13u
X360 oa_sar8_acore18_opt_0.sw_tg_opt_0.bot.t3 oa_sar8_acore18_opt_0.sw_bitcell_opt_b5_0.bot.t15 cap_cmim l=2.14u w=2.14u
X361 VDD.t426 sar_ctrl_async_phys_0.sg13g2_buf_1_44.A a_36056_46508# VDD.t29 sg13_lv_pmos ad=0.2114p pd=1.54u as=0.2856p ps=2.36u w=0.84u l=0.13u
X362 a_32521_44549# a_31579_44356# a_32319_44311# VDD.t69 sg13_lv_pmos ad=93.45f pd=0.865u as=0.2048p ps=1.63u w=0.42u l=0.13u
X363 a_34201_37065# a_33844_36992# VDD.t500 VDD.t13 sg13_lv_pmos ad=63f pd=0.72u as=0.1563p ps=1.22u w=0.42u l=0.13u
X364 a_32715_43020# sar_ctrl_async_phys_0.sg13g2_a21oi_1_6.B1 sar_ctrl_async_phys_0.sg13g2_a22oi_1_1.A2 VDD.t0 sg13_lv_pmos ad=0.2128p pd=1.5u as=0.3808p ps=2.92u w=1.12u l=0.13u
X365 oa_sar8_acore18_opt_0.sw_tg_opt_0.bot.t3 oa_sar8_acore18_opt_0.sw_bitcell_opt_b6_0.bot.t55 cap_cmim l=2.14u w=2.14u
X366 VSS.t977 VDD.t230 VSS.t979 VSS.t978 sg13_lv_nmos ad=79.8f pd=0.8u as=0 ps=0 w=0.42u l=1u
X367 VSS.t178 sar_ctrl_async_phys_0.sg13g2_nand2_1_3.A a_35327_42342# VSS.t652 sg13_lv_nmos ad=0.14505p pd=1.15u as=0.1406p ps=1.12u w=0.74u l=0.13u
X368 a_25878_40460# a_25608_40501# VSS.t66 VSS.t334 sg13_lv_nmos ad=0.1428p pd=1.52u as=79.8f ps=0.8u w=0.42u l=0.5u
X369 a_31060_31813# a_30772_31392# a_30998_31813# VSS.t1181 sg13_lv_nmos ad=0.1428p pd=1.52u as=37.8f ps=0.6u w=0.42u l=0.13u
X370 sar_ctrl_async_phys_0.sg13g2_buf_1_6.A a_35288_38224# VSS.t88 VSS.t87 sg13_lv_nmos ad=0.2886p pd=2.26u as=0.14875p ps=1.16u w=0.74u l=0.13u
X371 sar_ctrl_async_phys_0.sg13g2_inv_1_2.A sar_ctrl_async_phys_0.sg13g2_buf_1_8.A a_34319_32120# VSS.t8 sg13_lv_nmos ad=0.2664p pd=1.46u as=0.13875p ps=1.115u w=0.74u l=0.13u
X372 VSS.t60 sar_ctrl_async_phys_0.sg13g2_nor2_1_12.B sar_ctrl_async_phys_0.sg13g2_nand2b_1_0.A_N VSS.t492 sg13_lv_nmos ad=0.2516p pd=2.16u as=0.1406p ps=1.12u w=0.74u l=0.13u
X373 VDD.t238 VSS.t974 VDD.t237 VDD.t54 sg13_lv_pmos ad=0.19p pd=1.38u as=0 ps=0 w=1u l=1u
X374 a_26681_38232# sar_ctrl_async_phys_0.sg13g2_buf_1_26.X VSS.t144 VSS.t146 sg13_lv_nmos ad=0.1216p pd=1.02u as=0.1331p ps=1.12u w=0.64u l=0.13u
X375 oa_sar8_acore18_opt_0.sw_tg_opt_1.bot.t3 oa_sar8_acore18_opt_0.sw_bitcell_opt_b5_1.bot.t21 cap_cmim l=2.14u w=2.14u
X376 sar_ctrl_async_phys_0.dac_code_n[0] a_34904_47296# VDD.t345 VDD.t15 sg13_lv_pmos ad=0.42p pd=2.99u as=0.2114p ps=1.54u w=1.12u l=0.13u
X377 VSS.t27 a_34596_40424# sar_ctrl_async_phys_0.sg13g2_nor2b_1_3.Y VSS.t74 sg13_lv_nmos ad=0.17255p pd=1.25u as=0.1406p ps=1.12u w=0.74u l=0.13u
X378 oa_sar8_acore18_opt_0.sw_tg_opt_1.bot.t3 oa_sar8_acore18_opt_0.sw_bitcell_opt_b7_1.bot.t99 cap_cmim l=2.14u w=2.14u
X379 VSS.t672 VDD.t101 VSS.t672 VSS.t673 sg13_lv_nmos ad=79.8f pd=0.8u as=0 ps=0 w=0.42u l=1u
X380 VDD.t187 a_29238_41972# a_29350_41996# VDD.t5 sg13_lv_pmos ad=0.2254p pd=1.53u as=0.34p ps=2.68u w=1u l=0.5u
X381 VSS.t125 a_32341_32117# a_32443_32260# VSS.t124 sg13_lv_nmos ad=4.0265p pd=25.31u as=0.2516p ps=2.16u w=0.74u l=0.13u
X382 a_29620_33650# sar_ctrl_async_phys_0.sg13g2_inv_1_5.Y a_29526_33650# VSS.t187 sg13_lv_nmos ad=60.89999f pd=0.71u as=0.1428p ps=1.52u w=0.42u l=0.13u
X383 sar_ctrl_async_phys_0.sg13g2_nor2_1_3.A a_25496_34412# VDD.t254 VDD.t54 sg13_lv_pmos ad=0.42p pd=2.99u as=0.2114p ps=1.54u w=1.12u l=0.13u
X384 VDD.t361 VSS.t144 VDD.t361 VDD.t13 sg13_lv_pmos ad=0.34p pd=2.68u as=0 ps=0 w=1u l=1u
X385 VDD.t247 VSS.t172 VDD.t247 VDD.t162 sg13_lv_pmos ad=0.34p pd=2.68u as=0 ps=0 w=1u l=1u
X386 oa_sar8_acore18_opt_0.sw_tg_opt_0.bot.t4 oa_sar8_acore18_opt_0.sw_bitcell_opt_b7_0.bot.t15 cap_cmim l=2.14u w=2.14u
X387 oa_sar8_acore18_opt_0.sw_tg_opt_1.bot.t3 oa_sar8_acore18_opt_0.sw_bitcell_opt_b6_1.bot.t34 cap_cmim l=2.14u w=2.14u
X388 sar_ctrl_async_phys_0.bit_active[1] a_36056_33688# VSS.t64 VSS.t63 sg13_lv_nmos ad=0.2886p pd=2.26u as=0.14875p ps=1.16u w=0.74u l=0.13u
X389 VSS.t205 sar_ctrl_async_phys_0.sg13g2_dfrbpq_1_9.RESET_B a_33748_44234# VSS.t315 sg13_lv_nmos ad=0.1626p pd=1.415u as=60.89999f ps=0.71u w=0.42u l=0.13u
X390 VDD.t1021 sar_ctrl_async_phys_0.dac_code_n[7] oa_sar8_acore18_opt_0.sw_bitcell_opt_b7_1.bot.t169 VDD.t1020 sg13_lv_pmos ad=2.38p pd=14.3u as=1.326p ps=7.19u w=6.8u l=0.13u
X391 VSS.t926 VDD.t192 VSS.t926 VSS.t114 sg13_lv_nmos ad=0.1428p pd=1.52u as=0 ps=0 w=0.42u l=1u
X392 a_32020_45421# a_31732_45000# a_31958_45421# VSS.t599 sg13_lv_nmos ad=0.1428p pd=1.52u as=37.8f ps=0.6u w=0.42u l=0.13u
X393 a_25596_41174# sar_ctrl_async_phys_0.sg13g2_nor4_1_0.Y VSS.t354 VSS.t353 sg13_lv_nmos ad=0.187p pd=1.78u as=0.14875p ps=1.16u w=0.55u l=0.13u
X394 a_31898_32361# a_32341_32117# a_32281_32529# VDD.t118 sg13_lv_pmos ad=79.8f pd=0.8u as=63f ps=0.72u w=0.42u l=0.13u
X395 a_33844_36362# sar_ctrl_async_phys_0.sg13g2_nor2_1_2.A a_33750_36362# VSS.t371 sg13_lv_nmos ad=60.89999f pd=0.71u as=0.1428p ps=1.52u w=0.42u l=0.13u
X396 VDD.t366 sar_ctrl_async_phys_0.sg13g2_a21oi_1_0.A1.t4 a_33675_43020# VDD.t0 sg13_lv_pmos ad=0.2128p pd=1.5u as=0.2128p ps=1.5u w=1.12u l=0.13u
X397 VSS.t123 a_33276_42686# sar_ctrl_async_phys_0.sg13g2_buf_1_35.A VSS.t491 sg13_lv_nmos ad=0.14875p pd=1.16u as=0.2886p ps=2.26u w=0.74u l=0.13u
X398 VSS.t40 sar_ctrl_async_phys_0.sg13g2_o21ai_1_1.B1 a_33364_39698# VSS.t39 sg13_lv_nmos ad=0.1626p pd=1.415u as=60.89999f ps=0.71u w=0.42u l=0.13u
X399 VDD.t600 sar_ctrl_async_phys_0.sg13g2_nand2_1_2.Y a_35672_42760# VDD.t0 sg13_lv_pmos ad=0.2114p pd=1.54u as=0.2856p ps=2.36u w=0.84u l=0.13u
X400 a_32817_42748# sar_ctrl_async_phys_0.sg13g2_a21oi_1_0.A1.t5 sar_ctrl_async_phys_0.sg13g2_a22oi_1_1.A2 VSS.t96 sg13_lv_nmos ad=0.1406p pd=1.12u as=0.1406p ps=1.12u w=0.74u l=0.13u
X401 VSS.t858 VDD.t247 VSS.t857 VSS.t856 sg13_lv_nmos ad=0.1428p pd=1.52u as=0 ps=0 w=0.42u l=1u
X402 sar_ctrl_async_phys_0.dac_code[1] a_34520_42760# VDD.t389 VDD.t0 sg13_lv_pmos ad=0.42p pd=2.99u as=0.2114p ps=1.54u w=1.12u l=0.13u
X403 a_33210_36972# sar_ctrl_async_phys_0.sg13g2_nor2b_1_0.A.t2 sar_ctrl_async_phys_0.sg13g2_nor2_1_1.A VDD.t13 sg13_lv_pmos ad=0.1176p pd=1.33u as=0.3808p ps=2.92u w=1.12u l=0.13u
X404 VDD.t345 sar_ctrl_async_phys_0.sg13g2_a21oi_1_5.B1 a_34904_47296# VDD.t15 sg13_lv_pmos ad=0.2114p pd=1.54u as=0.2856p ps=2.36u w=0.84u l=0.13u
X405 VDD.t54 a_31071_33727# a_31328_33870# VDD.t54 sg13_lv_pmos ad=2.2076p pd=14.4u as=79.8f ps=0.8u w=0.42u l=0.13u
X406 VDD.t323 a_33951_45823# a_34208_45966# VDD.t29 sg13_lv_pmos ad=2.2076p pd=14.4u as=79.8f ps=0.8u w=0.42u l=0.13u
X407 VDD.t415 sar_ctrl_async_phys_0.sg13g2_nand2_1_3.A sar_ctrl_async_phys_0.sg13g2_a21oi_1_6.B1 VDD.t69 sg13_lv_pmos ad=0.2198p pd=1.53u as=0.2128p ps=1.5u w=1.12u l=0.13u
X408 sar_ctrl_async_phys_0.sg13g2_nor2_1_12.A sar_ctrl_async_phys_0.sg13g2_o21ai_1_1.B1 VDD.t319 VDD.t311 sg13_lv_pmos ad=0.2128p pd=1.5u as=0.3808p ps=2.92u w=1.12u l=0.15u
X409 VSS.t920 VDD.t54 VSS.t920 VSS.t114 sg13_lv_nmos ad=0.1428p pd=1.52u as=0 ps=0 w=0.42u l=1u
X410 VSS.t72 sar_ctrl_async_phys_0.sg13g2_buf_1_13.X.t1 sar_ctrl_async_phys_0.sg13g2_nor2_1_13.Y VSS.t232 sg13_lv_nmos ad=0.2516p pd=2.16u as=0.1406p ps=1.12u w=0.74u l=0.13u
X411 a_30914_39386# sar_ctrl_async_phys_0.sg13g2_o21ai_1_1.B1 VSS.t37 VSS.t38 sg13_lv_nmos ad=37.8f pd=0.6u as=79.8f ps=0.8u w=0.42u l=0.13u
X412 oa_sar8_acore18_opt_0.sw_tg_opt_0.bot.t3 oa_sar8_acore18_opt_0.sw_bitcell_opt_b3_0.bot.t4 cap_cmim l=2.14u w=2.14u
X413 sar_ctrl_async_phys_0.sg13g2_a21oi_1_1.Y sar_ctrl_async_phys_0.sg13g2_a21oi_1_1.B1 VSS.t429 VSS.t118 sg13_lv_nmos ad=0.1406p pd=1.12u as=0.2516p ps=2.16u w=0.74u l=0.13u
X414 oa_sar8_acore18_opt_0.sw_tg_opt_0.bot.t3 oa_sar8_acore18_opt_0.sw_bitcell_opt_b7_0.bot.t83 cap_cmim l=2.14u w=2.14u
X415 a_34549_32911# sar_ctrl_async_phys_0.sg13g2_dfrbpq_1_0.CLK.t6 VDD.t340 VDD.t118 sg13_lv_pmos ad=0.4088p pd=2.97u as=1.79957p ps=11.62u w=1.12u l=0.13u
X416 sar_ctrl_async_phys_0.sg13g2_and2_1_0.B a_35962_35924# VSS.t101 VSS.t164 sg13_lv_nmos ad=0.2516p pd=2.16u as=0.1406p ps=1.12u w=0.74u l=0.13u
X417 a_34324_36349# a_34555_35935# a_34010_35892# VSS.t163 sg13_lv_nmos ad=0.2373p pd=1.97u as=79.8f ps=0.8u w=0.42u l=0.13u
X418 a_28862_36863# a_28977_36864# VDD.t766 VDD.t13 sg13_lv_pmos ad=0.34p pd=2.68u as=0.2254p ps=1.53u w=1u l=0.5u
X419 VDD.t40 sar_ctrl_async_phys_0.sg13g2_buf_1_9.A a_33080_30664# VDD.t39 sg13_lv_pmos ad=0.2114p pd=1.54u as=0.2856p ps=2.36u w=0.84u l=0.13u
X420 oa_sar8_acore18_opt_0.sw_bitcell_opt_b6_1.bot.t0 sar_ctrl_async_phys_0.dac_code_n[6] oa_sar8_acore18_opt_0.sw_bitcell_opt_b7_1.VSS VSS.t611 sg13_lv_nmos ad=0.585p pd=3.39u as=1.05p ps=6.7u w=3u l=0.13u
X421 VSS.t129 VDD.t16 VSS.t129 VSS.t687 sg13_lv_nmos ad=79.8f pd=0.8u as=0 ps=0 w=0.42u l=1u
X422 oa_sar8_acore18_opt_0.sw_tg_opt_1.bot.t3 oa_sar8_acore18_opt_0.sw_bitcell_opt_b7_1.bot.t30 cap_cmim l=2.14u w=2.14u
X423 sar_ctrl_async_phys_0.sg13g2_buf_1_25.A a_31258_32436# VDD.t343 VDD.t118 sg13_lv_pmos ad=0.3808p pd=2.92u as=0.2128p ps=1.5u w=1.12u l=0.13u
X424 VDD.t101 VSS.t672 VDD.t101 VDD.t15 sg13_lv_pmos ad=0.34p pd=2.68u as=0 ps=0 w=1u l=1u
X425 a_29524_39373# a_29236_38952# a_29462_39373# VSS.t1154 sg13_lv_nmos ad=0.1428p pd=1.52u as=37.8f ps=0.6u w=0.42u l=0.13u
X426 VSS.t730 VDD.t78 VSS.t730 VSS.t731 sg13_lv_nmos ad=0.1428p pd=1.52u as=0 ps=0 w=0.42u l=1u
X427 VSS.t31 a_32192_39918# a_31841_39775# VSS.t30 sg13_lv_nmos ad=79.8f pd=0.8u as=0.1428p ps=1.52u w=0.42u l=0.13u
X428 a_29258_36642# sar_ctrl_async_phys_0.sg13g2_dlygate4sd3_1_0.X VDD.t349 VDD.t13 sg13_lv_pmos ad=0.1428p pd=1.52u as=0.1523p ps=1.38u w=0.42u l=0.13u
X429 oa_sar8_acore18_opt_0.sw_tg_opt_0.bot.t3 oa_sar8_acore18_opt_0.sw_bitcell_opt_b6_0.bot.t5 cap_cmim l=2.14u w=2.14u
X430 a_30129_39724# sar_ctrl_async_phys_0.sg13g2_a21oi_1_0.A1 sar_ctrl_async_phys_0.sg13g2_nor2_1_10.B VSS.t401 sg13_lv_nmos ad=0.1406p pd=1.12u as=0.1406p ps=1.12u w=0.74u l=0.13u
X431 oa_sar8_acore18_opt_0.sw_tg_opt_0.bot.t3 oa_sar8_acore18_opt_0.sw_bitcell_opt_b7_0.bot.t35 cap_cmim l=2.14u w=2.14u
X432 VDD.t79 VSS.t784 VDD.t79 VDD.t69 sg13_lv_pmos ad=0.19p pd=1.38u as=0 ps=0 w=1u l=1u
X433 VSS.t736 VDD.t79 VSS.t733 VSS.t759 sg13_lv_nmos ad=0.1428p pd=1.52u as=0 ps=0 w=0.42u l=1u
X434 a_32576_44454# a_32319_44311# a_32738_44234# VSS.t138 sg13_lv_nmos ad=0.1428p pd=1.52u as=37.8f ps=0.6u w=0.42u l=0.13u
X435 oa_sar8_acore18_opt_0.sw_bitcell_opt_b7_1.VSS sar_ctrl_async_phys_0.hold_req VSS.t214 VSS.t215 sg13_lv_nmos ad=0.39p pd=2.39u as=0.7p ps=4.7u w=2u l=0.13u
X436 VDD.t38 VSS.t931 VDD.t38 VDD.t37 sg13_lv_pmos ad=0.19p pd=1.38u as=0 ps=0 w=1u l=1u
X437 a_31093_35935# sar_ctrl_async_phys_0.sg13g2_dfrbpq_1_0.CLK.t11 VSS.t552 VSS.t551 sg13_lv_nmos ad=0.2516p pd=2.16u as=4.1082p ps=26.51u w=0.74u l=0.13u
X438 sar_ctrl_async_phys_0.cmp_valid a_34520_47296# VSS.t62 VSS.t61 sg13_lv_nmos ad=0.2886p pd=2.26u as=0.14875p ps=1.16u w=0.74u l=0.13u
X439 VDD.t415 a_32991_45357# a_33658_44996# VDD.t69 sg13_lv_pmos ad=0.2128p pd=1.5u as=0.3864p ps=2.93u w=1.12u l=0.13u
X440 a_32192_39918# a_31935_39775# a_32354_39698# VSS.t30 sg13_lv_nmos ad=0.1428p pd=1.52u as=37.8f ps=0.6u w=0.42u l=0.13u
X441 VDD.t54 VSS.t920 VDD.t54 VDD.t54 sg13_lv_pmos ad=0.34p pd=2.68u as=0 ps=0 w=1u l=1u
X442 a_35807_45366# a_35725_45266# sar_ctrl_async_phys_0.sg13g2_a21oi_1_0.B1 VSS.t364 sg13_lv_nmos ad=0.1406p pd=1.12u as=0.333p ps=2.38u w=0.74u l=0.13u
X443 oa_sar8_acore18_opt_0.sw_tg_opt_0.bot.t3 oa_sar8_acore18_opt_0.sw_bitcell_opt_b7_0.bot.t44 cap_cmim l=2.14u w=2.14u
X444 oa_sar8_acore18_opt_0.sw_tg_opt_1.bot.t0 oa_sar8_acore18_opt_0.sw_bitcell_opt_term_0.trkb.t12 vcm VDD.t709 sg13_lv_pmos ad=0.39p pd=2.39u as=0.7p ps=4.7u w=2u l=0.13u
X445 oa_sar8_acore18_opt_0.sw_tg_opt_1.bot.t3 oa_sar8_acore18_opt_0.sw_bitcell_opt_b7_1.bot.t57 cap_cmim l=2.14u w=2.14u
X446 a_28758_35924# a_28488_35965# VDD.t38 VDD.t37 sg13_lv_pmos ad=0.34p pd=2.68u as=0.1523p ps=1.38u w=1u l=0.5u
X447 sar_ctrl_async_phys_0.sg13g2_nor4_1_0.C sar_ctrl_async_phys_0.sg13g2_and2_1_2.X VSS.t160 VSS.t89 sg13_lv_nmos ad=0.2516p pd=2.16u as=0.2516p ps=2.16u w=0.74u l=0.13u
X448 a_29236_38952# a_29210_38916# VDD.t163 VDD.t162 sg13_lv_pmos ad=0.34p pd=2.68u as=0.36237p ps=2.605u w=1u l=0.13u
X449 VSS.t35 sar_ctrl_async_phys_0.sg13g2_o21ai_1_1.B1 a_31924_40898# VSS.t34 sg13_lv_nmos ad=0.1626p pd=1.415u as=60.89999f ps=0.71u w=0.42u l=0.13u
X450 oa_sar8_acore18_opt_0.sw_tg_opt_0.bot.t3 oa_sar8_acore18_opt_0.sw_bitcell_opt_b7_0.bot.t86 cap_cmim l=2.14u w=2.14u
X451 VDD.t340 a_32341_32117# a_32443_32260# VDD.t118 sg13_lv_pmos ad=1.96315p pd=12.675u as=0.3864p ps=2.93u w=1.12u l=0.13u
X452 VDD.t192 a_27894_35924# a_28006_35948# VDD.t37 sg13_lv_pmos ad=0.2254p pd=1.53u as=0.34p ps=2.68u w=1u l=0.5u
X453 a_32580_36642# sar_ctrl_async_phys_0.sg13g2_buf_1_4.A VSS.t372 VSS.t85 sg13_lv_nmos ad=0.187p pd=1.78u as=0.17255p ps=1.25u w=0.55u l=0.13u
X454 a_35402_39318# sar_ctrl_async_phys_0.sg13g2_a21oi_1_2.B1 VSS.t50 VSS.t573 sg13_lv_nmos ad=0.1406p pd=1.12u as=0.2516p ps=2.16u w=0.74u l=0.13u
X455 oa_sar8_acore18_opt_0.sw_tg_opt_0.bot.t3 oa_sar8_acore18_opt_0.sw_bitcell_opt_b5_0.bot.t10 cap_cmim l=2.14u w=2.14u
X456 w_16692_n9960# oa_sar8_acore18_opt_0.sw_bitcell_opt_term_0.trkb.t10 oa_sar8_acore18_opt_0.bstrap_opt_w2_c1200_1.gb w_16692_n9960# sg13_lv_pmos ad=0.7p pd=4.7u as=0.7p ps=4.7u w=2u l=0.13u
X457 oa_sar8_acore18_opt_0.sw_tg_opt_1.bot.t3 oa_sar8_acore18_opt_0.sw_bitcell_opt_b6_1.bot.t21 cap_cmim l=2.14u w=2.14u
X458 VDD.t79 VSS.t736 VDD.t79 VDD.t69 sg13_lv_pmos ad=0.34p pd=2.68u as=0 ps=0 w=1u l=1u
X459 VDD.t70 VSS.t186 VDD.t70 VDD.t69 sg13_lv_pmos ad=0.34p pd=2.68u as=0 ps=0 w=1u l=1u
X460 VDD.t35 sar_ctrl_async_phys_0.sg13g2_a21oi_1_0.B1 a_34520_46508# VDD.t29 sg13_lv_pmos ad=0.2114p pd=1.54u as=0.2856p ps=2.36u w=0.84u l=0.13u
X461 a_33252_36642# sar_ctrl_async_phys_0.sg13g2_nor2b_1_1.B_N VDD.t500 VDD.t13 sg13_lv_pmos ad=0.2856p pd=2.36u as=0.2618p ps=1.63u w=0.84u l=0.13u
X462 VSS.t801 VDD.t144 VSS.t801 VSS.t800 sg13_lv_nmos ad=0.1428p pd=1.52u as=0 ps=0 w=0.42u l=1u
X463 VDD.t16 VSS.t129 VDD.t16 VDD.t15 sg13_lv_pmos ad=0.34p pd=2.68u as=0 ps=0 w=1u l=1u
X464 VSS.t677 VDD.t67 VSS.t684 VSS.t709 sg13_lv_nmos ad=79.8f pd=0.8u as=0 ps=0 w=0.42u l=1u
X465 sar_ctrl_async_phys_0.sg13g2_buf_1_34.A sar_ctrl_async_phys_0.sg13g2_dfrbpq_1_9.Q VDD.t35 VDD.t29 sg13_lv_pmos ad=0.2128p pd=1.5u as=0.3808p ps=2.92u w=1.12u l=0.13u
X466 VDD.t39 sar_ctrl_async_phys_0.sg13g2_dfrbpq_1_0.CLK.t2 a_34767_31359# VDD.t39 sg13_lv_pmos ad=1.79957p pd=11.62u as=0.4088p ps=2.97u w=1.12u l=0.13u
X467 VSS.t346 a_31140_42690# sar_ctrl_async_phys_0.sg13g2_nor2_1_11.A VSS.t411 sg13_lv_nmos ad=0.17255p pd=1.25u as=0.1406p ps=1.12u w=0.74u l=0.13u
X468 VDD.t205 VSS.t1000 VDD.t205 VDD.t118 sg13_lv_pmos ad=0.34p pd=2.68u as=0 ps=0 w=1u l=1u
X469 a_32137_36047# a_31195_35935# a_31935_36285# VDD.t37 sg13_lv_pmos ad=93.45f pd=0.865u as=0.2048p ps=1.63u w=0.42u l=0.13u
X470 VDD.t182 VSS.t1003 VDD.t182 VDD.t39 sg13_lv_pmos ad=0.19p pd=1.38u as=0 ps=0 w=1u l=1u
X471 a_31540_45434# sar_ctrl_async_phys_0.sg13g2_dfrbpq_1_9.D a_31446_45434# VSS.t1157 sg13_lv_nmos ad=60.89999f pd=0.71u as=0.1428p ps=1.52u w=0.42u l=0.13u
X472 sar_ctrl_async_phys_0.sg13g2_nand2_1_6.B a_34618_46044# VSS.t82 VSS.t1276 sg13_lv_nmos ad=0.2516p pd=2.16u as=0.1406p ps=1.12u w=0.74u l=0.13u
X473 oa_sar8_acore18_opt_0.sw_bitcell_opt_b4_0.bot.t1 sar_ctrl_async_phys_0.dac_code[4] VDD.t623 VDD.t621 sg13_lv_pmos ad=0.936p pd=5.19u as=1.68p ps=10.3u w=4.8u l=0.13u
X474 VDD.t67 VSS.t677 VDD.t78 VDD.t29 sg13_lv_pmos ad=0.34p pd=2.68u as=0 ps=0 w=1u l=1u
X475 a_33375_40821# a_32533_40471# a_32116_40464# VDD.t311 sg13_lv_pmos ad=0.2048p pd=1.63u as=0.34p ps=2.68u w=1u l=0.13u
X476 a_32666_45969# a_33109_45725# a_33049_46137# VDD.t29 sg13_lv_pmos ad=79.8f pd=0.8u as=63f ps=0.72u w=0.42u l=0.13u
X477 a_36074_40830# sar_ctrl_async_phys_0.sg13g2_buf_1_6.A sar_ctrl_async_phys_0.sg13g2_nand2_1_1.Y VSS.t477 sg13_lv_nmos ad=0.1406p pd=1.12u as=0.2516p ps=2.16u w=0.74u l=0.13u
X478 oa_sar8_acore18_opt_0.sw_tg_opt_1.bot.t3 oa_sar8_acore18_opt_0.sw_bitcell_opt_b6_1.bot.t41 cap_cmim l=2.14u w=2.14u
X479 VSS.t1008 VDD.t227 VSS.t1008 VSS.t17 sg13_lv_nmos ad=79.8f pd=0.8u as=0 ps=0 w=0.42u l=1u
X480 a_29046_32138# sar_ctrl_async_phys_0.sg13g2_inv_1_6.Y VDD.t205 VDD.t118 sg13_lv_pmos ad=79.8f pd=0.8u as=0.1428p ps=1.52u w=0.42u l=0.13u
X481 VDD.t311 a_34815_39775# a_35072_39918# VDD.t311 sg13_lv_pmos ad=1.6658p pd=10.66u as=79.8f ps=0.8u w=0.42u l=0.13u
X482 oa_sar8_acore18_opt_0.sw_tg_opt_0.bot.t4 oa_sar8_acore18_opt_0.sw_bitcell_opt_b7_0.bot.t5 cap_cmim l=2.14u w=2.14u
X483 a_31189_31399# sar_ctrl_async_phys_0.sg13g2_dfrbpq_1_0.CLK.t3 VDD.t39 VDD.t39 sg13_lv_pmos ad=0.4088p pd=2.97u as=1.79957p ps=11.62u w=1.12u l=0.13u
X484 VSS.t11 sar_ctrl_async_phys_0.sg13g2_a22oi_1_1.A2 a_32094_33292# VSS.t6 sg13_lv_nmos ad=0.2516p pd=2.16u as=96.2f ps=1u w=0.74u l=0.13u
X485 VDD.t44 VSS.t464 VDD.t44 VDD.t39 sg13_lv_pmos ad=0.19p pd=1.38u as=0 ps=0 w=1u l=1u
X486 a_29238_41972# a_28968_42013# VSS.t137 VSS.t601 sg13_lv_nmos ad=0.1428p pd=1.52u as=79.8f ps=0.8u w=0.42u l=0.5u
X487 sar_ctrl_async_phys_0.sg13g2_buf_1_2.A a_34520_33688# VSS.t11 VSS.t1178 sg13_lv_nmos ad=0.2886p pd=2.26u as=0.14875p ps=1.16u w=0.74u l=0.13u
X488 a_27738_40460# sar_ctrl_async_phys_0.sg13g2_nor2_1_12.A VDD.t419 VDD.t311 sg13_lv_pmos ad=0.1176p pd=1.33u as=0.4032p ps=2.96u w=1.12u l=0.13u
X489 oa_sar8_acore18_opt_0.bstrap_opt_w2_c1200_1.out oa_sar8_acore18_opt_0.sw_bitcell_opt_term_0.trkb.t29 oa_sar8_acore18_opt_0.sw_bitcell_opt_b0_1.bot.t0 VDD.t510 sg13_lv_pmos ad=0.7p pd=4.7u as=0.39p ps=2.39u w=2u l=0.13u
X490 VSS.t967 VDD.t238 VSS.t966 VSS.t965 sg13_lv_nmos ad=0.1428p pd=1.52u as=0 ps=0 w=0.42u l=1u
X491 a_33948_41936# sar_ctrl_async_phys_0.sg13g2_buf_1_3.A.t2 VSS.t123 VSS.t394 sg13_lv_nmos ad=0.187p pd=1.78u as=0.14875p ps=1.16u w=0.55u l=0.13u
X492 a_29812_33968# a_30331_33772# a_31071_33727# VSS.t126 sg13_lv_nmos ad=0.3473p pd=2.71u as=0.12665p ps=1.145u w=0.74u l=0.13u
X493 oa_sar8_acore18_opt_0.sw_tg_opt_1.bot.t3 oa_sar8_acore18_opt_0.sw_bitcell_opt_b6_1.bot.t21 cap_cmim l=2.14u w=2.14u
X494 a_32223_46869# a_31381_46519# a_32129_46869# VSS.t91 sg13_lv_nmos ad=0.12665p pd=1.145u as=0.1428p ps=1.52u w=0.42u l=0.13u
X495 a_30591_32215# a_29749_32117# a_30497_32215# VSS.t70 sg13_lv_nmos ad=0.12665p pd=1.145u as=0.1428p ps=1.52u w=0.42u l=0.13u
X496 VSS.t115 sar_ctrl_async_phys_0.sg13g2_buf_1_2.X.t5 a_31540_35162# VSS.t224 sg13_lv_nmos ad=0.1626p pd=1.415u as=60.89999f ps=0.71u w=0.42u l=0.13u
X497 VDD.t314 sar_ctrl_async_phys_0.sg13g2_buf_1_6.A sar_ctrl_async_phys_0.sg13g2_nand2b_1_1.Y VDD.t311 sg13_lv_pmos ad=0.2198p pd=1.53u as=0.2128p ps=1.5u w=1.12u l=0.13u
X498 a_29044_39386# sar_ctrl_async_phys_0.sg13g2_nor2_1_6.A a_28950_39386# VSS.t89 sg13_lv_nmos ad=60.89999f pd=0.71u as=0.1428p ps=1.52u w=0.42u l=0.13u
X499 a_30495_39309# a_29653_38959# a_30401_39309# VSS.t95 sg13_lv_nmos ad=0.12665p pd=1.145u as=0.1428p ps=1.52u w=0.42u l=0.13u
X500 oa_sar8_acore18_opt_0.sw_tg_opt_0.bot.t3 oa_sar8_acore18_opt_0.sw_bitcell_opt_b7_0.bot.t146 cap_cmim l=2.14u w=2.14u
X501 a_31071_33727# a_30229_33629# a_29812_33968# VDD.t54 sg13_lv_pmos ad=0.2048p pd=1.63u as=0.34p ps=2.68u w=1u l=0.13u
X502 a_29498_40428# a_29941_40471# a_29238_40898# VSS.t1243 sg13_lv_nmos ad=79.8f pd=0.8u as=0.1296p ps=1.52u w=0.42u l=0.13u
X503 VSS.t144 VDD.t351 VSS.t144 VSS.t861 sg13_lv_nmos ad=0.1428p pd=1.52u as=0 ps=0 w=0.42u l=1u
X504 oa_sar8_acore18_opt_0.sw_tg_opt_0.bot.t3 oa_sar8_acore18_opt_0.sw_bitcell_opt_b5_0.bot.t35 cap_cmim l=2.14u w=2.14u
X505 VDD.t163 VSS.t154 VDD.t163 VDD.t162 sg13_lv_pmos ad=0.34p pd=2.68u as=0 ps=0 w=1u l=1u
X506 VSS.t72 VDD.t6 VSS.t72 VSS.t812 sg13_lv_nmos ad=0.1428p pd=1.52u as=0 ps=0 w=0.42u l=1u
X507 VSS.t11 sar_ctrl_async_phys_0.sg13g2_buf_1_2.X a_33940_33338# VSS.t487 sg13_lv_nmos ad=0.1626p pd=1.415u as=60.89999f ps=0.71u w=0.42u l=0.13u
X508 VDD.t198 VSS.t11 VDD.t198 VDD.t54 sg13_lv_pmos ad=0.19p pd=1.38u as=0 ps=0 w=1u l=1u
X509 VSS.t113 sar_ctrl_async_phys_0.sg13g2_buf_1_14.A a_36056_35200# VSS.t203 sg13_lv_nmos ad=0.14875p pd=1.16u as=0.187p ps=1.78u w=0.55u l=0.13u
X510 sar_ctrl_async_phys_0.bit_active[3] a_35672_35200# VSS.t113 VSS.t203 sg13_lv_nmos ad=0.2886p pd=2.26u as=0.14875p ps=1.16u w=0.74u l=0.13u
X511 a_32400_41413# sar_ctrl_async_phys_0.sg13g2_a21oi_1_7.A2 a_32537_41256# VSS.t279 sg13_lv_nmos ad=0.2176p pd=1.96u as=0.1216p ps=1.02u w=0.64u l=0.13u
X512 a_32094_33292# sar_ctrl_async_phys_0.sg13g2_a22oi_1_0.A1.t12 sar_ctrl_async_phys_0.sg13g2_a22oi_1_1.Y VSS.t6 sg13_lv_nmos ad=96.2f pd=1u as=0.2664p ps=1.46u w=0.74u l=0.13u
X513 VSS.t982 VDD.t212 VSS.t981 VSS.t980 sg13_lv_nmos ad=0.1428p pd=1.52u as=0 ps=0 w=0.42u l=1u
X514 a_31060_31813# a_31291_31399# a_30746_31356# VSS.t235 sg13_lv_nmos ad=0.2373p pd=1.97u as=79.8f ps=0.8u w=0.42u l=0.13u
X515 VSS.t129 VDD.t16 VSS.t129 VSS.t686 sg13_lv_nmos ad=0.1428p pd=1.52u as=0 ps=0 w=0.42u l=1u
X516 VDD.t346 a_32991_45357# a_33248_45238# VDD.t69 sg13_lv_pmos ad=1.96315p pd=12.675u as=79.8f ps=0.8u w=0.42u l=0.13u
X517 VDD.t179 VSS.t801 VDD.t177 VDD.t5 sg13_lv_pmos ad=0.34p pd=2.68u as=0 ps=0 w=1u l=1u
X518 VDD.t209 VSS.t346 VDD.t209 VDD.t5 sg13_lv_pmos ad=0.19p pd=1.38u as=0 ps=0 w=1u l=1u
X519 oa_sar8_acore18_opt_0.sw_tg_opt_1.bot.t3 oa_sar8_acore18_opt_0.sw_bitcell_opt_b7_1.bot.t110 cap_cmim l=2.14u w=2.14u
X520 VSS.t1008 VDD.t61 VSS.t1008 VSS.t17 sg13_lv_nmos ad=0.1428p pd=1.52u as=0 ps=0 w=0.42u l=1u
X521 VDD.t116 VSS.t739 VDD.t114 VDD.t29 sg13_lv_pmos ad=0.34p pd=2.68u as=0 ps=0 w=1u l=1u
X522 a_30486_31826# sar_ctrl_async_phys_0.sg13g2_dfrbpq_1_17.D VDD.t44 VDD.t39 sg13_lv_pmos ad=79.8f pd=0.8u as=0.1428p ps=1.52u w=0.42u l=0.13u
X523 a_33844_36992# a_33818_36897# VSS.t403 VSS.t402 sg13_lv_nmos ad=0.2516p pd=2.16u as=0.1626p ps=1.415u w=0.74u l=0.13u
X524 oa_sar8_acore18_opt_0.sw_tg_opt_1.bot.t3 oa_sar8_acore18_opt_0.sw_bitcell_opt_b2_1.bot.t6 cap_cmim l=2.14u w=2.14u
X525 w_39600_n9960# a_35948_n9612# cap_cmim l=9.94u w=39.8u
X526 oa_sar8_acore18_opt_0.sw_tg_opt_1.bot.t3 oa_sar8_acore18_opt_0.sw_bitcell_opt_b6_1.bot.t69 cap_cmim l=2.14u w=2.14u
X527 oa_sar8_acore18_opt_0.sw_tg_opt_0.bot.t3 oa_sar8_acore18_opt_0.sw_bitcell_opt_b7_0.bot.t30 cap_cmim l=2.14u w=2.14u
X528 oa_sar8_acore18_opt_0.sw_tg_opt_0.bot.t3 oa_sar8_acore18_opt_0.sw_bitcell_opt_b6_0.bot.t35 cap_cmim l=2.14u w=2.14u
X529 a_30752_39190# a_30495_39309# a_30914_39386# VSS.t1271 sg13_lv_nmos ad=0.1428p pd=1.52u as=37.8f ps=0.6u w=0.42u l=0.13u
X530 oa_sar8_acore18_opt_0.sw_tg_opt_1.bot.t2 oa_sar8_acore18_opt_0.sw_bitcell_opt_b7_1.bot.t152 cap_cmim l=2.14u w=2.14u
X531 VDD.t100 VSS.t805 VDD.t99 VDD.t0 sg13_lv_pmos ad=0.19p pd=1.38u as=0 ps=0 w=1u l=1u
X532 VSS.t123 VDD.t209 VSS.t123 VSS.t829 sg13_lv_nmos ad=0.1428p pd=1.52u as=0 ps=0 w=0.42u l=1u
X533 oa_sar8_acore18_opt_0.sw_tg_opt_0.bot.t3 oa_sar8_acore18_opt_0.sw_bitcell_opt_b6_0.bot.t45 cap_cmim l=2.14u w=2.14u
X534 oa_sar8_acore18_opt_0.sw_bitcell_opt_b1_1.bot.t0 oa_sar8_acore18_opt_0.bstrap_opt_w2_c1200_1.gb oa_sar8_acore18_opt_0.bstrap_opt_w2_c1200_1.out VSS.t1091 sg13_lv_nmos ad=0.195p pd=1.39u as=0.35p ps=2.7u w=1u l=0.13u
X535 a_34420_33325# a_34132_32904# a_34358_33325# VSS.t399 sg13_lv_nmos ad=0.1428p pd=1.52u as=37.8f ps=0.6u w=0.42u l=0.13u
X536 sar_ctrl_async_phys_0.sg13g2_dfrbpq_1_9.D sar_ctrl_async_phys_0.sg13g2_nor2b_1_4.Y VSS.t485 VSS.t484 sg13_lv_nmos ad=0.1406p pd=1.12u as=0.2516p ps=2.16u w=0.74u l=0.13u
X537 a_29238_41972# a_28968_42013# VDD.t186 VDD.t5 sg13_lv_pmos ad=0.34p pd=2.68u as=0.1523p ps=1.38u w=1u l=0.5u
X538 sar_ctrl_async_phys_0.sg13g2_nor4_1_0.C sar_ctrl_async_phys_0.sg13g2_and2_1_2.X VDD.t319 VDD.t311 sg13_lv_pmos ad=0.3808p pd=2.92u as=0.3808p ps=2.92u w=1.12u l=0.13u
X539 VDD.t560 sar_ctrl_async_phys_0.dac_code_n[0] oa_sar8_acore18_opt_0.sw_bitcell_opt_b0_1.bot.t1 VDD.t559 sg13_lv_pmos ad=1.05p pd=6.7u as=0.585p ps=3.39u w=3u l=0.13u
X540 VDD.t13 a_35103_36751# a_35770_36972# VDD.t13 sg13_lv_pmos ad=0.2128p pd=1.5u as=0.3864p ps=2.93u w=1.12u l=0.13u
X541 VDD.t311 a_31040_40702# a_30985_40583# VDD.t311 sg13_lv_pmos ad=1.6658p pd=10.66u as=93.45f ps=0.865u w=0.42u l=0.13u
X542 sar_ctrl_async_phys_0.sg13g2_a21oi_1_0.A1 sar_ctrl_async_phys_0.sg13g2_nor2_1_5.B VSS.t626 VSS.t625 sg13_lv_nmos ad=0.2516p pd=2.16u as=0.2516p ps=2.16u w=0.74u l=0.13u
X543 VDD.t14 VSS.t471 VDD.t14 VDD.t13 sg13_lv_pmos ad=0.34p pd=2.68u as=0 ps=0 w=1u l=1u
X544 VSS.t84 a_29258_36642# a_28977_36864# VSS.t83 sg13_lv_nmos ad=79.8f pd=0.8u as=0.1428p ps=1.52u w=0.42u l=0.5u
X545 VDD.t346 a_35199_44311# a_35456_44454# VDD.t69 sg13_lv_pmos ad=1.96315p pd=12.675u as=79.8f ps=0.8u w=0.42u l=0.13u
X546 sar_ctrl_async_phys_0.sg13g2_buf_1_22.A a_31261_38232# VDD.t818 VDD.t162 sg13_lv_pmos ad=0.3808p pd=2.92u as=0.1918p ps=1.5u w=1.12u l=0.13u
X547 oa_sar8_acore18_opt_0.sw_tg_opt_0.bot.t3 oa_sar8_acore18_opt_0.sw_bitcell_opt_b4_0.bot.t16 cap_cmim l=2.14u w=2.14u
X548 VSS.t926 VDD.t38 VSS.t926 VSS.t114 sg13_lv_nmos ad=79.8f pd=0.8u as=0 ps=0 w=0.42u l=1u
X549 oa_sar8_acore18_opt_0.sw_tg_opt_1.bot.t3 oa_sar8_acore18_opt_0.sw_bitcell_opt_b6_1.bot.t69 cap_cmim l=2.14u w=2.14u
X550 a_32212_32151# a_32443_32260# a_31898_32361# VSS.t97 sg13_lv_nmos ad=0.2373p pd=1.97u as=79.8f ps=0.8u w=0.42u l=0.13u
X551 VSS.t914 VDD.t38 VSS.t84 VSS.t913 sg13_lv_nmos ad=0.1428p pd=1.52u as=0 ps=0 w=0.42u l=1u
X552 sar_ctrl_async_phys_0.sg13g2_nand3_1_0.C sar_ctrl_async_phys_0.sg13g2_dlygate4sd3_1_4.X a_25914_38948# VDD.t162 sg13_lv_pmos ad=0.3808p pd=2.92u as=0.1176p ps=1.33u w=1.12u l=0.13u
X553 oa_sar8_acore18_opt_0.sw_tg_opt_1.bot.t3 oa_sar8_acore18_opt_0.sw_bitcell_opt_b6_1.bot.t9 cap_cmim l=2.14u w=2.14u
X554 a_32480_46750# a_32223_46869# a_32642_46946# VSS.t91 sg13_lv_nmos ad=0.1428p pd=1.52u as=37.8f ps=0.6u w=0.42u l=0.13u
X555 oa_sar8_acore18_opt_0.sw_tg_opt_0.bot.t3 oa_sar8_acore18_opt_0.sw_bitcell_opt_b6_0.bot.t15 cap_cmim l=2.14u w=2.14u
X556 oa_sar8_acore18_opt_0.sw_bitcell_opt_b1_0.bot.t0 oa_sar8_acore18_opt_0.sw_bitcell_opt_term_0.gb.t6 oa_sar8_acore18_opt_0.sw_bitcell_opt_term_0.vin VSS.t542 sg13_lv_nmos ad=0.195p pd=1.39u as=0.35p ps=2.7u w=1u l=0.13u
X557 oa_sar8_acore18_opt_0.sw_tg_opt_0.bot.t3 oa_sar8_acore18_opt_0.sw_bitcell_opt_b4_0.bot.t28 cap_cmim l=2.14u w=2.14u
X558 oa_sar8_acore18_opt_0.sw_bitcell_opt_term_0.VSS sar_ctrl_async_phys_0.dac_code[3] oa_sar8_acore18_opt_0.sw_bitcell_opt_b3_0.bot.t0 VSS.t427 sg13_lv_nmos ad=0.735p pd=4.9u as=0.4095p ps=2.49u w=2.1u l=0.13u
X559 VSS.t115 a_30507_35204# a_30944_35166# VSS.t114 sg13_lv_nmos ad=0.148p pd=1.14u as=0.3367p ps=1.65u w=0.74u l=0.13u
X560 oa_sar8_acore18_opt_0.sw_tg_opt_0.bot.t3 oa_sar8_acore18_opt_0.sw_bitcell_opt_b5_0.bot.t2 cap_cmim l=2.14u w=2.14u
X561 VDD.t238 VSS.t961 VDD.t54 VDD.t54 sg13_lv_pmos ad=0.34p pd=2.68u as=0 ps=0 w=1u l=1u
X562 oa_sar8_acore18_opt_0.sw_bitcell_opt_b7_1.bot.t169 sar_ctrl_async_phys_0.dac_code_n[7] VDD.t1022 VDD.t1020 sg13_lv_pmos ad=1.326p pd=7.19u as=2.38p ps=14.3u w=6.8u l=0.13u
X563 VDD.t447 sar_ctrl_async_phys_0.sg13g2_buf_1_23.A a_35672_35200# VDD.t37 sg13_lv_pmos ad=0.2114p pd=1.54u as=0.2856p ps=2.36u w=0.84u l=0.13u
X564 VDD.t101 VSS.t672 VDD.t101 VDD.t15 sg13_lv_pmos ad=0.34p pd=2.68u as=0 ps=0 w=1u l=1u
X565 oa_sar8_acore18_opt_0.sw_tg_opt_1.bot.t3 oa_sar8_acore18_opt_0.sw_bitcell_opt_b5_1.bot.t14 cap_cmim l=2.14u w=2.14u
X566 oa_sar8_acore18_opt_0.sw_tg_opt_0.bot.t3 oa_sar8_acore18_opt_0.sw_bitcell_opt_b7_0.bot.t57 cap_cmim l=2.14u w=2.14u
X567 VSS.t733 VDD.t81 VSS.t733 VSS.t734 sg13_lv_nmos ad=0.1428p pd=1.52u as=0 ps=0 w=0.42u l=1u
X568 VDD.t366 sar_ctrl_async_phys_0.sg13g2_a21oi_1_0.A1.t5 a_32715_43020# VDD.t0 sg13_lv_pmos ad=0.2128p pd=1.5u as=0.2128p ps=1.5u w=1.12u l=0.13u
X569 VDD.t351 a_26666_38912# a_26385_39214# VDD.t162 sg13_lv_pmos ad=0.1523p pd=1.38u as=0.34p ps=2.68u w=1u l=0.5u
X570 VSS.t926 VDD.t211 VSS.t926 VSS.t114 sg13_lv_nmos ad=0.1428p pd=1.52u as=0 ps=0 w=0.42u l=1u
X571 VSS.t144 VDD.t196 VSS.t144 VSS.t865 sg13_lv_nmos ad=0.1428p pd=1.52u as=0 ps=0 w=0.42u l=1u
X572 oa_sar8_acore18_opt_0.sw_tg_opt_1.bot.t2 oa_sar8_acore18_opt_0.sw_bitcell_opt_b7_1.bot.t157 cap_cmim l=2.14u w=2.14u
X573 VDD.t38 VSS.t926 VDD.t38 VDD.t37 sg13_lv_pmos ad=0.34p pd=2.68u as=0 ps=0 w=1u l=1u
X574 a_33364_39698# sar_ctrl_async_phys_0.sg13g2_nor2b_1_3.Y a_33270_39698# VSS.t30 sg13_lv_nmos ad=60.89999f pd=0.71u as=0.1428p ps=1.52u w=0.42u l=0.13u
X575 oa_sar8_acore18_opt_0.sw_bitcell_opt_term_0.vin oa_sar8_acore18_opt_0.sw_bitcell_opt_term_0.gb.t3 vinn VSS.t210 sg13_lv_nmos ad=0.195p pd=1.39u as=0.35p ps=2.7u w=1u l=0.13u
X576 VDD.t16 VSS.t684 VDD.t16 VDD.t15 sg13_lv_pmos ad=0.34p pd=2.68u as=0 ps=0 w=1u l=1u
X577 VSS.t672 VDD.t68 VSS.t672 VSS.t702 sg13_lv_nmos ad=0.1428p pd=1.52u as=0 ps=0 w=0.42u l=1u
X578 sar_ctrl_async_phys_0.sg13g2_nand2_1_2.B a_35866_44532# VDD.t568 VDD.t69 sg13_lv_pmos ad=0.3808p pd=2.92u as=0.2128p ps=1.5u w=1.12u l=0.13u
X579 VDD.t100 VSS.t777 VDD.t99 VDD.t0 sg13_lv_pmos ad=0.34p pd=2.68u as=0 ps=0 w=1u l=1u
X580 a_30100_33663# a_29812_33968# a_30038_33663# VSS.t226 sg13_lv_nmos ad=0.1428p pd=1.52u as=37.8f ps=0.6u w=0.42u l=0.13u
X581 sar_ctrl_async_phys_0.sg13g2_nand2b_1_3.Y a_34765_42242# VDD.t668 VDD.t5 sg13_lv_pmos ad=0.2128p pd=1.5u as=0.3808p ps=2.92u w=1.12u l=0.13u
X582 a_33878_41223# sar_ctrl_async_phys_0.sg13g2_o21ai_1_1.B1 VSS.t20 VSS.t28 sg13_lv_nmos ad=37.8f pd=0.6u as=0.1701p ps=1.65u w=0.42u l=0.13u
X583 a_33530_39921# a_33973_39677# a_33913_40089# VDD.t311 sg13_lv_pmos ad=79.8f pd=0.8u as=63f ps=0.72u w=0.42u l=0.13u
X584 VDD.t13 a_33344_37678# a_33289_37559# VDD.t13 sg13_lv_pmos ad=2.48357p pd=16.205u as=93.45f ps=0.865u w=0.42u l=0.13u
X585 vcm sar_ctrl_async_phys_0.sample oa_sar8_acore18_opt_0.sw_tg_opt_0.bot.t1 VSS.t245 sg13_lv_nmos ad=0.35p pd=2.7u as=0.195p ps=1.39u w=1u l=0.13u
X586 a_31958_45421# sar_ctrl_async_phys_0.sg13g2_dfrbpq_1_9.RESET_B VSS.t22 VSS.t303 sg13_lv_nmos ad=37.8f pd=0.6u as=0.1701p ps=1.65u w=0.42u l=0.13u
X587 oa_sar8_acore18_opt_0.sw_tg_opt_1.bot.t3 oa_sar8_acore18_opt_0.sw_bitcell_opt_b5_1.bot.t34 cap_cmim l=2.14u w=2.14u
X588 sar_ctrl_async_phys_0.sg13g2_buf_1_3.A.t0 a_32696_30664# VDD.t40 VDD.t39 sg13_lv_pmos ad=0.42p pd=2.99u as=0.2114p ps=1.54u w=1.12u l=0.13u
X589 VDD.t366 a_32580_43448# a_32538_43484# VDD.t0 sg13_lv_pmos ad=0.2618p pd=1.63u as=0.1176p ps=1.33u w=1.12u l=0.13u
X590 oa_sar8_acore18_opt_0.sw_tg_opt_1.bot.t4 oa_sar8_acore18_opt_0.sw_bitcell_opt_b7_1.bot.t9 cap_cmim l=2.14u w=2.14u
X591 oa_sar8_acore18_opt_0.sw_tg_opt_1.bot.t3 oa_sar8_acore18_opt_0.sw_bitcell_opt_b7_1.bot.t127 cap_cmim l=2.14u w=2.14u
X592 VDD.t61 VSS.t1046 VDD.t61 VDD.t39 sg13_lv_pmos ad=0.19p pd=1.38u as=0 ps=0 w=1u l=1u
X593 VSS.t677 VDD.t67 VSS.t677 VSS.t708 sg13_lv_nmos ad=0.1428p pd=1.52u as=0 ps=0 w=0.42u l=1u
X594 VSS.t27 a_35168_41430# a_34817_41287# VSS.t1160 sg13_lv_nmos ad=79.8f pd=0.8u as=0.1428p ps=1.52u w=0.42u l=0.13u
X595 VDD.t343 sar_ctrl_async_phys_0.sg13g2_buf_1_2.X.t1 a_31898_32361# VDD.t118 sg13_lv_pmos ad=0.1563p pd=1.22u as=0.147p ps=1.54u w=0.42u l=0.13u
X596 VDD.t119 VSS.t966 VDD.t119 VDD.t118 sg13_lv_pmos ad=0.34p pd=2.68u as=0 ps=0 w=1u l=1u
X597 VDD.t169 VSS.t22 VDD.t169 VDD.t29 sg13_lv_pmos ad=0.34p pd=2.68u as=0 ps=0 w=1u l=1u
X598 oa_sar8_acore18_opt_0.sw_tg_opt_0.bot.t3 oa_sar8_acore18_opt_0.sw_bitcell_opt_b6_0.bot.t25 cap_cmim l=2.14u w=2.14u
X599 oa_sar8_acore18_opt_0.sw_tg_opt_0.bot.t4 oa_sar8_acore18_opt_0.sw_bitcell_opt_b7_0.bot.t20 cap_cmim l=2.14u w=2.14u
X600 VSS.t103 sar_ctrl_async_phys_0.sg13g2_buf_1_13.X a_32027_43832# VSS.t296 sg13_lv_nmos ad=0.1331p pd=1.12u as=0.1216p ps=1.02u w=0.64u l=0.13u
X601 a_30902_39711# sar_ctrl_async_phys_0.sg13g2_o21ai_1_1.B1 VSS.t37 VSS.t36 sg13_lv_nmos ad=37.8f pd=0.6u as=0.1701p ps=1.65u w=0.42u l=0.13u
X602 VDD.t382 sar_ctrl_async_phys_0.sg13g2_a21oi_1_0.A1.t1 a_35211_37436# VDD.t13 sg13_lv_pmos ad=0.2128p pd=1.5u as=0.2128p ps=1.5u w=1.12u l=0.13u
X603 a_30229_33629# sar_ctrl_async_phys_0.sg13g2_dfrbpq_1_0.CLK.t7 VDD.t54 VDD.t54 sg13_lv_pmos ad=0.4088p pd=2.97u as=1.98685p ps=12.96u w=1.12u l=0.13u
X604 VDD.t163 VSS.t144 VDD.t276 VDD.t162 sg13_lv_pmos ad=0.34p pd=2.68u as=0 ps=0 w=1u l=1u
X605 a_30676_35928# a_31195_35935# a_31935_36285# VSS.t371 sg13_lv_nmos ad=0.3473p pd=2.71u as=0.12665p ps=1.145u w=0.74u l=0.13u
X606 VDD.t30 VSS.t711 VDD.t51 VDD.t29 sg13_lv_pmos ad=0.34p pd=2.68u as=0 ps=0 w=1u l=1u
X607 VSS.t592 rst_n a_32696_30664# VSS.t1140 sg13_lv_nmos ad=0.14875p pd=1.16u as=0.187p ps=1.78u w=0.55u l=0.13u
X608 VDD.t573 a_33936_31675# sar_ctrl_async_phys_0.sg13g2_buf_1_7.A VDD.t39 sg13_lv_pmos ad=0.2128p pd=1.5u as=0.3808p ps=2.92u w=1.12u l=0.13u
X609 a_33940_44552# a_34459_44356# a_35199_44311# VSS.t252 sg13_lv_nmos ad=0.3473p pd=2.71u as=0.12665p ps=1.145u w=0.74u l=0.13u
X610 VDD.t68 VSS.t724 VDD.t86 VDD.t29 sg13_lv_pmos ad=0.34p pd=2.68u as=0 ps=0 w=1u l=1u
X611 VDD.t79 VSS.t775 VDD.t97 VDD.t69 sg13_lv_pmos ad=0.34p pd=2.68u as=0 ps=0 w=1u l=1u
X612 a_29653_38959# sar_ctrl_async_phys_0.sg13g2_dfrbpq_1_0.CLK.t16 VSS.t94 VSS.t107 sg13_lv_nmos ad=0.2516p pd=2.16u as=4.48835p ps=28.62u w=0.74u l=0.13u
X613 a_29462_39373# sar_ctrl_async_phys_0.sg13g2_o21ai_1_1.B1 VSS.t52 VSS.t51 sg13_lv_nmos ad=37.8f pd=0.6u as=0.1701p ps=1.65u w=0.42u l=0.13u
X614 oa_sar8_acore18_opt_0.sw_tg_opt_1.bot.t3 oa_sar8_acore18_opt_0.sw_bitcell_opt_b7_1.bot.t83 cap_cmim l=2.14u w=2.14u
X615 VSS.t151 a_30229_33629# a_30331_33772# VSS.t1280 sg13_lv_nmos ad=5.99755p pd=39.725u as=0.2516p ps=2.16u w=0.74u l=0.13u
X616 VDD.t22 VSS.t129 VDD.t22 VDD.t15 sg13_lv_pmos ad=0.34p pd=2.68u as=0 ps=0 w=1u l=1u
X617 oa_sar8_acore18_opt_0.sw_tg_opt_0.bot.t3 oa_sar8_acore18_opt_0.sw_bitcell_opt_b7_0.bot.t120 cap_cmim l=2.14u w=2.14u
X618 VDD.t44 VSS.t1026 VDD.t44 VDD.t39 sg13_lv_pmos ad=0.19p pd=1.38u as=0 ps=0 w=1u l=1u
X619 a_32738_44234# sar_ctrl_async_phys_0.sg13g2_dfrbpq_1_9.RESET_B VSS.t103 VSS.t313 sg13_lv_nmos ad=37.8f pd=0.6u as=79.8f ps=0.8u w=0.42u l=0.13u
X620 VSS.t11 sar_ctrl_async_phys_0.sg13g2_inv_1_2.A sar_ctrl_async_phys_0.sg13g2_inv_1_2.Y VSS.t126 sg13_lv_nmos ad=0.2516p pd=2.16u as=0.2516p ps=2.16u w=0.74u l=0.13u
X621 a_31924_40898# sar_ctrl_async_phys_0.sg13g2_dfrbpq_1_11.D a_31830_40898# VSS.t44 sg13_lv_nmos ad=60.89999f pd=0.71u as=0.1428p ps=1.52u w=0.42u l=0.13u
X622 sar_ctrl_async_phys_0.sg13g2_nor2_1_5.Y sar_ctrl_async_phys_0.sg13g2_nor2_1_5.B a_28026_36972# VDD.t13 sg13_lv_pmos ad=0.3808p pd=2.92u as=0.1176p ps=1.33u w=1.12u l=0.13u
X623 sar_ctrl_async_phys_0.sg13g2_a22oi_1_0.A1 a_34904_38224# VSS.t88 VSS.t87 sg13_lv_nmos ad=0.2886p pd=2.26u as=0.14875p ps=1.16u w=0.74u l=0.13u
X624 VDD.t338 sar_ctrl_async_phys_0.sg13g2_buf_1_4.A a_36056_33688# VDD.t54 sg13_lv_pmos ad=0.2114p pd=1.54u as=0.2856p ps=2.36u w=0.84u l=0.13u
X625 oa_sar8_acore18_opt_0.sw_tg_opt_1.bot.t3 oa_sar8_acore18_opt_0.sw_bitcell_opt_b7_1.bot.t35 cap_cmim l=2.14u w=2.14u
X626 oa_sar8_acore18_opt_0.sw_tg_opt_1.bot.t3 oa_sar8_acore18_opt_0.sw_bitcell_opt_b7_1.bot.t85 cap_cmim l=2.14u w=2.14u
X627 VSS.t295 sar_ctrl_async_phys_0.sg13g2_nand2b_1_0.A_N a_28651_39740# VSS.t89 sg13_lv_nmos ad=0.14505p pd=1.15u as=0.187p ps=1.78u w=0.55u l=0.13u
X628 a_30942_33292# sar_ctrl_async_phys_0.sg13g2_a22oi_1_0.A1.t14 sar_ctrl_async_phys_0.sg13g2_a22oi_1_5.Y VSS.t448 sg13_lv_nmos ad=96.2f pd=1u as=0.2664p ps=1.46u w=0.74u l=0.13u
X629 a_31040_40702# a_30783_40821# a_31202_40898# VSS.t44 sg13_lv_nmos ad=0.1428p pd=1.52u as=37.8f ps=0.6u w=0.42u l=0.13u
X630 oa_sar8_acore18_opt_0.sw_tg_opt_0.bot.t3 oa_sar8_acore18_opt_0.sw_bitcell_opt_b6_0.bot.t10 cap_cmim l=2.14u w=2.14u
X631 VSS.t464 sar_ctrl_async_phys_0.sg13g2_buf_1_2.X a_29140_32138# VSS.t465 sg13_lv_nmos ad=0.1626p pd=1.415u as=60.89999f ps=0.71u w=0.42u l=0.13u
X632 VDD.t209 sar_ctrl_async_phys_0.sg13g2_o21ai_1_1.B1 a_33626_41433# VDD.t5 sg13_lv_pmos ad=0.1563p pd=1.22u as=0.147p ps=1.54u w=0.42u l=0.13u
X633 a_33940_44552# a_33914_44457# VDD.t415 VDD.t69 sg13_lv_pmos ad=0.34p pd=2.68u as=0.36237p ps=2.605u w=1u l=0.13u
X634 VDD.t311 a_29941_40471# a_30043_40471# VDD.t311 sg13_lv_pmos ad=1.6658p pd=10.66u as=0.3864p ps=2.93u w=1.12u l=0.13u
X635 oa_sar8_acore18_opt_0.sw_tg_opt_0.bot.t2 oa_sar8_acore18_opt_0.sw_bitcell_opt_b7_0.bot.t162 cap_cmim l=2.14u w=2.14u
X636 VSS.t552 a_31093_35935# a_31195_35935# VSS.t1219 sg13_lv_nmos ad=5.13525p pd=33.135u as=0.2516p ps=2.16u w=0.74u l=0.13u
X637 a_35199_44311# a_34357_44213# a_35105_44311# VSS.t252 sg13_lv_nmos ad=0.12665p pd=1.145u as=0.1428p ps=1.52u w=0.42u l=0.13u
X638 VSS.t178 sar_ctrl_async_phys_0.sg13g2_nand2_1_3.A a_34847_42342# VSS.t653 sg13_lv_nmos ad=0.14505p pd=1.15u as=0.1406p ps=1.12u w=0.74u l=0.13u
X639 oa_sar8_acore18_opt_0.sw_tg_opt_0.bot.t3 oa_sar8_acore18_opt_0.sw_bitcell_opt_b7_0.bot.t131 cap_cmim l=2.14u w=2.14u
X640 a_35391_33261# a_34549_32911# a_34132_32904# VDD.t118 sg13_lv_pmos ad=0.2048p pd=1.63u as=0.34p ps=2.68u w=1u l=0.13u
X641 sar_ctrl_async_phys_0.sg13g2_a21oi_1_6.A2 a_32890_46508# VDD.t33 VDD.t29 sg13_lv_pmos ad=0.3808p pd=2.92u as=0.2128p ps=1.5u w=1.12u l=0.13u
X642 VSS.t58 a_26558_40727# sar_ctrl_async_phys_0.sg13g2_nand3_1_0.A VSS.t1217 sg13_lv_nmos ad=0.1426p pd=1.16u as=0.2516p ps=2.16u w=0.74u l=0.13u
X643 a_34308_37400# sar_ctrl_async_phys_0.sg13g2_buf_1_23.A VSS.t172 VSS.t118 sg13_lv_nmos ad=0.187p pd=1.78u as=0.17255p ps=1.25u w=0.55u l=0.13u
X644 oa_sar8_acore18_opt_0.sw_tg_opt_0.bot.t3 oa_sar8_acore18_opt_0.sw_bitcell_opt_b7_0.bot.t47 cap_cmim l=2.14u w=2.14u
X645 oa_sar8_acore18_opt_0.sw_bitcell_opt_b0_1.bot.t0 oa_sar8_acore18_opt_0.sw_bitcell_opt_term_0.trkb.t29 oa_sar8_acore18_opt_0.bstrap_opt_w2_c1200_1.out VDD.t510 sg13_lv_pmos ad=0.39p pd=2.39u as=0.7p ps=4.7u w=2u l=0.13u
X646 a_26666_38912# sar_ctrl_async_phys_0.sg13g2_dlygate4sd3_1_9.X VSS.t432 VSS.t89 sg13_lv_nmos ad=0.1428p pd=1.52u as=79.8f ps=0.8u w=0.42u l=0.13u
X647 VSS.t962 VDD.t119 VSS.t964 VSS.t963 sg13_lv_nmos ad=79.8f pd=0.8u as=0 ps=0 w=0.42u l=1u
X648 VSS.t1003 VDD.t119 VSS.t1003 VSS.t17 sg13_lv_nmos ad=0.1428p pd=1.52u as=0 ps=0 w=0.42u l=1u
X649 a_32500_45746# sar_ctrl_async_phys_0.sg13g2_nor2_1_0.Y a_32406_45746# VSS.t598 sg13_lv_nmos ad=60.89999f pd=0.71u as=0.1428p ps=1.52u w=0.42u l=0.13u
X650 oa_sar8_acore18_opt_0.sw_bitcell_opt_b3_1.bot.t0 oa_sar8_acore18_opt_0.bstrap_opt_w2_c1200_1.gb oa_sar8_acore18_opt_0.bstrap_opt_w2_c1200_1.out VSS.t1093 sg13_lv_nmos ad=0.195p pd=1.39u as=0.35p ps=2.7u w=1u l=0.13u
X651 VDD.t254 VSS.t959 VDD.t54 VDD.t54 sg13_lv_pmos ad=0.19p pd=1.38u as=0 ps=0 w=1u l=1u
X652 VDD.t135 VSS.t137 VDD.t137 VDD.t0 sg13_lv_pmos ad=0.19p pd=1.38u as=0 ps=0 w=1u l=1u
X653 sar_ctrl_async_phys_0.sg13g2_dlygate4sd3_1_8.A a_26662_41278# VDD.t8 VDD.t5 sg13_lv_pmos ad=0.4256p pd=3u as=0.2254p ps=1.53u w=1.12u l=0.13u
X654 VDD.t349 sar_ctrl_async_phys_0.sg13g2_nor2_1_7.A a_29276_37436# VDD.t13 sg13_lv_pmos ad=0.4032p pd=2.96u as=0.1176p ps=1.33u w=1.12u l=0.13u
X655 VDD.t247 VSS.t56 VDD.t247 VDD.t162 sg13_lv_pmos ad=0.19p pd=1.38u as=0 ps=0 w=1u l=1u
X656 sar_ctrl_async_phys_0.cmp_n sar_ctrl_async_phys_0.cmp_fire VDD.t845 VDD.t844 sg13_lv_pmos ad=0.7p pd=4.7u as=0.7p ps=4.7u w=2u l=0.13u
X657 a_32406_45746# a_33211_45868# a_32666_45969# VDD.t29 sg13_lv_pmos ad=0.1428p pd=1.52u as=79.8f ps=0.8u w=0.42u l=0.13u
X658 VSS.t260 sar_ctrl_async_phys_0.sg13g2_nand2_1_1.B a_36074_40830# VSS.t406 sg13_lv_nmos ad=0.2516p pd=2.16u as=0.1406p ps=1.12u w=0.74u l=0.13u
X659 oa_sar8_acore18_opt_0.sw_bitcell_opt_b7_1.VSS sar_ctrl_async_phys_0.dac_code_n[2] oa_sar8_acore18_opt_0.sw_bitcell_opt_b2_1.bot.t0 VSS.t397 sg13_lv_nmos ad=0.665p pd=4.5u as=0.3705p ps=2.29u w=1.9u l=0.13u
X660 a_34393_35971# a_34036_35928# VDD.t197 VDD.t37 sg13_lv_pmos ad=63f pd=0.72u as=0.1563p ps=1.22u w=0.42u l=0.13u
X661 a_27530_39666# sar_ctrl_async_phys_0.sg13g2_dlygate4sd3_1_4.A VDD.t419 VDD.t311 sg13_lv_pmos ad=0.1428p pd=1.52u as=0.1523p ps=1.38u w=0.42u l=0.13u
X662 VDD.t342 sar_ctrl_async_phys_0.sg13g2_buf_1_2.A a_35384_32176# VDD.t118 sg13_lv_pmos ad=0.2114p pd=1.54u as=0.2856p ps=2.36u w=0.84u l=0.13u
X663 oa_sar8_acore18_opt_0.sw_tg_opt_0.bot.t3 oa_sar8_acore18_opt_0.sw_bitcell_opt_b7_0.bot.t89 cap_cmim l=2.14u w=2.14u
X664 VSS.t277 sar_ctrl_async_phys_0.sg13g2_dfrbpq_1_0.CLK.t12 a_27624_35965# VSS.t550 sg13_lv_nmos ad=79.8f pd=0.8u as=0.1428p ps=1.52u w=0.42u l=0.13u
X665 a_32580_43448# sar_ctrl_async_phys_0.sg13g2_buf_1_20.A VSS.t103 VSS.t1267 sg13_lv_nmos ad=0.187p pd=1.78u as=0.17255p ps=1.25u w=0.55u l=0.13u
X666 oa_sar8_acore18_opt_0.sw_tg_opt_0.bot.t4 oa_sar8_acore18_opt_0.sw_bitcell_opt_b7_0.bot.t10 cap_cmim l=2.14u w=2.14u
X667 VSS.t5 VDD.t198 VSS.t5 VSS.t953 sg13_lv_nmos ad=0.1428p pd=1.52u as=0 ps=0 w=0.42u l=1u
X668 VDD.t42 VSS.t918 VDD.t42 VDD.t37 sg13_lv_pmos ad=0.19p pd=1.38u as=0 ps=0 w=1u l=1u
X669 a_30697_39071# a_29755_38959# a_30495_39309# VDD.t162 sg13_lv_pmos ad=93.45f pd=0.865u as=0.2048p ps=1.63u w=0.42u l=0.13u
X670 oa_sar8_acore18_opt_0.sw_tg_opt_1.bot.t3 oa_sar8_acore18_opt_0.sw_bitcell_opt_b7_1.bot.t25 cap_cmim l=2.14u w=2.14u
X671 VDD.t39 a_31189_31399# a_31291_31399# VDD.t39 sg13_lv_pmos ad=1.96315p pd=12.675u as=0.3864p ps=2.93u w=1.12u l=0.13u
X672 oa_sar8_acore18_opt_0.sw_tg_opt_0.bot.t3 oa_sar8_acore18_opt_0.sw_bitcell_opt_b5_0.bot.t15 cap_cmim l=2.14u w=2.14u
X673 VDD.t547 a_35557_31435# a_34636_31749# VDD.t39 sg13_lv_pmos ad=0.36237p pd=2.605u as=0.34p ps=2.68u w=1u l=0.13u
X674 oa_sar8_acore18_opt_0.sw_bitcell_opt_term_0.vin oa_sar8_acore18_opt_0.sw_bitcell_opt_term_0.gb.t11 oa_sar8_acore18_opt_0.sw_bitcell_opt_b6_0.bot.t1 VSS.t541 sg13_lv_nmos ad=0.35p pd=2.7u as=0.195p ps=1.39u w=1u l=0.13u
X675 a_33914_44457# a_34357_44213# a_33654_44234# VSS.t1294 sg13_lv_nmos ad=79.8f pd=0.8u as=0.1296p ps=1.52u w=0.42u l=0.13u
X676 VDD.t13 a_32245_37447# a_32347_37447# VDD.t13 sg13_lv_pmos ad=2.48357p pd=16.205u as=0.3864p ps=2.93u w=1.12u l=0.13u
X677 oa_sar8_acore18_opt_0.bstrap_opt_w2_c1200_1.out oa_sar8_acore18_opt_0.sw_bitcell_opt_term_0.trkb.t24 oa_sar8_acore18_opt_0.sw_bitcell_opt_b5_1.bot.t0 VDD.t613 sg13_lv_pmos ad=0.7p pd=4.7u as=0.39p ps=2.39u w=2u l=0.13u
X678 a_33940_44552# a_33914_44457# VSS.t205 VSS.t1139 sg13_lv_nmos ad=0.2516p pd=2.16u as=0.1626p ps=1.415u w=0.74u l=0.13u
X679 oa_sar8_acore18_opt_0.sw_bitcell_opt_b0_1.bot.t1 sar_ctrl_async_phys_0.dac_code_n[0] VDD.t561 VDD.t559 sg13_lv_pmos ad=0.585p pd=3.39u as=1.05p ps=6.7u w=3u l=0.13u
X680 VDD.t498 sar_ctrl_async_phys_0.dac_code[1] oa_sar8_acore18_opt_0.sw_bitcell_opt_b1_0.bot.t1 VDD.t497 sg13_lv_pmos ad=1.19p pd=7.5u as=0.663p ps=3.79u w=3.4u l=0.13u
X681 sar_ctrl_async_phys_0.bit_active[7] a_35672_38224# VDD.t350 VDD.t162 sg13_lv_pmos ad=0.42p pd=2.99u as=0.2114p ps=1.54u w=1.12u l=0.13u
X682 vcm sar_ctrl_async_phys_0.sample oa_sar8_acore18_opt_0.sw_tg_opt_1.bot.t1 VSS.t244 sg13_lv_nmos ad=0.35p pd=2.7u as=0.195p ps=1.39u w=1u l=0.13u
X683 a_34132_36687# a_34363_36796# a_33818_36897# VSS.t1286 sg13_lv_nmos ad=0.2373p pd=1.97u as=79.8f ps=0.8u w=0.42u l=0.13u
X684 VDD.t38 VSS.t111 VDD.t185 VDD.t37 sg13_lv_pmos ad=0.34p pd=2.68u as=0 ps=0 w=1u l=1u
X685 a_30037_43495# sar_ctrl_async_phys_0.sg13g2_dfrbpq_1_0.CLK VDD.t576 VDD.t0 sg13_lv_pmos ad=0.4088p pd=2.97u as=2.2076p ps=14.4u w=1.12u l=0.13u
X686 VSS.t931 VDD.t55 VSS.t931 VSS.t114 sg13_lv_nmos ad=0.1428p pd=1.52u as=0 ps=0 w=0.42u l=1u
X687 VSS.t727 VDD.t89 VSS.t724 VSS.t753 sg13_lv_nmos ad=0.1428p pd=1.52u as=0 ps=0 w=0.42u l=1u
X688 oa_sar8_acore18_opt_0.sw_tg_opt_1.bot.t3 oa_sar8_acore18_opt_0.sw_bitcell_opt_b7_1.bot.t120 cap_cmim l=2.14u w=2.14u
X689 VDD.t311 a_33632_40702# a_33577_40583# VDD.t311 sg13_lv_pmos ad=1.6658p pd=10.66u as=93.45f ps=0.865u w=0.42u l=0.13u
X690 a_35280_35365# sar_ctrl_async_phys_0.sg13g2_buf_1_6.A a_35417_35208# VSS.t203 sg13_lv_nmos ad=0.2176p pd=1.96u as=0.1216p ps=1.02u w=0.64u l=0.13u
X691 VDD.t371 sar_ctrl_async_phys_0.sg13g2_buf_1_3.A.t1 a_34520_33688# VDD.t54 sg13_lv_pmos ad=0.2114p pd=1.54u as=0.2856p ps=2.36u w=0.84u l=0.13u
X692 oa_sar8_acore18_opt_0.sw_tg_opt_1.bot.t3 oa_sar8_acore18_opt_0.sw_bitcell_opt_b6_1.bot.t29 cap_cmim l=2.14u w=2.14u
X693 a_34358_33325# sar_ctrl_async_phys_0.sg13g2_buf_1_2.X VSS.t11 VSS.t489 sg13_lv_nmos ad=37.8f pd=0.6u as=0.1701p ps=1.65u w=0.42u l=0.13u
X694 VDD.t38 VSS.t931 VDD.t38 VDD.t37 sg13_lv_pmos ad=0.34p pd=2.68u as=0 ps=0 w=1u l=1u
X695 a_32425_46631# a_31483_46519# a_32223_46869# VDD.t29 sg13_lv_pmos ad=93.45f pd=0.865u as=0.2048p ps=1.63u w=0.42u l=0.13u
X696 VDD.t191 VSS.t894 VDD.t191 VDD.t13 sg13_lv_pmos ad=0.19p pd=1.38u as=0 ps=0 w=1u l=1u
X697 oa_sar8_acore18_opt_0.sw_tg_opt_1.bot.t3 oa_sar8_acore18_opt_0.sw_bitcell_opt_b7_1.bot.t21 cap_cmim l=2.14u w=2.14u
X698 a_30671_32876# sar_ctrl_async_phys_0.sg13g2_a22oi_1_0.A1.t9 VDD.t205 VDD.t118 sg13_lv_pmos ad=0.2716p pd=1.605u as=0.3808p ps=2.92u w=1.12u l=0.13u
X699 a_34489_34459# a_34132_34416# VDD.t371 VDD.t54 sg13_lv_pmos ad=63f pd=0.72u as=0.1563p ps=1.22u w=0.42u l=0.13u
X700 a_33248_35382# sar_ctrl_async_phys_0.sg13g2_buf_1_2.X.t4 VDD.t37 VDD.t37 sg13_lv_pmos ad=79.8f pd=0.8u as=1.79957p ps=11.62u w=0.42u l=0.13u
X701 oa_sar8_acore18_opt_0.sw_tg_opt_0.bot.t3 oa_sar8_acore18_opt_0.sw_bitcell_opt_b6_0.bot.t35 cap_cmim l=2.14u w=2.14u
X702 VSS.t485 sar_ctrl_async_phys_0.sg13g2_a22oi_1_1.A2 sar_ctrl_async_phys_0.sg13g2_dfrbpq_1_9.D VSS.t561 sg13_lv_nmos ad=0.2516p pd=2.16u as=0.1406p ps=1.12u w=0.74u l=0.13u
X703 oa_sar8_acore18_opt_0.sw_tg_opt_0.bot.t3 oa_sar8_acore18_opt_0.sw_bitcell_opt_b5_0.bot.t35 cap_cmim l=2.14u w=2.14u
X704 sar_ctrl_async_phys_0.cmp_n sar_ctrl_async_phys_0.cmp_p VDD.t475 VDD.t473 sg13_lv_pmos ad=0.585p pd=3.39u as=1.05p ps=6.7u w=3u l=0.13u
X705 a_30964_46512# a_30938_46476# VSS.t129 VSS.t128 sg13_lv_nmos ad=0.2516p pd=2.16u as=0.1626p ps=1.415u w=0.74u l=0.13u
X706 sar_ctrl_async_phys_0.sg13g2_buf_1_22.A a_31261_38232# VSS.t471 VSS.t1172 sg13_lv_nmos ad=0.2516p pd=2.16u as=0.1331p ps=1.12u w=0.74u l=0.13u
X707 sar_ctrl_async_phys_0.sg13g2_a21oi_1_0.A2 a_35770_36972# VDD.t13 VDD.t13 sg13_lv_pmos ad=0.3808p pd=2.92u as=0.2128p ps=1.5u w=1.12u l=0.13u
X708 a_30774_44234# sar_ctrl_async_phys_0.sg13g2_nor2_1_11.Y VDD.t117 VDD.t69 sg13_lv_pmos ad=79.8f pd=0.8u as=0.1428p ps=1.52u w=0.42u l=0.13u
X709 VSS.t129 VDD.t30 VSS.t711 VSS.t710 sg13_lv_nmos ad=0.1428p pd=1.52u as=0 ps=0 w=0.42u l=1u
X710 sar_ctrl_async_phys_0.sg13g2_nor2_1_5.B sar_ctrl_async_phys_0.sg13g2_nor2_1_5.Y VSS.t154 VSS.t480 sg13_lv_nmos ad=0.1406p pd=1.12u as=0.2516p ps=2.16u w=0.74u l=0.13u
X711 oa_sar8_acore18_opt_0.sw_tg_opt_1.bot.t3 oa_sar8_acore18_opt_0.sw_bitcell_opt_term_1.bot.t1 cap_cmim l=2.14u w=2.14u
X712 VDD.t227 VSS.t971 VDD.t119 VDD.t118 sg13_lv_pmos ad=0.34p pd=2.68u as=0 ps=0 w=1u l=1u
X713 a_32642_46946# sar_ctrl_async_phys_0.sg13g2_dfrbpq_1_9.RESET_B VSS.t129 VSS.t91 sg13_lv_nmos ad=37.8f pd=0.6u as=79.8f ps=0.8u w=0.42u l=0.13u
X714 oa_sar8_acore18_opt_0.sw_tg_opt_1.bot.t3 oa_sar8_acore18_opt_0.sw_bitcell_opt_b3_1.bot.t14 cap_cmim l=2.14u w=2.14u
X715 VDD.t35 a_34236_46472# sar_ctrl_async_phys_0.sg13g2_dfrbpq_1_9.RESET_B VDD.t29 sg13_lv_pmos ad=0.2114p pd=1.54u as=0.42p ps=2.99u w=1.12u l=0.13u
X716 VSS.t78 a_34357_44213# a_34459_44356# VSS.t1295 sg13_lv_nmos ad=4.3785p pd=27.07u as=0.2516p ps=2.16u w=0.74u l=0.13u
X717 VDD.t68 VSS.t672 VDD.t68 VDD.t29 sg13_lv_pmos ad=0.34p pd=2.68u as=0 ps=0 w=1u l=1u
X718 oa_sar8_acore18_opt_0.sw_tg_opt_1.bot.t3 oa_sar8_acore18_opt_0.sw_bitcell_opt_b6_1.bot.t74 cap_cmim l=2.14u w=2.14u
X719 VDD.t500 sar_ctrl_async_phys_0.sg13g2_buf_1_2.A.t3 a_33558_36674# VDD.t13 sg13_lv_pmos ad=0.36237p pd=2.605u as=79.8f ps=0.8u w=0.42u l=0.13u
X720 oa_sar8_acore18_opt_0.sw_tg_opt_0.bot.t2 oa_sar8_acore18_opt_0.sw_bitcell_opt_b7_0.bot.t152 cap_cmim l=2.14u w=2.14u
X721 VSS.t325 a_35648_30846# a_35297_30703# VSS.t324 sg13_lv_nmos ad=79.8f pd=0.8u as=0.1428p ps=1.52u w=0.42u l=0.13u
X722 VSS.t60 sar_ctrl_async_phys_0.sg13g2_nand2b_1_0.A_N a_28392_41214# VSS.t362 sg13_lv_nmos ad=79.8f pd=0.8u as=0.1428p ps=1.52u w=0.42u l=0.13u
X723 oa_sar8_acore18_opt_0.sw_tg_opt_0.bot.t3 oa_sar8_acore18_opt_0.sw_bitcell_opt_b7_0.bot.t35 cap_cmim l=2.14u w=2.14u
X724 VSS.t1003 VDD.t119 VSS.t1003 VSS.t17 sg13_lv_nmos ad=79.8f pd=0.8u as=0 ps=0 w=0.42u l=1u
X725 VDD.t77 VSS.t730 VDD.t76 VDD.t29 sg13_lv_pmos ad=0.19p pd=1.38u as=0 ps=0 w=1u l=1u
X726 oa_sar8_acore18_opt_0.sw_tg_opt_1.bot.t3 oa_sar8_acore18_opt_0.sw_bitcell_opt_b6_1.bot.t14 cap_cmim l=2.14u w=2.14u
X727 a_33366_41210# sar_ctrl_async_phys_0.sg13g2_nor2_1_15.Y VDD.t209 VDD.t5 sg13_lv_pmos ad=79.8f pd=0.8u as=0.1428p ps=1.52u w=0.42u l=0.13u
X728 VDD.t342 a_35391_33261# a_36058_32900# VDD.t118 sg13_lv_pmos ad=0.2128p pd=1.5u as=0.3864p ps=2.93u w=1.12u l=0.13u
X729 oa_sar8_acore18_opt_0.sw_tg_opt_0.bot.t3 oa_sar8_acore18_opt_0.sw_bitcell_opt_b6_0.bot.t50 cap_cmim l=2.14u w=2.14u
X730 a_34132_43909# a_33844_43488# a_34070_43909# VSS.t1137 sg13_lv_nmos ad=0.1428p pd=1.52u as=37.8f ps=0.6u w=0.42u l=0.13u
X731 VSS.t1073 VDD.t40 VSS.t592 VSS.t1074 sg13_lv_nmos ad=79.8f pd=0.8u as=0 ps=0 w=0.42u l=1u
X732 a_34526_31826# a_34268_31826# VSS.t9 VSS.t14 sg13_lv_nmos ad=0.1428p pd=1.52u as=79.8f ps=0.8u w=0.42u l=0.13u
X733 a_31093_35935# sar_ctrl_async_phys_0.sg13g2_dfrbpq_1_0.CLK.t11 VDD.t37 VDD.t37 sg13_lv_pmos ad=0.4088p pd=2.97u as=1.66112p ps=10.725u w=1.12u l=0.13u
X734 VSS.t101 a_35360_36894# a_35009_36751# VSS.t100 sg13_lv_nmos ad=79.8f pd=0.8u as=0.1428p ps=1.52u w=0.42u l=0.13u
X735 a_26544_38389# sar_ctrl_async_phys_0.sg13g2_buf_1_26.X VDD.t351 VDD.t162 sg13_lv_pmos ad=0.1596p pd=1.22u as=0.1918p ps=1.5u w=0.84u l=0.13u
X736 a_30038_33663# sar_ctrl_async_phys_0.sg13g2_buf_1_2.X.t3 VSS.t7 VSS.t226 sg13_lv_nmos ad=37.8f pd=0.6u as=0.1701p ps=1.65u w=0.42u l=0.13u
X737 sar_ctrl_async_phys_0.sg13g2_buf_1_0.A a_33658_35460# VSS.t5 VSS.t455 sg13_lv_nmos ad=0.2516p pd=2.16u as=0.1406p ps=1.12u w=0.74u l=0.13u
X738 oa_sar8_acore18_opt_0.sw_tg_opt_0.bot.t3 oa_sar8_acore18_opt_0.sw_bitcell_opt_b5_0.bot.t5 cap_cmim l=2.14u w=2.14u
X739 oa_sar8_acore18_opt_0.sw_tg_opt_0.bot.t3 oa_sar8_acore18_opt_0.sw_bitcell_opt_b7_0.bot.t62 cap_cmim l=2.14u w=2.14u
X740 VDD.t185 a_30507_35204# a_31007_35460# VDD.t37 sg13_lv_pmos ad=0.2198p pd=1.52u as=0.2975p ps=1.595u w=1u l=0.13u
X741 VSS.t62 sar_ctrl_async_phys_0.sg13g2_a21oi_1_5.B1 a_34904_47296# VSS.t61 sg13_lv_nmos ad=0.14875p pd=1.16u as=0.187p ps=1.78u w=0.55u l=0.13u
X742 a_34596_40424# sar_ctrl_async_phys_0.sg13g2_buf_1_14.A VSS.t27 VSS.t74 sg13_lv_nmos ad=0.187p pd=1.78u as=0.17255p ps=1.25u w=0.55u l=0.13u
X743 VDD.t182 VSS.t1033 VDD.t189 VDD.t39 sg13_lv_pmos ad=0.34p pd=2.68u as=0 ps=0 w=1u l=1u
X744 VDD.t415 sar_ctrl_async_phys_0.sg13g2_nand2_1_2.A sar_ctrl_async_phys_0.sg13g2_buf_1_32.A VDD.t69 sg13_lv_pmos ad=0.3808p pd=2.92u as=0.2128p ps=1.5u w=1.12u l=0.13u
X745 VDD.t387 sar_ctrl_async_phys_0.dac_code[7] oa_sar8_acore18_opt_0.sw_bitcell_opt_b7_0.bot.t1 VDD.t386 sg13_lv_pmos ad=2.38p pd=14.3u as=1.326p ps=7.19u w=6.8u l=0.13u
X746 VDD.t36 VSS.t346 VDD.t36 VDD.t5 sg13_lv_pmos ad=0.19p pd=1.38u as=0 ps=0 w=1u l=1u
X747 a_33087_37797# a_32245_37447# a_32993_37797# VSS.t118 sg13_lv_nmos ad=0.12665p pd=1.145u as=0.1428p ps=1.52u w=0.42u l=0.13u
X748 a_33344_37678# sar_ctrl_async_phys_0.sg13g2_buf_1_2.A.t5 VDD.t13 VDD.t13 sg13_lv_pmos ad=79.8f pd=0.8u as=2.2076p ps=14.4u w=0.42u l=0.13u
X749 a_31355_38232# sar_ctrl_async_phys_0.sg13g2_buf_1_13.X a_31261_38232# VSS.t1234 sg13_lv_nmos ad=0.1216p pd=1.02u as=0.2176p ps=1.96u w=0.64u l=0.13u
X750 a_33630_33292# sar_ctrl_async_phys_0.sg13g2_a22oi_1_0.A1.t10 sar_ctrl_async_phys_0.sg13g2_inv_1_0.A VSS.t6 sg13_lv_nmos ad=96.2f pd=1u as=0.2664p ps=1.46u w=0.74u l=0.13u
X751 VSS.t231 a_26364_45710# sar_ctrl_async_phys_0.sg13g2_buf_1_29.A VSS.t1133 sg13_lv_nmos ad=0.14875p pd=1.16u as=0.2886p ps=2.26u w=0.74u l=0.13u
X752 a_28236_40440# sar_ctrl_async_phys_0.sg13g2_o21ai_1_1.A2 sar_ctrl_async_phys_0.sg13g2_nor2_1_12.A VDD.t311 sg13_lv_pmos ad=0.2128p pd=1.5u as=0.2128p ps=1.5u w=1.12u l=0.15u
X753 VSS.t172 VDD.t247 VSS.t172 VSS.t875 sg13_lv_nmos ad=0.1428p pd=1.52u as=0 ps=0 w=0.42u l=1u
X754 VSS.t967 VDD.t119 VSS.t969 VSS.t968 sg13_lv_nmos ad=79.8f pd=0.8u as=0 ps=0 w=0.42u l=1u
X755 VSS.t178 sar_ctrl_async_phys_0.sg13g2_nand2_1_2.Y a_35672_42760# VSS.t431 sg13_lv_nmos ad=0.14875p pd=1.16u as=0.187p ps=1.78u w=0.55u l=0.13u
X756 a_34895_32460# sar_ctrl_async_phys_0.sg13g2_a22oi_1_0.B2 sar_ctrl_async_phys_0.sg13g2_a22oi_1_0.Y VDD.t118 sg13_lv_pmos ad=0.2744p pd=1.61u as=0.2128p ps=1.5u w=1.12u l=0.13u
X757 a_30678_46946# a_31483_46519# a_30938_46476# VDD.t29 sg13_lv_pmos ad=0.1428p pd=1.52u as=79.8f ps=0.8u w=0.42u l=0.13u
X758 VDD.t155 sar_ctrl_async_phys_0.sg13g2_buf_1_13.X.t1 a_25820_43020# VDD.t0 sg13_lv_pmos ad=0.4032p pd=2.96u as=0.1176p ps=1.33u w=1.12u l=0.13u
X759 oa_sar8_acore18_opt_0.sw_tg_opt_0.bot.t4 oa_sar8_acore18_opt_0.sw_bitcell_opt_b7_0.bot.t2 cap_cmim l=2.14u w=2.14u
X760 oa_sar8_acore18_opt_0.sw_tg_opt_0.bot.t2 oa_sar8_acore18_opt_0.sw_bitcell_opt_b7_0.bot.t157 cap_cmim l=2.14u w=2.14u
X761 VDD.t346 a_34357_44213# a_34459_44356# VDD.t69 sg13_lv_pmos ad=1.96315p pd=12.675u as=0.3864p ps=2.93u w=1.12u l=0.13u
X762 oa_sar8_acore18_opt_0.sw_tg_opt_1.bot.t4 oa_sar8_acore18_opt_0.sw_bitcell_opt_b7_1.bot.t14 cap_cmim l=2.14u w=2.14u
X763 a_31247_32876# sar_ctrl_async_phys_0.sg13g2_a22oi_1_0.A1.t8 VDD.t647 VDD.t118 sg13_lv_pmos ad=0.2716p pd=1.605u as=0.3808p ps=2.92u w=1.12u l=0.13u
X764 oa_sar8_acore18_opt_0.sw_tg_opt_0.bot.t3 oa_sar8_acore18_opt_0.sw_bitcell_opt_b6_0.bot.t62 cap_cmim l=2.14u w=2.14u
X765 result[1] a_33464_30664# VSS.t271 VSS.t270 sg13_lv_nmos ad=0.2886p pd=2.26u as=0.14875p ps=1.16u w=0.74u l=0.13u
X766 VSS.t5 sar_ctrl_async_phys_0.sg13g2_buf_1_2.A a_33940_34850# VSS.t457 sg13_lv_nmos ad=0.1626p pd=1.415u as=60.89999f ps=0.71u w=0.42u l=0.13u
X767 sar_ctrl_async_phys_0.sg13g2_nand2_1_3.B a_32986_44532# VSS.t103 VSS.t610 sg13_lv_nmos ad=0.2516p pd=2.16u as=0.1406p ps=1.12u w=0.74u l=0.13u
X768 VDD.t366 VSS.t346 VDD.t366 VDD.t0 sg13_lv_pmos ad=0.19p pd=1.38u as=0 ps=0 w=1u l=1u
X769 VDD.t247 VSS.t50 VDD.t247 VDD.t162 sg13_lv_pmos ad=0.19p pd=1.38u as=0 ps=0 w=1u l=1u
X770 oa_sar8_acore18_opt_0.sw_tg_opt_1.bot.t3 oa_sar8_acore18_opt_0.sw_bitcell_opt_b6_1.bot.t1 cap_cmim l=2.14u w=2.14u
X771 oa_sar8_acore18_opt_0.sw_tg_opt_0.bot.t3 oa_sar8_acore18_opt_0.sw_bitcell_opt_b6_0.bot.t30 cap_cmim l=2.14u w=2.14u
X772 sar_ctrl_async_phys_0.sg13g2_inv_1_2.A sar_ctrl_async_phys_0.sg13g2_a22oi_1_0.B1 a_34319_32460# VDD.t118 sg13_lv_pmos ad=0.2128p pd=1.5u as=0.2716p ps=1.605u w=1.12u l=0.13u
X773 VSS.t58 a_26550_41214# a_26662_41278# VSS.t57 sg13_lv_nmos ad=0.1426p pd=1.16u as=0.1428p ps=1.52u w=0.42u l=0.5u
X774 a_32288_31630# sar_ctrl_async_phys_0.sg13g2_buf_1_2.X VDD.t39 VDD.t39 sg13_lv_pmos ad=79.8f pd=0.8u as=1.79957p ps=11.62u w=0.42u l=0.13u
X775 sar_ctrl_async_phys_0.bit_active[1] a_36056_33688# VDD.t338 VDD.t54 sg13_lv_pmos ad=0.42p pd=2.99u as=0.2114p ps=1.54u w=1.12u l=0.13u
X776 a_32089_35553# a_31732_35480# VDD.t457 VDD.t37 sg13_lv_pmos ad=63f pd=0.72u as=0.1563p ps=1.22u w=0.42u l=0.13u
X777 VDD.t242 VSS.t979 VDD.t211 VDD.t54 sg13_lv_pmos ad=0.19p pd=1.38u as=0 ps=0 w=1u l=1u
X778 VSS.t920 VDD.t46 VSS.t920 VSS.t114 sg13_lv_nmos ad=79.8f pd=0.8u as=0 ps=0 w=0.42u l=1u
X779 VSS.t101 a_35552_36166# a_35201_36285# VSS.t164 sg13_lv_nmos ad=79.8f pd=0.8u as=0.1428p ps=1.52u w=0.42u l=0.13u
X780 VSS.t144 VDD.t191 VSS.t144 VSS.t862 sg13_lv_nmos ad=79.8f pd=0.8u as=0 ps=0 w=0.42u l=1u
X781 oa_sar8_acore18_opt_0.sw_tg_opt_0.bot.t3 oa_sar8_acore18_opt_0.sw_bitcell_opt_b6_0.bot.t55 cap_cmim l=2.14u w=2.14u
X782 oa_sar8_acore18_opt_0.sw_tg_opt_0.bot.t3 oa_sar8_acore18_opt_0.sw_bitcell_opt_b7_0.bot.t73 cap_cmim l=2.14u w=2.14u
X783 a_35557_31435# a_34615_31475# a_35418_31668# VSS.t15 sg13_lv_nmos ad=79.8f pd=0.8u as=0.2373p ps=1.97u w=0.42u l=0.13u
X784 VDD.t315 a_29653_38959# a_29755_38959# VDD.t162 sg13_lv_pmos ad=3.62845p pd=23.965u as=0.3864p ps=2.93u w=1.12u l=0.13u
X785 VDD.t311 a_32533_40471# a_32635_40471# VDD.t311 sg13_lv_pmos ad=1.6658p pd=10.66u as=0.3864p ps=2.93u w=1.12u l=0.13u
X786 VSS.t283 VDD.t42 VSS.t918 VSS.t371 sg13_lv_nmos ad=79.8f pd=0.8u as=0 ps=0 w=0.42u l=1u
X787 VDD.t33 a_32223_46869# a_32890_46508# VDD.t29 sg13_lv_pmos ad=0.2128p pd=1.5u as=0.3864p ps=2.93u w=1.12u l=0.13u
X788 oa_sar8_acore18_opt_0.bstrap_opt_w2_c1200_1.out oa_sar8_acore18_opt_0.bstrap_opt_w2_c1200_1.gb oa_sar8_acore18_opt_0.sw_bitcell_opt_b6_1.bot.t0 VSS.t1096 sg13_lv_nmos ad=0.35p pd=2.7u as=0.195p ps=1.39u w=1u l=0.13u
X789 VSS.t64 sar_ctrl_async_phys_0.sg13g2_buf_1_4.A a_36056_33688# VSS.t63 sg13_lv_nmos ad=0.14875p pd=1.16u as=0.187p ps=1.78u w=0.55u l=0.13u
X790 VSS.t782 VDD.t79 VSS.t784 VSS.t783 sg13_lv_nmos ad=79.8f pd=0.8u as=0 ps=0 w=0.42u l=1u
X791 VDD.t339 a_26454_39702# a_26566_39766# VDD.t311 sg13_lv_pmos ad=0.2254p pd=1.53u as=0.34p ps=2.68u w=1u l=0.5u
X792 oa_sar8_acore18_opt_0.sw_tg_opt_1.bot.t3 oa_sar8_acore18_opt_0.sw_bitcell_opt_b5_1.bot.t21 cap_cmim l=2.14u w=2.14u
X793 oa_sar8_acore18_opt_0.sw_tg_opt_1.bot.t3 oa_sar8_acore18_opt_0.sw_bitcell_opt_b7_1.bot.t64 cap_cmim l=2.14u w=2.14u
X794 a_25596_41174# sar_ctrl_async_phys_0.sg13g2_nor4_1_0.Y VDD.t6 VDD.t5 sg13_lv_pmos ad=0.2856p pd=2.36u as=0.2114p ps=1.54u w=0.84u l=0.13u
X795 oa_sar8_acore18_opt_0.sw_tg_opt_0.bot.t3 oa_sar8_acore18_opt_0.sw_bitcell_opt_b7_0.bot.t25 cap_cmim l=2.14u w=2.14u
X796 sar_ctrl_async_phys_0.sg13g2_a22oi_1_0.Y sar_ctrl_async_phys_0.sg13g2_a22oi_1_0.B2 a_34895_32120# VSS.t1258 sg13_lv_nmos ad=0.2664p pd=1.46u as=0.13875p ps=1.115u w=0.74u l=0.13u
X797 a_33602_32138# sar_ctrl_async_phys_0.sg13g2_buf_1_2.X.t0 VSS.t98 VSS.t8 sg13_lv_nmos ad=37.8f pd=0.6u as=79.8f ps=0.8u w=0.42u l=0.13u
X798 VDD.t46 VSS.t886 VDD.t46 VDD.t37 sg13_lv_pmos ad=0.34p pd=2.68u as=0 ps=0 w=1u l=1u
X799 a_29084_38484# sar_ctrl_async_phys_0.sg13g2_dfrbpq_1_0.CLK.t15 sar_ctrl_async_phys_0.sg13g2_nand2_1_0.B VDD.t162 sg13_lv_pmos ad=0.1176p pd=1.33u as=0.3808p ps=2.92u w=1.12u l=0.13u
X800 oa_sar8_acore18_opt_0.sw_tg_opt_1.bot.t3 oa_sar8_acore18_opt_0.sw_bitcell_opt_b6_1.bot.t59 cap_cmim l=2.14u w=2.14u
X801 a_33818_43452# a_34261_43495# a_33558_43922# VSS.t535 sg13_lv_nmos ad=79.8f pd=0.8u as=0.1296p ps=1.52u w=0.42u l=0.13u
X802 VDD.t611 a_31140_42690# a_31098_43020# VDD.t0 sg13_lv_pmos ad=0.2618p pd=1.63u as=0.1176p ps=1.33u w=1.12u l=0.13u
X803 sar_ctrl_async_phys_0.dac_code[6].t0 a_35672_38948# VDD.t350 VDD.t162 sg13_lv_pmos ad=0.42p pd=2.99u as=0.2114p ps=1.54u w=1.12u l=0.13u
X804 a_33344_37678# a_33087_37797# a_33506_37874# VSS.t118 sg13_lv_nmos ad=0.1428p pd=1.52u as=37.8f ps=0.6u w=0.42u l=0.13u
X805 oa_sar8_acore18_opt_0.sw_tg_opt_1.bot.t3 oa_sar8_acore18_opt_0.sw_bitcell_opt_b6_1.bot.t1 cap_cmim l=2.14u w=2.14u
X806 VDD.t1013 sar_ctrl_async_phys_0.dac_code_n[5] oa_sar8_acore18_opt_0.sw_bitcell_opt_b5_1.bot.t41 VDD.t1012 sg13_lv_pmos ad=1.89p pd=11.5u as=1.053p ps=5.79u w=5.4u l=0.13u
X807 VSS.t920 VDD.t238 VSS.t920 VSS.t114 sg13_lv_nmos ad=0.1428p pd=1.52u as=0 ps=0 w=0.42u l=1u
X808 VSS.t103 sar_ctrl_async_phys_0.sg13g2_a21oi_1_6.A2 a_33179_43832# VSS.t1162 sg13_lv_nmos ad=0.1331p pd=1.12u as=0.1216p ps=1.02u w=0.64u l=0.13u
X809 sar_ctrl_async_phys_0.sg13g2_nor2_1_2.Y sar_ctrl_async_phys_0.sg13g2_nor2_1_2.A VSS.t172 VSS.t87 sg13_lv_nmos ad=0.1406p pd=1.12u as=0.2516p ps=2.16u w=0.74u l=0.13u
X810 a_34208_45966# a_33951_45823# a_34370_45746# VSS.t80 sg13_lv_nmos ad=0.1428p pd=1.52u as=37.8f ps=0.6u w=0.42u l=0.13u
X811 VSS.t730 VDD.t79 VSS.t730 VSS.t756 sg13_lv_nmos ad=79.8f pd=0.8u as=0 ps=0 w=0.42u l=1u
X812 sar_ctrl_async_phys_0.sg13g2_nor2_1_12.B sar_ctrl_async_phys_0.sg13g2_o21ai_1_1.A2 VSS.t1122 VSS.t89 sg13_lv_nmos ad=0.1406p pd=1.12u as=0.2516p ps=2.16u w=0.74u l=0.13u
X813 oa_sar8_acore18_opt_0.sw_tg_opt_0.bot.t3 oa_sar8_acore18_opt_0.sw_bitcell_opt_b7_0.bot.t125 cap_cmim l=2.14u w=2.14u
X814 VDD.t192 VSS.t920 VDD.t46 VDD.t37 sg13_lv_pmos ad=0.34p pd=2.68u as=0 ps=0 w=1u l=1u
X815 VSS.t764 VDD.t70 VSS.t186 VSS.t185 sg13_lv_nmos ad=0.1428p pd=1.52u as=0 ps=0 w=0.42u l=1u
X816 oa_sar8_acore18_opt_0.sw_tg_opt_0.bot.t3 oa_sar8_acore18_opt_0.sw_bitcell_opt_b3_0.bot.t16 cap_cmim l=2.14u w=2.14u
X817 VDD.t133 VSS.t768 VDD.t132 VDD.t0 sg13_lv_pmos ad=0.34p pd=2.68u as=0 ps=0 w=1u l=1u
X818 VDD.t13 a_35664_37695# sar_ctrl_async_phys_0.sg13g2_buf_1_4.A VDD.t13 sg13_lv_pmos ad=0.1918p pd=1.5u as=0.3808p ps=2.92u w=1.12u l=0.13u
X819 sar_ctrl_async_phys_0.sg13g2_a22oi_1_1.B2 a_32698_31388# VDD.t40 VDD.t39 sg13_lv_pmos ad=0.3808p pd=2.92u as=0.2128p ps=1.5u w=1.12u l=0.13u
X820 a_34261_43495# sar_ctrl_async_phys_0.sg13g2_dfrbpq_1_0.CLK VDD.t485 VDD.t0 sg13_lv_pmos ad=0.4088p pd=2.97u as=2.2076p ps=14.4u w=1.12u l=0.13u
X821 VDD.t191 VSS.t899 VDD.t191 VDD.t13 sg13_lv_pmos ad=0.19p pd=1.38u as=0 ps=0 w=1u l=1u
X822 oa_sar8_acore18_opt_0.sw_bitcell_opt_b5_1.bot.t0 oa_sar8_acore18_opt_0.sw_bitcell_opt_term_0.trkb.t24 oa_sar8_acore18_opt_0.bstrap_opt_w2_c1200_1.out VDD.t613 sg13_lv_pmos ad=0.39p pd=2.39u as=0.7p ps=4.7u w=2u l=0.13u
X823 a_34132_30944# a_34106_30849# VDD.t573 VDD.t39 sg13_lv_pmos ad=0.34p pd=2.68u as=0.36237p ps=2.605u w=1u l=0.13u
X824 a_34132_34416# a_34106_34380# VDD.t198 VDD.t54 sg13_lv_pmos ad=0.34p pd=2.68u as=0.36237p ps=2.605u w=1u l=0.13u
X825 a_27530_39666# sar_ctrl_async_phys_0.sg13g2_dlygate4sd3_1_4.A VSS.t160 VSS.t89 sg13_lv_nmos ad=0.1428p pd=1.52u as=79.8f ps=0.8u w=0.42u l=0.13u
X826 a_31093_39677# sar_ctrl_async_phys_0.sg13g2_dfrbpq_1_0.CLK.t18 VDD.t311 VDD.t311 sg13_lv_pmos ad=0.4088p pd=2.97u as=1.55472p ps=9.945u w=1.12u l=0.13u
X827 oa_sar8_acore18_opt_0.sw_tg_opt_1.bot.t3 oa_sar8_acore18_opt_0.sw_bitcell_opt_b7_1.bot.t89 cap_cmim l=2.14u w=2.14u
X828 oa_sar8_acore18_opt_0.sw_bitcell_opt_b1_0.bot.t1 sar_ctrl_async_phys_0.dac_code[1] VDD.t499 VDD.t497 sg13_lv_pmos ad=0.663p pd=3.79u as=1.19p ps=7.5u w=3.4u l=0.13u
X829 a_33951_45823# a_33109_45725# a_32692_46064# VDD.t29 sg13_lv_pmos ad=0.2048p pd=1.63u as=0.34p ps=2.68u w=1u l=0.13u
X830 VDD.t314 a_33375_40821# a_34042_40460# VDD.t311 sg13_lv_pmos ad=0.2128p pd=1.5u as=0.3864p ps=2.93u w=1.12u l=0.13u
X831 a_31140_42690# sar_ctrl_async_phys_0.sg13g2_and2_1_5.X VSS.t346 VSS.t1080 sg13_lv_nmos ad=0.187p pd=1.78u as=0.17255p ps=1.25u w=0.55u l=0.13u
X832 VSS.t368 a_31644_36638# sar_ctrl_async_phys_0.sg13g2_buf_1_13.X VSS.t1166 sg13_lv_nmos ad=0.14875p pd=1.16u as=0.2886p ps=2.26u w=0.74u l=0.13u
X833 VSS.t98 a_32031_31749# a_32698_31388# VSS.t333 sg13_lv_nmos ad=0.1406p pd=1.12u as=0.2516p ps=2.16u w=0.74u l=0.13u
X834 oa_sar8_acore18_opt_0.sw_tg_opt_0.bot.t3 oa_sar8_acore18_opt_0.sw_bitcell_opt_b6_0.bot.t15 cap_cmim l=2.14u w=2.14u
X835 VDD.t194 VSS.t1031 VDD.t189 VDD.t39 sg13_lv_pmos ad=0.19p pd=1.38u as=0 ps=0 w=1u l=1u
X836 sar_ctrl_async_phys_0.sg13g2_inv_1_0.Y sar_ctrl_async_phys_0.sg13g2_inv_1_0.A VDD.t342 VDD.t118 sg13_lv_pmos ad=0.3808p pd=2.92u as=0.3808p ps=2.92u w=1.12u l=0.13u
X837 a_28410_39996# sar_ctrl_async_phys_0.sg13g2_o21ai_1_1.A2 VDD.t319 VDD.t311 sg13_lv_pmos ad=0.1176p pd=1.33u as=0.4032p ps=2.96u w=1.12u l=0.13u
X838 sar_ctrl_async_phys_0.sg13g2_buf_1_44.A sar_ctrl_async_phys_0.sg13g2_nand2_1_2.A a_35786_45750# VSS.t498 sg13_lv_nmos ad=0.2516p pd=2.16u as=0.1406p ps=1.12u w=0.74u l=0.13u
X839 VDD.t311 a_32192_39918# a_32137_40013# VDD.t311 sg13_lv_pmos ad=1.6658p pd=10.66u as=93.45f ps=0.865u w=0.42u l=0.13u
X840 a_33359_32876# sar_ctrl_async_phys_0.sg13g2_a22oi_1_0.A1.t5 VDD.t343 VDD.t118 sg13_lv_pmos ad=0.2716p pd=1.605u as=0.3808p ps=2.92u w=1.12u l=0.13u
X841 oa_sar8_acore18_opt_0.sw_tg_opt_0.bot.t3 oa_sar8_acore18_opt_0.sw_bitcell_opt_b7_0.bot.t136 cap_cmim l=2.14u w=2.14u
X842 VDD.t312 sar_ctrl_async_phys_0.sg13g2_nor2_1_6.A a_28782_40460# VDD.t311 sg13_lv_pmos ad=0.3808p pd=2.92u as=0.2128p ps=1.5u w=1.12u l=0.13u
X843 oa_sar8_acore18_opt_0.sw_tg_opt_0.bot.t3 oa_sar8_acore18_opt_0.sw_bitcell_opt_b5_0.bot.t25 cap_cmim l=2.14u w=2.14u
X844 VSS.t115 VDD.t56 VSS.t115 VSS.t114 sg13_lv_nmos ad=0.1428p pd=1.52u as=0 ps=0 w=0.42u l=1u
X845 VSS.t25 a_33248_45238# a_32897_45357# VSS.t308 sg13_lv_nmos ad=79.8f pd=0.8u as=0.1428p ps=1.52u w=0.42u l=0.13u
X846 a_29524_39373# a_29755_38959# a_29210_38916# VSS.t206 sg13_lv_nmos ad=0.2373p pd=1.97u as=79.8f ps=0.8u w=0.42u l=0.13u
X847 VDD.t68 VSS.t677 VDD.t94 VDD.t29 sg13_lv_pmos ad=0.34p pd=2.68u as=0 ps=0 w=1u l=1u
X848 VSS.t205 sar_ctrl_async_phys_0.sg13g2_dfrbpq_1_9.RESET_B a_33652_43922# VSS.t319 sg13_lv_nmos ad=0.1626p pd=1.415u as=60.89999f ps=0.71u w=0.42u l=0.13u
X849 VSS.t133 a_28662_41214# a_28774_41278# VSS.t1088 sg13_lv_nmos ad=0.1426p pd=1.16u as=0.1428p ps=1.52u w=0.42u l=0.5u
X850 a_35595_40460# sar_ctrl_async_phys_0.sg13g2_nand2b_1_2.Y sar_ctrl_async_phys_0.sg13g2_a22oi_1_2.A2 VDD.t311 sg13_lv_pmos ad=0.2128p pd=1.5u as=0.3808p ps=2.92u w=1.12u l=0.13u
X851 VDD.t209 sar_ctrl_async_phys_0.sg13g2_a21oi_1_7.A2 a_32400_41413# VDD.t5 sg13_lv_pmos ad=0.2856p pd=2.36u as=0.1596p ps=1.22u w=0.84u l=0.13u
X852 a_31802_37404# a_32245_37447# a_32185_37483# VDD.t13 sg13_lv_pmos ad=79.8f pd=0.8u as=63f ps=0.72u w=0.42u l=0.13u
X853 a_30676_35928# a_30650_35892# VDD.t185 VDD.t37 sg13_lv_pmos ad=0.34p pd=2.68u as=0.36237p ps=2.605u w=1u l=0.13u
X854 VSS.t174 a_36156_45710# sar_ctrl_async_phys_0.sg13g2_nand2_1_2.A VSS.t344 sg13_lv_nmos ad=0.14875p pd=1.16u as=0.2886p ps=2.26u w=0.74u l=0.13u
X855 a_34166_44247# sar_ctrl_async_phys_0.sg13g2_dfrbpq_1_9.RESET_B VSS.t205 VSS.t304 sg13_lv_nmos ad=37.8f pd=0.6u as=0.1701p ps=1.65u w=0.42u l=0.13u
X856 VDD.t474 sar_ctrl_async_phys_0.cmp_p sar_ctrl_async_phys_0.cmp_n VDD.t473 sg13_lv_pmos ad=1.05p pd=6.7u as=0.585p ps=3.39u w=3u l=0.13u
X857 VSS.t154 VDD.t163 VSS.t154 VSS.t869 sg13_lv_nmos ad=0.1428p pd=1.52u as=0 ps=0 w=0.42u l=1u
X858 VSS.t144 VDD.t361 VSS.t144 VSS.t866 sg13_lv_nmos ad=79.8f pd=0.8u as=0 ps=0 w=0.42u l=1u
X859 oa_sar8_acore18_opt_0.sw_tg_opt_0.bot.t3 oa_sar8_acore18_opt_0.sw_bitcell_opt_b5_0.bot.t15 cap_cmim l=2.14u w=2.14u
X860 VDD.t182 VSS.t1008 VDD.t61 VDD.t39 sg13_lv_pmos ad=0.19p pd=1.38u as=0 ps=0 w=1u l=1u
X861 sar_ctrl_async_phys_0.sg13g2_buf_1_2.A a_34520_33688# VDD.t371 VDD.t54 sg13_lv_pmos ad=0.42p pd=2.99u as=0.2114p ps=1.54u w=1.12u l=0.13u
X862 VDD.t198 sar_ctrl_async_phys_0.sg13g2_inv_1_2.A sar_ctrl_async_phys_0.sg13g2_inv_1_2.Y VDD.t54 sg13_lv_pmos ad=0.3808p pd=2.92u as=0.3808p ps=2.92u w=1.12u l=0.13u
X863 a_34266_37436# sar_ctrl_async_phys_0.sg13g2_a22oi_1_0.A1 sar_ctrl_async_phys_0.sg13g2_nor2_1_2.A VDD.t13 sg13_lv_pmos ad=0.1176p pd=1.33u as=0.3808p ps=2.92u w=1.12u l=0.13u
X864 oa_sar8_acore18_opt_0.sw_tg_opt_0.bot.t3 oa_sar8_acore18_opt_0.sw_bitcell_opt_b7_0.bot.t65 cap_cmim l=2.14u w=2.14u
X865 VSS.t672 VDD.t101 VSS.t672 VSS.t675 sg13_lv_nmos ad=79.8f pd=0.8u as=0 ps=0 w=0.42u l=1u
X866 a_33626_41433# a_34069_41189# a_34009_41601# VDD.t5 sg13_lv_pmos ad=79.8f pd=0.8u as=63f ps=0.72u w=0.42u l=0.13u
X867 a_32089_45043# a_31732_45000# VDD.t117 VDD.t69 sg13_lv_pmos ad=63f pd=0.72u as=0.1563p ps=1.22u w=0.42u l=0.13u
X868 sar_ctrl_async_phys_0.bit_active[5] a_36056_37436# VDD.t819 VDD.t13 sg13_lv_pmos ad=0.42p pd=2.99u as=0.2114p ps=1.54u w=1.12u l=0.13u
X869 oa_sar8_acore18_opt_0.sw_bitcell_opt_term_0.VSS VDD.t1092 oa_sar8_acore18_opt_0.sw_bitcell_opt_term_0.bot.t0 VSS.t1076 sg13_lv_nmos ad=0.525p pd=3.7u as=0.2925p ps=1.89u w=1.5u l=0.13u
X870 oa_sar8_acore18_opt_0.sw_tg_opt_1.bot.t2 oa_sar8_acore18_opt_0.sw_bitcell_opt_b7_1.bot.t162 cap_cmim l=2.14u w=2.14u
X871 oa_sar8_acore18_opt_0.sw_bitcell_opt_b4_0.bot.t0 sar_ctrl_async_phys_0.dac_code[4] oa_sar8_acore18_opt_0.sw_bitcell_opt_term_0.VSS VSS.t416 sg13_lv_nmos ad=0.468p pd=2.79u as=0.84p ps=5.5u w=2.4u l=0.13u
X872 a_30650_35892# a_31093_35935# a_30390_36362# VSS.t1218 sg13_lv_nmos ad=79.8f pd=0.8u as=0.1296p ps=1.52u w=0.42u l=0.13u
X873 VSS.t11 sar_ctrl_async_phys_0.sg13g2_buf_1_3.A.t1 a_34520_33688# VSS.t104 sg13_lv_nmos ad=0.14875p pd=1.16u as=0.187p ps=1.78u w=0.55u l=0.13u
X874 VSS.t972 VDD.t238 VSS.t971 VSS.t970 sg13_lv_nmos ad=0.1428p pd=1.52u as=0 ps=0 w=0.42u l=1u
X875 VSS.t677 VDD.t16 VSS.t677 VSS.t682 sg13_lv_nmos ad=79.8f pd=0.8u as=0 ps=0 w=0.42u l=1u
X876 oa_sar8_acore18_opt_0.sw_tg_opt_0.bot.t3 oa_sar8_acore18_opt_0.sw_bitcell_opt_b6_0.bot.t22 cap_cmim l=2.14u w=2.14u
X877 oa_sar8_acore18_opt_0.sw_tg_opt_0.bot.t4 oa_sar8_acore18_opt_0.sw_bitcell_opt_b7_0.bot.t15 cap_cmim l=2.14u w=2.14u
X878 a_31933_43832# sar_ctrl_async_phys_0.sg13g2_a21oi_1_4.A2 VDD.t366 VDD.t0 sg13_lv_pmos ad=0.1596p pd=1.22u as=0.2856p ps=2.36u w=0.84u l=0.13u
X879 oa_sar8_acore18_opt_0.sw_tg_opt_1.bot.t3 oa_sar8_acore18_opt_0.sw_bitcell_opt_b6_1.bot.t34 cap_cmim l=2.14u w=2.14u
X880 VSS.t27 a_33375_40821# a_34042_40460# VSS.t447 sg13_lv_nmos ad=0.1406p pd=1.12u as=0.2516p ps=2.16u w=0.74u l=0.13u
X881 a_30774_44234# a_31579_44356# a_31034_44457# VDD.t69 sg13_lv_pmos ad=0.1428p pd=1.52u as=79.8f ps=0.8u w=0.42u l=0.13u
X882 VSS.t801 VDD.t176 VSS.t801 VSS.t816 sg13_lv_nmos ad=0.1428p pd=1.52u as=0 ps=0 w=0.42u l=1u
X883 vinp oa_sar8_acore18_opt_0.bstrap_opt_w2_c1200_1.gb oa_sar8_acore18_opt_0.bstrap_opt_w2_c1200_1.out VSS.t1099 sg13_lv_nmos ad=0.35p pd=2.7u as=0.195p ps=1.39u w=1u l=0.13u
X884 a_32538_43484# sar_ctrl_async_phys_0.sg13g2_nor2b_1_0.A sar_ctrl_async_phys_0.sg13g2_nor2b_1_4.Y VDD.t0 sg13_lv_pmos ad=0.1176p pd=1.33u as=0.3808p ps=2.92u w=1.12u l=0.13u
X885 a_33844_39711# a_34075_39820# a_33530_39921# VSS.t377 sg13_lv_nmos ad=0.2373p pd=1.97u as=79.8f ps=0.8u w=0.42u l=0.13u
X886 VDD.t4 VSS.t72 VDD.t1 VDD.t0 sg13_lv_pmos ad=0.19p pd=1.38u as=0 ps=0 w=1u l=1u
X887 a_31140_42690# sar_ctrl_async_phys_0.sg13g2_and2_1_5.X VDD.t611 VDD.t0 sg13_lv_pmos ad=0.2856p pd=2.36u as=0.2618p ps=1.63u w=0.84u l=0.13u
X888 oa_sar8_acore18_opt_0.sw_tg_opt_0.bot.t3 oa_sar8_acore18_opt_0.sw_bitcell_opt_b3_0.bot.t6 cap_cmim l=2.14u w=2.14u
X889 oa_sar8_acore18_opt_0.sw_tg_opt_0.bot.t3 oa_sar8_acore18_opt_0.sw_bitcell_opt_b7_0.bot.t141 cap_cmim l=2.14u w=2.14u
X890 a_33375_40821# a_32533_40471# a_33281_40821# VSS.t332 sg13_lv_nmos ad=0.12665p pd=1.145u as=0.1428p ps=1.52u w=0.42u l=0.13u
X891 oa_sar8_acore18_opt_0.sw_tg_opt_1.bot.t3 oa_sar8_acore18_opt_0.sw_bitcell_opt_b4_1.bot.t23 cap_cmim l=2.14u w=2.14u
X892 sar_ctrl_async_phys_0.dac_code[2] a_35672_42760# VDD.t600 VDD.t0 sg13_lv_pmos ad=0.42p pd=2.99u as=0.2114p ps=1.54u w=1.12u l=0.13u
X893 VSS.t277 sar_ctrl_async_phys_0.sg13g2_nor2_1_5.B sar_ctrl_async_phys_0.sg13g2_nor2_1_5.Y VSS.t624 sg13_lv_nmos ad=0.2516p pd=2.16u as=0.1406p ps=1.12u w=0.74u l=0.13u
X894 oa_sar8_acore18_opt_0.sw_bitcell_opt_b7_0.bot.t1 sar_ctrl_async_phys_0.dac_code[7] VDD.t388 VDD.t386 sg13_lv_pmos ad=1.326p pd=7.19u as=2.38p ps=14.3u w=6.8u l=0.13u
X895 VDD.t485 a_30879_43845# a_31136_43726# VDD.t0 sg13_lv_pmos ad=2.48357p pd=16.205u as=79.8f ps=0.8u w=0.42u l=0.13u
X896 oa_sar8_acore18_opt_0.sw_tg_opt_1.bot.t3 oa_sar8_acore18_opt_0.sw_bitcell_opt_b7_1.bot.t30 cap_cmim l=2.14u w=2.14u
X897 VDD.t415 sar_ctrl_async_phys_0.sg13g2_dfrbpq_1_9.RESET_B a_33914_44457# VDD.t69 sg13_lv_pmos ad=0.1563p pd=1.22u as=0.147p ps=1.54u w=0.42u l=0.13u
X898 oa_sar8_acore18_opt_0.sw_tg_opt_1.bot.t3 oa_sar8_acore18_opt_0.sw_bitcell_opt_b4_1.bot.t3 cap_cmim l=2.14u w=2.14u
X899 oa_sar8_acore18_opt_0.sw_tg_opt_1.bot.t3 oa_sar8_acore18_opt_0.sw_bitcell_opt_b7_1.bot.t106 cap_cmim l=2.14u w=2.14u
X900 VSS.t920 VDD.t192 VSS.t920 VSS.t114 sg13_lv_nmos ad=79.8f pd=0.8u as=0 ps=0 w=0.42u l=1u
X901 VSS.t129 VDD.t22 VSS.t129 VSS.t61 sg13_lv_nmos ad=79.8f pd=0.8u as=0 ps=0 w=0.42u l=1u
X902 oa_sar8_acore18_opt_0.sw_tg_opt_0.bot.t3 oa_sar8_acore18_opt_0.sw_bitcell_opt_b6_0.bot.t5 cap_cmim l=2.14u w=2.14u
X903 w_39600_n9960# a_35948_n9612# cap_cmim l=9.94u w=39.8u
X904 VDD.t212 VSS.t984 VDD.t55 VDD.t54 sg13_lv_pmos ad=0.19p pd=1.38u as=0 ps=0 w=1u l=1u
X905 a_31540_35162# sar_ctrl_async_phys_0.sg13g2_dfrbpq_1_1.D a_31446_35162# VSS.t114 sg13_lv_nmos ad=60.89999f pd=0.71u as=0.1428p ps=1.52u w=0.42u l=0.13u
X906 sar_ctrl_async_phys_0.sg13g2_nor2_1_4.Y sar_ctrl_async_phys_0.sg13g2_buf_1_26.X a_26394_37436# VDD.t13 sg13_lv_pmos ad=0.3808p pd=2.92u as=0.1176p ps=1.33u w=1.12u l=0.13u
X907 oa_sar8_acore18_opt_0.sw_tg_opt_0.bot.t3 oa_sar8_acore18_opt_0.sw_bitcell_opt_b7_0.bot.t40 cap_cmim l=2.14u w=2.14u
X908 vinp oa_sar8_acore18_opt_0.bstrap_opt_w2_c1200_1.gb a_20412_n9612# VSS.t1100 sg13_lv_nmos ad=0.345p pd=2.69u as=0.19p ps=1.38u w=1u l=0.15u
X909 oa_sar8_acore18_opt_0.bstrap_opt_w2_c1200_1.out oa_sar8_acore18_opt_0.sw_bitcell_opt_term_0.trkb.t22 oa_sar8_acore18_opt_0.sw_bitcell_opt_b7_1.bot.t0 VDD.t616 sg13_lv_pmos ad=0.7p pd=4.7u as=0.39p ps=2.39u w=2u l=0.13u
X910 sar_ctrl_async_phys_0.sg13g2_a21oi_1_3.A2 a_35482_39996# VDD.t384 VDD.t311 sg13_lv_pmos ad=0.3808p pd=2.92u as=0.2128p ps=1.5u w=1.12u l=0.13u
X911 oa_sar8_acore18_opt_0.sw_tg_opt_1.bot.t3 oa_sar8_acore18_opt_0.sw_bitcell_opt_b7_1.bot.t146 cap_cmim l=2.14u w=2.14u
X912 a_35391_33261# a_34549_32911# a_35297_33261# VSS.t152 sg13_lv_nmos ad=0.12665p pd=1.145u as=0.1428p ps=1.52u w=0.42u l=0.13u
X913 VSS.t40 VDD.t247 VSS.t56 VSS.t196 sg13_lv_nmos ad=79.8f pd=0.8u as=0 ps=0 w=0.42u l=1u
X914 a_35648_33142# sar_ctrl_async_phys_0.sg13g2_buf_1_2.X VDD.t340 VDD.t118 sg13_lv_pmos ad=79.8f pd=0.8u as=1.79957p ps=11.62u w=0.42u l=0.13u
X915 a_27894_35924# a_27624_35965# VDD.t192 VDD.t37 sg13_lv_pmos ad=0.34p pd=2.68u as=0.1523p ps=1.38u w=1u l=0.5u
X916 a_31823_32876# sar_ctrl_async_phys_0.sg13g2_a22oi_1_0.A1.t7 VDD.t343 VDD.t118 sg13_lv_pmos ad=0.2716p pd=1.605u as=0.3808p ps=2.92u w=1.12u l=0.13u
X917 a_33940_33338# sar_ctrl_async_phys_0.sg13g2_inv_1_2.Y a_33846_33338# VSS.t6 sg13_lv_nmos ad=60.89999f pd=0.71u as=0.1428p ps=1.52u w=0.42u l=0.13u
X918 a_34731_37436# sar_ctrl_async_phys_0.sg13g2_a21oi_1_1.B1 sar_ctrl_async_phys_0.sg13g2_a21oi_1_1.Y VDD.t13 sg13_lv_pmos ad=0.2128p pd=1.5u as=0.3808p ps=2.92u w=1.12u l=0.13u
X919 oa_sar8_acore18_opt_0.sw_tg_opt_1.bot.t3 oa_sar8_acore18_opt_0.sw_bitcell_opt_b7_1.bot.t62 cap_cmim l=2.14u w=2.14u
X920 VDD.t37 a_31093_35935# a_31195_35935# VDD.t37 sg13_lv_pmos ad=1.79957p pd=11.62u as=0.3864p ps=2.93u w=1.12u l=0.13u
X921 sar_ctrl_async_phys_0.dac_code_n[4] a_35672_47296# VSS.t75 VSS.t61 sg13_lv_nmos ad=0.2886p pd=2.26u as=0.14875p ps=1.16u w=0.74u l=0.13u
X922 sar_ctrl_async_phys_0.sg13g2_a21oi_1_5.B1 a_35245_45936# VDD.t35 VDD.t29 sg13_lv_pmos ad=0.2128p pd=1.5u as=0.3808p ps=2.92u w=1.12u l=0.13u
X923 VSS.t115 sar_ctrl_async_phys_0.sg13g2_a22oi_1_2.B1 a_31832_34412# VSS.t1188 sg13_lv_nmos ad=0.14875p pd=1.16u as=0.187p ps=1.78u w=0.55u l=0.13u
X924 a_34069_41189# sar_ctrl_async_phys_0.sg13g2_dfrbpq_1_0.CLK.t22 VSS.t266 VSS.t265 sg13_lv_nmos ad=0.2516p pd=2.16u as=4.20675p ps=26.86u w=0.74u l=0.13u
X925 oa_sar8_acore18_opt_0.sw_tg_opt_0.bot.t3 oa_sar8_acore18_opt_0.sw_bitcell_opt_b7_0.bot.t99 cap_cmim l=2.14u w=2.14u
X926 VDD.t325 a_34911_41287# a_35168_41430# VDD.t5 sg13_lv_pmos ad=3.62845p pd=23.965u as=79.8f ps=0.8u w=0.42u l=0.13u
X927 VSS.t471 VDD.t165 VSS.t471 VSS.t874 sg13_lv_nmos ad=0.1428p pd=1.52u as=0 ps=0 w=0.42u l=1u
X928 VSS.t283 a_33252_36642# sar_ctrl_async_phys_0.sg13g2_nor2_1_1.A VSS.t85 sg13_lv_nmos ad=0.17255p pd=1.25u as=0.1406p ps=1.12u w=0.74u l=0.13u
X929 oa_sar8_acore18_opt_0.sw_bitcell_opt_b7_1.VSS sar_ctrl_async_phys_0.dac_code_n[7] oa_sar8_acore18_opt_0.sw_bitcell_opt_b7_1.bot.t0 VSS.t1097 sg13_lv_nmos ad=1.19p pd=7.5u as=0.663p ps=3.79u w=3.4u l=0.13u
X930 VDD.t101 VSS.t672 VDD.t101 VDD.t15 sg13_lv_pmos ad=0.19p pd=1.38u as=0 ps=0 w=1u l=1u
X931 VSS.t794 VDD.t146 VSS.t774 VSS.t185 sg13_lv_nmos ad=0.1428p pd=1.52u as=0 ps=0 w=0.42u l=1u
X932 VSS.t84 a_28758_35924# a_28870_35948# VSS.t299 sg13_lv_nmos ad=0.1426p pd=1.16u as=0.1428p ps=1.52u w=0.42u l=0.5u
X933 VSS.t727 VDD.t76 VSS.t730 VSS.t729 sg13_lv_nmos ad=79.8f pd=0.8u as=0 ps=0 w=0.42u l=1u
X934 VSS.t471 sar_ctrl_async_phys_0.sg13g2_a21oi_1_2.A2 a_31355_38232# VSS.t619 sg13_lv_nmos ad=0.1331p pd=1.12u as=0.1216p ps=1.02u w=0.64u l=0.13u
X935 a_35557_31435# sar_ctrl_async_phys_0.sg13g2_buf_1_2.X VDD.t547 VDD.t39 sg13_lv_pmos ad=0.147p pd=1.54u as=0.1563p ps=1.22u w=0.42u l=0.13u
X936 a_31381_46519# sar_ctrl_async_phys_0.sg13g2_dfrbpq_1_0.CLK VSS.t518 VSS.t517 sg13_lv_nmos ad=0.2516p pd=2.16u as=9.09497p ps=59.065u w=0.74u l=0.13u
X937 VSS.t926 VDD.t238 VSS.t920 VSS.t114 sg13_lv_nmos ad=0.1428p pd=1.52u as=0 ps=0 w=0.42u l=1u
X938 oa_sar8_acore18_opt_0.sw_bitcell_opt_term_0.VSS sar_ctrl_async_phys_0.dac_code[1] oa_sar8_acore18_opt_0.sw_bitcell_opt_b1_0.bot.t0 VSS.t282 sg13_lv_nmos ad=0.595p pd=4.1u as=0.3315p ps=2.09u w=1.7u l=0.13u
X939 oa_sar8_acore18_opt_0.sw_tg_opt_1.bot.t3 oa_sar8_acore18_opt_0.sw_bitcell_opt_b6_1.bot.t61 cap_cmim l=2.14u w=2.14u
X940 VDD.t192 VSS.t926 VDD.t192 VDD.t37 sg13_lv_pmos ad=0.34p pd=2.68u as=0 ps=0 w=1u l=1u
X941 VDD.t35 sar_ctrl_async_phys_0.sg13g2_nand2b_1_1.Y a_35672_46508# VDD.t29 sg13_lv_pmos ad=0.2114p pd=1.54u as=0.2856p ps=2.36u w=0.84u l=0.13u
X942 VDD.t340 a_30591_32215# a_30848_32358# VDD.t118 sg13_lv_pmos ad=1.96315p pd=12.675u as=79.8f ps=0.8u w=0.42u l=0.13u
X943 VSS.t1044 VDD.t61 VSS.t1046 VSS.t1045 sg13_lv_nmos ad=79.8f pd=0.8u as=0 ps=0 w=0.42u l=1u
X944 a_31665_42748# sar_ctrl_async_phys_0.sg13g2_a21oi_1_0.A1.t6 sar_ctrl_async_phys_0.sg13g2_a22oi_1_5.A2 VSS.t120 sg13_lv_nmos ad=0.1406p pd=1.12u as=0.1406p ps=1.12u w=0.74u l=0.13u
X945 VDD.t4 VSS.t771 VDD.t1 VDD.t0 sg13_lv_pmos ad=0.34p pd=2.68u as=0 ps=0 w=1u l=1u
X946 VSS.t31 sar_ctrl_async_phys_0.sg13g2_dfrbpq_1_22.D sar_ctrl_async_phys_0.sg13g2_dfrbpq_1_11.D VSS.t196 sg13_lv_nmos ad=0.2516p pd=2.16u as=0.1406p ps=1.12u w=0.74u l=0.13u
X947 VSS.t88 sar_ctrl_async_phys_0.sg13g2_buf_1_13.A a_35288_38224# VSS.t87 sg13_lv_nmos ad=0.14875p pd=1.16u as=0.187p ps=1.78u w=0.55u l=0.13u
X948 VSS.t346 VDD.t36 VSS.t137 VSS.t819 sg13_lv_nmos ad=0.1428p pd=1.52u as=0 ps=0 w=0.42u l=1u
X949 oa_sar8_acore18_opt_0.sw_tg_opt_0.bot.t3 oa_sar8_acore18_opt_0.sw_bitcell_opt_b7_0.bot.t110 cap_cmim l=2.14u w=2.14u
X950 VDD.t1002 sar_ctrl_async_phys_0.dac_code_n[1].t2 oa_sar8_acore18_opt_0.sw_bitcell_opt_b1_1.bot.t5 VDD.t1001 sg13_lv_pmos ad=1.19p pd=7.5u as=0.663p ps=3.79u w=3.4u l=0.13u
X951 a_27134_39887# a_27249_39888# VDD.t363 VDD.t311 sg13_lv_pmos ad=0.34p pd=2.68u as=0.2254p ps=1.53u w=1u l=0.5u
X952 oa_sar8_acore18_opt_0.sw_tg_opt_0.bot.t4 oa_sar8_acore18_opt_0.sw_bitcell_opt_b7_0.bot.t5 cap_cmim l=2.14u w=2.14u
X953 VSS.t60 sar_ctrl_async_phys_0.sg13g2_nor4_1_0.C sar_ctrl_async_phys_0.sg13g2_nor4_1_0.Y VSS.t59 sg13_lv_nmos ad=0.1406p pd=1.12u as=0.1406p ps=1.12u w=0.74u l=0.13u
X954 VDD.t35 a_33951_45823# a_34618_46044# VDD.t29 sg13_lv_pmos ad=0.2128p pd=1.5u as=0.3864p ps=2.93u w=1.12u l=0.13u
X955 VSS.t776 VDD.t79 VSS.t775 VSS.t185 sg13_lv_nmos ad=0.1428p pd=1.52u as=0 ps=0 w=0.42u l=1u
X956 oa_sar8_acore18_opt_0.sw_bitcell_opt_b5_1.bot.t41 sar_ctrl_async_phys_0.dac_code_n[5] VDD.t1014 VDD.t1012 sg13_lv_pmos ad=1.053p pd=5.79u as=1.89p ps=11.5u w=5.4u l=0.13u
X957 VDD.t16 VSS.t129 VDD.t16 VDD.t15 sg13_lv_pmos ad=0.19p pd=1.38u as=0 ps=0 w=1u l=1u
X958 VSS.t677 VDD.t94 VSS.t677 VSS.t704 sg13_lv_nmos ad=0.1428p pd=1.52u as=0 ps=0 w=0.42u l=1u
X959 busy a_35672_33688# VSS.t148 VSS.t63 sg13_lv_nmos ad=0.2886p pd=2.26u as=0.14875p ps=1.16u w=0.74u l=0.13u
X960 a_31828_37440# a_31802_37404# VSS.t471 VSS.t1222 sg13_lv_nmos ad=0.2516p pd=2.16u as=0.1626p ps=1.415u w=0.74u l=0.13u
X961 oa_sar8_acore18_opt_0.sw_tg_opt_0.bot.t3 oa_sar8_acore18_opt_0.sw_bitcell_opt_term_0.bot.t2 cap_cmim l=2.14u w=2.14u
X962 sar_ctrl_async_phys_0.sg13g2_inv_1_1.A sar_ctrl_async_phys_0.sg13g2_buf_1_9.A a_32687_33292# VSS.t6 sg13_lv_nmos ad=0.2664p pd=1.46u as=0.13875p ps=1.115u w=0.74u l=0.13u
X963 VDD.t37 a_32192_36166# a_32137_36047# VDD.t37 sg13_lv_pmos ad=1.79957p pd=11.62u as=93.45f ps=0.865u w=0.42u l=0.13u
X964 VDD.t62 VSS.t1051 VDD.t44 VDD.t39 sg13_lv_pmos ad=0.19p pd=1.38u as=0 ps=0 w=1u l=1u
X965 a_31010_32138# sar_ctrl_async_phys_0.sg13g2_buf_1_2.X VSS.t343 VSS.t466 sg13_lv_nmos ad=37.8f pd=0.6u as=79.8f ps=0.8u w=0.42u l=0.13u
X966 VDD.t37 a_32149_35141# a_32251_35284# VDD.t37 sg13_lv_pmos ad=1.79957p pd=11.62u as=0.3864p ps=2.93u w=1.12u l=0.13u
X967 sar_ctrl_async_phys_0.sg13g2_nor2_1_7.B sar_ctrl_async_phys_0.sg13g2_nor2_1_7.Y a_28506_37436# VDD.t13 sg13_lv_pmos ad=0.3808p pd=2.92u as=0.1176p ps=1.33u w=1.12u l=0.13u
X968 a_31370_34782# sar_ctrl_async_phys_0.sg13g2_nor2b_1_0.A.t1 VSS.t115 VSS.t114 sg13_lv_nmos ad=0.1406p pd=1.12u as=0.2516p ps=2.16u w=0.74u l=0.13u
X969 oa_sar8_acore18_opt_0.sw_tg_opt_0.bot.t3 oa_sar8_acore18_opt_0.sw_bitcell_opt_b6_0.bot.t65 cap_cmim l=2.14u w=2.14u
X970 oa_sar8_acore18_opt_0.sw_bitcell_opt_term_0.VSS sar_ctrl_async_phys_0.dac_code[6].t1 oa_sar8_acore18_opt_0.sw_bitcell_opt_b6_0.bot.t1 VSS.t486 sg13_lv_nmos ad=1.05p pd=6.7u as=0.585p ps=3.39u w=3u l=0.13u
X971 result[3] a_33464_31388# VSS.t98 VSS.t14 sg13_lv_nmos ad=0.2886p pd=2.26u as=0.14875p ps=1.16u w=0.74u l=0.13u
X972 VSS.t834 VDD.t10 VSS.t58 VSS.t833 sg13_lv_nmos ad=0.1428p pd=1.52u as=0 ps=0 w=0.42u l=1u
X973 VDD.t40 rst_n a_32696_30664# VDD.t39 sg13_lv_pmos ad=0.2114p pd=1.54u as=0.2856p ps=2.36u w=0.84u l=0.13u
X974 oa_sar8_acore18_opt_0.sw_tg_opt_0.bot.t3 oa_sar8_acore18_opt_0.sw_bitcell_opt_b7_0.bot.t30 cap_cmim l=2.14u w=2.14u
X975 oa_sar8_acore18_opt_0.sw_tg_opt_0.bot.t3 oa_sar8_acore18_opt_0.sw_bitcell_opt_b6_0.bot.t35 cap_cmim l=2.14u w=2.14u
X976 VDD.t366 a_30879_43845# a_31546_43484# VDD.t0 sg13_lv_pmos ad=0.2128p pd=1.5u as=0.3864p ps=2.93u w=1.12u l=0.13u
X977 VDD.t196 VSS.t851 VDD.t276 VDD.t162 sg13_lv_pmos ad=0.19p pd=1.38u as=0 ps=0 w=1u l=1u
X978 a_20412_n9612# oa_sar8_acore18_opt_0.bstrap_opt_w2_c1200_1.gb vinp VSS.t1100 sg13_lv_nmos ad=0.19p pd=1.38u as=0.345p ps=2.69u w=1u l=0.15u
X979 VSS.t7 sar_ctrl_async_phys_0.sg13g2_buf_1_2.X.t3 a_29620_33650# VSS.t226 sg13_lv_nmos ad=0.1626p pd=1.415u as=60.89999f ps=0.71u w=0.42u l=0.13u
X980 a_29334_43922# a_30139_43495# a_29594_43452# VDD.t0 sg13_lv_pmos ad=0.1428p pd=1.52u as=79.8f ps=0.8u w=0.42u l=0.13u
X981 oa_sar8_acore18_opt_0.sw_tg_opt_0.bot.t3 oa_sar8_acore18_opt_0.sw_bitcell_opt_b6_0.bot.t55 cap_cmim l=2.14u w=2.14u
X982 VSS.t977 VDD.t242 VSS.t979 VSS.t978 sg13_lv_nmos ad=79.8f pd=0.8u as=0 ps=0 w=0.42u l=1u
X983 VSS.t684 VDD.t16 VSS.t129 VSS.t685 sg13_lv_nmos ad=79.8f pd=0.8u as=0 ps=0 w=0.42u l=1u
X984 a_30902_36349# sar_ctrl_async_phys_0.sg13g2_buf_1_2.A.t1 VSS.t182 VSS.t445 sg13_lv_nmos ad=37.8f pd=0.6u as=0.1701p ps=1.65u w=0.42u l=0.13u
X985 a_33652_43922# sar_ctrl_async_phys_0.sg13g2_nor2_1_1.Y a_33558_43922# VSS.t600 sg13_lv_nmos ad=60.89999f pd=0.71u as=0.1428p ps=1.52u w=0.42u l=0.13u
X986 VDD.t36 VSS.t346 VDD.t36 VDD.t5 sg13_lv_pmos ad=0.34p pd=2.68u as=0 ps=0 w=1u l=1u
X987 sar_ctrl_async_phys_0.sg13g2_nand3_1_0.Y sar_ctrl_async_phys_0.sg13g2_nand3_1_0.A VDD.t339 VDD.t311 sg13_lv_pmos ad=0.3808p pd=2.92u as=0.2128p ps=1.5u w=1.12u l=0.13u
X988 VSS.t354 a_25596_41174# sar_ctrl_async_phys_0.cmp_fire VSS.t453 sg13_lv_nmos ad=0.14875p pd=1.16u as=0.2886p ps=2.26u w=0.74u l=0.13u
X989 VSS.t190 a_31716_38912# sar_ctrl_async_phys_0.sg13g2_dfrbpq_1_22.D VSS.t189 sg13_lv_nmos ad=0.17255p pd=1.25u as=0.1406p ps=1.12u w=0.74u l=0.13u
X990 VSS.t1008 VDD.t182 VSS.t1008 VSS.t17 sg13_lv_nmos ad=79.8f pd=0.8u as=0 ps=0 w=0.42u l=1u
X991 VDD.t114 VSS.t739 VDD.t32 VDD.t29 sg13_lv_pmos ad=0.19p pd=1.38u as=0 ps=0 w=1u l=1u
X992 a_31490_33650# sar_ctrl_async_phys_0.sg13g2_buf_1_2.X.t2 VSS.t7 VSS.t126 sg13_lv_nmos ad=37.8f pd=0.6u as=79.8f ps=0.8u w=0.42u l=0.13u
X993 oa_sar8_acore18_opt_0.sw_tg_opt_1.bot.t3 oa_sar8_acore18_opt_0.sw_bitcell_opt_b7_1.bot.t99 cap_cmim l=2.14u w=2.14u
X994 VDD.t227 VSS.t1008 VDD.t228 VDD.t118 sg13_lv_pmos ad=0.19p pd=1.38u as=0 ps=0 w=1u l=1u
X995 a_30390_36362# a_31195_35935# a_30650_35892# VDD.t37 sg13_lv_pmos ad=0.1428p pd=1.52u as=79.8f ps=0.8u w=0.42u l=0.13u
X996 a_35053_40730# sar_ctrl_async_phys_0.sg13g2_nand2_1_1.B VSS.t27 VSS.t407 sg13_lv_nmos ad=0.187p pd=1.78u as=0.14505p ps=1.15u w=0.55u l=0.13u
X997 oa_sar8_acore18_opt_0.bstrap_opt_w2_c1200_1.out oa_sar8_acore18_opt_0.sw_bitcell_opt_term_0.trkb.t23 oa_sar8_acore18_opt_0.sw_bitcell_opt_b6_1.bot.t0 VDD.t710 sg13_lv_pmos ad=0.7p pd=4.7u as=0.39p ps=2.39u w=2u l=0.13u
X998 VDD.t311 a_31093_39677# a_31195_39820# VDD.t311 sg13_lv_pmos ad=1.6658p pd=10.66u as=0.3864p ps=2.93u w=1.12u l=0.13u
X999 a_30676_40016# a_31195_39820# a_31935_39775# VSS.t30 sg13_lv_nmos ad=0.3473p pd=2.71u as=0.12665p ps=1.145u w=0.74u l=0.13u
X1000 oa_sar8_acore18_opt_0.sw_tg_opt_1.bot.t3 oa_sar8_acore18_opt_0.sw_bitcell_opt_b6_1.bot.t9 cap_cmim l=2.14u w=2.14u
X1001 a_26550_41214# a_26280_41214# VDD.t8 VDD.t5 sg13_lv_pmos ad=0.34p pd=2.68u as=0.1523p ps=1.38u w=1u l=0.5u
X1002 VDD.t89 VSS.t727 VDD.t96 VDD.t69 sg13_lv_pmos ad=0.19p pd=1.38u as=0 ps=0 w=1u l=1u
X1003 oa_sar8_acore18_opt_0.sw_bitcell_opt_term_1.bot.t0 oa_sar8_acore18_opt_0.bstrap_opt_w2_c1200_1.gb oa_sar8_acore18_opt_0.bstrap_opt_w2_c1200_1.out VSS.t1089 sg13_lv_nmos ad=0.195p pd=1.39u as=0.35p ps=2.7u w=1u l=0.13u
X1004 result[2] a_33080_31388# VDD.t40 VDD.t39 sg13_lv_pmos ad=0.42p pd=2.99u as=0.2114p ps=1.54u w=1.12u l=0.13u
X1005 a_35952_39901# sar_ctrl_async_phys_0.sg13g2_buf_1_6.A a_36089_39744# VSS.t1264 sg13_lv_nmos ad=0.2176p pd=1.96u as=0.1216p ps=1.02u w=0.64u l=0.13u
X1006 oa_sar8_acore18_opt_0.sw_tg_opt_0.bot.t3 oa_sar8_acore18_opt_0.sw_bitcell_opt_b6_0.bot.t15 cap_cmim l=2.14u w=2.14u
X1007 a_31706_44964# a_32149_45007# a_31446_45434# VSS.t557 sg13_lv_nmos ad=79.8f pd=0.8u as=0.1296p ps=1.52u w=0.42u l=0.13u
X1008 oa_sar8_acore18_opt_0.sw_tg_opt_1.bot.t3 oa_sar8_acore18_opt_0.sw_bitcell_opt_b6_1.bot.t41 cap_cmim l=2.14u w=2.14u
X1009 VDD.t384 sar_ctrl_async_phys_0.sg13g2_a21oi_1_0.A1.t3 a_35595_40460# VDD.t311 sg13_lv_pmos ad=0.2128p pd=1.5u as=0.2128p ps=1.5u w=1.12u l=0.13u
X1010 VSS.t88 sar_ctrl_async_phys_0.sg13g2_a21oi_1_0.A2 a_35313_37784# VSS.t118 sg13_lv_nmos ad=0.2516p pd=2.16u as=0.1406p ps=1.12u w=0.74u l=0.13u
X1011 oa_sar8_acore18_opt_0.sw_bitcell_opt_b7_1.VSS sar_ctrl_async_phys_0.dac_code_n[4] oa_sar8_acore18_opt_0.sw_bitcell_opt_b4_1.bot.t0 VSS.t614 sg13_lv_nmos ad=0.84p pd=5.5u as=0.468p ps=2.79u w=2.4u l=0.13u
X1012 oa_sar8_acore18_opt_0.sw_tg_opt_0.bot.t3 oa_sar8_acore18_opt_0.sw_bitcell_opt_b0_0.bot.t2 cap_cmim l=2.14u w=2.14u
X1013 a_35648_30846# sar_ctrl_async_phys_0.sg13g2_buf_1_2.X VDD.t39 VDD.t39 sg13_lv_pmos ad=79.8f pd=0.8u as=1.79957p ps=11.62u w=0.42u l=0.13u
X1014 a_33270_39698# sar_ctrl_async_phys_0.sg13g2_nor2b_1_3.Y VDD.t314 VDD.t311 sg13_lv_pmos ad=79.8f pd=0.8u as=0.1428p ps=1.52u w=0.42u l=0.13u
X1015 VSS.t471 VDD.t163 VSS.t471 VSS.t873 sg13_lv_nmos ad=0.1428p pd=1.52u as=0 ps=0 w=0.42u l=1u
X1016 VDD.t343 sar_ctrl_async_phys_0.sg13g2_a22oi_1_1.A2 a_31823_32876# VDD.t118 sg13_lv_pmos ad=0.3808p pd=2.92u as=0.2744p ps=1.61u w=1.12u l=0.13u
X1017 VSS.t113 a_35391_34773# a_36058_34412# VSS.t199 sg13_lv_nmos ad=0.1406p pd=1.12u as=0.2516p ps=2.16u w=0.74u l=0.13u
X1018 oa_sar8_acore18_opt_0.sw_tg_opt_1.bot.t3 oa_sar8_acore18_opt_0.sw_bitcell_opt_b5_1.bot.t19 cap_cmim l=2.14u w=2.14u
X1019 VDD.t212 VSS.t981 VDD.t211 VDD.t54 sg13_lv_pmos ad=0.34p pd=2.68u as=0 ps=0 w=1u l=1u
X1020 VDD.t16 VSS.t129 VDD.t16 VDD.t15 sg13_lv_pmos ad=0.34p pd=2.68u as=0 ps=0 w=1u l=1u
X1021 VDD.t447 sar_ctrl_async_phys_0.sg13g2_buf_1_6.A a_35280_35365# VDD.t37 sg13_lv_pmos ad=0.2856p pd=2.36u as=0.1596p ps=1.22u w=0.84u l=0.13u
X1022 VDD.t485 a_35103_43845# a_35360_43726# VDD.t0 sg13_lv_pmos ad=2.48357p pd=16.205u as=79.8f ps=0.8u w=0.42u l=0.13u
X1023 VSS.t103 a_30879_43845# a_31546_43484# VSS.t1110 sg13_lv_nmos ad=0.1406p pd=1.12u as=0.2516p ps=2.16u w=0.74u l=0.13u
X1024 a_33366_41210# a_34171_41332# a_33626_41433# VDD.t5 sg13_lv_pmos ad=0.1428p pd=1.52u as=79.8f ps=0.8u w=0.42u l=0.13u
X1025 VSS.t858 VDD.t247 VSS.t50 VSS.t859 sg13_lv_nmos ad=79.8f pd=0.8u as=0 ps=0 w=0.42u l=1u
X1026 sar_ctrl_async_phys_0.dac_code[0] a_36056_46508# VSS.t75 VSS.t91 sg13_lv_nmos ad=0.2886p pd=2.26u as=0.14875p ps=1.16u w=0.74u l=0.13u
X1027 a_34526_31826# a_34767_31359# a_34055_31352# VSS.t14 sg13_lv_nmos ad=0.1428p pd=1.52u as=0.12665p ps=1.145u w=0.42u l=0.13u
X1028 VDD.t489 sar_ctrl_async_phys_0.sg13g2_buf_1_7.A a_33464_31388# VDD.t39 sg13_lv_pmos ad=0.2114p pd=1.54u as=0.2856p ps=2.36u w=0.84u l=0.13u
X1029 a_26174_42911# a_26289_42912# VSS.t72 VSS.t140 sg13_lv_nmos ad=0.1428p pd=1.52u as=0.1426p ps=1.16u w=0.42u l=0.5u
X1030 a_28578_40460# sar_ctrl_async_phys_0.sg13g2_nand2b_1_0.Y sar_ctrl_async_phys_0.sg13g2_nor4_1_0.Y VDD.t311 sg13_lv_pmos ad=0.2128p pd=1.5u as=0.4368p ps=3.02u w=1.12u l=0.13u
X1031 VDD.t14 VSS.t182 VDD.t14 VDD.t13 sg13_lv_pmos ad=0.19p pd=1.38u as=0 ps=0 w=1u l=1u
X1032 a_29140_32138# sar_ctrl_async_phys_0.sg13g2_inv_1_6.Y a_29046_32138# VSS.t17 sg13_lv_nmos ad=60.89999f pd=0.71u as=0.1428p ps=1.52u w=0.42u l=0.13u
X1033 oa_sar8_acore18_opt_0.bstrap_opt_w2_c1200_1.out oa_sar8_acore18_opt_0.sw_bitcell_opt_term_0.trkb.t26 oa_sar8_acore18_opt_0.sw_bitcell_opt_b3_1.bot.t0 VDD.t703 sg13_lv_pmos ad=0.7p pd=4.7u as=0.39p ps=2.39u w=2u l=0.13u
X1034 oa_sar8_acore18_opt_0.sw_tg_opt_0.bot.t3 oa_sar8_acore18_opt_0.sw_bitcell_opt_b5_0.bot.t30 cap_cmim l=2.14u w=2.14u
X1035 a_31706_35385# a_32149_35141# a_31446_35162# VSS.t1254 sg13_lv_nmos ad=79.8f pd=0.8u as=0.1296p ps=1.52u w=0.42u l=0.13u
X1036 VSS.t837 VDD.t187 VSS.t133 VSS.t836 sg13_lv_nmos ad=0.1428p pd=1.52u as=0 ps=0 w=0.42u l=1u
X1037 VDD.t500 a_33087_37797# a_33754_37436# VDD.t13 sg13_lv_pmos ad=0.2128p pd=1.5u as=0.3864p ps=2.93u w=1.12u l=0.13u
X1038 VSS.t892 VDD.t191 VSS.t894 VSS.t893 sg13_lv_nmos ad=79.8f pd=0.8u as=0 ps=0 w=0.42u l=1u
X1039 a_31732_35480# a_31706_35385# VSS.t115 VSS.t578 sg13_lv_nmos ad=0.2516p pd=2.16u as=0.1626p ps=1.415u w=0.74u l=0.13u
X1040 a_32245_37447# sar_ctrl_async_phys_0.sg13g2_dfrbpq_1_0.CLK.t14 VSS.t606 VSS.t605 sg13_lv_nmos ad=0.2516p pd=2.16u as=9.86937p ps=64.34499u w=0.74u l=0.13u
X1041 VSS.t113 sar_ctrl_async_phys_0.sg13g2_buf_1_23.A a_35672_35200# VSS.t203 sg13_lv_nmos ad=0.14875p pd=1.16u as=0.187p ps=1.78u w=0.55u l=0.13u
X1042 a_34308_37400# sar_ctrl_async_phys_0.sg13g2_buf_1_23.A VDD.t382 VDD.t13 sg13_lv_pmos ad=0.2856p pd=2.36u as=0.2618p ps=1.63u w=0.84u l=0.13u
X1043 oa_sar8_acore18_opt_0.sw_bitcell_opt_b7_1.bot.t0 oa_sar8_acore18_opt_0.sw_bitcell_opt_term_0.trkb.t22 oa_sar8_acore18_opt_0.bstrap_opt_w2_c1200_1.out VDD.t616 sg13_lv_pmos ad=0.39p pd=2.39u as=0.7p ps=4.7u w=2u l=0.13u
X1044 VSS.t231 VDD.t70 VSS.t722 VSS.t750 sg13_lv_nmos ad=79.8f pd=0.8u as=0 ps=0 w=0.42u l=1u
X1045 oa_sar8_acore18_opt_0.sw_bitcell_opt_term_1.bot.t0 VDD.t1093 oa_sar8_acore18_opt_0.sw_bitcell_opt_b7_1.VSS VSS.t1075 sg13_lv_nmos ad=0.2925p pd=1.89u as=0.525p ps=3.7u w=1.5u l=0.13u
X1046 a_29749_32117# sar_ctrl_async_phys_0.sg13g2_dfrbpq_1_0.CLK.t5 VSS.t69 VSS.t68 sg13_lv_nmos ad=0.2516p pd=2.16u as=3.35542p ps=21.09u w=0.74u l=0.13u
X1047 VSS.t277 a_27894_35924# a_28006_35948# VSS.t292 sg13_lv_nmos ad=0.1426p pd=1.16u as=0.1428p ps=1.52u w=0.42u l=0.5u
X1048 oa_sar8_acore18_opt_0.sw_tg_opt_0.bot.t3 oa_sar8_acore18_opt_0.sw_bitcell_opt_b6_0.bot.t25 cap_cmim l=2.14u w=2.14u
X1049 oa_sar8_acore18_opt_0.sw_tg_opt_0.bot.t3 oa_sar8_acore18_opt_0.sw_bitcell_opt_b7_0.bot.t20 cap_cmim l=2.14u w=2.14u
X1050 a_35497_36047# a_34555_35935# a_35295_36285# VDD.t37 sg13_lv_pmos ad=93.45f pd=0.865u as=0.2048p ps=1.63u w=0.42u l=0.13u
X1051 sar_ctrl_async_phys_0.sg13g2_nor2_1_11.Y sar_ctrl_async_phys_0.sg13g2_nor2_1_11.A VSS.t346 VSS.t1299 sg13_lv_nmos ad=0.1406p pd=1.12u as=0.2516p ps=2.16u w=0.74u l=0.13u
X1052 oa_sar8_acore18_opt_0.sw_bitcell_opt_b7_1.VSS sar_ctrl_async_phys_0.dac_code_n[5] oa_sar8_acore18_opt_0.sw_bitcell_opt_b5_1.bot.t0 VSS.t1225 sg13_lv_nmos ad=0.945p pd=6.1u as=0.5265p ps=3.09u w=2.7u l=0.13u
X1053 VSS.t129 VDD.t16 VSS.t129 VSS.t690 sg13_lv_nmos ad=0.1428p pd=1.52u as=0 ps=0 w=0.42u l=1u
X1054 a_35402_42726# sar_ctrl_async_phys_0.sg13g2_nand2_1_3.B VSS.t178 VSS.t505 sg13_lv_nmos ad=0.1406p pd=1.12u as=0.2516p ps=2.16u w=0.74u l=0.13u
X1055 a_30783_40821# a_29941_40471# a_30689_40821# VSS.t44 sg13_lv_nmos ad=0.12665p pd=1.145u as=0.1428p ps=1.52u w=0.42u l=0.13u
X1056 a_29593_38995# a_29236_38952# VDD.t163 VDD.t162 sg13_lv_pmos ad=63f pd=0.72u as=0.1563p ps=1.22u w=0.42u l=0.13u
X1057 VDD.t42 a_32991_35239# a_33658_35460# VDD.t37 sg13_lv_pmos ad=0.2128p pd=1.5u as=0.3864p ps=2.93u w=1.12u l=0.13u
X1058 VDD.t13 a_35103_36751# a_35360_36894# VDD.t13 sg13_lv_pmos ad=2.48357p pd=16.205u as=79.8f ps=0.8u w=0.42u l=0.13u
X1059 VSS.t801 VDD.t179 VSS.t801 VSS.t818 sg13_lv_nmos ad=0.1428p pd=1.52u as=0 ps=0 w=0.42u l=1u
X1060 VDD.t179 sar_ctrl_async_phys_0.sg13g2_nand2b_1_0.A_N a_28392_41214# VDD.t5 sg13_lv_pmos ad=0.1523p pd=1.38u as=0.1428p ps=1.52u w=0.42u l=0.13u
X1061 sar_ctrl_async_phys_0.sg13g2_o21ai_1_1.A2 sar_ctrl_async_phys_0.sg13g2_nor2_1_3.B a_27304_38928# VDD.t162 sg13_lv_pmos ad=0.2128p pd=1.5u as=0.2128p ps=1.5u w=1.12u l=0.15u
X1062 a_28662_41214# a_28392_41214# VDD.t179 VDD.t5 sg13_lv_pmos ad=0.34p pd=2.68u as=0.1523p ps=1.38u w=1u l=0.5u
X1063 oa_sar8_acore18_opt_0.sw_tg_opt_1.bot.t2 oa_sar8_acore18_opt_0.sw_bitcell_opt_b7_1.bot.t152 cap_cmim l=2.14u w=2.14u
X1064 VDD.t242 VSS.t926 VDD.t244 VDD.t54 sg13_lv_pmos ad=0.19p pd=1.38u as=0 ps=0 w=1u l=1u
X1065 a_34765_42242# sar_ctrl_async_phys_0.sg13g2_a21oi_1_2.B1 VSS.t178 VSS.t572 sg13_lv_nmos ad=0.187p pd=1.78u as=0.14505p ps=1.15u w=0.55u l=0.13u
X1066 a_32580_36642# sar_ctrl_async_phys_0.sg13g2_buf_1_4.A VDD.t676 VDD.t13 sg13_lv_pmos ad=0.2856p pd=2.36u as=0.2618p ps=1.63u w=0.84u l=0.13u
X1067 VSS.t677 VDD.t128 VSS.t677 VSS.t707 sg13_lv_nmos ad=79.8f pd=0.8u as=0 ps=0 w=0.42u l=1u
X1068 oa_sar8_acore18_opt_0.sw_tg_opt_0.bot.t3 oa_sar8_acore18_opt_0.sw_bitcell_opt_b7_0.bot.t22 cap_cmim l=2.14u w=2.14u
X1069 VDD.t119 VSS.t964 VDD.t119 VDD.t118 sg13_lv_pmos ad=0.19p pd=1.38u as=0 ps=0 w=1u l=1u
X1070 sar_ctrl_async_phys_0.sg13g2_buf_1_34.A sar_ctrl_async_phys_0.sg13g2_nand2_1_2.A a_35402_46878# VSS.t91 sg13_lv_nmos ad=0.2516p pd=2.16u as=0.1406p ps=1.12u w=0.74u l=0.13u
X1071 VSS.t260 a_34911_41287# a_35578_41508# VSS.t594 sg13_lv_nmos ad=0.1406p pd=1.12u as=0.2516p ps=2.16u w=0.74u l=0.13u
X1072 oa_sar8_acore18_opt_0.sw_tg_opt_1.bot.t3 oa_sar8_acore18_opt_0.sw_bitcell_opt_b7_1.bot.t35 cap_cmim l=2.14u w=2.14u
X1073 VDD.t366 sar_ctrl_async_phys_0.sg13g2_a21oi_1_0.A1.t6 a_31563_43020# VDD.t0 sg13_lv_pmos ad=0.2128p pd=1.5u as=0.2128p ps=1.5u w=1.12u l=0.13u
X1074 VSS.t739 VDD.t79 VSS.t739 VSS.t762 sg13_lv_nmos ad=79.8f pd=0.8u as=0 ps=0 w=0.42u l=1u
X1075 VDD.t800 oa_sar8_acore18_opt_0.sw_bitcell_opt_term_0.gb.t2 w_39600_n9960# w_39600_n9960# sg13_lv_pmos ad=0.7p pd=4.7u as=0.7p ps=4.7u w=2u l=0.13u
X1076 sar_ctrl_async_phys_0.sg13g2_dlygate4sd3_1_9.X a_26566_39766# VSS.t432 VSS.t89 sg13_lv_nmos ad=0.2516p pd=2.16u as=0.1426p ps=1.16u w=0.74u l=0.13u
X1077 oa_sar8_acore18_opt_0.sw_tg_opt_0.bot.t3 oa_sar8_acore18_opt_0.sw_bitcell_opt_b6_0.bot.t10 cap_cmim l=2.14u w=2.14u
X1078 a_33085_43832# sar_ctrl_async_phys_0.sg13g2_buf_1_35.A VDD.t366 VDD.t0 sg13_lv_pmos ad=0.1596p pd=1.22u as=0.2856p ps=2.36u w=0.84u l=0.13u
X1079 oa_sar8_acore18_opt_0.sw_bitcell_opt_b1_1.bot.t5 sar_ctrl_async_phys_0.dac_code_n[1].t2 VDD.t1003 VDD.t1001 sg13_lv_pmos ad=0.663p pd=3.79u as=1.19p ps=7.5u w=3.4u l=0.13u
X1080 VDD.t343 sar_ctrl_async_phys_0.sg13g2_inv_1_1.A sar_ctrl_async_phys_0.sg13g2_inv_1_1.Y VDD.t118 sg13_lv_pmos ad=0.3808p pd=2.92u as=0.3808p ps=2.92u w=1.12u l=0.13u
X1081 a_31261_38232# sar_ctrl_async_phys_0.sg13g2_buf_1_13.X VDD.t818 VDD.t162 sg13_lv_pmos ad=0.1596p pd=1.22u as=0.2856p ps=2.36u w=0.84u l=0.13u
X1082 VDD.t44 VSS.t1056 VDD.t44 VDD.t39 sg13_lv_pmos ad=0.19p pd=1.38u as=0 ps=0 w=1u l=1u
X1083 VDD.t340 a_33183_32215# a_33440_32358# VDD.t118 sg13_lv_pmos ad=1.96315p pd=12.675u as=79.8f ps=0.8u w=0.42u l=0.13u
X1084 VSS.t1003 VDD.t119 VSS.t1003 VSS.t17 sg13_lv_nmos ad=0.1428p pd=1.52u as=0 ps=0 w=0.42u l=1u
X1085 a_30676_35928# a_30650_35892# VSS.t182 VSS.t181 sg13_lv_nmos ad=0.2516p pd=2.16u as=0.1626p ps=1.415u w=0.74u l=0.13u
X1086 oa_sar8_acore18_opt_0.sw_tg_opt_0.bot.t3 oa_sar8_acore18_opt_0.sw_bitcell_opt_b7_0.bot.t146 cap_cmim l=2.14u w=2.14u
X1087 sar_ctrl_async_phys_0.sg13g2_a22oi_1_0.B2 a_36058_30924# VDD.t547 VDD.t39 sg13_lv_pmos ad=0.3808p pd=2.92u as=0.2128p ps=1.5u w=1.12u l=0.13u
X1088 VSS.t1034 VDD.t182 VSS.t1033 VSS.t1032 sg13_lv_nmos ad=0.1428p pd=1.52u as=0 ps=0 w=0.42u l=1u
X1089 VDD.t61 VSS.t1008 VDD.t61 VDD.t39 sg13_lv_pmos ad=0.34p pd=2.68u as=0 ps=0 w=1u l=1u
X1090 oa_sar8_acore18_opt_0.sw_tg_opt_0.bot.t3 oa_sar8_acore18_opt_0.sw_bitcell_opt_b5_0.bot.t35 cap_cmim l=2.14u w=2.14u
X1091 oa_sar8_acore18_opt_0.sw_tg_opt_0.bot.t3 oa_sar8_acore18_opt_0.sw_bitcell_opt_b7_0.bot.t52 cap_cmim l=2.14u w=2.14u
X1092 a_30985_40583# a_30043_40471# a_30783_40821# VDD.t311 sg13_lv_pmos ad=93.45f pd=0.865u as=0.2048p ps=1.63u w=0.42u l=0.13u
X1093 VDD.t401 a_32319_44311# a_32986_44532# VDD.t69 sg13_lv_pmos ad=0.2128p pd=1.5u as=0.3864p ps=2.93u w=1.12u l=0.13u
X1094 oa_sar8_acore18_opt_0.sw_bitcell_opt_b2_1.bot.t0 oa_sar8_acore18_opt_0.bstrap_opt_w2_c1200_1.gb oa_sar8_acore18_opt_0.bstrap_opt_w2_c1200_1.out VSS.t1092 sg13_lv_nmos ad=0.195p pd=1.39u as=0.35p ps=2.7u w=1u l=0.13u
X1095 a_32354_36362# sar_ctrl_async_phys_0.sg13g2_buf_1_2.A.t0 VSS.t417 VSS.t371 sg13_lv_nmos ad=37.8f pd=0.6u as=79.8f ps=0.8u w=0.42u l=0.13u
X1096 VSS.t266 a_34069_41189# a_34171_41332# VSS.t265 sg13_lv_nmos ad=5.25845p pd=33.575u as=0.2516p ps=2.16u w=0.74u l=0.13u
X1097 a_29862_36682# sar_ctrl_async_phys_0.sg13g2_buf_1_2.A.t4 a_29760_36682# VSS.t405 sg13_lv_nmos ad=0.1406p pd=1.12u as=0.1406p ps=1.12u w=0.74u l=0.13u
X1098 VDD.t67 VSS.t733 VDD.t78 VDD.t29 sg13_lv_pmos ad=0.19p pd=1.38u as=0 ps=0 w=1u l=1u
X1099 sar_ctrl_async_phys_0.sg13g2_a21oi_1_7.A2 a_32602_39996# VSS.t369 VSS.t30 sg13_lv_nmos ad=0.2516p pd=2.16u as=0.1406p ps=1.12u w=0.74u l=0.13u
X1100 oa_sar8_acore18_opt_0.sw_bitcell_opt_term_0.vin oa_sar8_acore18_opt_0.sw_bitcell_opt_term_0.trkb.t19 oa_sar8_acore18_opt_0.sw_bitcell_opt_b5_0.bot.t0 VDD.t971 sg13_lv_pmos ad=0.7p pd=4.7u as=0.39p ps=2.39u w=2u l=0.13u
X1101 a_29749_32117# sar_ctrl_async_phys_0.sg13g2_dfrbpq_1_0.CLK.t5 VDD.t340 VDD.t118 sg13_lv_pmos ad=0.4088p pd=2.97u as=1.79957p ps=11.62u w=1.12u l=0.13u
X1102 oa_sar8_acore18_opt_0.sw_tg_opt_1.bot.t3 oa_sar8_acore18_opt_0.sw_bitcell_opt_b1_1.bot.t3 cap_cmim l=2.14u w=2.14u
X1103 oa_sar8_acore18_opt_0.sw_tg_opt_1.bot.t3 oa_sar8_acore18_opt_0.sw_bitcell_opt_b7_1.bot.t43 cap_cmim l=2.14u w=2.14u
X1104 a_35618_44234# sar_ctrl_async_phys_0.sg13g2_dfrbpq_1_9.RESET_B VSS.t253 VSS.t252 sg13_lv_nmos ad=37.8f pd=0.6u as=79.8f ps=0.8u w=0.42u l=0.13u
X1105 sar_ctrl_async_phys_0.dac_code_n[1] a_34520_46508# VSS.t62 VSS.t91 sg13_lv_nmos ad=0.2886p pd=2.26u as=0.14875p ps=1.16u w=0.74u l=0.13u
X1106 VDD.t6 VSS.t72 VDD.t6 VDD.t5 sg13_lv_pmos ad=0.34p pd=2.68u as=0 ps=0 w=1u l=1u
X1107 VDD.t350 VSS.t50 VDD.t413 VDD.t162 sg13_lv_pmos ad=0.34p pd=2.68u as=0 ps=0 w=1u l=1u
X1108 VSS.t518 a_31381_46519# a_31483_46519# VSS.t1228 sg13_lv_nmos ad=9.09497p pd=59.065u as=0.2516p ps=2.16u w=0.74u l=0.13u
X1109 VSS.t346 sar_ctrl_async_phys_0.sg13g2_a21oi_1_4.A2 a_31665_42748# VSS.t1261 sg13_lv_nmos ad=0.2516p pd=2.16u as=0.1406p ps=1.12u w=0.74u l=0.13u
X1110 VDD.t500 a_33252_36642# a_33210_36972# VDD.t13 sg13_lv_pmos ad=0.2618p pd=1.63u as=0.1176p ps=1.33u w=1.12u l=0.13u
X1111 a_28758_35924# a_28488_35965# VSS.t277 VSS.t276 sg13_lv_nmos ad=0.1428p pd=1.52u as=79.8f ps=0.8u w=0.42u l=0.5u
X1112 oa_sar8_acore18_opt_0.sw_tg_opt_1.bot.t3 oa_sar8_acore18_opt_0.sw_bitcell_opt_b5_1.bot.t39 cap_cmim l=2.14u w=2.14u
X1113 VDD.t600 a_35103_43845# a_35770_43484# VDD.t0 sg13_lv_pmos ad=0.2128p pd=1.5u as=0.3864p ps=2.93u w=1.12u l=0.13u
X1114 VDD.t351 a_26544_38389# sar_ctrl_async_phys_0.sg13g2_and2_1_2.X VDD.t162 sg13_lv_pmos ad=0.1918p pd=1.5u as=0.3808p ps=2.92u w=1.12u l=0.13u
X1115 VDD.t197 sar_ctrl_async_phys_0.sg13g2_buf_1_2.A a_34010_35892# VDD.t37 sg13_lv_pmos ad=0.1563p pd=1.22u as=0.147p ps=1.54u w=0.42u l=0.13u
X1116 a_28853_39702# sar_ctrl_async_phys_0.sg13g2_nor2_1_7.B VSS.t295 VSS.t89 sg13_lv_nmos ad=0.1406p pd=1.12u as=0.14505p ps=1.15u w=0.74u l=0.13u
X1117 VSS.t172 sar_ctrl_async_phys_0.sg13g2_a22oi_1_3.A2 sar_ctrl_async_phys_0.sg13g2_nor2_1_0.Y VSS.t660 sg13_lv_nmos ad=0.2516p pd=2.16u as=0.1406p ps=1.12u w=0.74u l=0.13u
X1118 oa_sar8_acore18_opt_0.sw_tg_opt_0.bot.t3 oa_sar8_acore18_opt_0.sw_bitcell_opt_b6_0.bot.t45 cap_cmim l=2.14u w=2.14u
X1119 oa_sar8_acore18_opt_0.sw_tg_opt_1.bot.t3 oa_sar8_acore18_opt_0.sw_bitcell_opt_b7_1.bot.t131 cap_cmim l=2.14u w=2.14u
X1120 a_34132_30944# a_34651_30748# a_35391_30703# VSS.t583 sg13_lv_nmos ad=0.3473p pd=2.71u as=0.12665p ps=1.145u w=0.74u l=0.13u
X1121 oa_sar8_acore18_opt_0.sw_tg_opt_0.bot.t3 oa_sar8_acore18_opt_0.sw_bitcell_opt_b7_0.bot.t104 cap_cmim l=2.14u w=2.14u
X1122 VSS.t1064 VDD.t44 VSS.t1063 VSS.t1062 sg13_lv_nmos ad=0.1428p pd=1.52u as=0 ps=0 w=0.42u l=1u
X1123 sar_ctrl_async_phys_0.dac_code_n[3] a_34904_46508# VDD.t35 VDD.t29 sg13_lv_pmos ad=0.42p pd=2.99u as=0.2114p ps=1.54u w=1.12u l=0.13u
X1124 oa_sar8_acore18_opt_0.sw_bitcell_opt_b2_0.bot.t0 oa_sar8_acore18_opt_0.sw_bitcell_opt_term_0.gb.t7 oa_sar8_acore18_opt_0.sw_bitcell_opt_term_0.vin VSS.t209 sg13_lv_nmos ad=0.195p pd=1.39u as=0.35p ps=2.7u w=1u l=0.13u
X1125 VDD.t173 VSS.t801 VDD.t144 VDD.t0 sg13_lv_pmos ad=0.34p pd=2.68u as=0 ps=0 w=1u l=1u
X1126 VDD.t209 VSS.t123 VDD.t209 VDD.t5 sg13_lv_pmos ad=0.34p pd=2.68u as=0 ps=0 w=1u l=1u
X1127 VSS.t62 sar_ctrl_async_phys_0.sg13g2_nand2b_1_2.Y a_34904_46508# VSS.t91 sg13_lv_nmos ad=0.14875p pd=1.16u as=0.187p ps=1.78u w=0.55u l=0.13u
X1128 a_33844_36992# a_34363_36796# a_35103_36751# VSS.t1287 sg13_lv_nmos ad=0.3473p pd=2.71u as=0.12665p ps=1.145u w=0.74u l=0.13u
X1129 VDD.t8 sar_ctrl_async_phys_0.sg13g2_dlygate4sd3_1_6.X a_26184_42013# VDD.t5 sg13_lv_pmos ad=0.1523p pd=1.38u as=0.1428p ps=1.52u w=0.42u l=0.13u
X1130 oa_sar8_acore18_opt_0.sw_tg_opt_1.bot.t3 oa_sar8_acore18_opt_0.sw_bitcell_opt_b6_1.bot.t61 cap_cmim l=2.14u w=2.14u
X1131 a_33750_36362# sar_ctrl_async_phys_0.sg13g2_nor2_1_2.A VDD.t42 VDD.t37 sg13_lv_pmos ad=79.8f pd=0.8u as=0.1428p ps=1.52u w=0.42u l=0.13u
X1132 VDD.t169 sar_ctrl_async_phys_0.sg13g2_o21ai_1_1.B1 a_32406_45746# VDD.t29 sg13_lv_pmos ad=0.36237p pd=2.605u as=79.8f ps=0.8u w=0.42u l=0.13u
X1133 VDD.t150 a_26174_42911# sar_ctrl_async_phys_0.sg13g2_dlygate4sd3_1_6.X VDD.t0 sg13_lv_pmos ad=0.2254p pd=1.53u as=0.4256p ps=3u w=1.12u l=0.13u
X1134 oa_sar8_acore18_opt_0.sw_tg_opt_0.bot.t2 oa_sar8_acore18_opt_0.sw_bitcell_opt_b7_0.bot.t157 cap_cmim l=2.14u w=2.14u
X1135 a_31417_44625# a_31060_44552# VDD.t117 VDD.t69 sg13_lv_pmos ad=63f pd=0.72u as=0.1563p ps=1.22u w=0.42u l=0.13u
X1136 sar_ctrl_async_phys_0.sg13g2_nand2b_1_0.Y sar_ctrl_async_phys_0.sg13g2_nor2_1_7.B VDD.t312 VDD.t311 sg13_lv_pmos ad=0.2128p pd=1.5u as=0.2198p ps=1.53u w=1.12u l=0.13u
X1137 VDD.t163 VSS.t471 VDD.t163 VDD.t162 sg13_lv_pmos ad=0.19p pd=1.38u as=0 ps=0 w=1u l=1u
X1138 VDD.t346 a_32576_44454# a_32521_44549# VDD.t69 sg13_lv_pmos ad=1.96315p pd=12.675u as=93.45f ps=0.865u w=0.42u l=0.13u
X1139 a_31190_46933# sar_ctrl_async_phys_0.sg13g2_dfrbpq_1_9.RESET_B VSS.t129 VSS.t306 sg13_lv_nmos ad=37.8f pd=0.6u as=0.1701p ps=1.65u w=0.42u l=0.13u
X1140 VSS.t98 a_32288_31630# a_31937_31749# VSS.t236 sg13_lv_nmos ad=79.8f pd=0.8u as=0.1428p ps=1.52u w=0.42u l=0.13u
X1141 VDD.t384 a_35952_39901# sar_ctrl_async_phys_0.sg13g2_buf_1_23.A VDD.t311 sg13_lv_pmos ad=0.1918p pd=1.5u as=0.3808p ps=2.92u w=1.12u l=0.13u
X1142 oa_sar8_acore18_opt_0.sw_tg_opt_0.bot.t3 oa_sar8_acore18_opt_0.sw_bitcell_opt_b7_0.bot.t115 cap_cmim l=2.14u w=2.14u
X1143 oa_sar8_acore18_opt_0.sw_bitcell_opt_b6_1.bot.t0 oa_sar8_acore18_opt_0.sw_bitcell_opt_term_0.trkb.t23 oa_sar8_acore18_opt_0.bstrap_opt_w2_c1200_1.out VDD.t710 sg13_lv_pmos ad=0.39p pd=2.39u as=0.7p ps=4.7u w=2u l=0.13u
X1144 VDD.t38 VSS.t84 VDD.t38 VDD.t37 sg13_lv_pmos ad=0.34p pd=2.68u as=0 ps=0 w=1u l=1u
X1145 oa_sar8_acore18_opt_0.sw_tg_opt_0.bot.t3 oa_sar8_acore18_opt_0.sw_bitcell_opt_b4_0.bot.t26 cap_cmim l=2.14u w=2.14u
X1146 a_35391_30703# a_34549_30605# a_35297_30703# VSS.t530 sg13_lv_nmos ad=0.12665p pd=1.145u as=0.1428p ps=1.52u w=0.42u l=0.13u
X1147 a_34489_32947# a_34132_32904# VDD.t342 VDD.t118 sg13_lv_pmos ad=63f pd=0.72u as=0.1563p ps=1.22u w=0.42u l=0.13u
X1148 a_33270_39698# a_34075_39820# a_33530_39921# VDD.t311 sg13_lv_pmos ad=0.1428p pd=1.52u as=79.8f ps=0.8u w=0.42u l=0.13u
X1149 VSS.t172 VDD.t247 VSS.t172 VSS.t87 sg13_lv_nmos ad=0.1428p pd=1.52u as=0 ps=0 w=0.42u l=1u
X1150 VDD.t35 VSS.t129 VDD.t33 VDD.t29 sg13_lv_pmos ad=0.19p pd=1.38u as=0 ps=0 w=1u l=1u
X1151 a_31674_38948# sar_ctrl_async_phys_0.sg13g2_nor2b_1_0.A sar_ctrl_async_phys_0.sg13g2_dfrbpq_1_22.D VDD.t162 sg13_lv_pmos ad=0.1176p pd=1.33u as=0.3808p ps=2.92u w=1.12u l=0.13u
X1152 sar_ctrl_async_phys_0.sg13g2_nor2_1_3.A a_25496_34412# VSS.t920 VSS.t114 sg13_lv_nmos ad=0.2886p pd=2.26u as=0.14875p ps=1.16u w=0.74u l=0.13u
X1153 a_31924_32456# a_32443_32260# a_33183_32215# VSS.t8 sg13_lv_nmos ad=0.3473p pd=2.71u as=0.12665p ps=1.145u w=0.74u l=0.13u
X1154 VDD.t119 VSS.t1003 VDD.t119 VDD.t118 sg13_lv_pmos ad=0.34p pd=2.68u as=0 ps=0 w=1u l=1u
X1155 a_33844_36992# a_33818_36897# VDD.t500 VDD.t13 sg13_lv_pmos ad=0.34p pd=2.68u as=0.36237p ps=2.605u w=1u l=0.13u
X1156 VSS.t11 sar_ctrl_async_phys_0.sg13g2_inv_1_1.A sar_ctrl_async_phys_0.sg13g2_inv_1_1.Y VSS.t6 sg13_lv_nmos ad=0.2516p pd=2.16u as=0.2516p ps=2.16u w=0.74u l=0.13u
X1157 VDD.t338 sar_ctrl_async_phys_0.sg13g2_buf_1_6.A a_35672_33688# VDD.t54 sg13_lv_pmos ad=0.2114p pd=1.54u as=0.2856p ps=2.36u w=0.84u l=0.13u
X1158 a_32991_35239# a_32149_35141# a_32897_35239# VSS.t1256 sg13_lv_nmos ad=0.12665p pd=1.145u as=0.1428p ps=1.52u w=0.42u l=0.13u
X1159 a_35017_40013# a_34075_39820# a_34815_39775# VDD.t311 sg13_lv_pmos ad=93.45f pd=0.865u as=0.2048p ps=1.63u w=0.42u l=0.13u
X1160 VDD.t315 a_30752_39190# a_30697_39071# VDD.t162 sg13_lv_pmos ad=3.62845p pd=23.965u as=93.45f ps=0.865u w=0.42u l=0.13u
X1161 oa_sar8_acore18_opt_0.sw_tg_opt_0.bot.t3 oa_sar8_acore18_opt_0.sw_bitcell_opt_b6_0.bot.t35 cap_cmim l=2.14u w=2.14u
X1162 VSS.t616 a_35103_43845# a_35770_43484# VSS.t615 sg13_lv_nmos ad=0.1406p pd=1.12u as=0.2516p ps=2.16u w=0.74u l=0.13u
X1163 a_31129_31435# a_30772_31392# VDD.t40 VDD.t39 sg13_lv_pmos ad=63f pd=0.72u as=0.1563p ps=1.22u w=0.42u l=0.13u
X1164 VDD.t70 VSS.t749 VDD.t70 VDD.t69 sg13_lv_pmos ad=0.34p pd=2.68u as=0 ps=0 w=1u l=1u
X1165 a_35245_42242# sar_ctrl_async_phys_0.sg13g2_nand2b_1_2.A_N VSS.t178 VSS.t476 sg13_lv_nmos ad=0.187p pd=1.78u as=0.14505p ps=1.15u w=0.55u l=0.13u
X1166 a_35103_36751# a_34261_36653# a_35009_36751# VSS.t194 sg13_lv_nmos ad=0.12665p pd=1.145u as=0.1428p ps=1.52u w=0.42u l=0.13u
X1167 VSS.t48 sar_ctrl_async_phys_0.sg13g2_a21oi_1_7.A2 a_32049_41236# VSS.t278 sg13_lv_nmos ad=0.2516p pd=2.16u as=0.1406p ps=1.12u w=0.74u l=0.13u
X1168 a_34175_42726# a_34093_42912# sar_ctrl_async_phys_0.sg13g2_a21oi_1_4.B1 VSS.t1291 sg13_lv_nmos ad=0.1406p pd=1.12u as=0.333p ps=2.38u w=0.74u l=0.13u
X1169 VSS.t897 VDD.t191 VSS.t899 VSS.t898 sg13_lv_nmos ad=79.8f pd=0.8u as=0 ps=0 w=0.42u l=1u
X1170 oa_sar8_acore18_opt_0.sw_tg_opt_0.bot.t3 oa_sar8_acore18_opt_0.sw_bitcell_opt_b7_0.bot.t44 cap_cmim l=2.14u w=2.14u
X1171 a_34319_32460# sar_ctrl_async_phys_0.sg13g2_a22oi_1_0.A1.t4 VDD.t342 VDD.t118 sg13_lv_pmos ad=0.2716p pd=1.605u as=0.3808p ps=2.92u w=1.12u l=0.13u
X1172 VSS.t724 VDD.t70 VSS.t724 VSS.t752 sg13_lv_nmos ad=79.8f pd=0.8u as=0 ps=0 w=0.42u l=1u
X1173 a_33936_31675# a_34055_31352# VDD.t573 VDD.t39 sg13_lv_pmos ad=0.3864p pd=2.93u as=0.2128p ps=1.5u w=1.12u l=0.13u
X1174 VDD.t14 VSS.t368 VDD.t14 VDD.t13 sg13_lv_pmos ad=0.34p pd=2.68u as=0 ps=0 w=1u l=1u
X1175 a_30938_46476# a_31381_46519# a_30678_46946# VSS.t1227 sg13_lv_nmos ad=79.8f pd=0.8u as=0.1296p ps=1.52u w=0.42u l=0.13u
X1176 a_30027_39996# sar_ctrl_async_phys_0.sg13g2_a21oi_1_2.A2 VDD.t312 VDD.t311 sg13_lv_pmos ad=0.3808p pd=2.92u as=0.2128p ps=1.5u w=1.12u l=0.13u
X1177 sar_ctrl_async_phys_0.sg13g2_buf_1_1.A a_36058_34412# VDD.t338 VDD.t54 sg13_lv_pmos ad=0.3808p pd=2.92u as=0.2128p ps=1.5u w=1.12u l=0.13u
X1178 VSS.t123 sar_ctrl_async_phys_0.sg13g2_dfrbpq_1_2.Q a_33777_42748# VSS.t586 sg13_lv_nmos ad=0.2516p pd=2.16u as=0.1406p ps=1.12u w=0.74u l=0.13u
X1179 VSS.t1029 VDD.t194 VSS.t1031 VSS.t1030 sg13_lv_nmos ad=79.8f pd=0.8u as=0 ps=0 w=0.42u l=1u
X1180 a_33940_34850# sar_ctrl_async_phys_0.sg13g2_buf_1_16.A a_33846_34850# VSS.t117 sg13_lv_nmos ad=60.89999f pd=0.71u as=0.1428p ps=1.52u w=0.42u l=0.13u
X1181 oa_sar8_acore18_opt_0.sw_tg_opt_0.bot.t2 oa_sar8_acore18_opt_0.sw_bitcell_opt_b7_0.bot.t162 cap_cmim l=2.14u w=2.14u
X1182 VDD.t468 sar_ctrl_async_phys_0.sample oa_sar8_acore18_opt_0.sw_bitcell_opt_term_0.trkb.t3 VDD.t467 sg13_lv_pmos ad=0.7p pd=4.7u as=0.39p ps=2.39u w=2u l=0.13u
X1183 oa_sar8_acore18_opt_0.sw_bitcell_opt_b3_1.bot.t0 oa_sar8_acore18_opt_0.sw_bitcell_opt_term_0.trkb.t26 oa_sar8_acore18_opt_0.bstrap_opt_w2_c1200_1.out VDD.t703 sg13_lv_pmos ad=0.39p pd=2.39u as=0.7p ps=4.7u w=2u l=0.13u
X1184 oa_sar8_acore18_opt_0.sw_tg_opt_0.bot.t3 oa_sar8_acore18_opt_0.sw_bitcell_opt_b6_0.bot.t2 cap_cmim l=2.14u w=2.14u
X1185 oa_sar8_acore18_opt_0.sw_tg_opt_0.bot.t3 oa_sar8_acore18_opt_0.sw_bitcell_opt_b7_0.bot.t35 cap_cmim l=2.14u w=2.14u
X1186 a_34036_35928# a_34555_35935# a_35295_36285# VSS.t164 sg13_lv_nmos ad=0.3473p pd=2.71u as=0.12665p ps=1.145u w=0.74u l=0.13u
X1187 a_32020_45421# a_32251_45007# a_31706_44964# VSS.t383 sg13_lv_nmos ad=0.2373p pd=1.97u as=79.8f ps=0.8u w=0.42u l=0.13u
X1188 oa_sar8_acore18_opt_0.sw_tg_opt_1.bot.t3 oa_sar8_acore18_opt_0.sw_bitcell_opt_b6_1.bot.t14 cap_cmim l=2.14u w=2.14u
X1189 sar_ctrl_async_phys_0.bit_active[4] a_36056_35200# VDD.t447 VDD.t37 sg13_lv_pmos ad=0.42p pd=2.99u as=0.2114p ps=1.54u w=1.12u l=0.13u
X1190 a_31446_45434# sar_ctrl_async_phys_0.sg13g2_dfrbpq_1_9.D VDD.t117 VDD.t69 sg13_lv_pmos ad=79.8f pd=0.8u as=0.1428p ps=1.52u w=0.42u l=0.13u
X1191 sar_ctrl_async_phys_0.sg13g2_a21oi_1_2.A2 a_31162_38948# VDD.t818 VDD.t162 sg13_lv_pmos ad=0.3808p pd=2.92u as=0.2128p ps=1.5u w=1.12u l=0.13u
X1192 VSS.t372 a_31935_36285# a_32602_35924# VSS.t371 sg13_lv_nmos ad=0.1406p pd=1.12u as=0.2516p ps=2.16u w=0.74u l=0.13u
X1193 VDD.t314 sar_ctrl_async_phys_0.sg13g2_o21ai_1_1.B1 a_33270_39698# VDD.t311 sg13_lv_pmos ad=0.36237p pd=2.605u as=79.8f ps=0.8u w=0.42u l=0.13u
X1194 oa_sar8_acore18_opt_0.sw_tg_opt_1.bot.t3 oa_sar8_acore18_opt_0.sw_bitcell_opt_b6_1.bot.t49 cap_cmim l=2.14u w=2.14u
X1195 oa_sar8_acore18_opt_0.bstrap_opt_w2_c1200_1.out oa_sar8_acore18_opt_0.bstrap_opt_w2_c1200_1.gb oa_sar8_acore18_opt_0.sw_bitcell_opt_b5_1.bot.t0 VSS.t1095 sg13_lv_nmos ad=0.35p pd=2.7u as=0.195p ps=1.39u w=1u l=0.13u
X1196 VSS.t845 VDD.t36 VSS.t844 VSS.t628 sg13_lv_nmos ad=0.1428p pd=1.52u as=0 ps=0 w=0.42u l=1u
X1197 a_34106_30849# a_34549_30605# a_33846_30626# VSS.t527 sg13_lv_nmos ad=79.8f pd=0.8u as=0.1296p ps=1.52u w=0.42u l=0.13u
X1198 oa_sar8_acore18_opt_0.sw_bitcell_opt_term_0.vin oa_sar8_acore18_opt_0.sw_bitcell_opt_term_0.trkb.t14 oa_sar8_acore18_opt_0.sw_bitcell_opt_b0_0.bot.t0 VDD.t615 sg13_lv_pmos ad=0.7p pd=4.7u as=0.39p ps=2.39u w=2u l=0.13u
X1199 a_31935_39775# a_31093_39677# a_31841_39775# VSS.t30 sg13_lv_nmos ad=0.12665p pd=1.145u as=0.1428p ps=1.52u w=0.42u l=0.13u
X1200 VDD.t119 VSS.t969 VDD.t119 VDD.t118 sg13_lv_pmos ad=0.19p pd=1.38u as=0 ps=0 w=1u l=1u
X1201 VSS.t736 VDD.t32 VSS.t739 VSS.t738 sg13_lv_nmos ad=79.8f pd=0.8u as=0 ps=0 w=0.42u l=1u
X1202 oa_sar8_acore18_opt_0.sw_tg_opt_0.bot.t3 oa_sar8_acore18_opt_0.sw_bitcell_opt_b5_0.bot.t10 cap_cmim l=2.14u w=2.14u
X1203 oa_sar8_acore18_opt_0.sw_tg_opt_0.bot.t3 oa_sar8_acore18_opt_0.sw_bitcell_opt_b7_0.bot.t120 cap_cmim l=2.14u w=2.14u
X1204 sar_ctrl_async_phys_0.sg13g2_buf_1_13.A a_32602_35924# VDD.t42 VDD.t37 sg13_lv_pmos ad=0.3808p pd=2.92u as=0.2128p ps=1.5u w=1.12u l=0.13u
X1205 VDD.t68 VSS.t672 VDD.t68 VDD.t29 sg13_lv_pmos ad=0.19p pd=1.38u as=0 ps=0 w=1u l=1u
X1206 VDD.t68 VSS.t720 VDD.t68 VDD.t29 sg13_lv_pmos ad=0.19p pd=1.38u as=0 ps=0 w=1u l=1u
X1207 a_34420_30639# a_34132_30944# a_34358_30639# VSS.t370 sg13_lv_nmos ad=0.1428p pd=1.52u as=37.8f ps=0.6u w=0.42u l=0.13u
X1208 VSS.t220 sar_ctrl_async_phys_0.hold_req oa_sar8_acore18_opt_0.sw_bitcell_opt_term_0.VSS VSS.t222 sg13_lv_nmos ad=0.7p pd=4.7u as=0.39p ps=2.39u w=2u l=0.13u
X1209 VDD.t39 sar_ctrl_async_phys_0.sg13g2_buf_1_2.X a_34268_31826# VDD.t39 sg13_lv_pmos ad=1.79957p pd=11.62u as=79.8f ps=0.8u w=0.42u l=0.13u
X1210 a_32341_32117# sar_ctrl_async_phys_0.sg13g2_dfrbpq_1_0.CLK.t4 VSS.t125 VSS.t258 sg13_lv_nmos ad=0.2516p pd=2.16u as=3.35542p ps=21.09u w=0.74u l=0.13u
X1211 VDD.t68 VSS.t722 VDD.t68 VDD.t29 sg13_lv_pmos ad=0.34p pd=2.68u as=0 ps=0 w=1u l=1u
X1212 a_32404_40885# a_32116_40464# a_32342_40885# VSS.t581 sg13_lv_nmos ad=0.1428p pd=1.52u as=37.8f ps=0.6u w=0.42u l=0.13u
X1213 oa_sar8_acore18_opt_0.sw_tg_opt_1.bot.t3 oa_sar8_acore18_opt_0.sw_bitcell_opt_b5_1.bot.t1 cap_cmim l=2.14u w=2.14u
X1214 oa_sar8_acore18_opt_0.sw_tg_opt_1.bot.t3 oa_sar8_acore18_opt_0.sw_bitcell_opt_b7_1.bot.t85 cap_cmim l=2.14u w=2.14u
X1215 VDD.t44 VSS.t1053 VDD.t44 VDD.t39 sg13_lv_pmos ad=0.34p pd=2.68u as=0 ps=0 w=1u l=1u
X1216 VSS.t643 a_30591_32215# a_31258_32436# VSS.t642 sg13_lv_nmos ad=0.1406p pd=1.12u as=0.2516p ps=2.16u w=0.74u l=0.13u
X1217 sar_ctrl_async_phys_0.bit_active[0] a_34424_35200# VDD.t197 VDD.t37 sg13_lv_pmos ad=0.42p pd=2.99u as=0.2114p ps=1.54u w=1.12u l=0.13u
X1218 VSS.t129 sar_ctrl_async_phys_0.sg13g2_dfrbpq_1_9.RESET_B a_30772_46946# VSS.t307 sg13_lv_nmos ad=0.1626p pd=1.415u as=60.89999f ps=0.71u w=0.42u l=0.13u
X1219 VSS.t48 a_32400_41413# sar_ctrl_async_phys_0.sg13g2_and2_1_5.X VSS.t131 sg13_lv_nmos ad=0.1331p pd=1.12u as=0.2516p ps=2.16u w=0.74u l=0.13u
X1220 a_28950_39386# sar_ctrl_async_phys_0.sg13g2_nor2_1_6.A VDD.t163 VDD.t162 sg13_lv_pmos ad=79.8f pd=0.8u as=0.1428p ps=1.52u w=0.42u l=0.13u
X1221 VSS.t471 sar_ctrl_async_phys_0.sg13g2_buf_1_2.A.t6 a_31636_37874# VSS.t470 sg13_lv_nmos ad=0.1626p pd=1.415u as=60.89999f ps=0.71u w=0.42u l=0.13u
X1222 sar_ctrl_async_phys_0.sg13g2_buf_1_9.A a_33850_32436# VSS.t9 VSS.t8 sg13_lv_nmos ad=0.2516p pd=2.16u as=0.1406p ps=1.12u w=0.74u l=0.13u
X1223 VDD.t54 a_35391_34773# a_35648_34654# VDD.t54 sg13_lv_pmos ad=2.2076p pd=14.4u as=79.8f ps=0.8u w=0.42u l=0.13u
X1224 VDD.t209 VSS.t123 VDD.t209 VDD.t5 sg13_lv_pmos ad=0.19p pd=1.38u as=0 ps=0 w=1u l=1u
X1225 VSS.t84 a_28862_36863# sar_ctrl_async_phys_0.sg13g2_dlygate4sd3_1_1.X VSS.t1145 sg13_lv_nmos ad=0.1426p pd=1.16u as=0.2516p ps=2.16u w=0.74u l=0.13u
X1226 VSS.t346 VDD.t209 VSS.t346 VSS.t825 sg13_lv_nmos ad=0.1428p pd=1.52u as=0 ps=0 w=0.42u l=1u
X1227 a_32020_35175# a_32251_35284# a_31706_35385# VSS.t248 sg13_lv_nmos ad=0.2373p pd=1.97u as=79.8f ps=0.8u w=0.42u l=0.13u
X1228 VSS.t22 sar_ctrl_async_phys_0.sg13g2_o21ai_1_1.B1 a_32500_45746# VSS.t21 sg13_lv_nmos ad=0.1626p pd=1.415u as=60.89999f ps=0.71u w=0.42u l=0.13u
X1229 a_35772_41936# sar_ctrl_async_phys_0.sg13g2_buf_1_35.A VDD.t428 VDD.t5 sg13_lv_pmos ad=0.2856p pd=2.36u as=0.2114p ps=1.54u w=0.84u l=0.13u
X1230 VSS.t425 a_34453_35935# a_34555_35935# VSS.t192 sg13_lv_nmos ad=5.13525p pd=33.135u as=0.2516p ps=2.16u w=0.74u l=0.13u
X1231 oa_sar8_acore18_opt_0.sw_tg_opt_1.bot.t3 oa_sar8_acore18_opt_0.sw_bitcell_opt_b7_1.bot.t125 cap_cmim l=2.14u w=2.14u
X1232 VSS.t7 VDD.t205 VSS.t7 VSS.t141 sg13_lv_nmos ad=79.8f pd=0.8u as=0 ps=0 w=0.42u l=1u
X1233 a_29498_40428# a_29941_40471# a_29881_40507# VDD.t311 sg13_lv_pmos ad=79.8f pd=0.8u as=63f ps=0.72u w=0.42u l=0.13u
X1234 oa_sar8_acore18_opt_0.sw_tg_opt_0.bot.t3 oa_sar8_acore18_opt_0.sw_bitcell_opt_b7_0.bot.t131 cap_cmim l=2.14u w=2.14u
X1235 VSS.t263 a_31136_43726# a_30785_43845# VSS.t262 sg13_lv_nmos ad=79.8f pd=0.8u as=0.1428p ps=1.52u w=0.42u l=0.13u
X1236 oa_sar8_acore18_opt_0.sw_tg_opt_1.bot.t4 oa_sar8_acore18_opt_0.sw_bitcell_opt_b7_1.bot.t19 cap_cmim l=2.14u w=2.14u
X1237 VDD.t350 sar_ctrl_async_phys_0.sg13g2_nand2_1_3.Y a_36056_38948# VDD.t162 sg13_lv_pmos ad=0.2114p pd=1.54u as=0.2856p ps=2.36u w=0.84u l=0.13u
X1238 a_32223_46869# a_31381_46519# a_30964_46512# VDD.t29 sg13_lv_pmos ad=0.2048p pd=1.63u as=0.34p ps=2.68u w=1u l=0.13u
X1239 VSS.t346 sar_ctrl_async_phys_0.sg13g2_a22oi_1_5.A2 sar_ctrl_async_phys_0.sg13g2_nor2_1_11.Y VSS.t632 sg13_lv_nmos ad=0.2516p pd=2.16u as=0.1406p ps=1.12u w=0.74u l=0.13u
X1240 oa_sar8_acore18_opt_0.sw_tg_opt_0.bot.t3 oa_sar8_acore18_opt_0.sw_bitcell_opt_b6_0.bot.t75 cap_cmim l=2.14u w=2.14u
X1241 VSS.t439 oa_sar8_acore18_opt_0.sw_bitcell_opt_term_0.trkb.t6 a_35948_n9612# VSS.t438 sg13_lv_nmos ad=0.345p pd=2.69u as=0.19p ps=1.38u w=1u l=0.15u
X1242 oa_sar8_acore18_opt_0.sw_bitcell_opt_term_0.vin oa_sar8_acore18_opt_0.sw_bitcell_opt_term_0.gb.t4 oa_sar8_acore18_opt_0.sw_bitcell_opt_term_0.bot.t0 VSS.t607 sg13_lv_nmos ad=0.35p pd=2.7u as=0.195p ps=1.39u w=1u l=0.13u
X1243 VDD.t984 sar_ctrl_async_phys_0.dac_code[5] oa_sar8_acore18_opt_0.sw_bitcell_opt_b5_0.bot.t1 VDD.t983 sg13_lv_pmos ad=1.89p pd=11.5u as=1.053p ps=5.79u w=5.4u l=0.13u
X1244 a_31924_32456# a_31898_32361# VSS.t98 VSS.t97 sg13_lv_nmos ad=0.2516p pd=2.16u as=0.1626p ps=1.415u w=0.74u l=0.13u
X1245 VSS.t962 VDD.t238 VSS.t964 VSS.t963 sg13_lv_nmos ad=79.8f pd=0.8u as=0 ps=0 w=0.42u l=1u
X1246 VSS.t529 a_34549_30605# a_34651_30748# VSS.t528 sg13_lv_nmos ad=8.77817p pd=57.305u as=0.2516p ps=2.16u w=0.74u l=0.13u
X1247 a_35801_37784# sar_ctrl_async_phys_0.sg13g2_a21oi_1_0.A2 VSS.t88 VSS.t118 sg13_lv_nmos ad=0.1216p pd=1.02u as=0.1331p ps=1.12u w=0.64u l=0.13u
X1248 VDD.t528 sar_ctrl_async_phys_0.sg13g2_dfrbpq_1_9.RESET_B a_29334_43922# VDD.t0 sg13_lv_pmos ad=0.36237p pd=2.605u as=79.8f ps=0.8u w=0.42u l=0.13u
X1249 a_32116_37861# a_31828_37440# a_32054_37861# VSS.t580 sg13_lv_nmos ad=0.1428p pd=1.52u as=37.8f ps=0.6u w=0.42u l=0.13u
X1250 a_29689_32529# a_29332_32456# VDD.t205 VDD.t118 sg13_lv_pmos ad=63f pd=0.72u as=0.1563p ps=1.22u w=0.42u l=0.13u
X1251 oa_sar8_acore18_opt_0.sw_bitcell_opt_term_0.vin oa_sar8_acore18_opt_0.sw_bitcell_opt_term_0.trkb.t21 oa_sar8_acore18_opt_0.sw_bitcell_opt_b7_0.bot.t0 VDD.t641 sg13_lv_pmos ad=0.7p pd=4.7u as=0.39p ps=2.39u w=2u l=0.13u
X1252 a_31732_45000# a_32251_45007# a_32991_45357# VSS.t384 sg13_lv_nmos ad=0.3473p pd=2.71u as=0.12665p ps=1.145u w=0.74u l=0.13u
X1253 a_32212_32151# a_31924_32456# a_32150_32151# VSS.t97 sg13_lv_nmos ad=0.1428p pd=1.52u as=37.8f ps=0.6u w=0.42u l=0.13u
X1254 VDD.t119 VSS.t1003 VDD.t119 VDD.t118 sg13_lv_pmos ad=0.19p pd=1.38u as=0 ps=0 w=1u l=1u
X1255 VDD.t450 sar_ctrl_async_phys_0.sg13g2_nand2_1_3.A sar_ctrl_async_phys_0.sg13g2_nand2b_1_2.Y VDD.t5 sg13_lv_pmos ad=0.2198p pd=1.53u as=0.2128p ps=1.5u w=1.12u l=0.13u
X1256 VSS.t957 VDD.t119 VSS.t956 VSS.t955 sg13_lv_nmos ad=0.1428p pd=1.52u as=0 ps=0 w=0.42u l=1u
X1257 VDD.t40 VSS.t510 VDD.t40 VDD.t39 sg13_lv_pmos ad=0.34p pd=2.68u as=0 ps=0 w=1u l=1u
X1258 a_29812_33968# a_29786_33873# VSS.t7 VSS.t226 sg13_lv_nmos ad=0.2516p pd=2.16u as=0.1626p ps=1.415u w=0.74u l=0.13u
X1259 VSS.t902 VDD.t185 VSS.t111 VSS.t916 sg13_lv_nmos ad=0.1428p pd=1.52u as=0 ps=0 w=0.42u l=1u
X1260 oa_sar8_acore18_opt_0.sw_bitcell_opt_b5_0.bot.t0 oa_sar8_acore18_opt_0.sw_bitcell_opt_term_0.trkb.t19 oa_sar8_acore18_opt_0.sw_bitcell_opt_term_0.vin VDD.t971 sg13_lv_pmos ad=0.39p pd=2.39u as=0.7p ps=4.7u w=2u l=0.13u
X1261 VSS.t193 a_34261_36653# a_34363_36796# VSS.t192 sg13_lv_nmos ad=5.13525p pd=33.135u as=0.2516p ps=2.16u w=0.74u l=0.13u
X1262 VDD.t70 VSS.t720 VDD.t70 VDD.t69 sg13_lv_pmos ad=0.19p pd=1.38u as=0 ps=0 w=1u l=1u
X1263 a_36210_31826# sar_ctrl_async_phys_0.sg13g2_buf_1_2.X VSS.t434 VSS.t460 sg13_lv_nmos ad=60.89999f pd=0.71u as=0.1626p ps=1.415u w=0.42u l=0.13u
X1264 VDD.t185 sar_ctrl_async_phys_0.sg13g2_buf_1_2.X.t5 a_31446_35162# VDD.t37 sg13_lv_pmos ad=0.36237p pd=2.605u as=79.8f ps=0.8u w=0.42u l=0.13u
X1265 a_31563_43020# sar_ctrl_async_phys_0.sg13g2_a21oi_1_4.A2 VDD.t366 VDD.t0 sg13_lv_pmos ad=0.3808p pd=2.92u as=0.2128p ps=1.5u w=1.12u l=0.13u
X1266 oa_sar8_acore18_opt_0.sw_tg_opt_1.bot.t3 oa_sar8_acore18_opt_0.sw_bitcell_opt_b7_1.bot.t64 cap_cmim l=2.14u w=2.14u
X1267 sar_ctrl_async_phys_0.sg13g2_inv_1_1.A sar_ctrl_async_phys_0.sg13g2_a22oi_1_0.B1 a_32687_32876# VDD.t118 sg13_lv_pmos ad=0.2128p pd=1.5u as=0.2716p ps=1.605u w=1.12u l=0.13u
X1268 oa_sar8_acore18_opt_0.sw_tg_opt_0.bot.t3 oa_sar8_acore18_opt_0.sw_bitcell_opt_b7_0.bot.t89 cap_cmim l=2.14u w=2.14u
X1269 oa_sar8_acore18_opt_0.sw_bitcell_opt_b4_1.bot.t0 oa_sar8_acore18_opt_0.bstrap_opt_w2_c1200_1.gb oa_sar8_acore18_opt_0.bstrap_opt_w2_c1200_1.out VSS.t1094 sg13_lv_nmos ad=0.195p pd=1.39u as=0.35p ps=2.7u w=1u l=0.13u
X1270 VDD.t247 VSS.t852 VDD.t247 VDD.t162 sg13_lv_pmos ad=0.34p pd=2.68u as=0 ps=0 w=1u l=1u
X1271 oa_sar8_acore18_opt_0.sw_tg_opt_0.bot.t3 oa_sar8_acore18_opt_0.sw_bitcell_opt_b7_0.bot.t25 cap_cmim l=2.14u w=2.14u
X1272 a_32533_40471# sar_ctrl_async_phys_0.sg13g2_dfrbpq_1_0.CLK.t19 VDD.t311 VDD.t311 sg13_lv_pmos ad=0.4088p pd=2.97u as=1.55472p ps=9.945u w=1.12u l=0.13u
X1273 sar_ctrl_async_phys_0.sg13g2_nand2_1_0.B sar_ctrl_async_phys_0.sg13g2_dfrbpq_1_0.CLK.t15 VSS.t154 VSS.t1211 sg13_lv_nmos ad=0.1406p pd=1.12u as=0.2516p ps=2.16u w=0.74u l=0.13u
X1274 a_32341_32117# sar_ctrl_async_phys_0.sg13g2_dfrbpq_1_0.CLK.t4 VDD.t340 VDD.t118 sg13_lv_pmos ad=0.4088p pd=2.97u as=1.79957p ps=11.62u w=1.12u l=0.13u
X1275 a_30868_44234# sar_ctrl_async_phys_0.sg13g2_nor2_1_11.Y a_30774_44234# VSS.t1176 sg13_lv_nmos ad=60.89999f pd=0.71u as=0.1428p ps=1.52u w=0.42u l=0.13u
X1276 VDD.t818 sar_ctrl_async_phys_0.sg13g2_a21oi_1_2.A2 a_31261_38232# VDD.t162 sg13_lv_pmos ad=0.1918p pd=1.5u as=0.1596p ps=1.22u w=0.84u l=0.13u
X1277 VDD.t238 VSS.t966 VDD.t238 VDD.t54 sg13_lv_pmos ad=0.34p pd=2.68u as=0 ps=0 w=1u l=1u
X1278 VSS.t129 VDD.t16 VSS.t129 VSS.t691 sg13_lv_nmos ad=79.8f pd=0.8u as=0 ps=0 w=0.42u l=1u
X1279 sar_ctrl_async_phys_0.sg13g2_a22oi_1_2.B1 sar_ctrl_async_phys_0.sg13g2_nor2b_1_0.A.t1 VDD.t56 VDD.t54 sg13_lv_pmos ad=0.2128p pd=1.5u as=0.3808p ps=2.92u w=1.12u l=0.13u
X1280 VSS.t129 VDD.t33 VSS.t129 VSS.t91 sg13_lv_nmos ad=79.8f pd=0.8u as=0 ps=0 w=0.42u l=1u
X1281 VSS.t5 a_33248_35382# a_32897_35239# VSS.t326 sg13_lv_nmos ad=79.8f pd=0.8u as=0.1428p ps=1.52u w=0.42u l=0.13u
X1282 oa_sar8_acore18_opt_0.sw_tg_opt_0.bot.t2 oa_sar8_acore18_opt_0.sw_bitcell_opt_b7_0.bot.t152 cap_cmim l=2.14u w=2.14u
X1283 VSS.t220 sar_ctrl_async_phys_0.hold_req oa_sar8_acore18_opt_0.sw_bitcell_opt_term_0.VSS VSS.t219 sg13_lv_nmos ad=0.7p pd=4.7u as=0.39p ps=2.39u w=2u l=0.13u
X1284 a_35113_41525# a_34171_41332# a_34911_41287# VDD.t5 sg13_lv_pmos ad=93.45f pd=0.865u as=0.2048p ps=1.63u w=0.42u l=0.13u
X1285 VSS.t515 a_32149_45007# a_32251_45007# VSS.t558 sg13_lv_nmos ad=6.70155p pd=42.66u as=0.2516p ps=2.16u w=0.74u l=0.13u
X1286 oa_sar8_acore18_opt_0.sw_tg_opt_0.bot.t3 oa_sar8_acore18_opt_0.sw_bitcell_opt_b5_0.bot.t2 cap_cmim l=2.14u w=2.14u
X1287 a_34132_32904# a_34106_32868# VDD.t342 VDD.t118 sg13_lv_pmos ad=0.34p pd=2.68u as=0.36237p ps=2.605u w=1u l=0.13u
X1288 VDD.t363 a_26954_40424# a_26673_40726# VDD.t311 sg13_lv_pmos ad=0.1523p pd=1.38u as=0.34p ps=2.68u w=1u l=0.5u
X1289 VDD.t247 VSS.t172 VDD.t247 VDD.t162 sg13_lv_pmos ad=0.19p pd=1.38u as=0 ps=0 w=1u l=1u
X1290 VSS.t148 a_35648_33142# a_35297_33261# VSS.t152 sg13_lv_nmos ad=79.8f pd=0.8u as=0.1428p ps=1.52u w=0.42u l=0.13u
X1291 VSS.t172 a_34308_37400# sar_ctrl_async_phys_0.sg13g2_nor2_1_2.A VSS.t118 sg13_lv_nmos ad=0.17255p pd=1.25u as=0.1406p ps=1.12u w=0.74u l=0.13u
X1292 a_32473_40507# a_32116_40464# VDD.t328 VDD.t311 sg13_lv_pmos ad=63f pd=0.72u as=0.1563p ps=1.22u w=0.42u l=0.13u
X1293 VSS.t144 a_26544_38389# sar_ctrl_async_phys_0.sg13g2_and2_1_2.X VSS.t1142 sg13_lv_nmos ad=0.1331p pd=1.12u as=0.2516p ps=2.16u w=0.74u l=0.13u
X1294 VDD.t39 a_34549_30605# a_34651_30748# VDD.t39 sg13_lv_pmos ad=1.96315p pd=12.675u as=0.3864p ps=2.93u w=1.12u l=0.13u
X1295 sar_ctrl_async_phys_0.sg13g2_nand2b_1_7.A_N a_35770_43484# VDD.t600 VDD.t0 sg13_lv_pmos ad=0.3808p pd=2.92u as=0.2128p ps=1.5u w=1.12u l=0.13u
X1296 oa_sar8_acore18_opt_0.sw_tg_opt_0.bot.t3 oa_sar8_acore18_opt_0.sw_bitcell_opt_b6_0.bot.t15 cap_cmim l=2.14u w=2.14u
X1297 VSS.t920 VDD.t54 VSS.t920 VSS.t114 sg13_lv_nmos ad=79.8f pd=0.8u as=0 ps=0 w=0.42u l=1u
X1298 sar_ctrl_async_phys_0.sg13g2_buf_1_26.X a_25496_31388# VDD.t194 VDD.t39 sg13_lv_pmos ad=0.42p pd=2.99u as=0.2114p ps=1.54u w=1.12u l=0.13u
X1299 VDD.t345 sar_ctrl_async_phys_0.sg13g2_a21oi_1_4.B1 a_36056_47296# VDD.t15 sg13_lv_pmos ad=0.2114p pd=1.54u as=0.2856p ps=2.36u w=0.84u l=0.13u
X1300 a_26454_39702# a_26184_39702# VDD.t339 VDD.t311 sg13_lv_pmos ad=0.34p pd=2.68u as=0.1523p ps=1.38u w=1u l=0.5u
X1301 VSS.t98 sar_ctrl_async_phys_0.sg13g2_buf_1_2.X.t1 a_31732_32138# VSS.t97 sg13_lv_nmos ad=0.1626p pd=1.415u as=60.89999f ps=0.71u w=0.42u l=0.13u
X1302 VDD.t46 VSS.t920 VDD.t46 VDD.t37 sg13_lv_pmos ad=0.19p pd=1.38u as=0 ps=0 w=1u l=1u
X1303 sar_ctrl_async_phys_0.sg13g2_a21oi_1_0.B1 a_35725_45266# VDD.t568 VDD.t69 sg13_lv_pmos ad=0.2128p pd=1.5u as=0.3808p ps=2.92u w=1.12u l=0.13u
X1304 oa_sar8_acore18_opt_0.sw_tg_opt_0.bot.t3 oa_sar8_acore18_opt_0.sw_bitcell_opt_b5_0.bot.t35 cap_cmim l=2.14u w=2.14u
X1305 oa_sar8_acore18_opt_0.sw_tg_opt_1.bot.t3 oa_sar8_acore18_opt_0.sw_bitcell_opt_b7_1.bot.t136 cap_cmim l=2.14u w=2.14u
X1306 VSS.t892 VDD.t46 VSS.t891 VSS.t890 sg13_lv_nmos ad=0.1428p pd=1.52u as=0 ps=0 w=0.42u l=1u
X1307 VDD.t13 a_34261_36653# a_34363_36796# VDD.t13 sg13_lv_pmos ad=2.48357p pd=16.205u as=0.3864p ps=2.93u w=1.12u l=0.13u
X1308 VDD.t151 VSS.t767 VDD.t150 VDD.t0 sg13_lv_pmos ad=0.19p pd=1.38u as=0 ps=0 w=1u l=1u
X1309 a_26544_38389# sar_ctrl_async_phys_0.sg13g2_nor2_1_3.A a_26681_38232# VSS.t1281 sg13_lv_nmos ad=0.2176p pd=1.96u as=0.1216p ps=1.02u w=0.64u l=0.13u
X1310 VDD.t191 VSS.t886 VDD.t191 VDD.t13 sg13_lv_pmos ad=0.34p pd=2.68u as=0 ps=0 w=1u l=1u
X1311 VDD.t42 sar_ctrl_async_phys_0.sg13g2_buf_1_2.A a_33750_36362# VDD.t37 sg13_lv_pmos ad=0.36237p pd=2.605u as=79.8f ps=0.8u w=0.42u l=0.13u
X1312 a_31732_45000# a_31706_44964# VDD.t117 VDD.t69 sg13_lv_pmos ad=0.34p pd=2.68u as=0.36237p ps=2.605u w=1u l=0.13u
X1313 sar_ctrl_async_phys_0.sg13g2_buf_1_21.A sar_ctrl_async_phys_0.sg13g2_a21oi_1_2.B1 VDD.t350 VDD.t162 sg13_lv_pmos ad=0.2128p pd=1.5u as=0.3808p ps=2.92u w=1.12u l=0.13u
X1314 a_35948_n9612# oa_sar8_acore18_opt_0.sw_bitcell_opt_term_0.trkb.t6 VSS.t439 VSS.t438 sg13_lv_nmos ad=0.19p pd=1.38u as=0.345p ps=2.69u w=1u l=0.15u
X1315 oa_sar8_acore18_opt_0.sw_tg_opt_1.bot.t3 oa_sar8_acore18_opt_0.sw_bitcell_opt_b6_1.bot.t74 cap_cmim l=2.14u w=2.14u
X1316 VSS.t166 a_35952_39901# sar_ctrl_async_phys_0.sg13g2_buf_1_23.A VSS.t385 sg13_lv_nmos ad=0.1331p pd=1.12u as=0.2516p ps=2.16u w=0.74u l=0.13u
X1317 oa_sar8_acore18_opt_0.sw_tg_opt_0.bot.t2 oa_sar8_acore18_opt_0.sw_bitcell_opt_b7_0.bot.t157 cap_cmim l=2.14u w=2.14u
X1318 VSS.t672 VDD.t68 VSS.t672 VSS.t701 sg13_lv_nmos ad=79.8f pd=0.8u as=0 ps=0 w=0.42u l=1u
X1319 VDD.t211 VSS.t926 VDD.t301 VDD.t54 sg13_lv_pmos ad=0.34p pd=2.68u as=0 ps=0 w=1u l=1u
X1320 VSS.t72 sar_ctrl_async_phys_0.sg13g2_dlygate4sd3_1_6.X a_26184_42013# VSS.t358 sg13_lv_nmos ad=79.8f pd=0.8u as=0.1428p ps=1.52u w=0.42u l=0.13u
X1321 sar_ctrl_async_phys_0.dac_code[5] a_36056_38948# VSS.t166 VSS.t246 sg13_lv_nmos ad=0.2886p pd=2.26u as=0.14875p ps=1.16u w=0.74u l=0.13u
X1322 VDD.t350 sar_ctrl_async_phys_0.sg13g2_buf_1_13.A a_35288_38224# VDD.t162 sg13_lv_pmos ad=0.2114p pd=1.54u as=0.2856p ps=2.36u w=0.84u l=0.13u
X1323 a_31638_32138# a_32443_32260# a_31898_32361# VDD.t118 sg13_lv_pmos ad=0.1428p pd=1.52u as=79.8f ps=0.8u w=0.42u l=0.13u
X1324 a_33675_43020# sar_ctrl_async_phys_0.sg13g2_dfrbpq_1_2.Q VDD.t366 VDD.t0 sg13_lv_pmos ad=0.3808p pd=2.92u as=0.2128p ps=1.5u w=1.12u l=0.13u
X1325 busy a_35672_33688# VDD.t338 VDD.t54 sg13_lv_pmos ad=0.42p pd=2.99u as=0.2114p ps=1.54u w=1.12u l=0.13u
X1326 a_34911_41287# a_34069_41189# a_33652_41528# VDD.t5 sg13_lv_pmos ad=0.2048p pd=1.63u as=0.34p ps=2.68u w=1u l=0.13u
X1327 oa_sar8_acore18_opt_0.sw_tg_opt_0.bot.t3 oa_sar8_acore18_opt_0.sw_bitcell_opt_b6_0.bot.t50 cap_cmim l=2.14u w=2.14u
X1328 VSS.t115 VDD.t56 VSS.t115 VSS.t114 sg13_lv_nmos ad=79.8f pd=0.8u as=0 ps=0 w=0.42u l=1u
X1329 VSS.t123 sar_ctrl_async_phys_0.sg13g2_a21oi_1_6.A2 a_32817_42748# VSS.t1161 sg13_lv_nmos ad=0.2516p pd=2.16u as=0.1406p ps=1.12u w=0.74u l=0.13u
X1330 oa_sar8_acore18_opt_0.sw_tg_opt_1.bot.t3 oa_sar8_acore18_opt_0.sw_bitcell_opt_b5_1.bot.t21 cap_cmim l=2.14u w=2.14u
X1331 oa_sar8_acore18_opt_0.sw_bitcell_opt_term_0.trkb.t3 sar_ctrl_async_phys_0.sample VDD.t469 VDD.t467 sg13_lv_pmos ad=0.39p pd=2.39u as=0.7p ps=4.7u w=2u l=0.13u
X1332 VDD.t68 VSS.t672 VDD.t68 VDD.t29 sg13_lv_pmos ad=0.19p pd=1.38u as=0 ps=0 w=1u l=1u
X1333 VDD.t668 sar_ctrl_async_phys_0.sg13g2_nand2b_1_3.Y a_34328_41972# VDD.t5 sg13_lv_pmos ad=0.2114p pd=1.54u as=0.2856p ps=2.36u w=0.84u l=0.13u
X1334 a_30772_31392# a_30746_31356# VDD.t44 VDD.t39 sg13_lv_pmos ad=0.34p pd=2.68u as=0.36237p ps=2.605u w=1u l=0.13u
X1335 a_35168_41430# a_34911_41287# a_35330_41210# VSS.t593 sg13_lv_nmos ad=0.1428p pd=1.52u as=37.8f ps=0.6u w=0.42u l=0.13u
X1336 a_29332_32456# a_29851_32260# a_30591_32215# VSS.t169 sg13_lv_nmos ad=0.3473p pd=2.71u as=0.12665p ps=1.145u w=0.74u l=0.13u
X1337 a_34833_37784# sar_ctrl_async_phys_0.sg13g2_a21oi_1_0.A1.t2 sar_ctrl_async_phys_0.sg13g2_a21oi_1_1.Y VSS.t118 sg13_lv_nmos ad=0.1406p pd=1.12u as=0.1406p ps=1.12u w=0.74u l=0.13u
X1338 VDD.t44 VSS.t1058 VDD.t44 VDD.t39 sg13_lv_pmos ad=0.34p pd=2.68u as=0 ps=0 w=1u l=1u
X1339 VSS.t148 sar_ctrl_async_phys_0.sg13g2_buf_1_6.A a_35672_33688# VSS.t63 sg13_lv_nmos ad=0.14875p pd=1.16u as=0.187p ps=1.78u w=0.55u l=0.13u
X1340 oa_sar8_acore18_opt_0.sw_tg_opt_1.bot.t3 oa_sar8_acore18_opt_0.sw_bitcell_opt_b6_1.bot.t39 cap_cmim l=2.14u w=2.14u
X1341 VDD.t189 VSS.t1003 VDD.t189 VDD.t39 sg13_lv_pmos ad=0.34p pd=2.68u as=0 ps=0 w=1u l=1u
X1342 sar_ctrl_async_phys_0.sg13g2_nand2b_1_7.A_N a_35770_43484# VSS.t616 VSS.t615 sg13_lv_nmos ad=0.2516p pd=2.16u as=0.1406p ps=1.12u w=0.74u l=0.13u
X1343 VSS.t123 VDD.t209 VSS.t123 VSS.t828 sg13_lv_nmos ad=79.8f pd=0.8u as=0 ps=0 w=0.42u l=1u
X1344 VDD.t876 VDD.t874 oa_sar8_acore18_opt_0.sw_bitcell_opt_term_0.bot.t1 VDD.t875 sg13_lv_pmos ad=1.05p pd=6.7u as=0.585p ps=3.39u w=3u l=0.13u
X1345 oa_sar8_acore18_opt_0.sw_bitcell_opt_term_0.VSS sar_ctrl_async_phys_0.dac_code[0] oa_sar8_acore18_opt_0.sw_bitcell_opt_b0_0.bot.t0 VSS.t482 sg13_lv_nmos ad=0.525p pd=3.7u as=0.2925p ps=1.89u w=1.5u l=0.13u
X1346 oa_sar8_acore18_opt_0.sw_bitcell_opt_b0_0.bot.t0 oa_sar8_acore18_opt_0.sw_bitcell_opt_term_0.trkb.t14 oa_sar8_acore18_opt_0.sw_bitcell_opt_term_0.vin VDD.t615 sg13_lv_pmos ad=0.39p pd=2.39u as=0.7p ps=4.7u w=2u l=0.13u
X1347 VSS.t123 sar_ctrl_async_phys_0.sg13g2_buf_1_35.A a_34175_42726# VSS.t176 sg13_lv_nmos ad=0.14505p pd=1.15u as=0.1406p ps=1.12u w=0.74u l=0.13u
X1348 sar_ctrl_async_phys_0.dac_code_n[7] a_34328_41972# VDD.t668 VDD.t5 sg13_lv_pmos ad=0.42p pd=2.99u as=0.2114p ps=1.54u w=1.12u l=0.13u
X1349 a_32354_39698# sar_ctrl_async_phys_0.sg13g2_o21ai_1_1.B1 VSS.t31 VSS.t30 sg13_lv_nmos ad=37.8f pd=0.6u as=79.8f ps=0.8u w=0.42u l=0.13u
X1350 VSS.t37 sar_ctrl_async_phys_0.sg13g2_a21oi_1_2.A2 a_30129_39724# VSS.t618 sg13_lv_nmos ad=0.2516p pd=2.16u as=0.1406p ps=1.12u w=0.74u l=0.13u
X1351 VDD.t351 VSS.t144 VDD.t351 VDD.t162 sg13_lv_pmos ad=0.19p pd=1.38u as=0 ps=0 w=1u l=1u
X1352 a_35327_45366# a_35245_45266# sar_ctrl_async_phys_0.sg13g2_a21oi_1_1.B1 VSS.t280 sg13_lv_nmos ad=0.1406p pd=1.12u as=0.333p ps=2.38u w=0.74u l=0.13u
X1353 VSS.t190 a_30495_39309# a_31162_38948# VSS.t1272 sg13_lv_nmos ad=0.1406p pd=1.12u as=0.2516p ps=2.16u w=0.74u l=0.13u
X1354 VDD.t736 VSS.t346 VDD.t139 VDD.t0 sg13_lv_pmos ad=0.19p pd=1.38u as=0 ps=0 w=1u l=1u
X1355 sar_ctrl_async_phys_0.sg13g2_dfrbpq_1_9.Q a_33658_44996# VDD.t415 VDD.t69 sg13_lv_pmos ad=0.3808p pd=2.92u as=0.2128p ps=1.5u w=1.12u l=0.13u
X1356 oa_sar8_acore18_opt_0.sw_tg_opt_0.bot.t3 oa_sar8_acore18_opt_0.sw_bitcell_opt_b3_0.bot.t10 cap_cmim l=2.14u w=2.14u
X1357 VSS.t174 sar_ctrl_async_phys_0.sg13g2_nand2_1_3.A a_35807_45366# VSS.t650 sg13_lv_nmos ad=0.14505p pd=1.15u as=0.1406p ps=1.12u w=0.74u l=0.13u
X1358 VSS.t967 VDD.t238 VSS.t969 VSS.t968 sg13_lv_nmos ad=79.8f pd=0.8u as=0 ps=0 w=0.42u l=1u
X1359 a_32156_38948# sar_ctrl_async_phys_0.sg13g2_a21oi_1_7.Y sar_ctrl_async_phys_0.sg13g2_dfrbpq_1_11.D VDD.t162 sg13_lv_pmos ad=0.1176p pd=1.33u as=0.3808p ps=2.92u w=1.12u l=0.13u
X1360 a_31381_46519# sar_ctrl_async_phys_0.sg13g2_dfrbpq_1_0.CLK VDD.t323 VDD.t29 sg13_lv_pmos ad=0.4088p pd=2.97u as=1.98685p ps=12.96u w=1.12u l=0.13u
X1361 a_34236_46472# sar_ctrl_async_phys_0.sg13g2_buf_1_3.A.t3 VSS.t62 VSS.t91 sg13_lv_nmos ad=0.187p pd=1.78u as=0.14875p ps=1.16u w=0.55u l=0.13u
X1362 VSS.t253 a_35360_43726# a_35009_43845# VSS.t321 sg13_lv_nmos ad=79.8f pd=0.8u as=0.1428p ps=1.52u w=0.42u l=0.13u
X1363 VDD.t6 a_25596_41174# sar_ctrl_async_phys_0.cmp_fire VDD.t5 sg13_lv_pmos ad=0.2114p pd=1.54u as=0.42p ps=2.99u w=1.12u l=0.13u
X1364 VSS.t72 VDD.t10 VSS.t72 VSS.t815 sg13_lv_nmos ad=79.8f pd=0.8u as=0 ps=0 w=0.42u l=1u
X1365 oa_sar8_acore18_opt_0.sw_tg_opt_1.bot.t3 oa_sar8_acore18_opt_0.sw_bitcell_opt_b4_1.bot.t5 cap_cmim l=2.14u w=2.14u
X1366 sar_ctrl_async_phys_0.sg13g2_buf_1_21.A sar_ctrl_async_phys_0.sg13g2_buf_1_6.A a_35402_39318# VSS.t1265 sg13_lv_nmos ad=0.2516p pd=2.16u as=0.1406p ps=1.12u w=0.74u l=0.13u
X1367 oa_sar8_acore18_opt_0.sw_tg_opt_0.bot.t3 oa_sar8_acore18_opt_0.sw_bitcell_opt_b6_0.bot.t5 cap_cmim l=2.14u w=2.14u
X1368 sar_ctrl_async_phys_0.sg13g2_dlygate4sd3_1_0.A a_28006_35948# VSS.t277 VSS.t1290 sg13_lv_nmos ad=0.2516p pd=2.16u as=0.1426p ps=1.16u w=0.74u l=0.13u
X1369 oa_sar8_acore18_opt_0.sw_tg_opt_1.bot.t2 oa_sar8_acore18_opt_0.sw_bitcell_opt_b7_1.bot.t157 cap_cmim l=2.14u w=2.14u
X1370 VSS.t115 VDD.t38 VSS.t115 VSS.t114 sg13_lv_nmos ad=79.8f pd=0.8u as=0 ps=0 w=0.42u l=1u
X1371 a_30772_46946# sar_ctrl_async_phys_0.sg13g2_nor2b_1_4.Y a_30678_46946# VSS.t483 sg13_lv_nmos ad=60.89999f pd=0.71u as=0.1428p ps=1.52u w=0.42u l=0.13u
X1372 oa_sar8_acore18_opt_0.sw_tg_opt_0.bot.t3 oa_sar8_acore18_opt_0.sw_bitcell_opt_b7_0.bot.t40 cap_cmim l=2.14u w=2.14u
X1373 oa_sar8_acore18_opt_0.sw_bitcell_opt_b2_0.bot.t0 sar_ctrl_async_phys_0.dac_code[2] oa_sar8_acore18_opt_0.sw_bitcell_opt_term_0.VSS VSS.t255 sg13_lv_nmos ad=0.3705p pd=2.29u as=0.665p ps=4.5u w=1.9u l=0.13u
X1374 a_34420_30639# a_34651_30748# a_34106_30849# VSS.t582 sg13_lv_nmos ad=0.2373p pd=1.97u as=79.8f ps=0.8u w=0.42u l=0.13u
X1375 a_34358_30639# sar_ctrl_async_phys_0.sg13g2_buf_1_2.X VSS.t421 VSS.t422 sg13_lv_nmos ad=37.8f pd=0.6u as=0.1701p ps=1.65u w=0.42u l=0.13u
X1376 VDD.t40 VSS.t1072 VDD.t40 VDD.t39 sg13_lv_pmos ad=0.34p pd=2.68u as=0 ps=0 w=1u l=1u
X1377 VSS.t9 a_33183_32215# a_33850_32436# VSS.t8 sg13_lv_nmos ad=0.1406p pd=1.12u as=0.2516p ps=2.16u w=0.74u l=0.13u
X1378 VDD.t337 sar_ctrl_async_phys_0.sg13g2_nor4_1_0.C a_34520_47296# VDD.t15 sg13_lv_pmos ad=0.2114p pd=1.54u as=0.2856p ps=2.36u w=0.84u l=0.13u
X1379 VDD.t35 sar_ctrl_async_phys_0.sg13g2_nand2_1_2.A sar_ctrl_async_phys_0.sg13g2_buf_1_34.A VDD.t29 sg13_lv_pmos ad=0.3808p pd=2.92u as=0.2128p ps=1.5u w=1.12u l=0.13u
X1380 VDD.t36 VSS.t346 VDD.t209 VDD.t5 sg13_lv_pmos ad=0.34p pd=2.68u as=0 ps=0 w=1u l=1u
X1381 VSS.t1008 VDD.t61 VSS.t1008 VSS.t17 sg13_lv_nmos ad=79.8f pd=0.8u as=0 ps=0 w=0.42u l=1u
X1382 VDD.t101 VSS.t672 VDD.t101 VDD.t15 sg13_lv_pmos ad=0.19p pd=1.38u as=0 ps=0 w=1u l=1u
X1383 result[6] a_36056_32176# VDD.t342 VDD.t118 sg13_lv_pmos ad=0.42p pd=2.99u as=0.2114p ps=1.54u w=1.12u l=0.13u
X1384 VSS.t730 VDD.t78 VSS.t733 VSS.t732 sg13_lv_nmos ad=79.8f pd=0.8u as=0 ps=0 w=0.42u l=1u
X1385 a_32342_40885# sar_ctrl_async_phys_0.sg13g2_o21ai_1_1.B1 VSS.t48 VSS.t47 sg13_lv_nmos ad=37.8f pd=0.6u as=0.1701p ps=1.65u w=0.42u l=0.13u
X1386 a_31194_44996# sar_ctrl_async_phys_0.sg13g2_nor2b_1_4.Y VDD.t117 VDD.t69 sg13_lv_pmos ad=0.1176p pd=1.33u as=0.4032p ps=2.96u w=1.12u l=0.13u
X1387 oa_sar8_acore18_opt_0.sw_tg_opt_0.bot.t3 oa_sar8_acore18_opt_0.sw_bitcell_opt_b6_0.bot.t50 cap_cmim l=2.14u w=2.14u
X1388 oa_sar8_acore18_opt_0.sw_bitcell_opt_b5_0.bot.t1 sar_ctrl_async_phys_0.dac_code[5] VDD.t985 VDD.t983 sg13_lv_pmos ad=1.053p pd=5.79u as=1.89p ps=11.5u w=5.4u l=0.13u
X1389 a_34201_43531# a_33844_43488# VDD.t389 VDD.t0 sg13_lv_pmos ad=63f pd=0.72u as=0.1563p ps=1.22u w=0.42u l=0.13u
X1390 VDD.t205 VSS.t464 VDD.t230 VDD.t118 sg13_lv_pmos ad=0.19p pd=1.38u as=0 ps=0 w=1u l=1u
X1391 VDD.t254 sar_ctrl_async_phys_0.cmp_n a_25496_34412# VDD.t54 sg13_lv_pmos ad=0.2114p pd=1.54u as=0.2856p ps=2.36u w=0.84u l=0.13u
X1392 VSS.t977 VDD.t230 VSS.t976 VSS.t975 sg13_lv_nmos ad=0.1428p pd=1.52u as=0 ps=0 w=0.42u l=1u
X1393 a_34070_36687# sar_ctrl_async_phys_0.sg13g2_buf_1_2.A.t3 VSS.t184 VSS.t404 sg13_lv_nmos ad=37.8f pd=0.6u as=0.1701p ps=1.65u w=0.42u l=0.13u
X1394 oa_sar8_acore18_opt_0.sw_bitcell_opt_b7_0.bot.t0 oa_sar8_acore18_opt_0.sw_bitcell_opt_term_0.trkb.t21 oa_sar8_acore18_opt_0.sw_bitcell_opt_term_0.vin VDD.t641 sg13_lv_pmos ad=0.39p pd=2.39u as=0.7p ps=4.7u w=2u l=0.13u
X1395 VSS.t887 VDD.t46 VSS.t889 VSS.t888 sg13_lv_nmos ad=79.8f pd=0.8u as=0 ps=0 w=0.42u l=1u
X1396 VSS.t182 VDD.t14 VSS.t182 VSS.t903 sg13_lv_nmos ad=79.8f pd=0.8u as=0 ps=0 w=0.42u l=1u
X1397 VDD.t79 VSS.t730 VDD.t79 VDD.t69 sg13_lv_pmos ad=0.19p pd=1.38u as=0 ps=0 w=1u l=1u
X1398 a_27206_39326# sar_ctrl_async_phys_0.sg13g2_nor2_1_3.B VSS.t511 VSS.t89 sg13_lv_nmos ad=0.1406p pd=1.12u as=0.1406p ps=1.12u w=0.74u l=0.15u
X1399 VSS.t436 oa_sar8_acore18_opt_0.sw_bitcell_opt_term_0.trkb.t9 a_20412_n9612# VSS.t435 sg13_lv_nmos ad=0.345p pd=2.69u as=0.19p ps=1.38u w=1u l=0.15u
X1400 VDD.t205 sar_ctrl_async_phys_0.sg13g2_buf_1_2.X a_29046_32138# VDD.t118 sg13_lv_pmos ad=0.36237p pd=2.605u as=79.8f ps=0.8u w=0.42u l=0.13u
X1401 VSS.t58 sar_ctrl_async_phys_0.sg13g2_dlygate4sd3_1_7.X a_26280_41214# VSS.t167 sg13_lv_nmos ad=79.8f pd=0.8u as=0.1428p ps=1.52u w=0.42u l=0.13u
X1402 VDD.t163 sar_ctrl_async_phys_0.sg13g2_o21ai_1_1.B1 a_28950_39386# VDD.t162 sg13_lv_pmos ad=0.36237p pd=2.605u as=79.8f ps=0.8u w=0.42u l=0.13u
X1403 VDD.t14 a_29701_36874# sar_ctrl_async_phys_0.sg13g2_nand3b_1_0.Y VDD.t13 sg13_lv_pmos ad=0.2128p pd=1.5u as=0.3808p ps=2.92u w=1.12u l=0.13u
X1404 VSS.t920 VDD.t46 VSS.t919 VSS.t114 sg13_lv_nmos ad=0.1428p pd=1.52u as=0 ps=0 w=0.42u l=1u
X1405 VDD.t238 VSS.t971 VDD.t238 VDD.t54 sg13_lv_pmos ad=0.34p pd=2.68u as=0 ps=0 w=1u l=1u
X1406 VDD.t16 VSS.t677 VDD.t16 VDD.t15 sg13_lv_pmos ad=0.19p pd=1.38u as=0 ps=0 w=1u l=1u
X1407 VSS.t434 sar_ctrl_async_phys_0.sg13g2_buf_1_5.A a_36056_32176# VSS.t1239 sg13_lv_nmos ad=0.14875p pd=1.16u as=0.187p ps=1.78u w=0.55u l=0.13u
X1408 a_30714_43020# sar_ctrl_async_phys_0.sg13g2_nor2_1_11.A VDD.t1089 VDD.t0 sg13_lv_pmos ad=0.1176p pd=1.33u as=0.4032p ps=2.96u w=1.12u l=0.13u
X1409 VSS.t115 VDD.t56 VSS.t115 VSS.t114 sg13_lv_nmos ad=0.1428p pd=1.52u as=0 ps=0 w=0.42u l=1u
X1410 oa_sar8_acore18_opt_0.sw_tg_opt_1.bot.t3 oa_sar8_acore18_opt_0.sw_bitcell_opt_b6_1.bot.t54 cap_cmim l=2.14u w=2.14u
X1411 sar_ctrl_async_phys_0.sg13g2_nand2_1_3.Y sar_ctrl_async_phys_0.sg13g2_nand2_1_3.B VDD.t389 VDD.t0 sg13_lv_pmos ad=0.2128p pd=1.5u as=0.3808p ps=2.92u w=1.12u l=0.13u
X1412 VDD.t312 sar_ctrl_async_phys_0.sg13g2_o21ai_1_1.B1 a_29498_40428# VDD.t311 sg13_lv_pmos ad=0.1563p pd=1.22u as=0.147p ps=1.54u w=0.42u l=0.13u
X1413 VDD.t314 a_34596_40424# a_34554_40460# VDD.t311 sg13_lv_pmos ad=0.2618p pd=1.63u as=0.1176p ps=1.33u w=1.12u l=0.13u
X1414 a_33940_41223# a_33652_41528# a_33878_41223# VSS.t130 sg13_lv_nmos ad=0.1428p pd=1.52u as=37.8f ps=0.6u w=0.42u l=0.13u
X1415 VDD.t196 sar_ctrl_async_phys_0.sg13g2_nand3_1_0.Y sar_ctrl_async_phys_0.sg13g2_o21ai_1_1.A2 VDD.t162 sg13_lv_pmos ad=0.3808p pd=2.92u as=0.2128p ps=1.5u w=1.12u l=0.15u
X1416 a_29594_43452# a_30037_43495# a_29334_43922# VSS.t374 sg13_lv_nmos ad=79.8f pd=0.8u as=0.1296p ps=1.52u w=0.42u l=0.13u
X1417 a_33818_36897# a_34261_36653# a_34201_37065# VDD.t13 sg13_lv_pmos ad=79.8f pd=0.8u as=63f ps=0.72u w=0.42u l=0.13u
X1418 VSS.t718 VDD.t68 VSS.t720 VSS.t719 sg13_lv_nmos ad=79.8f pd=0.8u as=0 ps=0 w=0.42u l=1u
X1419 a_33882_38484# sar_ctrl_async_phys_0.sg13g2_nor2_1_1.A VDD.t247 VDD.t162 sg13_lv_pmos ad=0.1176p pd=1.33u as=0.4032p ps=2.96u w=1.12u l=0.13u
X1420 oa_sar8_acore18_opt_0.sw_tg_opt_0.bot.t3 oa_sar8_acore18_opt_0.sw_bitcell_opt_b7_0.bot.t125 cap_cmim l=2.14u w=2.14u
X1421 a_32150_32151# sar_ctrl_async_phys_0.sg13g2_buf_1_2.X.t1 VSS.t98 VSS.t97 sg13_lv_nmos ad=37.8f pd=0.6u as=0.1701p ps=1.65u w=0.42u l=0.13u
X1422 a_30650_39921# a_31093_39677# a_30390_39698# VSS.t1086 sg13_lv_nmos ad=79.8f pd=0.8u as=0.1296p ps=1.52u w=0.42u l=0.13u
X1423 oa_sar8_acore18_opt_0.sw_tg_opt_0.bot.t3 oa_sar8_acore18_opt_0.sw_bitcell_opt_b3_0.bot.t14 cap_cmim l=2.14u w=2.14u
X1424 oa_sar8_acore18_opt_0.sw_tg_opt_0.bot.t4 oa_sar8_acore18_opt_0.sw_bitcell_opt_b7_0.bot.t10 cap_cmim l=2.14u w=2.14u
X1425 a_30229_33629# sar_ctrl_async_phys_0.sg13g2_dfrbpq_1_0.CLK.t7 VSS.t151 VSS.t604 sg13_lv_nmos ad=0.2516p pd=2.16u as=4.49817p ps=29.795u w=0.74u l=0.13u
X1426 VSS.t772 VDD.t4 VSS.t773 VSS.t185 sg13_lv_nmos ad=79.8f pd=0.8u as=0 ps=0 w=0.42u l=1u
X1427 VDD.t196 VSS.t144 VDD.t276 VDD.t162 sg13_lv_pmos ad=0.19p pd=1.38u as=0 ps=0 w=1u l=1u
X1428 oa_sar8_acore18_opt_0.sw_tg_opt_1.bot.t2 oa_sar8_acore18_opt_0.sw_bitcell_opt_b7_1.bot.t162 cap_cmim l=2.14u w=2.14u
X1429 VSS.t722 VDD.t68 VSS.t722 VSS.t721 sg13_lv_nmos ad=0.1428p pd=1.52u as=0 ps=0 w=0.42u l=1u
X1430 a_35772_41936# sar_ctrl_async_phys_0.sg13g2_buf_1_35.A VSS.t178 VSS.t177 sg13_lv_nmos ad=0.187p pd=1.78u as=0.14875p ps=1.16u w=0.55u l=0.13u
X1431 VSS.t239 sar_ctrl_async_phys_0.sample oa_sar8_acore18_opt_0.sw_bitcell_opt_term_0.trkb.t4 VSS.t238 sg13_lv_nmos ad=0.35p pd=2.7u as=0.195p ps=1.39u w=1u l=0.13u
X1432 VDD.t44 sar_ctrl_async_phys_0.sg13g2_buf_1_2.X a_30486_31826# VDD.t39 sg13_lv_pmos ad=0.36237p pd=2.605u as=79.8f ps=0.8u w=0.42u l=0.13u
X1433 VDD.t68 VSS.t724 VDD.t68 VDD.t29 sg13_lv_pmos ad=0.19p pd=1.38u as=0 ps=0 w=1u l=1u
X1434 VDD.t89 VSS.t774 VDD.t96 VDD.t69 sg13_lv_pmos ad=0.19p pd=1.38u as=0 ps=0 w=1u l=1u
X1435 VSS.t137 VDD.t139 VSS.t346 VSS.t809 sg13_lv_nmos ad=79.8f pd=0.8u as=0 ps=0 w=0.42u l=1u
X1436 a_30964_39711# a_30676_40016# a_30902_39711# VSS.t135 sg13_lv_nmos ad=0.1428p pd=1.52u as=37.8f ps=0.6u w=0.42u l=0.13u
X1437 oa_sar8_acore18_opt_0.sw_tg_opt_1.bot.t4 oa_sar8_acore18_opt_0.sw_bitcell_opt_b7_1.bot.t1 cap_cmim l=2.14u w=2.14u
X1438 VDD.t198 VSS.t5 VDD.t198 VDD.t54 sg13_lv_pmos ad=0.34p pd=2.68u as=0 ps=0 w=1u l=1u
X1439 VSS.t129 VDD.t32 VSS.t129 VSS.t713 sg13_lv_nmos ad=0.1428p pd=1.52u as=0 ps=0 w=0.42u l=1u
X1440 VSS.t50 sar_ctrl_async_phys_0.sg13g2_and2_1_5.X a_34904_38948# VSS.t1081 sg13_lv_nmos ad=0.14875p pd=1.16u as=0.187p ps=1.78u w=0.55u l=0.13u
X1441 VDD.t192 VSS.t920 VDD.t192 VDD.t37 sg13_lv_pmos ad=0.19p pd=1.38u as=0 ps=0 w=1u l=1u
X1442 VDD.t22 VSS.t129 VDD.t22 VDD.t15 sg13_lv_pmos ad=0.19p pd=1.38u as=0 ps=0 w=1u l=1u
X1443 oa_sar8_acore18_opt_0.sw_tg_opt_1.bot.t3 oa_sar8_acore18_opt_0.sw_bitcell_opt_b4_1.bot.t31 cap_cmim l=2.14u w=2.14u
X1444 VDD.t328 a_31935_39775# a_32602_39996# VDD.t311 sg13_lv_pmos ad=0.2128p pd=1.5u as=0.3864p ps=2.93u w=1.12u l=0.13u
X1445 oa_sar8_acore18_opt_0.sw_tg_opt_0.bot.t3 oa_sar8_acore18_opt_0.sw_bitcell_opt_b7_0.bot.t136 cap_cmim l=2.14u w=2.14u
X1446 oa_sar8_acore18_opt_0.sw_tg_opt_0.bot.t3 oa_sar8_acore18_opt_0.sw_bitcell_opt_b5_0.bot.t25 cap_cmim l=2.14u w=2.14u
X1447 a_29941_40471# sar_ctrl_async_phys_0.sg13g2_dfrbpq_1_0.CLK.t20 VDD.t311 VDD.t311 sg13_lv_pmos ad=0.4088p pd=2.97u as=1.55472p ps=9.945u w=1.12u l=0.13u
X1448 oa_sar8_acore18_opt_0.sw_tg_opt_1.bot.t3 oa_sar8_acore18_opt_0.sw_bitcell_opt_b7_1.bot.t110 cap_cmim l=2.14u w=2.14u
X1449 oa_sar8_acore18_opt_0.sw_tg_opt_0.bot.t3 oa_sar8_acore18_opt_0.sw_bitcell_opt_b6_0.bot.t75 cap_cmim l=2.14u w=2.14u
X1450 a_31040_40702# sar_ctrl_async_phys_0.sg13g2_o21ai_1_1.B1 VDD.t311 VDD.t311 sg13_lv_pmos ad=79.8f pd=0.8u as=1.55472p ps=9.945u w=0.42u l=0.13u
X1451 oa_sar8_acore18_opt_0.sw_tg_opt_1.bot.t3 oa_sar8_acore18_opt_0.sw_bitcell_opt_b7_1.bot.t68 cap_cmim l=2.14u w=2.14u
X1452 VSS.t1056 VDD.t44 VSS.t1054 VSS.t1055 sg13_lv_nmos ad=79.8f pd=0.8u as=0 ps=0 w=0.42u l=1u
X1453 VSS.t672 VDD.t68 VSS.t672 VSS.t703 sg13_lv_nmos ad=79.8f pd=0.8u as=0 ps=0 w=0.42u l=1u
X1454 VDD.t428 a_34911_41287# a_35578_41508# VDD.t5 sg13_lv_pmos ad=0.2128p pd=1.5u as=0.3864p ps=2.93u w=1.12u l=0.13u
X1455 VSS.t741 VDD.t116 VSS.t739 VSS.t740 sg13_lv_nmos ad=0.1428p pd=1.52u as=0 ps=0 w=0.42u l=1u
X1456 VDD.t323 a_32480_46750# a_32425_46631# VDD.t29 sg13_lv_pmos ad=2.2076p pd=14.4u as=93.45f ps=0.865u w=0.42u l=0.13u
X1457 oa_sar8_acore18_opt_0.sw_bitcell_opt_term_0.vin oa_sar8_acore18_opt_0.sw_bitcell_opt_term_0.trkb.t13 oa_sar8_acore18_opt_0.sw_bitcell_opt_term_0.bot.t0 VDD.t614 sg13_lv_pmos ad=0.7p pd=4.7u as=0.39p ps=2.39u w=2u l=0.13u
X1458 VDD.t334 sar_ctrl_async_phys_0.sg13g2_o21ai_1_1.B1 a_30650_39921# VDD.t311 sg13_lv_pmos ad=0.1563p pd=1.22u as=0.147p ps=1.54u w=0.42u l=0.13u
X1459 a_35327_45750# a_35245_45936# sar_ctrl_async_phys_0.sg13g2_a21oi_1_5.B1 VSS.t280 sg13_lv_nmos ad=0.1406p pd=1.12u as=0.333p ps=2.38u w=0.74u l=0.13u
X1460 oa_sar8_acore18_opt_0.sw_bitcell_opt_b7_1.VSS sar_ctrl_async_phys_0.dac_code_n[1].t1 oa_sar8_acore18_opt_0.sw_bitcell_opt_b1_1.bot.t0 VSS.t1232 sg13_lv_nmos ad=0.595p pd=4.1u as=0.3315p ps=2.09u w=1.7u l=0.13u
X1461 VDD.t182 VSS.t1038 VDD.t182 VDD.t39 sg13_lv_pmos ad=0.34p pd=2.68u as=0 ps=0 w=1u l=1u
X1462 sar_ctrl_async_phys_0.sg13g2_inv_1_0.Y sar_ctrl_async_phys_0.sg13g2_inv_1_0.A VSS.t9 VSS.t1143 sg13_lv_nmos ad=0.2516p pd=2.16u as=0.2516p ps=2.16u w=0.74u l=0.13u
X1463 a_33914_44457# a_34357_44213# a_34297_44625# VDD.t69 sg13_lv_pmos ad=79.8f pd=0.8u as=63f ps=0.72u w=0.42u l=0.13u
X1464 oa_sar8_acore18_opt_0.sw_tg_opt_0.bot.t3 oa_sar8_acore18_opt_0.sw_bitcell_opt_b7_0.bot.t94 cap_cmim l=2.14u w=2.14u
X1465 oa_sar8_acore18_opt_0.bstrap_opt_w2_c1200_1.out oa_sar8_acore18_opt_0.bstrap_opt_w2_c1200_1.gb oa_sar8_acore18_opt_0.sw_bitcell_opt_b0_1.bot.t0 VSS.t1090 sg13_lv_nmos ad=0.35p pd=2.7u as=0.195p ps=1.39u w=1u l=0.13u
X1466 a_31802_37404# a_32245_37447# a_31542_37874# VSS.t1167 sg13_lv_nmos ad=79.8f pd=0.8u as=0.1296p ps=1.52u w=0.42u l=0.13u
X1467 a_20412_n9612# oa_sar8_acore18_opt_0.sw_bitcell_opt_term_0.trkb.t9 VSS.t436 VSS.t435 sg13_lv_nmos ad=0.19p pd=1.38u as=0.345p ps=2.69u w=1u l=0.15u
X1468 a_30848_32358# a_30591_32215# a_31010_32138# VSS.t641 sg13_lv_nmos ad=0.1428p pd=1.52u as=37.8f ps=0.6u w=0.42u l=0.13u
X1469 a_32715_43020# sar_ctrl_async_phys_0.sg13g2_a21oi_1_6.A2 VDD.t366 VDD.t0 sg13_lv_pmos ad=0.3808p pd=2.92u as=0.2128p ps=1.5u w=1.12u l=0.13u
X1470 a_27304_38928# sar_ctrl_async_phys_0.sg13g2_and2_1_2.X VDD.t354 VDD.t162 sg13_lv_pmos ad=0.2128p pd=1.5u as=0.3808p ps=2.92u w=1.12u l=0.15u
X1471 a_26570_42690# sar_ctrl_async_phys_0.sg13g2_inv_1_9.Y VSS.t72 VSS.t73 sg13_lv_nmos ad=0.1428p pd=1.52u as=79.8f ps=0.8u w=0.42u l=0.13u
X1472 sar_ctrl_async_phys_0.sg13g2_nor2_1_7.B sar_ctrl_async_phys_0.sg13g2_nand2_1_0.Y VSS.t144 VSS.t275 sg13_lv_nmos ad=0.1406p pd=1.12u as=0.2516p ps=2.16u w=0.74u l=0.13u
X1473 VSS.t1008 VDD.t227 VSS.t1008 VSS.t17 sg13_lv_nmos ad=0.1428p pd=1.52u as=0 ps=0 w=0.42u l=1u
X1474 sar_ctrl_async_phys_0.sg13g2_a21oi_1_0.A1.t0 sar_ctrl_async_phys_0.sg13g2_nor2_1_5.B VDD.t14 VDD.t13 sg13_lv_pmos ad=0.3808p pd=2.92u as=0.3808p ps=2.92u w=1.12u l=0.13u
X1475 oa_sar8_acore18_opt_0.sw_tg_opt_0.bot.t3 oa_sar8_acore18_opt_0.sw_bitcell_opt_b6_0.bot.t15 cap_cmim l=2.14u w=2.14u
X1476 sar_ctrl_async_phys_0.sg13g2_nand2_1_1.Y sar_ctrl_async_phys_0.sg13g2_buf_1_6.A VDD.t384 VDD.t311 sg13_lv_pmos ad=0.2128p pd=1.5u as=0.3808p ps=2.92u w=1.12u l=0.13u
X1477 a_32245_37447# sar_ctrl_async_phys_0.sg13g2_dfrbpq_1_0.CLK.t14 VDD.t13 VDD.t13 sg13_lv_pmos ad=0.4088p pd=2.97u as=2.2076p ps=14.4u w=1.12u l=0.13u
X1478 VSS.t677 VDD.t120 VSS.t677 VSS.t679 sg13_lv_nmos ad=0.1428p pd=1.52u as=0 ps=0 w=0.42u l=1u
X1479 oa_sar8_acore18_opt_0.sw_tg_opt_0.bot.t4 oa_sar8_acore18_opt_0.sw_bitcell_opt_b7_0.bot.t2 cap_cmim l=2.14u w=2.14u
X1480 VSS.t5 VDD.t198 VSS.t5 VSS.t952 sg13_lv_nmos ad=79.8f pd=0.8u as=0 ps=0 w=0.42u l=1u
X1481 VDD.t450 sar_ctrl_async_phys_0.sg13g2_nand2_1_3.A sar_ctrl_async_phys_0.sg13g2_nand2b_1_3.Y VDD.t5 sg13_lv_pmos ad=0.2198p pd=1.53u as=0.2128p ps=1.5u w=1.12u l=0.13u
X1482 oa_sar8_acore18_opt_0.sw_bitcell_opt_term_0.bot.t1 VDD.t874 VDD.t878 VDD.t875 sg13_lv_pmos ad=0.585p pd=3.39u as=1.05p ps=6.7u w=3u l=0.13u
X1483 VSS.t1003 VDD.t189 VSS.t1003 VSS.t17 sg13_lv_nmos ad=0.1428p pd=1.52u as=0 ps=0 w=0.42u l=1u
X1484 VDD.t176 VSS.t801 VDD.t176 VDD.t5 sg13_lv_pmos ad=0.34p pd=2.68u as=0 ps=0 w=1u l=1u
X1485 oa_sar8_acore18_opt_0.sw_tg_opt_0.bot.t3 oa_sar8_acore18_opt_0.sw_bitcell_opt_b7_0.bot.t136 cap_cmim l=2.14u w=2.14u
X1486 VDD.t163 sar_ctrl_async_phys_0.sg13g2_nor2_1_6.A a_29084_38484# VDD.t162 sg13_lv_pmos ad=0.4032p pd=2.96u as=0.1176p ps=1.33u w=1.12u l=0.13u
X1487 VSS.t626 VDD.t163 VSS.t471 VSS.t872 sg13_lv_nmos ad=79.8f pd=0.8u as=0 ps=0 w=0.42u l=1u
X1488 VSS.t88 sar_ctrl_async_phys_0.sg13g2_nor2b_1_0.A a_34904_38224# VSS.t87 sg13_lv_nmos ad=0.14875p pd=1.16u as=0.187p ps=1.78u w=0.55u l=0.13u
X1489 oa_sar8_acore18_opt_0.sw_bitcell_opt_term_0.VSS sar_ctrl_async_phys_0.dac_code[5] oa_sar8_acore18_opt_0.sw_bitcell_opt_b5_0.bot.t0 VSS.t1197 sg13_lv_nmos ad=0.945p pd=6.1u as=0.5265p ps=3.09u w=2.7u l=0.13u
X1490 a_33087_37797# a_32245_37447# a_31828_37440# VDD.t13 sg13_lv_pmos ad=0.2048p pd=1.63u as=0.34p ps=2.68u w=1u l=0.13u
X1491 VDD.t198 VSS.t11 VDD.t198 VDD.t54 sg13_lv_pmos ad=0.34p pd=2.68u as=0 ps=0 w=1u l=1u
X1492 a_29786_33873# a_30229_33629# a_30169_34041# VDD.t54 sg13_lv_pmos ad=79.8f pd=0.8u as=63f ps=0.72u w=0.42u l=0.13u
X1493 a_35330_41210# sar_ctrl_async_phys_0.sg13g2_o21ai_1_1.B1 VSS.t27 VSS.t26 sg13_lv_nmos ad=37.8f pd=0.6u as=79.8f ps=0.8u w=0.42u l=0.13u
X1494 VDD.t10 VSS.t58 VDD.t8 VDD.t5 sg13_lv_pmos ad=0.34p pd=2.68u as=0 ps=0 w=1u l=1u
X1495 VSS.t346 VDD.t209 VSS.t346 VSS.t823 sg13_lv_nmos ad=0.1428p pd=1.52u as=0 ps=0 w=0.42u l=1u
X1496 sar_ctrl_async_phys_0.sg13g2_buf_1_20.A a_31933_43832# VSS.t103 VSS.t1293 sg13_lv_nmos ad=0.2516p pd=2.16u as=0.1331p ps=1.12u w=0.74u l=0.13u
X1497 sar_ctrl_async_phys_0.sg13g2_dlygate4sd3_1_4.A a_25990_40484# VDD.t339 VDD.t311 sg13_lv_pmos ad=0.4256p pd=3u as=0.2254p ps=1.53u w=1.12u l=0.13u
X1498 a_35211_37436# sar_ctrl_async_phys_0.sg13g2_a21oi_1_0.A2 VDD.t382 VDD.t13 sg13_lv_pmos ad=0.3808p pd=2.92u as=0.2128p ps=1.5u w=1.12u l=0.13u
X1499 sar_ctrl_async_phys_0.sg13g2_a21oi_1_4.B1 a_34093_42912# VDD.t389 VDD.t0 sg13_lv_pmos ad=0.2128p pd=1.5u as=0.3808p ps=2.92u w=1.12u l=0.13u
X1500 VDD.t8 a_26550_41214# a_26662_41278# VDD.t5 sg13_lv_pmos ad=0.2254p pd=1.53u as=0.34p ps=2.68u w=1u l=0.5u
X1501 oa_sar8_acore18_opt_0.sw_tg_opt_1.bot.t3 oa_sar8_acore18_opt_0.sw_bitcell_opt_b7_1.bot.t141 cap_cmim l=2.14u w=2.14u
X1502 VDD.t198 VSS.t5 VDD.t198 VDD.t54 sg13_lv_pmos ad=0.19p pd=1.38u as=0 ps=0 w=1u l=1u
X1503 oa_sar8_acore18_opt_0.sw_tg_opt_1.bot.t3 oa_sar8_acore18_opt_0.sw_bitcell_opt_b5_1.bot.t29 cap_cmim l=2.14u w=2.14u
X1504 VDD.t37 a_34453_35935# a_34555_35935# VDD.t37 sg13_lv_pmos ad=1.79957p pd=11.62u as=0.3864p ps=2.93u w=1.12u l=0.13u
X1505 VDD.t79 VSS.t733 VDD.t79 VDD.t69 sg13_lv_pmos ad=0.19p pd=1.38u as=0 ps=0 w=1u l=1u
X1506 VSS.t25 a_32991_45357# a_33658_44996# VSS.t1278 sg13_lv_nmos ad=0.1406p pd=1.12u as=0.2516p ps=2.16u w=0.74u l=0.13u
X1507 VDD.t161 VSS.t801 VDD.t99 VDD.t0 sg13_lv_pmos ad=0.34p pd=2.68u as=0 ps=0 w=1u l=1u
X1508 VSS.t129 VDD.t22 VSS.t129 VSS.t692 sg13_lv_nmos ad=0.1428p pd=1.52u as=0 ps=0 w=0.42u l=1u
X1509 VDD.t16 VSS.t129 VDD.t16 VDD.t15 sg13_lv_pmos ad=0.19p pd=1.38u as=0 ps=0 w=1u l=1u
X1510 VSS.t9 a_33936_31675# sar_ctrl_async_phys_0.sg13g2_buf_1_7.A VSS.t14 sg13_lv_nmos ad=0.1406p pd=1.12u as=0.2516p ps=2.16u w=0.74u l=0.13u
X1511 VDD.t197 VSS.t5 VDD.t197 VDD.t37 sg13_lv_pmos ad=0.34p pd=2.68u as=0 ps=0 w=1u l=1u
X1512 oa_sar8_acore18_opt_0.sw_tg_opt_0.bot.t3 oa_sar8_acore18_opt_0.sw_bitcell_opt_b6_0.bot.t30 cap_cmim l=2.14u w=2.14u
X1513 oa_sar8_acore18_opt_0.sw_tg_opt_0.bot.t3 oa_sar8_acore18_opt_0.sw_bitcell_opt_b7_0.bot.t99 cap_cmim l=2.14u w=2.14u
X1514 VSS.t369 VDD.t247 VSS.t852 VSS.t196 sg13_lv_nmos ad=0.1428p pd=1.52u as=0 ps=0 w=0.42u l=1u
X1515 VDD.t339 sar_ctrl_async_phys_0.sg13g2_dlygate4sd3_1_5.A a_25608_40501# VDD.t311 sg13_lv_pmos ad=0.1523p pd=1.38u as=0.1428p ps=1.52u w=0.42u l=0.13u
X1516 a_34357_44213# sar_ctrl_async_phys_0.sg13g2_dfrbpq_1_0.CLK VSS.t78 VSS.t1207 sg13_lv_nmos ad=0.2516p pd=2.16u as=3.64875p ps=22.56u w=0.74u l=0.13u
X1517 VDD.t139 sar_ctrl_async_phys_0.sg13g2_dfrbpq_1_9.RESET_B a_29594_43452# VDD.t0 sg13_lv_pmos ad=0.1563p pd=1.22u as=0.147p ps=1.54u w=0.42u l=0.13u
X1518 sar_ctrl_async_phys_0.sg13g2_nor2_1_12.B sar_ctrl_async_phys_0.sg13g2_nand2b_1_0.A_N a_28410_39996# VDD.t311 sg13_lv_pmos ad=0.3808p pd=2.92u as=0.1176p ps=1.33u w=1.12u l=0.13u
X1519 VSS.t123 sar_ctrl_async_phys_0.sg13g2_nand2b_1_3.Y a_34328_41972# VSS.t494 sg13_lv_nmos ad=0.14875p pd=1.16u as=0.187p ps=1.78u w=0.55u l=0.13u
X1520 VDD.t163 sar_ctrl_async_phys_0.sg13g2_o21ai_1_1.B1 a_29210_38916# VDD.t162 sg13_lv_pmos ad=0.1563p pd=1.22u as=0.147p ps=1.54u w=0.42u l=0.13u
X1521 w_16692_n9960# a_20412_n9612# cap_cmim l=9.94u w=39.8u
X1522 VSS.t926 VDD.t38 VSS.t926 VSS.t114 sg13_lv_nmos ad=0.1428p pd=1.52u as=0 ps=0 w=0.42u l=1u
X1523 oa_sar8_acore18_opt_0.sw_tg_opt_1.bot.t3 oa_sar8_acore18_opt_0.sw_bitcell_opt_b6_1.bot.t21 cap_cmim l=2.14u w=2.14u
X1524 oa_sar8_acore18_opt_0.sw_tg_opt_1.bot.t3 oa_sar8_acore18_opt_0.sw_bitcell_opt_b6_1.bot.t61 cap_cmim l=2.14u w=2.14u
X1525 VDD.t323 a_34208_45966# a_34153_46061# VDD.t29 sg13_lv_pmos ad=2.2076p pd=14.4u as=93.45f ps=0.865u w=0.42u l=0.13u
X1526 VDD.t54 a_31328_33870# a_31273_33965# VDD.t54 sg13_lv_pmos ad=2.2076p pd=14.4u as=93.45f ps=0.865u w=0.42u l=0.13u
X1527 oa_sar8_acore18_opt_0.sw_tg_opt_1.bot.t3 oa_sar8_acore18_opt_0.sw_bitcell_opt_b7_1.bot.t104 cap_cmim l=2.14u w=2.14u
X1528 a_34319_32120# sar_ctrl_async_phys_0.sg13g2_a22oi_1_0.B1 VSS.t9 VSS.t8 sg13_lv_nmos ad=0.13875p pd=1.115u as=0.2553p ps=2.17u w=0.74u l=0.13u
X1529 VSS.t724 VDD.t86 VSS.t724 VSS.t725 sg13_lv_nmos ad=0.1428p pd=1.52u as=0 ps=0 w=0.42u l=1u
X1530 sar_ctrl_async_phys_0.dac_code_n[7] a_34328_41972# VSS.t123 VSS.t467 sg13_lv_nmos ad=0.2886p pd=2.26u as=0.14875p ps=1.16u w=0.74u l=0.13u
X1531 VDD.t191 VSS.t144 VDD.t191 VDD.t13 sg13_lv_pmos ad=0.19p pd=1.38u as=0 ps=0 w=1u l=1u
X1532 oa_sar8_acore18_opt_0.sw_tg_opt_0.bot.t3 oa_sar8_acore18_opt_0.sw_bitcell_opt_b7_0.bot.t110 cap_cmim l=2.14u w=2.14u
X1533 oa_sar8_acore18_opt_0.sw_tg_opt_1.bot.t3 oa_sar8_acore18_opt_0.sw_bitcell_opt_b7_1.bot.t40 cap_cmim l=2.14u w=2.14u
X1534 VDD.t323 a_31381_46519# a_31483_46519# VDD.t29 sg13_lv_pmos ad=2.2076p pd=14.4u as=0.3864p ps=2.93u w=1.12u l=0.13u
X1535 oa_sar8_acore18_opt_0.sw_tg_opt_1.bot.t3 oa_sar8_acore18_opt_0.sw_bitcell_opt_b4_1.bot.t13 cap_cmim l=2.14u w=2.14u
X1536 VSS.t160 a_27530_39666# a_27249_39888# VSS.t89 sg13_lv_nmos ad=79.8f pd=0.8u as=0.1428p ps=1.52u w=0.42u l=0.5u
X1537 VSS.t1039 VDD.t182 VSS.t1038 VSS.t1037 sg13_lv_nmos ad=0.1428p pd=1.52u as=0 ps=0 w=0.42u l=1u
X1538 VSS.t113 a_35648_34654# a_35297_34773# VSS.t199 sg13_lv_nmos ad=79.8f pd=0.8u as=0.1428p ps=1.52u w=0.42u l=0.13u
X1539 VDD.t447 a_35295_36285# a_35962_35924# VDD.t37 sg13_lv_pmos ad=0.2128p pd=1.5u as=0.3864p ps=2.93u w=1.12u l=0.13u
X1540 a_30772_31392# a_31291_31399# a_32031_31749# VSS.t236 sg13_lv_nmos ad=0.3473p pd=2.71u as=0.12665p ps=1.145u w=0.74u l=0.13u
X1541 sar_ctrl_async_phys_0.sg13g2_nor2_1_2.Y sar_ctrl_async_phys_0.sg13g2_a21oi_1_1.Y a_34266_38484# VDD.t162 sg13_lv_pmos ad=0.3808p pd=2.92u as=0.1176p ps=1.33u w=1.12u l=0.13u
X1542 VDD.t36 VSS.t137 VDD.t36 VDD.t5 sg13_lv_pmos ad=0.34p pd=2.68u as=0 ps=0 w=1u l=1u
X1543 VDD.t30 VSS.t736 VDD.t81 VDD.t29 sg13_lv_pmos ad=0.19p pd=1.38u as=0 ps=0 w=1u l=1u
X1544 VDD.t37 a_35552_36166# a_35497_36047# VDD.t37 sg13_lv_pmos ad=1.79957p pd=11.62u as=93.45f ps=0.865u w=0.42u l=0.13u
X1545 a_33973_39677# sar_ctrl_async_phys_0.sg13g2_dfrbpq_1_0.CLK.t17 VSS.t109 VSS.t108 sg13_lv_nmos ad=0.2516p pd=2.16u as=4.48835p ps=28.62u w=0.74u l=0.13u
X1546 a_35103_43845# a_34261_43495# a_33844_43488# VDD.t0 sg13_lv_pmos ad=0.2048p pd=1.63u as=0.34p ps=2.68u w=1u l=0.13u
X1547 VSS.t1054 VDD.t44 VSS.t1053 VSS.t1052 sg13_lv_nmos ad=0.1428p pd=1.52u as=0 ps=0 w=0.42u l=1u
X1548 VDD.t238 VSS.t920 VDD.t238 VDD.t54 sg13_lv_pmos ad=0.34p pd=2.68u as=0 ps=0 w=1u l=1u
X1549 a_26550_41214# a_26280_41214# VSS.t58 VSS.t285 sg13_lv_nmos ad=0.1428p pd=1.52u as=79.8f ps=0.8u w=0.42u l=0.5u
X1550 VDD.t573 sar_ctrl_async_phys_0.sg13g2_buf_1_2.X a_34106_30849# VDD.t39 sg13_lv_pmos ad=0.1563p pd=1.22u as=0.147p ps=1.54u w=0.42u l=0.13u
X1551 oa_sar8_acore18_opt_0.sw_bitcell_opt_b3_0.bot.t0 sar_ctrl_async_phys_0.dac_code[3] oa_sar8_acore18_opt_0.sw_bitcell_opt_term_0.VSS VSS.t427 sg13_lv_nmos ad=0.4095p pd=2.49u as=0.735p ps=4.9u w=2.1u l=0.13u
X1552 a_27894_35924# a_27624_35965# VSS.t277 VSS.t1155 sg13_lv_nmos ad=0.1428p pd=1.52u as=79.8f ps=0.8u w=0.42u l=0.5u
X1553 oa_sar8_acore18_opt_0.sw_tg_opt_1.bot.t3 oa_sar8_acore18_opt_0.sw_bitcell_opt_b7_1.bot.t43 cap_cmim l=2.14u w=2.14u
X1554 VDD.t186 a_28662_41214# a_28774_41278# VDD.t5 sg13_lv_pmos ad=0.2254p pd=1.53u as=0.34p ps=2.68u w=1u l=0.5u
X1555 oa_sar8_acore18_opt_0.sw_tg_opt_0.bot.t3 oa_sar8_acore18_opt_0.sw_bitcell_opt_b6_0.bot.t65 cap_cmim l=2.14u w=2.14u
X1556 VSS.t11 a_31071_33727# a_31738_33948# VSS.t126 sg13_lv_nmos ad=0.1406p pd=1.12u as=0.2516p ps=2.16u w=0.74u l=0.13u
X1557 a_34055_31352# a_34615_31475# a_34636_31749# VSS.t14 sg13_lv_nmos ad=0.12665p pd=1.145u as=0.3473p ps=2.71u w=0.74u l=0.13u
X1558 a_34357_44213# sar_ctrl_async_phys_0.sg13g2_dfrbpq_1_0.CLK VDD.t346 VDD.t69 sg13_lv_pmos ad=0.4088p pd=2.97u as=1.79957p ps=11.62u w=1.12u l=0.13u
X1559 VDD.t70 VSS.t766 VDD.t70 VDD.t69 sg13_lv_pmos ad=0.34p pd=2.68u as=0 ps=0 w=1u l=1u
X1560 a_32090_40428# a_32533_40471# a_31830_40898# VSS.t329 sg13_lv_nmos ad=79.8f pd=0.8u as=0.1296p ps=1.52u w=0.42u l=0.13u
X1561 VSS.t801 VDD.t99 VSS.t801 VSS.t803 sg13_lv_nmos ad=0.1428p pd=1.52u as=0 ps=0 w=0.42u l=1u
X1562 VDD.t182 VSS.t1043 VDD.t61 VDD.t39 sg13_lv_pmos ad=0.34p pd=2.68u as=0 ps=0 w=1u l=1u
X1563 sar_ctrl_async_phys_0.dac_code_n[6] a_35672_46508# VSS.t75 VSS.t91 sg13_lv_nmos ad=0.2886p pd=2.26u as=0.14875p ps=1.16u w=0.74u l=0.13u
X1564 a_32692_46064# a_32666_45969# VDD.t169 VDD.t29 sg13_lv_pmos ad=0.34p pd=2.68u as=0.36237p ps=2.605u w=1u l=0.13u
X1565 VDD.t500 sar_ctrl_async_phys_0.sg13g2_buf_1_2.A.t3 a_33818_36897# VDD.t13 sg13_lv_pmos ad=0.1563p pd=1.22u as=0.147p ps=1.54u w=0.42u l=0.13u
X1566 VDD.t16 VSS.t129 VDD.t16 VDD.t15 sg13_lv_pmos ad=0.34p pd=2.68u as=0 ps=0 w=1u l=1u
X1567 a_34228_44247# a_34459_44356# a_33914_44457# VSS.t479 sg13_lv_nmos ad=0.2373p pd=1.97u as=79.8f ps=0.8u w=0.42u l=0.13u
X1568 a_33556_40016# a_33530_39921# VSS.t40 VSS.t162 sg13_lv_nmos ad=0.2516p pd=2.16u as=0.1626p ps=1.415u w=0.74u l=0.13u
X1569 VSS.t346 VDD.t36 VSS.t346 VSS.t822 sg13_lv_nmos ad=79.8f pd=0.8u as=0 ps=0 w=0.42u l=1u
X1570 oa_sar8_acore18_opt_0.sw_tg_opt_0.bot.t3 oa_sar8_acore18_opt_0.sw_bitcell_opt_b6_0.bot.t55 cap_cmim l=2.14u w=2.14u
X1571 a_34847_45366# a_34765_45266# sar_ctrl_async_phys_0.sg13g2_a21oi_1_6.B1 VSS.t198 sg13_lv_nmos ad=0.1406p pd=1.12u as=0.333p ps=2.38u w=0.74u l=0.13u
X1572 a_29653_38959# sar_ctrl_async_phys_0.sg13g2_dfrbpq_1_0.CLK.t16 VDD.t315 VDD.t162 sg13_lv_pmos ad=0.4088p pd=2.97u as=3.62845p ps=23.965u w=1.12u l=0.13u
X1573 oa_sar8_acore18_opt_0.sw_tg_opt_0.bot.t3 oa_sar8_acore18_opt_0.sw_bitcell_opt_b6_0.bot.t22 cap_cmim l=2.14u w=2.14u
X1574 VDD.t56 VSS.t115 VDD.t56 VDD.t54 sg13_lv_pmos ad=0.34p pd=2.68u as=0 ps=0 w=1u l=1u
X1575 oa_sar8_acore18_opt_0.sw_tg_opt_0.bot.t1 sar_ctrl_async_phys_0.sample vcm VSS.t245 sg13_lv_nmos ad=0.195p pd=1.39u as=0.35p ps=2.7u w=1u l=0.13u
X1576 oa_sar8_acore18_opt_0.sw_bitcell_opt_term_0.bot.t0 oa_sar8_acore18_opt_0.sw_bitcell_opt_term_0.trkb.t13 oa_sar8_acore18_opt_0.sw_bitcell_opt_term_0.vin VDD.t614 sg13_lv_pmos ad=0.39p pd=2.39u as=0.7p ps=4.7u w=2u l=0.13u
X1577 VSS.t1008 VDD.t230 VSS.t464 VSS.t17 sg13_lv_nmos ad=79.8f pd=0.8u as=0 ps=0 w=0.42u l=1u
X1578 a_35199_44311# a_34357_44213# a_33940_44552# VDD.t69 sg13_lv_pmos ad=0.2048p pd=1.63u as=0.34p ps=2.68u w=1u l=0.13u
X1579 a_33632_40702# sar_ctrl_async_phys_0.sg13g2_o21ai_1_1.B1 VDD.t311 VDD.t311 sg13_lv_pmos ad=79.8f pd=0.8u as=1.55472p ps=9.945u w=0.42u l=0.13u
X1580 VSS.t1068 VDD.t40 VSS.t510 VSS.t1067 sg13_lv_nmos ad=0.1428p pd=1.52u as=0 ps=0 w=0.42u l=1u
X1581 VDD.t209 a_33948_41936# sar_ctrl_async_phys_0.sg13g2_o21ai_1_1.B1 VDD.t5 sg13_lv_pmos ad=0.2114p pd=1.54u as=0.42p ps=2.99u w=1.12u l=0.13u
X1582 VSS.t182 sar_ctrl_async_phys_0.sg13g2_buf_1_2.A.t1 a_30484_36362# VSS.t444 sg13_lv_nmos ad=0.1626p pd=1.415u as=60.89999f ps=0.71u w=0.42u l=0.13u
X1583 VDD.t361 VSS.t144 VDD.t361 VDD.t13 sg13_lv_pmos ad=0.19p pd=1.38u as=0 ps=0 w=1u l=1u
X1584 VDD.t37 a_32991_35239# a_33248_35382# VDD.t37 sg13_lv_pmos ad=1.79957p pd=11.62u as=79.8f ps=0.8u w=0.42u l=0.13u
X1585 sar_ctrl_async_phys_0.dac_code_n[5] a_36056_47296# VDD.t345 VDD.t15 sg13_lv_pmos ad=0.42p pd=2.99u as=0.2114p ps=1.54u w=1.12u l=0.13u
X1586 a_29908_43909# a_29620_43488# a_29846_43909# VSS.t341 sg13_lv_nmos ad=0.1428p pd=1.52u as=37.8f ps=0.6u w=0.42u l=0.13u
X1587 VDD.t342 sar_ctrl_async_phys_0.sg13g2_a21oi_1_1.Y a_34319_32460# VDD.t118 sg13_lv_pmos ad=0.3808p pd=2.92u as=0.2744p ps=1.61u w=1.12u l=0.13u
X1588 oa_sar8_acore18_opt_0.sw_tg_opt_1.bot.t3 oa_sar8_acore18_opt_0.sw_bitcell_opt_b6_1.bot.t41 cap_cmim l=2.14u w=2.14u
X1589 VDD.t346 a_33248_45238# a_33193_45119# VDD.t69 sg13_lv_pmos ad=1.96315p pd=12.675u as=93.45f ps=0.865u w=0.42u l=0.13u
X1590 a_35018_42726# sar_ctrl_async_phys_0.sg13g2_nand2_1_2.A sar_ctrl_async_phys_0.sg13g2_nand2_1_2.Y VSS.t500 sg13_lv_nmos ad=0.1406p pd=1.12u as=0.2516p ps=2.16u w=0.74u l=0.13u
X1591 oa_sar8_acore18_opt_0.sw_tg_opt_0.bot.t3 oa_sar8_acore18_opt_0.sw_bitcell_opt_b1_0.bot.t4 cap_cmim l=2.14u w=2.14u
X1592 oa_sar8_acore18_opt_0.sw_tg_opt_1.bot.t3 oa_sar8_acore18_opt_0.sw_bitcell_opt_b7_1.bot.t115 cap_cmim l=2.14u w=2.14u
X1593 VDD.t117 sar_ctrl_async_phys_0.sg13g2_dfrbpq_1_9.RESET_B a_30774_44234# VDD.t69 sg13_lv_pmos ad=0.36237p pd=2.605u as=79.8f ps=0.8u w=0.42u l=0.13u
X1594 a_34815_39775# a_33973_39677# a_33556_40016# VDD.t311 sg13_lv_pmos ad=0.2048p pd=1.63u as=0.34p ps=2.68u w=1u l=0.13u
X1595 VSS.t154 sar_ctrl_async_phys_0.sg13g2_nand3b_1_0.Y sar_ctrl_async_phys_0.sg13g2_nor2_1_5.B VSS.t197 sg13_lv_nmos ad=0.2516p pd=2.16u as=0.1406p ps=1.12u w=0.74u l=0.13u
X1596 VSS.t75 sar_ctrl_async_phys_0.sg13g2_a21oi_1_4.B1 a_36056_47296# VSS.t61 sg13_lv_nmos ad=0.14875p pd=1.16u as=0.187p ps=1.78u w=0.55u l=0.13u
X1597 VSS.t722 VDD.t68 VSS.t724 VSS.t723 sg13_lv_nmos ad=79.8f pd=0.8u as=0 ps=0 w=0.42u l=1u
X1598 VSS.t464 VDD.t44 VSS.t464 VSS.t17 sg13_lv_nmos ad=0.1428p pd=1.52u as=0 ps=0 w=0.42u l=1u
X1599 VDD.t169 VSS.t485 VDD.t169 VDD.t29 sg13_lv_pmos ad=0.34p pd=2.68u as=0 ps=0 w=1u l=1u
X1600 oa_sar8_acore18_opt_0.sw_bitcell_opt_term_0.vin oa_sar8_acore18_opt_0.sw_bitcell_opt_term_0.gb.t10 oa_sar8_acore18_opt_0.sw_bitcell_opt_b5_0.bot.t0 VSS.t0 sg13_lv_nmos ad=0.35p pd=2.7u as=0.195p ps=1.39u w=1u l=0.13u
X1601 a_33440_32358# a_33183_32215# a_33602_32138# VSS.t8 sg13_lv_nmos ad=0.1428p pd=1.52u as=37.8f ps=0.6u w=0.42u l=0.13u
X1602 VSS.t64 a_35391_33261# a_36058_32900# VSS.t152 sg13_lv_nmos ad=0.1406p pd=1.12u as=0.2516p ps=2.16u w=0.74u l=0.13u
X1603 VSS.t172 VDD.t247 VSS.t172 VSS.t87 sg13_lv_nmos ad=79.8f pd=0.8u as=0 ps=0 w=0.42u l=1u
X1604 a_31636_37874# sar_ctrl_async_phys_0.sg13g2_nor2_1_0.A a_31542_37874# VSS.t1120 sg13_lv_nmos ad=60.89999f pd=0.71u as=0.1428p ps=1.52u w=0.42u l=0.13u
X1605 oa_sar8_acore18_opt_0.sw_tg_opt_1.bot.t2 oa_sar8_acore18_opt_0.sw_bitcell_opt_b7_1.bot.t152 cap_cmim l=2.14u w=2.14u
X1606 sar_ctrl_async_phys_0.dac_code[4] a_36056_41972# VDD.t428 VDD.t5 sg13_lv_pmos ad=0.42p pd=2.99u as=0.2114p ps=1.54u w=1.12u l=0.13u
X1607 oa_sar8_acore18_opt_0.sw_tg_opt_1.bot.t3 oa_sar8_acore18_opt_0.sw_bitcell_opt_b6_1.bot.t41 cap_cmim l=2.14u w=2.14u
X1608 a_35810_30626# sar_ctrl_async_phys_0.sg13g2_buf_1_2.X VSS.t325 VSS.t423 sg13_lv_nmos ad=37.8f pd=0.6u as=79.8f ps=0.8u w=0.42u l=0.13u
X1609 a_28662_41214# a_28392_41214# VSS.t60 VSS.t637 sg13_lv_nmos ad=0.1428p pd=1.52u as=79.8f ps=0.8u w=0.42u l=0.5u
X1610 sar_ctrl_async_phys_0.sg13g2_buf_1_6.A a_35288_38224# VDD.t350 VDD.t162 sg13_lv_pmos ad=0.42p pd=2.99u as=0.2114p ps=1.54u w=1.12u l=0.13u
X1611 VDD.t79 VSS.t730 VDD.t79 VDD.t69 sg13_lv_pmos ad=0.34p pd=2.68u as=0 ps=0 w=1u l=1u
X1612 VDD.t209 sar_ctrl_async_phys_0.sg13g2_o21ai_1_1.B1 a_33366_41210# VDD.t5 sg13_lv_pmos ad=0.36237p pd=2.605u as=79.8f ps=0.8u w=0.42u l=0.13u
X1613 sar_ctrl_async_phys_0.sg13g2_buf_1_8.A a_36058_32900# VDD.t342 VDD.t118 sg13_lv_pmos ad=0.3808p pd=2.92u as=0.2128p ps=1.5u w=1.12u l=0.13u
X1614 a_30783_40821# a_29941_40471# a_29524_40464# VDD.t311 sg13_lv_pmos ad=0.2048p pd=1.63u as=0.34p ps=2.68u w=1u l=0.13u
X1615 a_33556_40016# a_33530_39921# VDD.t314 VDD.t311 sg13_lv_pmos ad=0.34p pd=2.68u as=0.36237p ps=2.605u w=1u l=0.13u
X1616 oa_sar8_acore18_opt_0.sw_tg_opt_0.bot.t3 oa_sar8_acore18_opt_0.sw_bitcell_opt_b5_0.bot.t30 cap_cmim l=2.14u w=2.14u
X1617 VDD.t247 VSS.t854 VDD.t247 VDD.t162 sg13_lv_pmos ad=0.34p pd=2.68u as=0 ps=0 w=1u l=1u
X1618 VDD.t346 a_35456_44454# a_35401_44549# VDD.t69 sg13_lv_pmos ad=1.96315p pd=12.675u as=93.45f ps=0.865u w=0.42u l=0.13u
X1619 oa_sar8_acore18_opt_0.sw_tg_opt_1.bot.t3 oa_sar8_acore18_opt_0.sw_bitcell_opt_b3_1.bot.t12 cap_cmim l=2.14u w=2.14u
X1620 VSS.t736 VDD.t79 VSS.t736 VSS.t760 sg13_lv_nmos ad=79.8f pd=0.8u as=0 ps=0 w=0.42u l=1u
X1621 a_35463_31435# sar_ctrl_async_phys_0.sg13g2_buf_1_2.X VDD.t547 VDD.t39 sg13_lv_pmos ad=79.8f pd=0.8u as=0.36237p ps=2.605u w=0.42u l=0.13u
X1622 a_35522_36674# sar_ctrl_async_phys_0.sg13g2_buf_1_2.A.t2 VSS.t101 VSS.t100 sg13_lv_nmos ad=37.8f pd=0.6u as=79.8f ps=0.8u w=0.42u l=0.13u
X1623 VDD.t351 sar_ctrl_async_phys_0.sg13g2_nor2_1_3.A a_26544_38389# VDD.t162 sg13_lv_pmos ad=0.2856p pd=2.36u as=0.1596p ps=1.22u w=0.84u l=0.13u
X1624 a_33049_46137# a_32692_46064# VDD.t33 VDD.t29 sg13_lv_pmos ad=63f pd=0.72u as=0.1563p ps=1.22u w=0.42u l=0.13u
X1625 VDD.t605 sar_ctrl_async_phys_0.sg13g2_nand2_1_1.B sar_ctrl_async_phys_0.sg13g2_nand2_1_1.Y VDD.t311 sg13_lv_pmos ad=0.3808p pd=2.92u as=0.2128p ps=1.5u w=1.12u l=0.13u
X1626 a_31033_40089# a_30676_40016# VDD.t334 VDD.t311 sg13_lv_pmos ad=63f pd=0.72u as=0.1563p ps=1.22u w=0.42u l=0.13u
X1627 oa_sar8_acore18_opt_0.sw_tg_opt_1.bot.t3 oa_sar8_acore18_opt_0.sw_bitcell_opt_b6_1.bot.t19 cap_cmim l=2.14u w=2.14u
X1628 sar_ctrl_async_phys_0.cmp_p sar_ctrl_async_phys_0.cmp_fire VDD.t839 VDD.t838 sg13_lv_pmos ad=0.7p pd=4.7u as=0.7p ps=4.7u w=2u l=0.13u
X1629 oa_sar8_acore18_opt_0.bstrap_opt_w2_c1200_1.out oa_sar8_acore18_opt_0.sw_bitcell_opt_term_0.trkb.t28 oa_sar8_acore18_opt_0.sw_bitcell_opt_b1_1.bot.t0 VDD.t661 sg13_lv_pmos ad=0.7p pd=4.7u as=0.39p ps=2.39u w=2u l=0.13u
X1630 sar_ctrl_async_phys_0.cmp_fault a_34136_47296# VSS.t62 VSS.t61 sg13_lv_nmos ad=0.2886p pd=2.26u as=0.14875p ps=1.16u w=0.74u l=0.13u
X1631 oa_sar8_acore18_opt_0.bstrap_opt_w2_c1200_1.out oa_sar8_acore18_opt_0.sw_bitcell_opt_term_0.trkb.t25 oa_sar8_acore18_opt_0.sw_bitcell_opt_b4_1.bot.t0 VDD.t618 sg13_lv_pmos ad=0.7p pd=4.7u as=0.39p ps=2.39u w=2u l=0.13u
X1632 VSS.t887 VDD.t191 VSS.t886 VSS.t885 sg13_lv_nmos ad=0.1428p pd=1.52u as=0 ps=0 w=0.42u l=1u
X1633 VDD.t13 a_33087_37797# a_33344_37678# VDD.t13 sg13_lv_pmos ad=2.48357p pd=16.205u as=79.8f ps=0.8u w=0.42u l=0.13u
X1634 VDD.t70 VSS.t765 VDD.t70 VDD.t69 sg13_lv_pmos ad=0.19p pd=1.38u as=0 ps=0 w=1u l=1u
X1635 VSS.t718 VDD.t70 VSS.t717 VSS.t716 sg13_lv_nmos ad=0.1428p pd=1.52u as=0 ps=0 w=0.42u l=1u
X1636 VSS.t801 VDD.t144 VSS.t801 VSS.t802 sg13_lv_nmos ad=79.8f pd=0.8u as=0 ps=0 w=0.42u l=1u
X1637 sar_ctrl_async_phys_0.sg13g2_nor2_1_7.Y sar_ctrl_async_phys_0.sg13g2_nor2_1_7.B VSS.t154 VSS.t524 sg13_lv_nmos ad=0.1406p pd=1.12u as=0.2516p ps=2.16u w=0.74u l=0.13u
X1638 VDD.t16 VSS.t129 VDD.t16 VDD.t15 sg13_lv_pmos ad=0.19p pd=1.38u as=0 ps=0 w=1u l=1u
X1639 VSS.t78 a_30037_43495# a_30139_43495# VSS.t375 sg13_lv_nmos ad=4.3785p pd=27.07u as=0.2516p ps=2.16u w=0.74u l=0.13u
X1640 a_33844_43488# a_33818_43452# VDD.t366 VDD.t0 sg13_lv_pmos ad=0.34p pd=2.68u as=0.36237p ps=2.605u w=1u l=0.13u
X1641 VDD.t205 VSS.t7 VDD.t205 VDD.t118 sg13_lv_pmos ad=0.19p pd=1.38u as=0 ps=0 w=1u l=1u
X1642 oa_sar8_acore18_opt_0.sw_bitcell_opt_term_0.vin oa_sar8_acore18_opt_0.sw_bitcell_opt_term_0.gb.t9 oa_sar8_acore18_opt_0.sw_bitcell_opt_b4_0.bot.t0 VSS.t540 sg13_lv_nmos ad=0.35p pd=2.7u as=0.195p ps=1.39u w=1u l=0.13u
X1643 oa_sar8_acore18_opt_0.sw_bitcell_opt_b2_1.bot.t0 sar_ctrl_async_phys_0.dac_code_n[2] oa_sar8_acore18_opt_0.sw_bitcell_opt_b7_1.VSS VSS.t397 sg13_lv_nmos ad=0.3705p pd=2.29u as=0.665p ps=4.5u w=1.9u l=0.13u
X1644 a_29526_33650# a_30331_33772# a_29786_33873# VDD.t54 sg13_lv_pmos ad=0.1428p pd=1.52u as=79.8f ps=0.8u w=0.42u l=0.13u
X1645 a_31732_35480# a_32251_35284# a_32991_35239# VSS.t249 sg13_lv_nmos ad=0.3473p pd=2.71u as=0.12665p ps=1.145u w=0.74u l=0.13u
X1646 VDD.t36 VSS.t848 VDD.t209 VDD.t5 sg13_lv_pmos ad=0.34p pd=2.68u as=0 ps=0 w=1u l=1u
X1647 oa_sar8_acore18_opt_0.sw_tg_opt_1.bot.t3 oa_sar8_acore18_opt_0.sw_bitcell_opt_b7_1.bot.t78 cap_cmim l=2.14u w=2.14u
X1648 a_34228_44247# a_33940_44552# a_34166_44247# VSS.t1237 sg13_lv_nmos ad=0.1428p pd=1.52u as=37.8f ps=0.6u w=0.42u l=0.13u
X1649 a_34010_35892# a_34453_35935# a_34393_35971# VDD.t37 sg13_lv_pmos ad=79.8f pd=0.8u as=63f ps=0.72u w=0.42u l=0.13u
X1650 sar_ctrl_async_phys_0.sg13g2_dlygate4sd3_1_4.A a_25990_40484# VSS.t832 VSS.t1226 sg13_lv_nmos ad=0.2516p pd=2.16u as=0.1426p ps=1.16u w=0.74u l=0.13u
X1651 oa_sar8_acore18_opt_0.sw_tg_opt_1.bot.t3 oa_sar8_acore18_opt_0.sw_bitcell_opt_b5_1.bot.t1 cap_cmim l=2.14u w=2.14u
X1652 VDD.t389 sar_ctrl_async_phys_0.sg13g2_buf_1_35.A sar_ctrl_async_phys_0.sg13g2_a21oi_1_4.B1 VDD.t0 sg13_lv_pmos ad=0.2198p pd=1.53u as=0.2128p ps=1.5u w=1.12u l=0.13u
X1653 VSS.t144 VDD.t163 VSS.t144 VSS.t867 sg13_lv_nmos ad=0.1428p pd=1.52u as=0 ps=0 w=0.42u l=1u
X1654 a_30650_39921# a_31093_39677# a_31033_40089# VDD.t311 sg13_lv_pmos ad=79.8f pd=0.8u as=63f ps=0.72u w=0.42u l=0.13u
X1655 a_34319_32460# sar_ctrl_async_phys_0.sg13g2_buf_1_8.A sar_ctrl_async_phys_0.sg13g2_inv_1_2.A VDD.t118 sg13_lv_pmos ad=0.2744p pd=1.61u as=0.2128p ps=1.5u w=1.12u l=0.13u
X1656 VSS.t616 a_35199_44311# a_35866_44532# VSS.t252 sg13_lv_nmos ad=0.1406p pd=1.12u as=0.2516p ps=2.16u w=0.74u l=0.13u
X1657 oa_sar8_acore18_opt_0.bstrap_opt_w2_c1200_1.out oa_sar8_acore18_opt_0.bstrap_opt_w2_c1200_1.gb oa_sar8_acore18_opt_0.sw_bitcell_opt_b7_1.bot.t0 VSS.t1097 sg13_lv_nmos ad=0.35p pd=2.7u as=0.195p ps=1.39u w=1u l=0.13u
X1658 sar_ctrl_async_phys_0.cmp_valid a_34520_47296# VDD.t337 VDD.t15 sg13_lv_pmos ad=0.42p pd=2.99u as=0.2114p ps=1.54u w=1.12u l=0.13u
X1659 VSS.t841 VDD.t36 VSS.t843 VSS.t842 sg13_lv_nmos ad=79.8f pd=0.8u as=0 ps=0 w=0.42u l=1u
X1660 VDD.t39 a_32031_31749# a_32288_31630# VDD.t39 sg13_lv_pmos ad=1.96315p pd=12.675u as=79.8f ps=0.8u w=0.42u l=0.13u
X1661 VDD.t238 VSS.t920 VDD.t238 VDD.t54 sg13_lv_pmos ad=0.34p pd=2.68u as=0 ps=0 w=1u l=1u
X1662 VSS.t166 a_34815_39775# a_35482_39996# VSS.t640 sg13_lv_nmos ad=0.1406p pd=1.12u as=0.2516p ps=2.16u w=0.74u l=0.13u
X1663 VSS.t1059 VDD.t44 VSS.t1058 VSS.t1057 sg13_lv_nmos ad=0.1428p pd=1.52u as=0 ps=0 w=0.42u l=1u
X1664 oa_sar8_acore18_opt_0.sw_bitcell_opt_b6_0.bot.t1 oa_sar8_acore18_opt_0.sw_bitcell_opt_term_0.gb.t11 oa_sar8_acore18_opt_0.sw_bitcell_opt_term_0.vin VSS.t541 sg13_lv_nmos ad=0.195p pd=1.39u as=0.35p ps=2.7u w=1u l=0.13u
X1665 VDD.t119 VSS.t956 VDD.t119 VDD.t118 sg13_lv_pmos ad=0.34p pd=2.68u as=0 ps=0 w=1u l=1u
X1666 oa_sar8_acore18_opt_0.sw_tg_opt_0.bot.t2 oa_sar8_acore18_opt_0.sw_bitcell_opt_b7_0.bot.t162 cap_cmim l=2.14u w=2.14u
X1667 a_35714_36362# sar_ctrl_async_phys_0.sg13g2_buf_1_2.A VSS.t101 VSS.t164 sg13_lv_nmos ad=37.8f pd=0.6u as=79.8f ps=0.8u w=0.42u l=0.13u
X1668 oa_sar8_acore18_opt_0.sw_tg_opt_0.bot.t3 oa_sar8_acore18_opt_0.sw_bitcell_opt_b7_0.bot.t141 cap_cmim l=2.14u w=2.14u
X1669 a_35463_31435# a_34767_31359# a_35557_31435# VSS.t1274 sg13_lv_nmos ad=0.1296p pd=1.52u as=79.8f ps=0.8u w=0.42u l=0.13u
X1670 sar_ctrl_async_phys_0.bit_active[2] a_34808_35200# VSS.t113 VSS.t1101 sg13_lv_nmos ad=0.2886p pd=2.26u as=0.14875p ps=1.16u w=0.74u l=0.13u
X1671 oa_sar8_acore18_opt_0.sw_tg_opt_0.bot.t3 oa_sar8_acore18_opt_0.sw_bitcell_opt_b5_0.bot.t30 cap_cmim l=2.14u w=2.14u
X1672 oa_sar8_acore18_opt_0.sw_tg_opt_1.bot.t1 sar_ctrl_async_phys_0.sample vcm VSS.t244 sg13_lv_nmos ad=0.195p pd=1.39u as=0.35p ps=2.7u w=1u l=0.13u
X1673 VSS.t144 VDD.t351 VSS.t144 VSS.t862 sg13_lv_nmos ad=79.8f pd=0.8u as=0 ps=0 w=0.42u l=1u
X1674 result[5] a_34136_33688# VSS.t11 VSS.t233 sg13_lv_nmos ad=0.2886p pd=2.26u as=0.14875p ps=1.16u w=0.74u l=0.13u
X1675 a_34453_35935# sar_ctrl_async_phys_0.sg13g2_dfrbpq_1_0.CLK.t10 VSS.t425 VSS.t192 sg13_lv_nmos ad=0.2516p pd=2.16u as=4.1082p ps=26.51u w=0.74u l=0.13u
X1676 VSS.t62 sar_ctrl_async_phys_0.sg13g2_nor4_1_0.C a_34520_47296# VSS.t61 sg13_lv_nmos ad=0.14875p pd=1.16u as=0.187p ps=1.78u w=0.55u l=0.13u
X1677 VSS.t72 VDD.t6 VSS.t72 VSS.t813 sg13_lv_nmos ad=79.8f pd=0.8u as=0 ps=0 w=0.42u l=1u
X1678 a_34815_39775# a_33973_39677# a_34721_39775# VSS.t1131 sg13_lv_nmos ad=0.12665p pd=1.145u as=0.1428p ps=1.52u w=0.42u l=0.13u
X1679 VDD.t163 VSS.t154 VDD.t163 VDD.t162 sg13_lv_pmos ad=0.19p pd=1.38u as=0 ps=0 w=1u l=1u
X1680 VDD.t40 sar_ctrl_async_phys_0.sg13g2_buf_1_2.X a_30746_31356# VDD.t39 sg13_lv_pmos ad=0.1563p pd=1.22u as=0.147p ps=1.54u w=0.42u l=0.13u
X1681 VDD.t55 VSS.t931 VDD.t212 VDD.t54 sg13_lv_pmos ad=0.34p pd=2.68u as=0 ps=0 w=1u l=1u
X1682 a_31732_35480# a_31706_35385# VDD.t185 VDD.t37 sg13_lv_pmos ad=0.34p pd=2.68u as=0.36237p ps=2.605u w=1u l=0.13u
X1683 a_34554_40460# sar_ctrl_async_phys_0.sg13g2_nor2b_1_0.A sar_ctrl_async_phys_0.sg13g2_nor2b_1_3.Y VDD.t311 sg13_lv_pmos ad=0.1176p pd=1.33u as=0.3808p ps=2.92u w=1.12u l=0.13u
X1684 sar_ctrl_async_phys_0.sg13g2_a22oi_1_2.A2 sar_ctrl_async_phys_0.sg13g2_nand2b_1_2.Y VSS.t27 VSS.t328 sg13_lv_nmos ad=0.1406p pd=1.12u as=0.2516p ps=2.16u w=0.74u l=0.13u
X1685 VSS.t11 VDD.t198 VSS.t11 VSS.t126 sg13_lv_nmos ad=0.1428p pd=1.52u as=0 ps=0 w=0.42u l=1u
X1686 VSS.t346 VDD.t209 VSS.t346 VSS.t824 sg13_lv_nmos ad=79.8f pd=0.8u as=0 ps=0 w=0.42u l=1u
X1687 VSS.t471 VDD.t14 VSS.t471 VSS.t884 sg13_lv_nmos ad=79.8f pd=0.8u as=0 ps=0 w=0.42u l=1u
X1688 oa_sar8_acore18_opt_0.sw_tg_opt_1.bot.t3 oa_sar8_acore18_opt_0.sw_bitcell_opt_b5_1.bot.t34 cap_cmim l=2.14u w=2.14u
X1689 VDD.t588 sar_ctrl_async_phys_0.dac_code_n[3] oa_sar8_acore18_opt_0.sw_bitcell_opt_b3_1.bot.t1 VDD.t587 sg13_lv_pmos ad=1.47p pd=9.1u as=0.819p ps=4.59u w=4.2u l=0.13u
X1690 a_34132_43909# a_34363_43495# a_33818_43452# VSS.t661 sg13_lv_nmos ad=0.2373p pd=1.97u as=79.8f ps=0.8u w=0.42u l=0.13u
X1691 a_34549_30605# sar_ctrl_async_phys_0.sg13g2_dfrbpq_1_0.CLK.t1 VSS.t529 VSS.t1209 sg13_lv_nmos ad=0.2516p pd=2.16u as=8.77817p ps=57.305u w=0.74u l=0.13u
X1692 VDD.t94 VSS.t727 VDD.t76 VDD.t29 sg13_lv_pmos ad=0.34p pd=2.68u as=0 ps=0 w=1u l=1u
X1693 a_33558_43922# sar_ctrl_async_phys_0.sg13g2_nor2_1_1.Y VDD.t366 VDD.t0 sg13_lv_pmos ad=79.8f pd=0.8u as=0.1428p ps=1.52u w=0.42u l=0.13u
X1694 VDD.t36 VSS.t844 VDD.t36 VDD.t5 sg13_lv_pmos ad=0.34p pd=2.68u as=0 ps=0 w=1u l=1u
X1695 sar_ctrl_async_phys_0.sg13g2_buf_1_14.A a_33085_43832# VSS.t103 VSS.t357 sg13_lv_nmos ad=0.2516p pd=2.16u as=0.1331p ps=1.12u w=0.74u l=0.13u
X1696 VSS.t172 sar_ctrl_async_phys_0.sg13g2_a21oi_1_1.Y sar_ctrl_async_phys_0.sg13g2_nor2_1_2.Y VSS.t87 sg13_lv_nmos ad=0.2516p pd=2.16u as=0.1406p ps=1.12u w=0.74u l=0.13u
X1697 vinn oa_sar8_acore18_opt_0.sw_bitcell_opt_term_0.gb.t0 a_35948_n9612# VSS.t539 sg13_lv_nmos ad=0.345p pd=2.69u as=0.19p ps=1.38u w=1u l=0.15u
X1698 oa_sar8_acore18_opt_0.sw_bitcell_opt_term_0.vin oa_sar8_acore18_opt_0.sw_bitcell_opt_term_0.gb.t5 oa_sar8_acore18_opt_0.sw_bitcell_opt_b0_0.bot.t0 VSS.t608 sg13_lv_nmos ad=0.35p pd=2.7u as=0.195p ps=1.39u w=1u l=0.13u
X1699 VSS.t361 sar_ctrl_async_phys_0.sg13g2_nand2b_1_0.A_N sar_ctrl_async_phys_0.sg13g2_nor2_1_12.B VSS.t89 sg13_lv_nmos ad=0.2516p pd=2.16u as=0.1406p ps=1.12u w=0.74u l=0.13u
X1700 oa_sar8_acore18_opt_0.sw_tg_opt_0.bot.t3 oa_sar8_acore18_opt_0.sw_bitcell_opt_b6_0.bot.t45 cap_cmim l=2.14u w=2.14u
X1701 a_31007_35460# sar_ctrl_async_phys_0.sg13g2_nor2_1_10.B a_30830_35166# VDD.t37 sg13_lv_pmos ad=0.2975p pd=1.595u as=0.2225p ps=1.445u w=1u l=0.13u
X1702 oa_sar8_acore18_opt_0.sw_tg_opt_1.bot.t3 oa_sar8_acore18_opt_0.sw_bitcell_opt_b7_1.bot.t131 cap_cmim l=2.14u w=2.14u
X1703 VSS.t123 VDD.t209 VSS.t123 VSS.t830 sg13_lv_nmos ad=79.8f pd=0.8u as=0 ps=0 w=0.42u l=1u
X1704 oa_sar8_acore18_opt_0.sw_tg_opt_1.bot.t3 oa_sar8_acore18_opt_0.sw_bitcell_opt_b7_1.bot.t68 cap_cmim l=2.14u w=2.14u
X1705 VSS.t1073 VDD.t40 VSS.t1072 VSS.t1071 sg13_lv_nmos ad=0.1428p pd=1.52u as=0 ps=0 w=0.42u l=1u
X1706 sar_ctrl_async_phys_0.sg13g2_o21ai_1_1.A2 sar_ctrl_async_phys_0.sg13g2_nand3_1_0.Y a_27206_39326# VSS.t89 sg13_lv_nmos ad=0.2516p pd=2.16u as=0.1406p ps=1.12u w=0.74u l=0.15u
X1707 oa_sar8_acore18_opt_0.sw_tg_opt_0.bot.t3 oa_sar8_acore18_opt_0.sw_bitcell_opt_b7_0.bot.t104 cap_cmim l=2.14u w=2.14u
X1708 result[0] a_33080_30664# VSS.t271 VSS.t658 sg13_lv_nmos ad=0.2886p pd=2.26u as=0.14875p ps=1.16u w=0.74u l=0.13u
X1709 a_34106_34380# a_34549_34423# a_33846_34850# VSS.t533 sg13_lv_nmos ad=79.8f pd=0.8u as=0.1296p ps=1.52u w=0.42u l=0.13u
X1710 oa_sar8_acore18_opt_0.sw_tg_opt_0.bot.t3 oa_sar8_acore18_opt_0.sw_bitcell_opt_b7_0.bot.t30 cap_cmim l=2.14u w=2.14u
X1711 a_35664_37695# sar_ctrl_async_phys_0.sg13g2_a21oi_1_0.A2 VDD.t13 VDD.t13 sg13_lv_pmos ad=0.1596p pd=1.22u as=0.1918p ps=1.5u w=0.84u l=0.13u
X1712 oa_sar8_acore18_opt_0.sw_bitcell_opt_term_0.vin oa_sar8_acore18_opt_0.sw_bitcell_opt_term_0.gb.t8 oa_sar8_acore18_opt_0.sw_bitcell_opt_b3_0.bot.t0 VSS.t2 sg13_lv_nmos ad=0.35p pd=2.7u as=0.195p ps=1.39u w=1u l=0.13u
X1713 a_31060_44552# a_31034_44457# VDD.t117 VDD.t69 sg13_lv_pmos ad=0.34p pd=2.68u as=0.36237p ps=2.605u w=1u l=0.13u
X1714 a_31947_41508# sar_ctrl_async_phys_0.sg13g2_nand2b_1_1.Y sar_ctrl_async_phys_0.sg13g2_a21oi_1_7.Y VDD.t5 sg13_lv_pmos ad=0.2128p pd=1.5u as=0.3808p ps=2.92u w=1.12u l=0.13u
X1715 VDD.t328 a_30783_40821# a_31450_40460# VDD.t311 sg13_lv_pmos ad=0.2128p pd=1.5u as=0.3864p ps=2.93u w=1.12u l=0.13u
X1716 VDD.t14 VSS.t471 VDD.t14 VDD.t13 sg13_lv_pmos ad=0.19p pd=1.38u as=0 ps=0 w=1u l=1u
X1717 oa_sar8_acore18_opt_0.sw_tg_opt_1.bot.t3 oa_sar8_acore18_opt_0.sw_bitcell_opt_b7_1.bot.t21 cap_cmim l=2.14u w=2.14u
X1718 sar_ctrl_async_phys_0.sg13g2_nand2_1_1.B a_34042_40460# VDD.t314 VDD.t311 sg13_lv_pmos ad=0.3808p pd=2.92u as=0.2128p ps=1.5u w=1.12u l=0.13u
X1719 oa_sar8_acore18_opt_0.sw_tg_opt_0.bot.t2 oa_sar8_acore18_opt_0.sw_bitcell_opt_b7_0.bot.t167 cap_cmim l=2.14u w=2.14u
X1720 sar_ctrl_async_phys_0.sg13g2_a22oi_1_1.B2 a_32698_31388# VSS.t98 VSS.t322 sg13_lv_nmos ad=0.2516p pd=2.16u as=0.1406p ps=1.12u w=0.74u l=0.13u
X1721 VSS.t914 VDD.t38 VSS.t111 VSS.t915 sg13_lv_nmos ad=79.8f pd=0.8u as=0 ps=0 w=0.42u l=1u
X1722 VDD.t8 sar_ctrl_async_phys_0.sg13g2_dlygate4sd3_1_7.X a_26280_41214# VDD.t5 sg13_lv_pmos ad=0.1523p pd=1.38u as=0.1428p ps=1.52u w=0.42u l=0.13u
X1723 oa_sar8_acore18_opt_0.sw_tg_opt_1.bot.t3 oa_sar8_acore18_opt_0.sw_bitcell_opt_b7_1.bot.t127 cap_cmim l=2.14u w=2.14u
X1724 a_34132_30944# a_34106_30849# VSS.t421 VSS.t1164 sg13_lv_nmos ad=0.2516p pd=2.16u as=0.1626p ps=1.415u w=0.74u l=0.13u
X1725 sar_ctrl_async_phys_0.bit_active[3] a_35672_35200# VDD.t447 VDD.t37 sg13_lv_pmos ad=0.42p pd=2.99u as=0.2114p ps=1.54u w=1.12u l=0.13u
X1726 a_32192_39918# sar_ctrl_async_phys_0.sg13g2_o21ai_1_1.B1 VDD.t311 VDD.t311 sg13_lv_pmos ad=79.8f pd=0.8u as=1.55472p ps=9.945u w=0.42u l=0.13u
X1727 VSS.t109 a_33973_39677# a_34075_39820# VSS.t108 sg13_lv_nmos ad=5.61045p pd=35.775u as=0.2516p ps=2.16u w=0.74u l=0.13u
X1728 VSS.t464 VDD.t44 VSS.t1024 VSS.t1023 sg13_lv_nmos ad=0.1428p pd=1.52u as=0 ps=0 w=0.42u l=1u
X1729 VDD.t328 sar_ctrl_async_phys_0.sg13g2_o21ai_1_1.B1 a_32090_40428# VDD.t311 sg13_lv_pmos ad=0.1563p pd=1.22u as=0.147p ps=1.54u w=0.42u l=0.13u
X1730 oa_sar8_acore18_opt_0.sw_tg_opt_0.bot.t3 oa_sar8_acore18_opt_0.sw_bitcell_opt_b7_0.bot.t115 cap_cmim l=2.14u w=2.14u
X1731 VSS.t920 VDD.t238 VSS.t920 VSS.t114 sg13_lv_nmos ad=79.8f pd=0.8u as=0 ps=0 w=0.42u l=1u
X1732 a_33410_45434# sar_ctrl_async_phys_0.sg13g2_dfrbpq_1_9.RESET_B VSS.t25 VSS.t308 sg13_lv_nmos ad=37.8f pd=0.6u as=79.8f ps=0.8u w=0.42u l=0.13u
X1733 oa_sar8_acore18_opt_0.sw_tg_opt_0.bot.t3 oa_sar8_acore18_opt_0.sw_bitcell_opt_b4_0.bot.t24 cap_cmim l=2.14u w=2.14u
X1734 oa_sar8_acore18_opt_0.sw_tg_opt_1.bot.t3 oa_sar8_acore18_opt_0.sw_bitcell_opt_b7_1.bot.t89 cap_cmim l=2.14u w=2.14u
X1735 a_34636_31749# a_34767_31359# a_34055_31352# VDD.t39 sg13_lv_pmos ad=0.34p pd=2.68u as=0.2048p ps=1.63u w=1u l=0.13u
X1736 a_31542_37874# a_32347_37447# a_31802_37404# VDD.t13 sg13_lv_pmos ad=0.1428p pd=1.52u as=79.8f ps=0.8u w=0.42u l=0.13u
X1737 VDD.t447 sar_ctrl_async_phys_0.sg13g2_nor2b_1_1.B_N a_34808_35200# VDD.t37 sg13_lv_pmos ad=0.2114p pd=1.54u as=0.2856p ps=2.36u w=0.84u l=0.13u
X1738 VSS.t841 VDD.t36 VSS.t840 VSS.t839 sg13_lv_nmos ad=0.1428p pd=1.52u as=0 ps=0 w=0.42u l=1u
X1739 oa_sar8_acore18_opt_0.sw_tg_opt_1.bot.t3 oa_sar8_acore18_opt_0.sw_bitcell_opt_b7_1.bot.t47 cap_cmim l=2.14u w=2.14u
X1740 VSS.t897 VDD.t192 VSS.t896 VSS.t895 sg13_lv_nmos ad=0.1428p pd=1.52u as=0 ps=0 w=0.42u l=1u
X1741 a_31321_46555# a_30964_46512# VDD.t169 VDD.t29 sg13_lv_pmos ad=63f pd=0.72u as=0.1563p ps=1.22u w=0.42u l=0.13u
X1742 VDD.t79 VSS.t733 VDD.t79 VDD.t69 sg13_lv_pmos ad=0.34p pd=2.68u as=0 ps=0 w=1u l=1u
X1743 VDD.t238 VSS.t964 VDD.t238 VDD.t54 sg13_lv_pmos ad=0.19p pd=1.38u as=0 ps=0 w=1u l=1u
X1744 VDD.t101 VSS.t677 VDD.t120 VDD.t15 sg13_lv_pmos ad=0.19p pd=1.38u as=0 ps=0 w=1u l=1u
X1745 VDD.t2 VSS.t770 VDD.t133 VDD.t0 sg13_lv_pmos ad=0.19p pd=1.38u as=0 ps=0 w=1u l=1u
X1746 a_30484_36362# sar_ctrl_async_phys_0.sg13g2_a22oi_1_0.B1 a_30390_36362# VSS.t3 sg13_lv_nmos ad=60.89999f pd=0.71u as=0.1428p ps=1.52u w=0.42u l=0.13u
X1747 a_30879_43845# a_30037_43495# a_29620_43488# VDD.t0 sg13_lv_pmos ad=0.2048p pd=1.63u as=0.34p ps=2.68u w=1u l=0.13u
X1748 oa_sar8_acore18_opt_0.sw_bitcell_opt_term_0.vin oa_sar8_acore18_opt_0.sw_bitcell_opt_term_0.gb.t12 oa_sar8_acore18_opt_0.sw_bitcell_opt_b7_0.bot.t0 VSS.t1 sg13_lv_nmos ad=0.35p pd=2.7u as=0.195p ps=1.39u w=1u l=0.13u
X1749 VSS.t733 VDD.t81 VSS.t736 VSS.t735 sg13_lv_nmos ad=79.8f pd=0.8u as=0 ps=0 w=0.42u l=1u
X1750 VSS.t926 VDD.t211 VSS.t926 VSS.t114 sg13_lv_nmos ad=79.8f pd=0.8u as=0 ps=0 w=0.42u l=1u
X1751 VSS.t144 VDD.t196 VSS.t144 VSS.t866 sg13_lv_nmos ad=79.8f pd=0.8u as=0 ps=0 w=0.42u l=1u
X1752 a_33844_43488# a_34363_43495# a_35103_43845# VSS.t662 sg13_lv_nmos ad=0.3473p pd=2.71u as=0.12665p ps=1.145u w=0.74u l=0.13u
X1753 a_34549_30605# sar_ctrl_async_phys_0.sg13g2_dfrbpq_1_0.CLK.t1 VDD.t39 VDD.t39 sg13_lv_pmos ad=0.4088p pd=2.97u as=1.79957p ps=11.62u w=1.12u l=0.13u
X1754 a_34153_46061# a_33211_45868# a_33951_45823# VDD.t29 sg13_lv_pmos ad=93.45f pd=0.865u as=0.2048p ps=1.63u w=0.42u l=0.13u
X1755 VSS.t773 VDD.t89 VSS.t774 VSS.t185 sg13_lv_nmos ad=79.8f pd=0.8u as=0 ps=0 w=0.42u l=1u
X1756 a_31273_33965# a_30331_33772# a_31071_33727# VDD.t54 sg13_lv_pmos ad=93.45f pd=0.865u as=0.2048p ps=1.63u w=0.42u l=0.13u
X1757 a_25596_47222# sar_ctrl_async_phys_0.sg13g2_buf_1_29.A VDD.t101 VDD.t15 sg13_lv_pmos ad=0.2856p pd=2.36u as=0.2114p ps=1.54u w=0.84u l=0.13u
X1758 a_32666_45969# a_33109_45725# a_32406_45746# VSS.t1113 sg13_lv_nmos ad=79.8f pd=0.8u as=0.1296p ps=1.52u w=0.42u l=0.13u
X1759 oa_sar8_acore18_opt_0.sw_bitcell_opt_b7_1.VSS sar_ctrl_async_phys_0.dac_code_n[0] oa_sar8_acore18_opt_0.sw_bitcell_opt_b0_1.bot.t0 VSS.t356 sg13_lv_nmos ad=0.525p pd=3.7u as=0.2925p ps=1.89u w=1.5u l=0.13u
X1760 a_30964_36349# a_31195_35935# a_30650_35892# VSS.t602 sg13_lv_nmos ad=0.2373p pd=1.97u as=79.8f ps=0.8u w=0.42u l=0.13u
X1761 VDD.t135 VSS.t779 VDD.t100 VDD.t0 sg13_lv_pmos ad=0.19p pd=1.38u as=0 ps=0 w=1u l=1u
X1762 a_29846_43909# sar_ctrl_async_phys_0.sg13g2_dfrbpq_1_9.RESET_B VSS.t312 VSS.t311 sg13_lv_nmos ad=37.8f pd=0.6u as=0.1701p ps=1.65u w=0.42u l=0.13u
X1763 VDD.t311 a_33375_40821# a_33632_40702# VDD.t311 sg13_lv_pmos ad=1.6658p pd=10.66u as=79.8f ps=0.8u w=0.42u l=0.13u
X1764 VDD.t342 sar_ctrl_async_phys_0.sg13g2_buf_1_5.A a_36056_32176# VDD.t118 sg13_lv_pmos ad=0.2114p pd=1.54u as=0.2856p ps=2.36u w=0.84u l=0.13u
X1765 sar_ctrl_async_phys_0.sg13g2_nor2_1_6.A sar_ctrl_async_phys_0.sg13g2_buf_1_13.X VSS.t295 VSS.t89 sg13_lv_nmos ad=0.2516p pd=2.16u as=0.2516p ps=2.16u w=0.74u l=0.13u
X1766 oa_sar8_acore18_opt_0.sw_tg_opt_0.bot.t3 oa_sar8_acore18_opt_0.sw_bitcell_opt_b6_0.bot.t70 cap_cmim l=2.14u w=2.14u
X1767 a_32149_35141# sar_ctrl_async_phys_0.sg13g2_dfrbpq_1_0.CLK.t9 VDD.t37 VDD.t37 sg13_lv_pmos ad=0.4088p pd=2.97u as=1.66112p ps=10.725u w=1.12u l=0.13u
X1768 sar_ctrl_async_phys_0.bit_active[5] a_36056_37436# VSS.t88 VSS.t118 sg13_lv_nmos ad=0.2886p pd=2.26u as=0.14875p ps=1.16u w=0.74u l=0.13u
X1769 oa_sar8_acore18_opt_0.sw_tg_opt_1.bot.t3 oa_sar8_acore18_opt_0.sw_bitcell_opt_b3_1.bot.t8 cap_cmim l=2.14u w=2.14u
X1770 oa_sar8_acore18_opt_0.sw_tg_opt_0.bot.t2 oa_sar8_acore18_opt_0.sw_bitcell_opt_b7_0.bot.t149 cap_cmim l=2.14u w=2.14u
X1771 VDD.t198 VSS.t11 VDD.t198 VDD.t54 sg13_lv_pmos ad=0.34p pd=2.68u as=0 ps=0 w=1u l=1u
X1772 VSS.t283 VDD.t42 VSS.t86 VSS.t371 sg13_lv_nmos ad=0.1428p pd=1.52u as=0 ps=0 w=0.42u l=1u
X1773 a_31060_44552# a_31034_44457# VSS.t263 VSS.t497 sg13_lv_nmos ad=0.2516p pd=2.16u as=0.1626p ps=1.415u w=0.74u l=0.13u
X1774 VSS.t293 a_30783_40821# a_31450_40460# VSS.t44 sg13_lv_nmos ad=0.1406p pd=1.12u as=0.2516p ps=2.16u w=0.74u l=0.13u
X1775 VDD.t350 sar_ctrl_async_phys_0.sg13g2_nand2_1_1.Y a_35672_38948# VDD.t162 sg13_lv_pmos ad=0.2114p pd=1.54u as=0.2856p ps=2.36u w=0.84u l=0.13u
X1776 a_35552_36166# a_35295_36285# a_35714_36362# VSS.t164 sg13_lv_nmos ad=0.1428p pd=1.52u as=37.8f ps=0.6u w=0.42u l=0.13u
X1777 VDD.t366 sar_ctrl_async_phys_0.sg13g2_buf_1_13.X a_31933_43832# VDD.t0 sg13_lv_pmos ad=0.1918p pd=1.5u as=0.1596p ps=1.22u w=0.84u l=0.13u
X1778 a_29238_40898# sar_ctrl_async_phys_0.sg13g2_nor2_1_10.Y VDD.t312 VDD.t311 sg13_lv_pmos ad=79.8f pd=0.8u as=0.1428p ps=1.52u w=0.42u l=0.13u
X1779 sar_ctrl_async_phys_0.sg13g2_nand2_1_1.B a_34042_40460# VSS.t27 VSS.t170 sg13_lv_nmos ad=0.2516p pd=2.16u as=0.1406p ps=1.12u w=0.74u l=0.13u
X1780 sar_ctrl_async_phys_0.sg13g2_a22oi_1_0.B1 a_31832_34412# VDD.t198 VDD.t54 sg13_lv_pmos ad=0.42p pd=2.99u as=0.2114p ps=1.54u w=1.12u l=0.13u
X1781 VDD.t132 a_26570_42690# a_26289_42912# VDD.t0 sg13_lv_pmos ad=0.1523p pd=1.38u as=0.34p ps=2.68u w=1u l=0.5u
X1782 VSS.t393 a_32149_35141# a_32251_35284# VSS.t1255 sg13_lv_nmos ad=6.27915p pd=40.31u as=0.2516p ps=2.16u w=0.74u l=0.13u
X1783 VDD.t16 VSS.t129 VDD.t22 VDD.t15 sg13_lv_pmos ad=0.19p pd=1.38u as=0 ps=0 w=1u l=1u
X1784 VSS.t511 sar_ctrl_async_phys_0.sg13g2_and2_1_2.X a_27206_39326# VSS.t89 sg13_lv_nmos ad=0.1406p pd=1.12u as=0.2516p ps=2.16u w=0.74u l=0.15u
X1785 oa_sar8_acore18_opt_0.sw_tg_opt_1.bot.t3 oa_sar8_acore18_opt_0.sw_bitcell_opt_b6_1.bot.t49 cap_cmim l=2.14u w=2.14u
X1786 VSS.t58 a_26954_40424# a_26673_40726# VSS.t212 sg13_lv_nmos ad=79.8f pd=0.8u as=0.1428p ps=1.52u w=0.42u l=0.5u
X1787 VSS.t794 VDD.t146 VSS.t776 VSS.t185 sg13_lv_nmos ad=79.8f pd=0.8u as=0 ps=0 w=0.42u l=1u
X1788 a_30495_39309# a_29653_38959# a_29236_38952# VDD.t162 sg13_lv_pmos ad=0.2048p pd=1.63u as=0.34p ps=2.68u w=1u l=0.13u
X1789 VDD.t247 sar_ctrl_async_phys_0.sg13g2_dfrbpq_1_22.D a_32156_38948# VDD.t162 sg13_lv_pmos ad=0.4032p pd=2.96u as=0.1176p ps=1.33u w=1.12u l=0.13u
X1790 a_35948_n9612# oa_sar8_acore18_opt_0.sw_bitcell_opt_term_0.gb.t0 vinn VSS.t539 sg13_lv_nmos ad=0.19p pd=1.38u as=0.345p ps=2.69u w=1u l=0.15u
X1791 VDD.t31 VSS.t129 VDD.t30 VDD.t29 sg13_lv_pmos ad=0.19p pd=1.38u as=0 ps=0 w=1u l=1u
X1792 VSS.t123 a_33948_41936# sar_ctrl_async_phys_0.sg13g2_o21ai_1_1.B1 VSS.t595 sg13_lv_nmos ad=0.14875p pd=1.16u as=0.2886p ps=2.26u w=0.74u l=0.13u
X1793 oa_sar8_acore18_opt_0.sw_tg_opt_0.bot.t3 oa_sar8_acore18_opt_0.sw_bitcell_opt_b7_0.bot.t22 cap_cmim l=2.14u w=2.14u
X1794 VDD.t366 a_33276_42686# sar_ctrl_async_phys_0.sg13g2_buf_1_35.A VDD.t0 sg13_lv_pmos ad=0.2114p pd=1.54u as=0.42p ps=2.99u w=1.12u l=0.13u
X1795 VDD.t79 VSS.t777 VDD.t79 VDD.t69 sg13_lv_pmos ad=0.19p pd=1.38u as=0 ps=0 w=1u l=1u
X1796 a_28368_36877# sar_ctrl_async_phys_0.sg13g2_nand2_1_0.B VDD.t471 VDD.t13 sg13_lv_pmos ad=0.1596p pd=1.22u as=0.1918p ps=1.5u w=0.84u l=0.13u
X1797 oa_sar8_acore18_opt_0.sw_bitcell_opt_b1_1.bot.t0 oa_sar8_acore18_opt_0.sw_bitcell_opt_term_0.trkb.t28 oa_sar8_acore18_opt_0.bstrap_opt_w2_c1200_1.out VDD.t661 sg13_lv_pmos ad=0.39p pd=2.39u as=0.7p ps=4.7u w=2u l=0.13u
X1798 VSS.t730 VDD.t79 VSS.t727 VSS.t755 sg13_lv_nmos ad=0.1428p pd=1.52u as=0 ps=0 w=0.42u l=1u
X1799 VSS.t78 a_34261_43495# a_34363_43495# VSS.t536 sg13_lv_nmos ad=4.3785p pd=27.07u as=0.2516p ps=2.16u w=0.74u l=0.13u
X1800 oa_sar8_acore18_opt_0.sw_bitcell_opt_b4_1.bot.t0 oa_sar8_acore18_opt_0.sw_bitcell_opt_term_0.trkb.t25 oa_sar8_acore18_opt_0.bstrap_opt_w2_c1200_1.out VDD.t618 sg13_lv_pmos ad=0.39p pd=2.39u as=0.7p ps=4.7u w=2u l=0.13u
X1801 VSS.t672 a_25596_47222# sar_ctrl_async_phys_0.hold_req VSS.t1198 sg13_lv_nmos ad=0.14875p pd=1.16u as=0.2886p ps=2.26u w=0.74u l=0.13u
X1802 oa_sar8_acore18_opt_0.sw_tg_opt_0.bot.t3 oa_sar8_acore18_opt_0.sw_bitcell_opt_b7_0.bot.t115 cap_cmim l=2.14u w=2.14u
X1803 oa_sar8_acore18_opt_0.sw_bitcell_opt_b6_1.bot.t0 oa_sar8_acore18_opt_0.bstrap_opt_w2_c1200_1.gb oa_sar8_acore18_opt_0.bstrap_opt_w2_c1200_1.out VSS.t1096 sg13_lv_nmos ad=0.195p pd=1.39u as=0.35p ps=2.7u w=1u l=0.13u
X1804 a_31935_36285# a_31093_35935# a_30676_35928# VDD.t37 sg13_lv_pmos ad=0.2048p pd=1.63u as=0.34p ps=2.68u w=1u l=0.13u
X1805 VSS.t45 a_31040_40702# a_30689_40821# VSS.t44 sg13_lv_nmos ad=79.8f pd=0.8u as=0.1428p ps=1.52u w=0.42u l=0.13u
X1806 VDD.t68 VSS.t672 VDD.t68 VDD.t29 sg13_lv_pmos ad=0.34p pd=2.68u as=0 ps=0 w=1u l=1u
X1807 sar_ctrl_async_phys_0.dac_code[7] a_36056_38224# VSS.t88 VSS.t87 sg13_lv_nmos ad=0.2886p pd=2.26u as=0.14875p ps=1.16u w=0.74u l=0.13u
X1808 VDD.t340 a_35391_33261# a_35648_33142# VDD.t118 sg13_lv_pmos ad=1.96315p pd=12.675u as=79.8f ps=0.8u w=0.42u l=0.13u
X1809 oa_sar8_acore18_opt_0.sw_tg_opt_1.bot.t3 oa_sar8_acore18_opt_0.sw_bitcell_opt_b7_1.bot.t120 cap_cmim l=2.14u w=2.14u
X1810 oa_sar8_acore18_opt_0.sw_tg_opt_1.bot.t3 oa_sar8_acore18_opt_0.sw_bitcell_opt_b4_1.bot.t21 cap_cmim l=2.14u w=2.14u
X1811 VSS.t239 oa_sar8_acore18_opt_0.sw_bitcell_opt_term_0.trkb.t0 oa_sar8_acore18_opt_0.sw_bitcell_opt_term_0.trkb.t1 VDD.t713 sg13_lv_pmos ad=0.7p pd=4.7u as=0.39p ps=2.39u w=2u l=0.13u
X1812 a_30964_36349# a_30676_35928# a_30902_36349# VSS.t1085 sg13_lv_nmos ad=0.1428p pd=1.52u as=37.8f ps=0.6u w=0.42u l=0.13u
X1813 VDD.t187 VSS.t133 VDD.t186 VDD.t5 sg13_lv_pmos ad=0.34p pd=2.68u as=0 ps=0 w=1u l=1u
X1814 sar_ctrl_async_phys_0.dac_code[4] a_36056_41972# VSS.t273 VSS.t272 sg13_lv_nmos ad=0.2886p pd=2.26u as=0.14875p ps=1.16u w=0.74u l=0.13u
X1815 VDD.t382 sar_ctrl_async_phys_0.sg13g2_a21oi_1_0.A1.t2 a_34731_37436# VDD.t13 sg13_lv_pmos ad=0.2128p pd=1.5u as=0.2128p ps=1.5u w=1.12u l=0.13u
X1816 oa_sar8_acore18_opt_0.sw_tg_opt_0.bot.t2 oa_sar8_acore18_opt_0.sw_bitcell_opt_b7_0.bot.t152 cap_cmim l=2.14u w=2.14u
X1817 VDD.t230 VSS.t976 VDD.t229 VDD.t118 sg13_lv_pmos ad=0.34p pd=2.68u as=0 ps=0 w=1u l=1u
X1818 a_31328_33870# a_31071_33727# a_31490_33650# VSS.t126 sg13_lv_nmos ad=0.1428p pd=1.52u as=37.8f ps=0.6u w=0.42u l=0.13u
X1819 VSS.t22 VDD.t169 VSS.t485 VSS.t743 sg13_lv_nmos ad=0.1428p pd=1.52u as=0 ps=0 w=0.42u l=1u
X1820 VDD.t35 sar_ctrl_async_phys_0.sg13g2_nand2_1_3.A sar_ctrl_async_phys_0.sg13g2_a21oi_1_5.B1 VDD.t29 sg13_lv_pmos ad=0.2198p pd=1.53u as=0.2128p ps=1.5u w=1.12u l=0.13u
X1821 oa_sar8_acore18_opt_0.sw_tg_opt_0.bot.t3 oa_sar8_acore18_opt_0.sw_bitcell_opt_b7_0.bot.t131 cap_cmim l=2.14u w=2.14u
X1822 VDD.t209 VSS.t346 VDD.t209 VDD.t5 sg13_lv_pmos ad=0.34p pd=2.68u as=0 ps=0 w=1u l=1u
X1823 oa_sar8_acore18_opt_0.sw_tg_opt_1.bot.t3 oa_sar8_acore18_opt_0.sw_bitcell_opt_b4_1.bot.t7 cap_cmim l=2.14u w=2.14u
X1824 VSS.t417 VDD.t14 VSS.t368 VSS.t85 sg13_lv_nmos ad=0.1428p pd=1.52u as=0 ps=0 w=0.42u l=1u
X1825 oa_sar8_acore18_opt_0.sw_tg_opt_0.bot.t3 oa_sar8_acore18_opt_0.sw_bitcell_opt_b6_0.bot.t10 cap_cmim l=2.14u w=2.14u
X1826 oa_sar8_acore18_opt_0.sw_tg_opt_0.bot.t3 oa_sar8_acore18_opt_0.sw_bitcell_opt_b6_0.bot.t75 cap_cmim l=2.14u w=2.14u
X1827 a_35463_31435# sar_ctrl_async_phys_0.sg13g2_inv_1_0.Y a_36210_31826# VSS.t1084 sg13_lv_nmos ad=0.1428p pd=1.52u as=60.89999f ps=0.71u w=0.42u l=0.13u
X1828 a_29332_32456# a_29306_32361# VDD.t205 VDD.t118 sg13_lv_pmos ad=0.34p pd=2.68u as=0.36237p ps=2.605u w=1u l=0.13u
X1829 a_25794_39706# sar_ctrl_async_phys_0.sg13g2_nand3_1_0.C VSS.t1229 VSS.t89 sg13_lv_nmos ad=0.1406p pd=1.12u as=0.2886p ps=2.26u w=0.74u l=0.13u
X1830 a_33556_40016# a_34075_39820# a_34815_39775# VSS.t378 sg13_lv_nmos ad=0.3473p pd=2.71u as=0.12665p ps=1.145u w=0.74u l=0.13u
X1831 VDD.t819 sar_ctrl_async_phys_0.sg13g2_buf_1_20.A a_36056_37436# VDD.t13 sg13_lv_pmos ad=0.2114p pd=1.54u as=0.2856p ps=2.36u w=0.84u l=0.13u
X1832 VSS.t1003 VDD.t119 VSS.t1003 VSS.t17 sg13_lv_nmos ad=79.8f pd=0.8u as=0 ps=0 w=0.42u l=1u
X1833 oa_sar8_acore18_opt_0.sw_tg_opt_1.bot.t3 oa_sar8_acore18_opt_0.sw_bitcell_opt_b6_1.bot.t1 cap_cmim l=2.14u w=2.14u
X1834 sar_ctrl_async_phys_0.cmp_p sar_ctrl_async_phys_0.cmp_n VDD.t952 VDD.t949 sg13_lv_pmos ad=0.585p pd=3.39u as=1.05p ps=6.7u w=3u l=0.13u
X1835 a_35725_45266# sar_ctrl_async_phys_0.sg13g2_nand2b_1_7.A_N VDD.t568 VDD.t69 sg13_lv_pmos ad=0.2856p pd=2.36u as=0.2198p ps=1.53u w=0.84u l=0.13u
X1836 VSS.t263 sar_ctrl_async_phys_0.sg13g2_dfrbpq_1_9.RESET_B a_30868_44234# VSS.t305 sg13_lv_nmos ad=0.1626p pd=1.415u as=60.89999f ps=0.71u w=0.42u l=0.13u
X1837 VDD.t766 a_28862_36863# sar_ctrl_async_phys_0.sg13g2_dlygate4sd3_1_1.X VDD.t13 sg13_lv_pmos ad=0.2254p pd=1.53u as=0.4256p ps=3u w=1.12u l=0.13u
X1838 sar_ctrl_async_phys_0.cmp_n sar_ctrl_async_phys_0.cmp_p a_30632_22281# VSS.t251 sg13_lv_nmos ad=0.39p pd=2.39u as=0.7p ps=4.7u w=2u l=0.13u
X1839 VSS.t957 VDD.t254 VSS.t956 VSS.t955 sg13_lv_nmos ad=0.1428p pd=1.52u as=0 ps=0 w=0.42u l=1u
X1840 VDD.t345 sar_ctrl_async_phys_0.sg13g2_a21oi_1_6.B1 a_35672_47296# VDD.t15 sg13_lv_pmos ad=0.2114p pd=1.54u as=0.2856p ps=2.36u w=0.84u l=0.13u
X1841 oa_sar8_acore18_opt_0.sw_tg_opt_1.bot.t3 oa_sar8_acore18_opt_0.sw_bitcell_opt_b6_1.bot.t79 cap_cmim l=2.14u w=2.14u
X1842 VSS.t37 sar_ctrl_async_phys_0.sg13g2_o21ai_1_1.B1 a_30484_39698# VSS.t43 sg13_lv_nmos ad=0.1626p pd=1.415u as=60.89999f ps=0.71u w=0.42u l=0.13u
X1843 VDD.t165 a_31716_38912# a_31674_38948# VDD.t162 sg13_lv_pmos ad=0.2618p pd=1.63u as=0.1176p ps=1.33u w=1.12u l=0.13u
X1844 sar_ctrl_async_phys_0.sg13g2_a22oi_1_0.A1.t0 a_34904_38224# VDD.t350 VDD.t162 sg13_lv_pmos ad=0.42p pd=2.99u as=0.2114p ps=1.54u w=1.12u l=0.13u
X1845 a_33193_45119# a_32251_45007# a_32991_45357# VDD.t69 sg13_lv_pmos ad=93.45f pd=0.865u as=0.2048p ps=1.63u w=0.42u l=0.13u
X1846 oa_sar8_acore18_opt_0.sw_tg_opt_0.bot.t3 oa_sar8_acore18_opt_0.sw_bitcell_opt_b7_0.bot.t68 cap_cmim l=2.14u w=2.14u
X1847 sar_ctrl_async_phys_0.sg13g2_nor4_1_0.Y sar_ctrl_async_phys_0.sg13g2_dfrbpq_1_0.CLK.t21 VSS.t60 VSS.t1216 sg13_lv_nmos ad=0.1406p pd=1.12u as=0.1406p ps=1.12u w=0.74u l=0.13u
X1848 oa_sar8_acore18_opt_0.sw_tg_opt_0.bot.t3 oa_sar8_acore18_opt_0.sw_bitcell_opt_b7_0.bot.t89 cap_cmim l=2.14u w=2.14u
X1849 sar_ctrl_async_phys_0.sg13g2_nand2_1_6.B a_34618_46044# VDD.t35 VDD.t29 sg13_lv_pmos ad=0.3808p pd=2.92u as=0.2128p ps=1.5u w=1.12u l=0.13u
X1850 oa_sar8_acore18_opt_0.sw_bitcell_opt_b3_1.bot.t1 sar_ctrl_async_phys_0.dac_code_n[3] VDD.t589 VDD.t587 sg13_lv_pmos ad=0.819p pd=4.59u as=1.47p ps=9.1u w=4.2u l=0.13u
X1851 oa_sar8_acore18_opt_0.sw_tg_opt_1.bot.t3 oa_sar8_acore18_opt_0.sw_bitcell_opt_b5_1.bot.t1 cap_cmim l=2.14u w=2.14u
X1852 VSS.t5 VDD.t198 VSS.t5 VSS.t954 sg13_lv_nmos ad=79.8f pd=0.8u as=0 ps=0 w=0.42u l=1u
X1853 VSS.t1003 VDD.t182 VSS.t1003 VSS.t17 sg13_lv_nmos ad=0.1428p pd=1.52u as=0 ps=0 w=0.42u l=1u
X1854 sar_ctrl_async_phys_0.dac_code[6] a_35672_38948# VSS.t166 VSS.t165 sg13_lv_nmos ad=0.2886p pd=2.26u as=0.14875p ps=1.16u w=0.74u l=0.13u
X1855 sar_ctrl_async_phys_0.dac_code_n[2] a_35288_47296# VSS.t62 VSS.t61 sg13_lv_nmos ad=0.2886p pd=2.26u as=0.14875p ps=1.16u w=0.74u l=0.13u
X1856 VDD.t350 sar_ctrl_async_phys_0.sg13g2_nor2b_1_0.A a_34904_38224# VDD.t162 sg13_lv_pmos ad=0.2114p pd=1.54u as=0.2856p ps=2.36u w=0.84u l=0.13u
X1857 VDD.t119 VSS.t1003 VDD.t119 VDD.t118 sg13_lv_pmos ad=0.34p pd=2.68u as=0 ps=0 w=1u l=1u
X1858 VSS.t11 sar_ctrl_async_phys_0.sg13g2_a22oi_1_0.Y sar_ctrl_async_phys_0.sg13g2_inv_1_3.Y VSS.t126 sg13_lv_nmos ad=0.2516p pd=2.16u as=0.2516p ps=2.16u w=0.74u l=0.13u
X1859 a_29620_43488# a_29594_43452# VSS.t312 VSS.t1124 sg13_lv_nmos ad=0.2516p pd=2.16u as=0.1626p ps=1.415u w=0.74u l=0.13u
X1860 w_16692_n9960# a_20412_n9612# cap_cmim l=9.94u w=39.8u
X1861 a_32192_36166# sar_ctrl_async_phys_0.sg13g2_buf_1_2.A.t0 VDD.t37 VDD.t37 sg13_lv_pmos ad=79.8f pd=0.8u as=1.66112p ps=10.725u w=0.42u l=0.13u
X1862 VSS.t325 a_35391_30703# a_36058_30924# VSS.t1147 sg13_lv_nmos ad=0.1406p pd=1.12u as=0.2516p ps=2.16u w=0.74u l=0.13u
X1863 VDD.t70 VSS.t722 VDD.t70 VDD.t69 sg13_lv_pmos ad=0.34p pd=2.68u as=0 ps=0 w=1u l=1u
X1864 oa_sar8_acore18_opt_0.sw_bitcell_opt_term_0.bot.t0 VDD.t1092 oa_sar8_acore18_opt_0.sw_bitcell_opt_term_0.VSS VSS.t1076 sg13_lv_nmos ad=0.2925p pd=1.89u as=0.525p ps=3.7u w=1.5u l=0.13u
X1865 a_35401_44549# a_34459_44356# a_35199_44311# VDD.t69 sg13_lv_pmos ad=93.45f pd=0.865u as=0.2048p ps=1.63u w=0.42u l=0.13u
X1866 VSS.t129 VDD.t16 VSS.t129 VSS.t689 sg13_lv_nmos ad=79.8f pd=0.8u as=0 ps=0 w=0.42u l=1u
X1867 a_35697_40808# sar_ctrl_async_phys_0.sg13g2_a21oi_1_0.A1.t3 sar_ctrl_async_phys_0.sg13g2_a22oi_1_2.A2 VSS.t119 sg13_lv_nmos ad=0.1406p pd=1.12u as=0.1406p ps=1.12u w=0.74u l=0.13u
X1868 VDD.t238 VSS.t969 VDD.t238 VDD.t54 sg13_lv_pmos ad=0.19p pd=1.38u as=0 ps=0 w=1u l=1u
X1869 sar_ctrl_async_phys_0.sg13g2_a22oi_1_2.B1 sar_ctrl_async_phys_0.sg13g2_buf_1_13.X a_31370_34782# VSS.t114 sg13_lv_nmos ad=0.2516p pd=2.16u as=0.1406p ps=1.12u w=0.74u l=0.13u
X1870 oa_sar8_acore18_opt_0.sw_tg_opt_1.bot.t4 oa_sar8_acore18_opt_0.sw_bitcell_opt_b7_1.bot.t1 cap_cmim l=2.14u w=2.14u
X1871 oa_sar8_acore18_opt_0.sw_bitcell_opt_term_0.vin oa_sar8_acore18_opt_0.sw_bitcell_opt_term_0.trkb.t18 oa_sar8_acore18_opt_0.sw_bitcell_opt_b4_0.bot.t0 VDD.t512 sg13_lv_pmos ad=0.7p pd=4.7u as=0.39p ps=2.39u w=2u l=0.13u
X1872 VSS.t931 VDD.t55 VSS.t115 VSS.t114 sg13_lv_nmos ad=79.8f pd=0.8u as=0 ps=0 w=0.42u l=1u
X1873 sar_ctrl_async_phys_0.dac_code[3] a_36056_42760# VSS.t273 VSS.t272 sg13_lv_nmos ad=0.2886p pd=2.26u as=0.14875p ps=1.16u w=0.74u l=0.13u
X1874 a_31638_32138# sar_ctrl_async_phys_0.sg13g2_inv_1_1.Y VDD.t343 VDD.t118 sg13_lv_pmos ad=79.8f pd=0.8u as=0.1428p ps=1.52u w=0.42u l=0.13u
X1875 a_32288_31630# a_32031_31749# a_32450_31826# VSS.t236 sg13_lv_nmos ad=0.1428p pd=1.52u as=37.8f ps=0.6u w=0.42u l=0.13u
X1876 VDD.t38 VSS.t115 VDD.t38 VDD.t37 sg13_lv_pmos ad=0.19p pd=1.38u as=0 ps=0 w=1u l=1u
X1877 sar_ctrl_async_phys_0.sg13g2_a21oi_1_4.A2 a_31546_43484# VDD.t366 VDD.t0 sg13_lv_pmos ad=0.3808p pd=2.92u as=0.2128p ps=1.5u w=1.12u l=0.13u
X1878 VDD.t371 sar_ctrl_async_phys_0.sg13g2_buf_1_2.A a_34106_34380# VDD.t54 sg13_lv_pmos ad=0.1563p pd=1.22u as=0.147p ps=1.54u w=0.42u l=0.13u
X1879 oa_sar8_acore18_opt_0.bstrap_opt_w2_c1200_1.out oa_sar8_acore18_opt_0.bstrap_opt_w2_c1200_1.gb vinp VSS.t1099 sg13_lv_nmos ad=0.195p pd=1.39u as=0.35p ps=2.7u w=1u l=0.13u
X1880 sar_ctrl_async_phys_0.sg13g2_nor2b_1_0.A a_34520_38224# VSS.t429 VSS.t87 sg13_lv_nmos ad=0.2886p pd=2.26u as=0.14875p ps=1.16u w=0.74u l=0.13u
X1881 oa_sar8_acore18_opt_0.sw_tg_opt_0.bot.t3 oa_sar8_acore18_opt_0.sw_bitcell_opt_b5_0.bot.t35 cap_cmim l=2.14u w=2.14u
X1882 oa_sar8_acore18_opt_0.sw_tg_opt_1.bot.t3 oa_sar8_acore18_opt_0.sw_bitcell_opt_b7_1.bot.t136 cap_cmim l=2.14u w=2.14u
X1883 a_34420_34837# a_34651_34423# a_34106_34380# VSS.t1126 sg13_lv_nmos ad=0.2373p pd=1.97u as=79.8f ps=0.8u w=0.42u l=0.13u
X1884 VDD.t371 sar_ctrl_async_phys_0.sg13g2_buf_1_25.A a_34136_33688# VDD.t54 sg13_lv_pmos ad=0.2114p pd=1.54u as=0.2856p ps=2.36u w=0.84u l=0.13u
X1885 VSS.t90 a_27134_39887# sar_ctrl_async_phys_0.sg13g2_dlygate4sd3_1_4.X VSS.t89 sg13_lv_nmos ad=0.1426p pd=1.16u as=0.2516p ps=2.16u w=0.74u l=0.13u
X1886 a_29526_33650# sar_ctrl_async_phys_0.sg13g2_inv_1_5.Y VDD.t55 VDD.t54 sg13_lv_pmos ad=79.8f pd=0.8u as=0.1428p ps=1.52u w=0.42u l=0.13u
X1887 a_33846_34850# sar_ctrl_async_phys_0.sg13g2_buf_1_16.A VDD.t198 VDD.t54 sg13_lv_pmos ad=79.8f pd=0.8u as=0.1428p ps=1.52u w=0.42u l=0.13u
X1888 VSS.t787 VDD.t150 VSS.t765 VSS.t185 sg13_lv_nmos ad=0.1428p pd=1.52u as=0 ps=0 w=0.42u l=1u
X1889 oa_sar8_acore18_opt_0.sw_tg_opt_0.bot.t3 oa_sar8_acore18_opt_0.sw_bitcell_opt_b6_0.bot.t2 cap_cmim l=2.14u w=2.14u
X1890 oa_sar8_acore18_opt_0.sw_tg_opt_1.bot.t3 oa_sar8_acore18_opt_0.sw_bitcell_opt_b7_1.bot.t73 cap_cmim l=2.14u w=2.14u
X1891 sar_ctrl_async_phys_0.sg13g2_a21oi_1_2.B1 a_31450_40460# VDD.t328 VDD.t311 sg13_lv_pmos ad=0.3808p pd=2.92u as=0.2128p ps=1.5u w=1.12u l=0.13u
X1892 VSS.t129 VDD.t30 VSS.t129 VSS.t712 sg13_lv_nmos ad=79.8f pd=0.8u as=0 ps=0 w=0.42u l=1u
X1893 a_26174_42911# a_26289_42912# VDD.t150 VDD.t0 sg13_lv_pmos ad=0.34p pd=2.68u as=0.2254p ps=1.53u w=1u l=0.5u
X1894 done a_35288_33688# VSS.t148 VSS.t63 sg13_lv_nmos ad=0.2886p pd=2.26u as=0.14875p ps=1.16u w=0.74u l=0.13u
X1895 VDD.t46 VSS.t919 VDD.t46 VDD.t37 sg13_lv_pmos ad=0.34p pd=2.68u as=0 ps=0 w=1u l=1u
X1896 VDD.t46 VSS.t891 VDD.t46 VDD.t37 sg13_lv_pmos ad=0.34p pd=2.68u as=0 ps=0 w=1u l=1u
X1897 a_34442_45366# sar_ctrl_async_phys_0.sg13g2_nand2b_1_7.A_N VSS.t25 VSS.t667 sg13_lv_nmos ad=0.1406p pd=1.12u as=0.2516p ps=2.16u w=0.74u l=0.13u
X1898 VDD.t311 a_31935_39775# a_32192_39918# VDD.t311 sg13_lv_pmos ad=1.6658p pd=10.66u as=79.8f ps=0.8u w=0.42u l=0.13u
X1899 a_29786_33873# a_30229_33629# a_29526_33650# VSS.t226 sg13_lv_nmos ad=79.8f pd=0.8u as=0.1296p ps=1.52u w=0.42u l=0.13u
X1900 VSS.t727 VDD.t76 VSS.t727 VSS.t728 sg13_lv_nmos ad=0.1428p pd=1.52u as=0 ps=0 w=0.42u l=1u
X1901 VDD.t14 VSS.t626 VDD.t14 VDD.t13 sg13_lv_pmos ad=0.34p pd=2.68u as=0 ps=0 w=1u l=1u
X1902 a_28862_36863# a_28977_36864# VSS.t84 VSS.t1128 sg13_lv_nmos ad=0.1428p pd=1.52u as=0.1426p ps=1.16u w=0.42u l=0.5u
X1903 VDD.t79 VSS.t780 VDD.t79 VDD.t69 sg13_lv_pmos ad=0.19p pd=1.38u as=0 ps=0 w=1u l=1u
X1904 sar_ctrl_async_phys_0.sg13g2_nand3_1_0.C track VSS.t1202 VSS.t89 sg13_lv_nmos ad=0.1406p pd=1.12u as=0.2516p ps=2.16u w=0.74u l=0.13u
X1905 oa_sar8_acore18_opt_0.sw_tg_opt_1.bot.t2 oa_sar8_acore18_opt_0.sw_bitcell_opt_b7_1.bot.t157 cap_cmim l=2.14u w=2.14u
X1906 a_35595_40460# sar_ctrl_async_phys_0.sg13g2_a21oi_1_3.A2 VDD.t384 VDD.t311 sg13_lv_pmos ad=0.3808p pd=2.92u as=0.2128p ps=1.5u w=1.12u l=0.13u
X1907 oa_sar8_acore18_opt_0.sw_tg_opt_1.bot.t3 oa_sar8_acore18_opt_0.sw_bitcell_opt_b5_1.bot.t21 cap_cmim l=2.14u w=2.14u
X1908 VSS.t767 VDD.t70 VSS.t766 VSS.t185 sg13_lv_nmos ad=0.1428p pd=1.52u as=0 ps=0 w=0.42u l=1u
X1909 a_29660_37436# sar_ctrl_async_phys_0.sg13g2_nor2_1_5.Y sar_ctrl_async_phys_0.sg13g2_nor2_1_5.B VDD.t13 sg13_lv_pmos ad=0.1176p pd=1.33u as=0.3808p ps=2.92u w=1.12u l=0.13u
X1910 VDD.t39 a_35391_30703# a_35648_30846# VDD.t39 sg13_lv_pmos ad=1.96315p pd=12.675u as=79.8f ps=0.8u w=0.42u l=0.13u
X1911 VSS.t50 a_35072_39918# a_34721_39775# VSS.t268 sg13_lv_nmos ad=79.8f pd=0.8u as=0.1428p ps=1.52u w=0.42u l=0.13u
X1912 oa_sar8_acore18_opt_0.sw_tg_opt_1.bot.t3 oa_sar8_acore18_opt_0.sw_bitcell_opt_b7_1.bot.t94 cap_cmim l=2.14u w=2.14u
X1913 result[2] a_33080_31388# VSS.t98 VSS.t14 sg13_lv_nmos ad=0.2886p pd=2.26u as=0.14875p ps=1.16u w=0.74u l=0.13u
X1914 VSS.t1044 VDD.t61 VSS.t1043 VSS.t1042 sg13_lv_nmos ad=0.1428p pd=1.52u as=0 ps=0 w=0.42u l=1u
X1915 a_30746_31356# a_31189_31399# a_31129_31435# VDD.t39 sg13_lv_pmos ad=79.8f pd=0.8u as=63f ps=0.72u w=0.42u l=0.13u
X1916 sar_ctrl_async_phys_0.sg13g2_buf_1_1.A a_36058_34412# VSS.t113 VSS.t199 sg13_lv_nmos ad=0.2516p pd=2.16u as=0.1406p ps=1.12u w=0.74u l=0.13u
X1917 a_30830_35166# sar_ctrl_async_phys_0.sg13g2_nor2_1_10.B a_30733_35166# VSS.t114 sg13_lv_nmos ad=0.1628p pd=1.18u as=0.13135p ps=1.095u w=0.74u l=0.13u
X1918 VSS.t672 VDD.t68 VSS.t672 VSS.t698 sg13_lv_nmos ad=0.1428p pd=1.52u as=0 ps=0 w=0.42u l=1u
X1919 a_35456_44454# a_35199_44311# a_35618_44234# VSS.t252 sg13_lv_nmos ad=0.1428p pd=1.52u as=37.8f ps=0.6u w=0.42u l=0.13u
X1920 a_35072_39918# a_34815_39775# a_35234_39698# VSS.t639 sg13_lv_nmos ad=0.1428p pd=1.52u as=37.8f ps=0.6u w=0.42u l=0.13u
X1921 sar_ctrl_async_phys_0.sg13g2_a21oi_1_4.A2 a_31546_43484# VSS.t103 VSS.t1115 sg13_lv_nmos ad=0.2516p pd=2.16u as=0.1406p ps=1.12u w=0.74u l=0.13u
X1922 oa_sar8_acore18_opt_0.sw_bitcell_opt_b7_1.bot.t0 sar_ctrl_async_phys_0.dac_code_n[7] oa_sar8_acore18_opt_0.sw_bitcell_opt_b7_1.VSS VSS.t1098 sg13_lv_nmos ad=0.663p pd=3.79u as=1.19p ps=7.5u w=3.4u l=0.13u
X1923 oa_sar8_acore18_opt_0.sw_bitcell_opt_term_0.vin oa_sar8_acore18_opt_0.sw_bitcell_opt_term_0.trkb.t15 oa_sar8_acore18_opt_0.sw_bitcell_opt_b1_0.bot.t0 VDD.t617 sg13_lv_pmos ad=0.7p pd=4.7u as=0.39p ps=2.39u w=2u l=0.13u
X1924 VDD.t198 a_31071_33727# a_31738_33948# VDD.t54 sg13_lv_pmos ad=0.2128p pd=1.5u as=0.3864p ps=2.93u w=1.12u l=0.13u
X1925 oa_sar8_acore18_opt_0.sw_bitcell_opt_term_0.vin oa_sar8_acore18_opt_0.sw_bitcell_opt_term_0.trkb.t17 oa_sar8_acore18_opt_0.sw_bitcell_opt_b3_0.bot.t0 VDD.t511 sg13_lv_pmos ad=0.7p pd=4.7u as=0.39p ps=2.39u w=2u l=0.13u
X1926 sar_ctrl_async_phys_0.sg13g2_a22oi_1_5.Y sar_ctrl_async_phys_0.sg13g2_buf_1_25.A a_30671_33292# VSS.t1241 sg13_lv_nmos ad=0.2664p pd=1.46u as=0.13875p ps=1.115u w=0.74u l=0.13u
X1927 a_32980_45759# a_33211_45868# a_32666_45969# VSS.t1113 sg13_lv_nmos ad=0.2373p pd=1.97u as=79.8f ps=0.8u w=0.42u l=0.13u
X1928 oa_sar8_acore18_opt_0.sw_tg_opt_1.bot.t3 oa_sar8_acore18_opt_0.sw_bitcell_opt_b5_1.bot.t21 cap_cmim l=2.14u w=2.14u
X1929 a_28680_40460# sar_ctrl_async_phys_0.sg13g2_nor4_1_0.C a_28578_40460# VDD.t311 sg13_lv_pmos ad=0.2128p pd=1.5u as=0.2128p ps=1.5u w=1.12u l=0.13u
X1930 VDD.t182 VSS.t1036 VDD.t182 VDD.t39 sg13_lv_pmos ad=0.19p pd=1.38u as=0 ps=0 w=1u l=1u
X1931 oa_sar8_acore18_opt_0.sw_bitcell_opt_b1_0.bot.t0 sar_ctrl_async_phys_0.dac_code[1] oa_sar8_acore18_opt_0.sw_bitcell_opt_term_0.VSS VSS.t282 sg13_lv_nmos ad=0.3315p pd=2.09u as=0.595p ps=4.1u w=1.7u l=0.13u
X1932 VDD.t56 sar_ctrl_async_phys_0.sg13g2_buf_1_2.X.t3 a_29786_33873# VDD.t54 sg13_lv_pmos ad=0.1563p pd=1.22u as=0.147p ps=1.54u w=0.42u l=0.13u
X1933 sar_ctrl_async_phys_0.sg13g2_nand2_1_2.Y sar_ctrl_async_phys_0.sg13g2_nand2_1_2.A VDD.t389 VDD.t0 sg13_lv_pmos ad=0.2128p pd=1.5u as=0.3808p ps=2.92u w=1.12u l=0.13u
X1934 sar_ctrl_async_phys_0.sg13g2_dfrbpq_1_2.Q a_33754_37436# VDD.t500 VDD.t13 sg13_lv_pmos ad=0.3808p pd=2.92u as=0.2128p ps=1.5u w=1.12u l=0.13u
X1935 oa_sar8_acore18_opt_0.sw_tg_opt_0.bot.t3 oa_sar8_acore18_opt_0.sw_bitcell_opt_b4_0.bot.t32 cap_cmim l=2.14u w=2.14u
X1936 VSS.t98 sar_ctrl_async_phys_0.sg13g2_buf_1_7.A a_33464_31388# VSS.t14 sg13_lv_nmos ad=0.14875p pd=1.16u as=0.187p ps=1.78u w=0.55u l=0.13u
X1937 sar_ctrl_async_phys_0.sg13g2_buf_1_2.X a_35384_32176# VSS.t9 VSS.t158 sg13_lv_nmos ad=0.2886p pd=2.26u as=0.14875p ps=1.16u w=0.74u l=0.13u
X1938 a_34132_34416# a_34651_34423# a_35391_34773# VSS.t199 sg13_lv_nmos ad=0.3473p pd=2.71u as=0.12665p ps=1.145u w=0.74u l=0.13u
X1939 oa_sar8_acore18_opt_0.sw_tg_opt_1.bot.t3 oa_sar8_acore18_opt_0.sw_bitcell_opt_b7_1.bot.t73 cap_cmim l=2.14u w=2.14u
X1940 a_30830_35166# sar_ctrl_async_phys_0.sg13g2_buf_1_0.A a_30733_35460# VDD.t37 sg13_lv_pmos ad=0.2225p pd=1.445u as=0.3325p ps=1.665u w=1u l=0.13u
X1941 VDD.t128 VSS.t677 VDD.t76 VDD.t29 sg13_lv_pmos ad=0.34p pd=2.68u as=0 ps=0 w=1u l=1u
X1942 sar_ctrl_async_phys_0.sg13g2_a21oi_1_2.B1 a_31450_40460# VSS.t293 VSS.t44 sg13_lv_nmos ad=0.2516p pd=2.16u as=0.1406p ps=1.12u w=0.74u l=0.13u
X1943 oa_sar8_acore18_opt_0.sw_tg_opt_0.bot.t3 oa_sar8_acore18_opt_0.sw_bitcell_opt_b2_0.bot.t2 cap_cmim l=2.14u w=2.14u
X1944 VSS.t137 VDD.t135 VSS.t137 VSS.t806 sg13_lv_nmos ad=0.1428p pd=1.52u as=0 ps=0 w=0.42u l=1u
X1945 oa_sar8_acore18_opt_0.sw_tg_opt_0.bot.t2 oa_sar8_acore18_opt_0.sw_bitcell_opt_b7_0.bot.t149 cap_cmim l=2.14u w=2.14u
X1946 oa_sar8_acore18_opt_0.sw_tg_opt_0.bot.t3 oa_sar8_acore18_opt_0.sw_bitcell_opt_b7_0.bot.t78 cap_cmim l=2.14u w=2.14u
X1947 VSS.t1003 VDD.t119 VSS.t1008 VSS.t17 sg13_lv_nmos ad=79.8f pd=0.8u as=0 ps=0 w=0.42u l=1u
X1948 a_29620_43488# a_30139_43495# a_30879_43845# VSS.t301 sg13_lv_nmos ad=0.3473p pd=2.71u as=0.12665p ps=1.145u w=0.74u l=0.13u
X1949 sar_ctrl_async_phys_0.dac_code[1] a_34520_42760# VSS.t123 VSS.t122 sg13_lv_nmos ad=0.2886p pd=2.26u as=0.14875p ps=1.16u w=0.74u l=0.13u
X1950 VSS.t172 a_33087_37797# a_33754_37436# VSS.t118 sg13_lv_nmos ad=0.1406p pd=1.12u as=0.2516p ps=2.16u w=0.74u l=0.13u
X1951 a_26184_21025# sar_ctrl_async_phys_0.cmp_fire VDD.t841 VDD.t840 sg13_lv_pmos ad=0.7p pd=4.7u as=0.7p ps=4.7u w=2u l=0.13u
X1952 oa_sar8_acore18_opt_0.sw_bitcell_opt_b7_1.VSS sar_ctrl_async_phys_0.dac_code_n[3] oa_sar8_acore18_opt_0.sw_bitcell_opt_b3_1.bot.t0 VSS.t389 sg13_lv_nmos ad=0.735p pd=4.9u as=0.4095p ps=2.49u w=2.1u l=0.13u
X1953 VDD.t62 VSS.t1008 VDD.t61 VDD.t39 sg13_lv_pmos ad=0.19p pd=1.38u as=0 ps=0 w=1u l=1u
X1954 VSS.t22 VDD.t169 VSS.t22 VSS.t745 sg13_lv_nmos ad=0.1428p pd=1.52u as=0 ps=0 w=0.42u l=1u
X1955 a_26570_42690# sar_ctrl_async_phys_0.sg13g2_inv_1_9.Y VDD.t132 VDD.t0 sg13_lv_pmos ad=0.1428p pd=1.52u as=0.1523p ps=1.38u w=0.42u l=0.13u
X1956 oa_sar8_acore18_opt_0.sw_bitcell_opt_term_0.trkb.t1 oa_sar8_acore18_opt_0.sw_bitcell_opt_term_0.trkb.t0 VSS.t239 VDD.t713 sg13_lv_pmos ad=0.39p pd=2.39u as=0.7p ps=4.7u w=2u l=0.13u
X1957 VSS.t20 a_33632_40702# a_33281_40821# VSS.t507 sg13_lv_nmos ad=79.8f pd=0.8u as=0.1428p ps=1.52u w=0.42u l=0.13u
X1958 oa_sar8_acore18_opt_0.sw_tg_opt_1.bot.t2 oa_sar8_acore18_opt_0.sw_bitcell_opt_b7_1.bot.t162 cap_cmim l=2.14u w=2.14u
X1959 VDD.t197 sar_ctrl_async_phys_0.sg13g2_buf_1_16.A a_34424_35200# VDD.t37 sg13_lv_pmos ad=0.2114p pd=1.54u as=0.2856p ps=2.36u w=0.84u l=0.13u
X1960 VSS.t677 VDD.t101 VSS.t677 VSS.t678 sg13_lv_nmos ad=79.8f pd=0.8u as=0 ps=0 w=0.42u l=1u
X1961 VSS.t33 sar_ctrl_async_phys_0.sg13g2_o21ai_1_1.B1 a_29332_40898# VSS.t32 sg13_lv_nmos ad=0.1626p pd=1.415u as=60.89999f ps=0.71u w=0.42u l=0.13u
X1962 a_31252_46933# a_30964_46512# a_31190_46933# VSS.t1242 sg13_lv_nmos ad=0.1428p pd=1.52u as=37.8f ps=0.6u w=0.42u l=0.13u
X1963 sar_ctrl_async_phys_0.sg13g2_nand2_1_3.Y sar_ctrl_async_phys_0.sg13g2_nand2_1_3.A a_35402_42726# VSS.t651 sg13_lv_nmos ad=0.2516p pd=2.16u as=0.1406p ps=1.12u w=0.74u l=0.13u
X1964 sar_ctrl_async_phys_0.bit_active[6] a_34904_38948# VDD.t350 VDD.t162 sg13_lv_pmos ad=0.42p pd=2.99u as=0.2114p ps=1.54u w=1.12u l=0.13u
X1965 VDD.t471 sar_ctrl_async_phys_0.sg13g2_dlygate4sd3_1_1.X a_28368_36877# VDD.t13 sg13_lv_pmos ad=0.2856p pd=2.36u as=0.1596p ps=1.22u w=0.84u l=0.13u
X1966 VSS.t9 sar_ctrl_async_phys_0.sg13g2_a21oi_1_1.Y a_34590_32120# VSS.t8 sg13_lv_nmos ad=0.2516p pd=2.16u as=96.2f ps=1u w=0.74u l=0.13u
X1967 sar_ctrl_async_phys_0.sg13g2_buf_1_0.A a_33658_35460# VDD.t42 VDD.t37 sg13_lv_pmos ad=0.3808p pd=2.92u as=0.2128p ps=1.5u w=1.12u l=0.13u
X1968 VDD.t12 VSS.t72 VDD.t10 VDD.t5 sg13_lv_pmos ad=0.19p pd=1.38u as=0 ps=0 w=1u l=1u
X1969 VSS.t850 VDD.t196 VSS.t851 VSS.t89 sg13_lv_nmos ad=79.8f pd=0.8u as=0 ps=0 w=0.42u l=1u
X1970 a_29701_36874# sar_ctrl_async_phys_0.sg13g2_nor2_1_7.A VDD.t14 VDD.t13 sg13_lv_pmos ad=0.2856p pd=2.36u as=0.2198p ps=1.53u w=0.84u l=0.13u
X1971 VDD.t44 VSS.t1066 VDD.t43 VDD.t39 sg13_lv_pmos ad=0.19p pd=1.38u as=0 ps=0 w=1u l=1u
X1972 VSS.t977 VDD.t242 VSS.t976 VSS.t975 sg13_lv_nmos ad=0.1428p pd=1.52u as=0 ps=0 w=0.42u l=1u
X1973 a_34453_35935# sar_ctrl_async_phys_0.sg13g2_dfrbpq_1_0.CLK.t10 VDD.t37 VDD.t37 sg13_lv_pmos ad=0.4088p pd=2.97u as=1.66112p ps=10.725u w=1.12u l=0.13u
X1974 a_32918_45759# sar_ctrl_async_phys_0.sg13g2_o21ai_1_1.B1 VSS.t22 VSS.t23 sg13_lv_nmos ad=37.8f pd=0.6u as=0.1701p ps=1.65u w=0.42u l=0.13u
X1975 oa_sar8_acore18_opt_0.sw_tg_opt_1.bot.t3 oa_sar8_acore18_opt_0.sw_bitcell_opt_b7_1.bot.t57 cap_cmim l=2.14u w=2.14u
X1976 VDD.t40 sar_ctrl_async_phys_0.sg13g2_buf_1_8.A a_33080_31388# VDD.t39 sg13_lv_pmos ad=0.2114p pd=1.54u as=0.2856p ps=2.36u w=0.84u l=0.13u
X1977 VDD.t14 VSS.t905 VDD.t14 VDD.t13 sg13_lv_pmos ad=0.34p pd=2.68u as=0 ps=0 w=1u l=1u
X1978 VSS.t393 a_34549_34423# a_34651_34423# VSS.t534 sg13_lv_nmos ad=6.27915p pd=40.31u as=0.2516p ps=2.16u w=0.74u l=0.13u
X1979 sar_ctrl_async_phys_0.sg13g2_nand2b_1_2.A_N a_35578_41508# VSS.t260 VSS.t1141 sg13_lv_nmos ad=0.2516p pd=2.16u as=0.1406p ps=1.12u w=0.74u l=0.13u
X1980 VSS.t1008 VDD.t182 VSS.t1008 VSS.t17 sg13_lv_nmos ad=0.1428p pd=1.52u as=0 ps=0 w=0.42u l=1u
X1981 oa_sar8_acore18_opt_0.sw_bitcell_opt_b6_0.bot.t1 sar_ctrl_async_phys_0.dac_code[6].t1 oa_sar8_acore18_opt_0.sw_bitcell_opt_term_0.VSS VSS.t486 sg13_lv_nmos ad=0.585p pd=3.39u as=1.05p ps=6.7u w=3u l=0.13u
X1982 VDD.t950 sar_ctrl_async_phys_0.cmp_n sar_ctrl_async_phys_0.cmp_p VDD.t949 sg13_lv_pmos ad=1.05p pd=6.7u as=0.585p ps=3.39u w=3u l=0.13u
X1983 sar_ctrl_async_phys_0.sg13g2_nor2_1_3.Y sar_ctrl_async_phys_0.sg13g2_nor2_1_3.A VSS.t144 VSS.t1282 sg13_lv_nmos ad=0.1406p pd=1.12u as=0.2516p ps=2.16u w=0.74u l=0.13u
X1984 oa_sar8_acore18_opt_0.sw_tg_opt_1.bot.t3 oa_sar8_acore18_opt_0.sw_bitcell_opt_b6_1.bot.t21 cap_cmim l=2.14u w=2.14u
X1985 oa_sar8_acore18_opt_0.sw_tg_opt_0.bot.t3 oa_sar8_acore18_opt_0.sw_bitcell_opt_b6_0.bot.t42 cap_cmim l=2.14u w=2.14u
X1986 a_30632_22281# sar_ctrl_async_phys_0.cmp_p sar_ctrl_async_phys_0.cmp_n VSS.t251 sg13_lv_nmos ad=0.7p pd=4.7u as=0.39p ps=2.39u w=2u l=0.13u
X1987 oa_sar8_acore18_opt_0.sw_bitcell_opt_term_0.VSS sar_ctrl_async_phys_0.dac_code[7] oa_sar8_acore18_opt_0.sw_bitcell_opt_b7_0.bot.t0 VSS.t121 sg13_lv_nmos ad=1.19p pd=7.5u as=0.663p ps=3.79u w=3.4u l=0.13u
X1988 a_34590_32120# sar_ctrl_async_phys_0.sg13g2_a22oi_1_0.A1.t2 sar_ctrl_async_phys_0.sg13g2_inv_1_2.A VSS.t8 sg13_lv_nmos ad=96.2f pd=1u as=0.2664p ps=1.46u w=0.74u l=0.13u
X1989 VDD.t227 VSS.t1008 VDD.t119 VDD.t118 sg13_lv_pmos ad=0.34p pd=2.68u as=0 ps=0 w=1u l=1u
X1990 oa_sar8_acore18_opt_0.sw_tg_opt_1.bot.t3 oa_sar8_acore18_opt_0.sw_bitcell_opt_b6_1.bot.t54 cap_cmim l=2.14u w=2.14u
X1991 VDD.t46 VSS.t889 VDD.t46 VDD.t37 sg13_lv_pmos ad=0.19p pd=1.38u as=0 ps=0 w=1u l=1u
X1992 VSS.t25 a_34208_45966# a_33857_45823# VSS.t1196 sg13_lv_nmos ad=79.8f pd=0.8u as=0.1428p ps=1.52u w=0.42u l=0.13u
X1993 VDD.t366 sar_ctrl_async_phys_0.sg13g2_a21oi_1_6.A2 a_33085_43832# VDD.t0 sg13_lv_pmos ad=0.1918p pd=1.5u as=0.1596p ps=1.22u w=0.84u l=0.13u
X1994 a_29258_36642# sar_ctrl_async_phys_0.sg13g2_dlygate4sd3_1_0.X VSS.t84 VSS.t574 sg13_lv_nmos ad=0.1428p pd=1.52u as=79.8f ps=0.8u w=0.42u l=0.13u
X1995 VDD.t89 VSS.t724 VDD.t70 VDD.t69 sg13_lv_pmos ad=0.34p pd=2.68u as=0 ps=0 w=1u l=1u
X1996 VDD.t339 sar_ctrl_async_phys_0.sg13g2_nand3_1_0.A a_26184_39702# VDD.t311 sg13_lv_pmos ad=0.1523p pd=1.38u as=0.1428p ps=1.52u w=0.42u l=0.13u
X1997 VDD.t120 VSS.t677 VDD.t120 VDD.t15 sg13_lv_pmos ad=0.34p pd=2.68u as=0 ps=0 w=1u l=1u
X1998 VDD.t485 a_31136_43726# a_31081_43607# VDD.t0 sg13_lv_pmos ad=2.48357p pd=16.205u as=93.45f ps=0.865u w=0.42u l=0.13u
X1999 a_30484_39698# sar_ctrl_async_phys_0.sg13g2_dfrbpq_1_22.D a_30390_39698# VSS.t195 sg13_lv_nmos ad=60.89999f pd=0.71u as=0.1428p ps=1.52u w=0.42u l=0.13u
X2000 a_26728_37416# sar_ctrl_async_phys_0.sg13g2_nor2_1_3.A VDD.t191 VDD.t13 sg13_lv_pmos ad=0.2128p pd=1.5u as=0.3808p ps=2.92u w=1.12u l=0.15u
X2001 a_31644_36638# sar_ctrl_async_phys_0.sg13g2_buf_1_13.A VDD.t14 VDD.t13 sg13_lv_pmos ad=0.2856p pd=2.36u as=0.2114p ps=1.54u w=0.84u l=0.13u
X2002 oa_sar8_acore18_opt_0.sw_tg_opt_0.bot.t3 oa_sar8_acore18_opt_0.sw_bitcell_opt_b7_0.bot.t120 cap_cmim l=2.14u w=2.14u
X2003 sar_ctrl_async_phys_0.sg13g2_nand2_1_3.B a_32986_44532# VDD.t401 VDD.t69 sg13_lv_pmos ad=0.3808p pd=2.92u as=0.2128p ps=1.5u w=1.12u l=0.13u
X2004 oa_sar8_acore18_opt_0.sw_tg_opt_0.bot.t3 oa_sar8_acore18_opt_0.sw_bitcell_opt_b3_0.bot.t12 cap_cmim l=2.14u w=2.14u
X2005 result[1] a_33464_30664# VDD.t489 VDD.t39 sg13_lv_pmos ad=0.42p pd=2.99u as=0.2114p ps=1.54u w=1.12u l=0.13u
X2006 VSS.t75 sar_ctrl_async_phys_0.sg13g2_buf_1_44.A a_36056_46508# VSS.t91 sg13_lv_nmos ad=0.14875p pd=1.16u as=0.187p ps=1.78u w=0.55u l=0.13u
X2007 a_25896_39706# sar_ctrl_async_phys_0.sg13g2_and2_1_2.X a_25794_39706# VSS.t89 sg13_lv_nmos ad=0.1406p pd=1.12u as=0.1406p ps=1.12u w=0.74u l=0.13u
X2008 VSS.t111 sar_ctrl_async_phys_0.sg13g2_buf_1_13.X a_29862_36682# VSS.t110 sg13_lv_nmos ad=0.18575p pd=1.26u as=0.1406p ps=1.12u w=0.74u l=0.13u
X2009 oa_sar8_acore18_opt_0.sw_tg_opt_1.bot.t3 oa_sar8_acore18_opt_0.sw_bitcell_opt_b4_1.bot.t15 cap_cmim l=2.14u w=2.14u
X2010 VSS.t764 VDD.t70 VSS.t765 VSS.t185 sg13_lv_nmos ad=79.8f pd=0.8u as=0 ps=0 w=0.42u l=1u
X2011 a_26270_39215# a_26385_39214# VSS.t237 VSS.t89 sg13_lv_nmos ad=0.1428p pd=1.52u as=0.1426p ps=1.16u w=0.42u l=0.5u
X2012 sar_ctrl_async_phys_0.sg13g2_inv_1_5.A sar_ctrl_async_phys_0.sg13g2_buf_1_5.A a_31247_33292# VSS.t6 sg13_lv_nmos ad=0.2664p pd=1.46u as=0.13875p ps=1.115u w=0.74u l=0.13u
X2013 sar_ctrl_async_phys_0.sg13g2_nor2_1_10.Y sar_ctrl_async_phys_0.sg13g2_nor2_1_6.A VSS.t52 VSS.t380 sg13_lv_nmos ad=0.1406p pd=1.12u as=0.2516p ps=2.16u w=0.74u l=0.13u
X2014 VSS.t129 VDD.t22 VSS.t129 VSS.t61 sg13_lv_nmos ad=79.8f pd=0.8u as=0 ps=0 w=0.42u l=1u
X2015 VSS.t271 sar_ctrl_async_phys_0.sg13g2_a22oi_1_0.B2 a_33464_30664# VSS.t1259 sg13_lv_nmos ad=0.14875p pd=1.16u as=0.187p ps=1.78u w=0.55u l=0.13u
X2016 VDD.t354 VSS.t144 VDD.t351 VDD.t162 sg13_lv_pmos ad=0.34p pd=2.68u as=0 ps=0 w=1u l=1u
X2017 oa_sar8_acore18_opt_0.sw_tg_opt_1.bot.t3 oa_sar8_acore18_opt_0.sw_bitcell_opt_b4_1.bot.t29 cap_cmim l=2.14u w=2.14u
X2018 sar_ctrl_async_phys_0.sg13g2_nand2b_1_0.Y a_28651_39740# a_28853_39702# VSS.t89 sg13_lv_nmos ad=0.333p pd=2.38u as=0.1406p ps=1.12u w=0.74u l=0.13u
X2019 oa_sar8_acore18_opt_0.sw_bitcell_opt_b4_0.bot.t0 oa_sar8_acore18_opt_0.sw_bitcell_opt_term_0.trkb.t18 oa_sar8_acore18_opt_0.sw_bitcell_opt_term_0.vin VDD.t512 sg13_lv_pmos ad=0.39p pd=2.39u as=0.7p ps=4.7u w=2u l=0.13u
X2020 VDD.t325 a_35168_41430# a_35113_41525# VDD.t5 sg13_lv_pmos ad=3.62845p pd=23.965u as=93.45f ps=0.865u w=0.42u l=0.13u
X2021 oa_sar8_acore18_opt_0.sw_bitcell_opt_b4_1.bot.t0 sar_ctrl_async_phys_0.dac_code_n[4] oa_sar8_acore18_opt_0.sw_bitcell_opt_b7_1.VSS VSS.t614 sg13_lv_nmos ad=0.468p pd=2.79u as=0.84p ps=5.5u w=2.4u l=0.13u
X2022 oa_sar8_acore18_opt_0.sw_tg_opt_0.bot.t3 oa_sar8_acore18_opt_0.sw_bitcell_opt_b5_0.bot.t25 cap_cmim l=2.14u w=2.14u
X2023 oa_sar8_acore18_opt_0.sw_tg_opt_1.bot.t3 oa_sar8_acore18_opt_0.sw_bitcell_opt_b7_1.bot.t110 cap_cmim l=2.14u w=2.14u
X2024 sar_ctrl_async_phys_0.sg13g2_dlygate4sd3_1_7.X a_26566_41996# VDD.t8 VDD.t5 sg13_lv_pmos ad=0.4256p pd=3u as=0.2254p ps=1.53u w=1.12u l=0.13u
X2025 VDD.t22 VSS.t129 VDD.t22 VDD.t15 sg13_lv_pmos ad=0.34p pd=2.68u as=0 ps=0 w=1u l=1u
X2026 oa_sar8_acore18_opt_0.sw_tg_opt_0.bot.t3 oa_sar8_acore18_opt_0.sw_bitcell_opt_b6_0.bot.t75 cap_cmim l=2.14u w=2.14u
X2027 oa_sar8_acore18_opt_0.sw_tg_opt_1.bot.t3 oa_sar8_acore18_opt_0.sw_bitcell_opt_b7_1.bot.t47 cap_cmim l=2.14u w=2.14u
X2028 a_29562_39996# sar_ctrl_async_phys_0.sg13g2_nor2_1_6.A VDD.t312 VDD.t311 sg13_lv_pmos ad=0.1176p pd=1.33u as=0.4032p ps=2.96u w=1.12u l=0.13u
X2029 sar_ctrl_async_phys_0.sg13g2_inv_1_9.Y track VSS.t58 VSS.t1201 sg13_lv_nmos ad=0.2516p pd=2.16u as=0.2516p ps=2.16u w=0.74u l=0.13u
X2030 a_26954_40424# sar_ctrl_async_phys_0.sg13g2_dlygate4sd3_1_8.A VDD.t363 VDD.t311 sg13_lv_pmos ad=0.1428p pd=1.52u as=0.1523p ps=1.38u w=0.42u l=0.13u
X2031 VSS.t777 VDD.t100 VSS.t777 VSS.t185 sg13_lv_nmos ad=0.1428p pd=1.52u as=0 ps=0 w=0.42u l=1u
X2032 VSS.t72 a_26454_41972# a_26566_41996# VSS.t1199 sg13_lv_nmos ad=0.1426p pd=1.16u as=0.1428p ps=1.52u w=0.42u l=0.5u
X2033 VDD.t79 VSS.t778 VDD.t79 VDD.t69 sg13_lv_pmos ad=0.34p pd=2.68u as=0 ps=0 w=1u l=1u
X2034 VDD.t312 a_28651_39740# sar_ctrl_async_phys_0.sg13g2_nand2b_1_0.Y VDD.t311 sg13_lv_pmos ad=0.3808p pd=2.92u as=0.2128p ps=1.5u w=1.12u l=0.13u
X2035 VDD.t38 VSS.t926 VDD.t192 VDD.t37 sg13_lv_pmos ad=0.34p pd=2.68u as=0 ps=0 w=1u l=1u
X2036 VSS.t154 VDD.t163 VSS.t154 VSS.t870 sg13_lv_nmos ad=79.8f pd=0.8u as=0 ps=0 w=0.42u l=1u
X2037 a_30772_31392# a_30746_31356# VSS.t343 VSS.t342 sg13_lv_nmos ad=0.2516p pd=2.16u as=0.1626p ps=1.415u w=0.74u l=0.13u
X2038 VDD.t37 a_31935_36285# a_32192_36166# VDD.t37 sg13_lv_pmos ad=1.79957p pd=11.62u as=79.8f ps=0.8u w=0.42u l=0.13u
X2039 a_32576_44454# sar_ctrl_async_phys_0.sg13g2_dfrbpq_1_9.RESET_B VDD.t346 VDD.t69 sg13_lv_pmos ad=79.8f pd=0.8u as=1.79957p ps=11.62u w=0.42u l=0.13u
X2040 oa_sar8_acore18_opt_0.sw_tg_opt_1.bot.t3 oa_sar8_acore18_opt_0.sw_bitcell_opt_b7_1.bot.t106 cap_cmim l=2.14u w=2.14u
X2041 VDD.t238 VSS.t920 VDD.t54 VDD.t54 sg13_lv_pmos ad=0.19p pd=1.38u as=0 ps=0 w=1u l=1u
X2042 VSS.t1049 VDD.t62 VSS.t1051 VSS.t1050 sg13_lv_nmos ad=79.8f pd=0.8u as=0 ps=0 w=0.42u l=1u
X2043 a_32450_31826# sar_ctrl_async_phys_0.sg13g2_buf_1_2.X VSS.t98 VSS.t236 sg13_lv_nmos ad=37.8f pd=0.6u as=79.8f ps=0.8u w=0.42u l=0.13u
X2044 a_34261_36653# sar_ctrl_async_phys_0.sg13g2_dfrbpq_1_0.CLK.t13 VSS.t193 VSS.t192 sg13_lv_nmos ad=0.2516p pd=2.16u as=4.1082p ps=26.51u w=0.74u l=0.13u
X2045 oa_sar8_acore18_opt_0.sw_tg_opt_0.bot.t3 oa_sar8_acore18_opt_0.sw_bitcell_opt_b7_0.bot.t94 cap_cmim l=2.14u w=2.14u
X2046 oa_sar8_acore18_opt_0.sw_tg_opt_1.bot.t3 oa_sar8_acore18_opt_0.sw_bitcell_opt_b3_1.bot.t2 cap_cmim l=2.14u w=2.14u
X2047 oa_sar8_acore18_opt_0.sw_tg_opt_1.bot.t3 oa_sar8_acore18_opt_0.sw_bitcell_opt_b6_1.bot.t61 cap_cmim l=2.14u w=2.14u
X2048 result[5] a_34136_33688# VDD.t371 VDD.t54 sg13_lv_pmos ad=0.42p pd=2.99u as=0.2114p ps=1.54u w=1.12u l=0.13u
X2049 a_32319_44311# a_31477_44213# a_32225_44311# VSS.t79 sg13_lv_nmos ad=0.12665p pd=1.145u as=0.1428p ps=1.52u w=0.42u l=0.13u
X2050 VDD.t14 a_31644_36638# sar_ctrl_async_phys_0.sg13g2_buf_1_13.X.t0 VDD.t13 sg13_lv_pmos ad=0.2114p pd=1.54u as=0.42p ps=2.99u w=1.12u l=0.13u
X2051 a_35166_32120# sar_ctrl_async_phys_0.sg13g2_a22oi_1_0.A1.t1 sar_ctrl_async_phys_0.sg13g2_a22oi_1_0.Y VSS.t415 sg13_lv_nmos ad=96.2f pd=1u as=0.2664p ps=1.46u w=0.74u l=0.13u
X2052 oa_sar8_acore18_opt_0.sw_tg_opt_1.bot.t4 oa_sar8_acore18_opt_0.sw_bitcell_opt_b7_1.bot.t4 cap_cmim l=2.14u w=2.14u
X2053 VDD.t182 VSS.t1041 VDD.t182 VDD.t39 sg13_lv_pmos ad=0.19p pd=1.38u as=0 ps=0 w=1u l=1u
X2054 VSS.t677 VDD.t128 VSS.t677 VSS.t706 sg13_lv_nmos ad=0.1428p pd=1.52u as=0 ps=0 w=0.42u l=1u
X2055 oa_sar8_acore18_opt_0.sw_tg_opt_0.bot.t3 oa_sar8_acore18_opt_0.sw_bitcell_opt_b4_0.bot.t10 cap_cmim l=2.14u w=2.14u
X2056 sar_ctrl_async_phys_0.sg13g2_dfrbpq_1_9.D sar_ctrl_async_phys_0.sg13g2_a22oi_1_1.A2 a_31194_44996# VDD.t69 sg13_lv_pmos ad=0.3808p pd=2.92u as=0.1176p ps=1.33u w=1.12u l=0.13u
X2057 a_30752_39190# sar_ctrl_async_phys_0.sg13g2_o21ai_1_1.B1 VDD.t315 VDD.t162 sg13_lv_pmos ad=79.8f pd=0.8u as=3.62845p ps=23.965u w=0.42u l=0.13u
X2058 a_34615_31475# a_34767_31359# VSS.t125 VSS.t1273 sg13_lv_nmos ad=0.2516p pd=2.16u as=4.0265p ps=25.31u w=0.74u l=0.13u
X2059 oa_sar8_acore18_opt_0.sw_bitcell_opt_b5_1.bot.t0 sar_ctrl_async_phys_0.dac_code_n[5] oa_sar8_acore18_opt_0.sw_bitcell_opt_b7_1.VSS VSS.t1225 sg13_lv_nmos ad=0.5265p pd=3.09u as=0.945p ps=6.1u w=2.7u l=0.13u
X2060 VSS.t11 sar_ctrl_async_phys_0.sg13g2_buf_1_25.A a_34136_33688# VSS.t1240 sg13_lv_nmos ad=0.14875p pd=1.16u as=0.187p ps=1.78u w=0.55u l=0.13u
X2061 sar_ctrl_async_phys_0.sg13g2_dlygate4sd3_1_0.X a_28870_35948# VDD.t38 VDD.t37 sg13_lv_pmos ad=0.4256p pd=3u as=0.2254p ps=1.53u w=1.12u l=0.13u
X2062 a_33652_41528# a_33626_41433# VDD.t209 VDD.t5 sg13_lv_pmos ad=0.34p pd=2.68u as=0.36237p ps=2.605u w=1u l=0.13u
X2063 sar_ctrl_async_phys_0.sg13g2_inv_1_0.A sar_ctrl_async_phys_0.sg13g2_buf_1_7.A a_33359_33292# VSS.t6 sg13_lv_nmos ad=0.2664p pd=1.46u as=0.13875p ps=1.115u w=0.74u l=0.13u
X2064 VDD.t56 VSS.t115 VDD.t56 VDD.t54 sg13_lv_pmos ad=0.19p pd=1.38u as=0 ps=0 w=1u l=1u
X2065 a_34324_36349# a_34036_35928# a_34262_36349# VSS.t576 sg13_lv_nmos ad=0.1428p pd=1.52u as=37.8f ps=0.6u w=0.42u l=0.13u
X2066 a_32149_45007# sar_ctrl_async_phys_0.sg13g2_dfrbpq_1_0.CLK VSS.t515 VSS.t516 sg13_lv_nmos ad=0.2516p pd=2.16u as=5.02618p ps=31.995u w=0.74u l=0.13u
X2067 a_33782_39711# sar_ctrl_async_phys_0.sg13g2_o21ai_1_1.B1 VSS.t56 VSS.t55 sg13_lv_nmos ad=37.8f pd=0.6u as=0.1701p ps=1.65u w=0.42u l=0.13u
X2068 a_29210_38916# a_29653_38959# a_29593_38995# VDD.t162 sg13_lv_pmos ad=79.8f pd=0.8u as=63f ps=0.72u w=0.42u l=0.13u
X2069 oa_sar8_acore18_opt_0.sw_tg_opt_1.bot.t2 oa_sar8_acore18_opt_0.sw_bitcell_opt_b7_1.bot.t148 cap_cmim l=2.14u w=2.14u
X2070 oa_sar8_acore18_opt_0.sw_bitcell_opt_b1_0.bot.t0 oa_sar8_acore18_opt_0.sw_bitcell_opt_term_0.trkb.t15 oa_sar8_acore18_opt_0.sw_bitcell_opt_term_0.vin VDD.t617 sg13_lv_pmos ad=0.39p pd=2.39u as=0.7p ps=4.7u w=2u l=0.13u
X2071 a_32020_35175# a_31732_35480# a_31958_35175# VSS.t269 sg13_lv_nmos ad=0.1428p pd=1.52u as=37.8f ps=0.6u w=0.42u l=0.13u
X2072 a_31252_46933# a_31483_46519# a_30938_46476# VSS.t1158 sg13_lv_nmos ad=0.2373p pd=1.97u as=79.8f ps=0.8u w=0.42u l=0.13u
X2073 VSS.t62 sar_ctrl_async_phys_0.sg13g2_a21oi_1_0.B1 a_34520_46508# VSS.t91 sg13_lv_nmos ad=0.14875p pd=1.16u as=0.187p ps=1.78u w=0.55u l=0.13u
X2074 sar_ctrl_async_phys_0.sg13g2_nor2_1_11.Y sar_ctrl_async_phys_0.sg13g2_a22oi_1_5.A2 a_30714_43020# VDD.t0 sg13_lv_pmos ad=0.3808p pd=2.92u as=0.1176p ps=1.33u w=1.12u l=0.13u
X2075 oa_sar8_acore18_opt_0.sw_bitcell_opt_b3_0.bot.t0 oa_sar8_acore18_opt_0.sw_bitcell_opt_term_0.trkb.t17 oa_sar8_acore18_opt_0.sw_bitcell_opt_term_0.vin VDD.t511 sg13_lv_pmos ad=0.39p pd=2.39u as=0.7p ps=4.7u w=2u l=0.13u
X2076 oa_sar8_acore18_opt_0.sw_bitcell_opt_term_0.vin oa_sar8_acore18_opt_0.sw_bitcell_opt_term_0.trkb.t20 oa_sar8_acore18_opt_0.sw_bitcell_opt_b6_0.bot.t1 VDD.t969 sg13_lv_pmos ad=0.7p pd=4.7u as=0.39p ps=2.39u w=2u l=0.13u
X2077 sar_ctrl_async_phys_0.dac_code_n[0] a_34904_47296# VSS.t62 VSS.t61 sg13_lv_nmos ad=0.2886p pd=2.26u as=0.14875p ps=1.16u w=0.74u l=0.13u
X2078 a_30678_46946# sar_ctrl_async_phys_0.sg13g2_nor2b_1_4.Y VDD.t114 VDD.t29 sg13_lv_pmos ad=79.8f pd=0.8u as=0.1428p ps=1.52u w=0.42u l=0.13u
X2079 sar_ctrl_async_phys_0.sg13g2_nor2_1_1.Y sar_ctrl_async_phys_0.sg13g2_nor2_1_1.A VSS.t172 VSS.t87 sg13_lv_nmos ad=0.1406p pd=1.12u as=0.2516p ps=2.16u w=0.74u l=0.13u
X2080 a_30100_33663# a_30331_33772# a_29786_33873# VSS.t226 sg13_lv_nmos ad=0.2373p pd=1.97u as=79.8f ps=0.8u w=0.42u l=0.13u
X2081 a_25596_47222# sar_ctrl_async_phys_0.sg13g2_buf_1_29.A VSS.t672 VSS.t1249 sg13_lv_nmos ad=0.187p pd=1.78u as=0.14875p ps=1.16u w=0.55u l=0.13u
X2082 VDD.t351 a_26270_39215# sar_ctrl_async_phys_0.sg13g2_dlygate4sd3_1_5.A VDD.t162 sg13_lv_pmos ad=0.2254p pd=1.53u as=0.4256p ps=3u w=1.12u l=0.13u
X2083 VSS.t432 a_26666_38912# a_26385_39214# VSS.t89 sg13_lv_nmos ad=79.8f pd=0.8u as=0.1428p ps=1.52u w=0.42u l=0.5u
X2084 oa_sar8_acore18_opt_0.sw_tg_opt_1.bot.t3 oa_sar8_acore18_opt_0.sw_bitcell_opt_b5_1.bot.t14 cap_cmim l=2.14u w=2.14u
X2085 a_33936_31675# a_34055_31352# VSS.t9 VSS.t14 sg13_lv_nmos ad=0.2516p pd=2.16u as=0.1406p ps=1.12u w=0.74u l=0.13u
X2086 VSS.t562 sar_ctrl_async_phys_0.sg13g2_dlygate4sd3_1_4.X sar_ctrl_async_phys_0.sg13g2_nand3_1_0.C VSS.t89 sg13_lv_nmos ad=0.2516p pd=2.16u as=0.1406p ps=1.12u w=0.74u l=0.13u
X2087 VSS.t832 a_25878_40460# a_25990_40484# VSS.t1288 sg13_lv_nmos ad=0.1426p pd=1.16u as=0.1428p ps=1.52u w=0.42u l=0.5u
X2088 VDD.t361 VSS.t277 VDD.t191 VDD.t13 sg13_lv_pmos ad=0.34p pd=2.68u as=0 ps=0 w=1u l=1u
X2089 a_34036_35928# a_34010_35892# VDD.t42 VDD.t37 sg13_lv_pmos ad=0.34p pd=2.68u as=0.36237p ps=2.605u w=1u l=0.13u
X2090 VDD.t117 sar_ctrl_async_phys_0.sg13g2_dfrbpq_1_9.RESET_B a_31446_45434# VDD.t69 sg13_lv_pmos ad=0.36237p pd=2.605u as=79.8f ps=0.8u w=0.42u l=0.13u
X2091 sar_ctrl_async_phys_0.sg13g2_nor2_1_1.Y sar_ctrl_async_phys_0.sg13g2_a22oi_1_0.A2 a_33882_38484# VDD.t162 sg13_lv_pmos ad=0.3808p pd=2.92u as=0.1176p ps=1.33u w=1.12u l=0.13u
X2092 a_28874_37806# sar_ctrl_async_phys_0.sg13g2_nand2_1_0.B VSS.t154 VSS.t570 sg13_lv_nmos ad=0.1406p pd=1.12u as=0.2516p ps=2.16u w=0.74u l=0.13u
X2093 oa_sar8_acore18_opt_0.sw_tg_opt_0.bot.t3 oa_sar8_acore18_opt_0.sw_bitcell_opt_b7_0.bot.t128 cap_cmim l=2.14u w=2.14u
X2094 VDD.t447 a_35280_35365# sar_ctrl_async_phys_0.sg13g2_nor2b_1_1.B_N VDD.t37 sg13_lv_pmos ad=0.1918p pd=1.5u as=0.3808p ps=2.92u w=1.12u l=0.13u
X2095 sar_ctrl_async_phys_0.sg13g2_buf_1_33.A sar_ctrl_async_phys_0.sg13g2_nand2b_1_2.A_N VDD.t428 VDD.t5 sg13_lv_pmos ad=0.2128p pd=1.5u as=0.3808p ps=2.92u w=1.12u l=0.13u
X2096 oa_sar8_acore18_opt_0.sw_tg_opt_1.bot.t3 oa_sar8_acore18_opt_0.sw_bitcell_opt_b7_1.bot.t141 cap_cmim l=2.14u w=2.14u
X2097 VSS.t113 a_35280_35365# sar_ctrl_async_phys_0.sg13g2_nor2b_1_1.B_N VSS.t203 sg13_lv_nmos ad=0.1331p pd=1.12u as=0.2516p ps=2.16u w=0.74u l=0.13u
X2098 sar_ctrl_async_phys_0.sg13g2_buf_1_13.A a_32602_35924# VSS.t372 VSS.t371 sg13_lv_nmos ad=0.2516p pd=2.16u as=0.1406p ps=1.12u w=0.74u l=0.13u
X2099 a_30486_31826# a_31291_31399# a_30746_31356# VDD.t39 sg13_lv_pmos ad=0.1428p pd=1.52u as=79.8f ps=0.8u w=0.42u l=0.13u
X2100 oa_sar8_acore18_opt_0.sw_tg_opt_1.bot.t3 oa_sar8_acore18_opt_0.sw_bitcell_opt_b5_1.bot.t29 cap_cmim l=2.14u w=2.14u
X2101 a_32687_33292# sar_ctrl_async_phys_0.sg13g2_a22oi_1_0.B1 VSS.t11 VSS.t6 sg13_lv_nmos ad=0.13875p pd=1.115u as=0.2553p ps=2.17u w=0.74u l=0.13u
X2102 a_31034_44457# a_31477_44213# a_30774_44234# VSS.t76 sg13_lv_nmos ad=79.8f pd=0.8u as=0.1296p ps=1.52u w=0.42u l=0.13u
X2103 sar_ctrl_async_phys_0.sg13g2_inv_1_9.Y track VDD.t363 VDD.t311 sg13_lv_pmos ad=0.3808p pd=2.92u as=0.3808p ps=2.92u w=1.12u l=0.13u
X2104 a_34261_36653# sar_ctrl_async_phys_0.sg13g2_dfrbpq_1_0.CLK.t13 VDD.t13 VDD.t13 sg13_lv_pmos ad=0.4088p pd=2.97u as=2.2076p ps=14.4u w=1.12u l=0.13u
X2105 VDD.t169 VSS.t485 VDD.t116 VDD.t29 sg13_lv_pmos ad=0.19p pd=1.38u as=0 ps=0 w=1u l=1u
X2106 oa_sar8_acore18_opt_0.sw_tg_opt_0.bot.t3 oa_sar8_acore18_opt_0.sw_bitcell_opt_b7_0.bot.t94 cap_cmim l=2.14u w=2.14u
X2107 VDD.t338 sar_ctrl_async_phys_0.sg13g2_buf_1_1.A a_35288_33688# VDD.t54 sg13_lv_pmos ad=0.2114p pd=1.54u as=0.2856p ps=2.36u w=0.84u l=0.13u
X2108 VDD.t198 sar_ctrl_async_phys_0.sg13g2_a22oi_1_0.Y sar_ctrl_async_phys_0.sg13g2_inv_1_3.Y VDD.t54 sg13_lv_pmos ad=0.3808p pd=2.92u as=0.3808p ps=2.92u w=1.12u l=0.13u
X2109 VDD.t547 a_34636_31749# a_35659_31435# VDD.t39 sg13_lv_pmos ad=0.1563p pd=1.22u as=63f ps=0.72u w=0.42u l=0.13u
X2110 sar_ctrl_async_phys_0.sg13g2_buf_1_25.A a_31258_32436# VSS.t643 VSS.t1108 sg13_lv_nmos ad=0.2516p pd=2.16u as=0.1406p ps=1.12u w=0.74u l=0.13u
X2111 VSS.t312 sar_ctrl_async_phys_0.sg13g2_dfrbpq_1_9.RESET_B a_29428_43922# VSS.t318 sg13_lv_nmos ad=0.1626p pd=1.415u as=60.89999f ps=0.71u w=0.42u l=0.13u
X2112 sar_ctrl_async_phys_0.sg13g2_a22oi_1_0.A2 sar_ctrl_async_phys_0.sg13g2_a21oi_1_0.B1 VSS.t88 VSS.t118 sg13_lv_nmos ad=0.1406p pd=1.12u as=0.2516p ps=2.16u w=0.74u l=0.13u
X2113 a_33626_41433# a_34069_41189# a_33366_41210# VSS.t264 sg13_lv_nmos ad=79.8f pd=0.8u as=0.1296p ps=1.52u w=0.42u l=0.13u
X2114 VSS.t544 oa_sar8_acore18_opt_0.sw_bitcell_opt_term_0.trkb.t7 a_35028_n9612# VSS.t543 sg13_lv_nmos ad=0.345p pd=2.69u as=0.19p ps=1.38u w=1u l=0.15u
X2115 a_34106_30849# a_34549_30605# a_34489_31017# VDD.t39 sg13_lv_pmos ad=79.8f pd=0.8u as=63f ps=0.72u w=0.42u l=0.13u
X2116 result[7] a_34904_33688# VSS.t350 VSS.t1200 sg13_lv_nmos ad=0.2886p pd=2.26u as=0.14875p ps=1.16u w=0.74u l=0.13u
X2117 a_35725_45266# sar_ctrl_async_phys_0.sg13g2_nand2b_1_7.A_N VSS.t174 VSS.t668 sg13_lv_nmos ad=0.187p pd=1.78u as=0.14505p ps=1.15u w=0.55u l=0.13u
X2118 oa_sar8_acore18_opt_0.sw_tg_opt_1.bot.t3 oa_sar8_acore18_opt_0.sw_bitcell_opt_b7_1.bot.t99 cap_cmim l=2.14u w=2.14u
X2119 VSS.t920 sar_ctrl_async_phys_0.cmp_n a_25496_34412# VSS.t114 sg13_lv_nmos ad=0.14875p pd=1.16u as=0.187p ps=1.78u w=0.55u l=0.13u
X2120 a_35103_36751# a_34261_36653# a_33844_36992# VDD.t13 sg13_lv_pmos ad=0.2048p pd=1.63u as=0.34p ps=2.68u w=1u l=0.13u
X2121 VDD.t485 a_35360_43726# a_35305_43607# VDD.t0 sg13_lv_pmos ad=2.48357p pd=16.205u as=93.45f ps=0.865u w=0.42u l=0.13u
X2122 oa_sar8_acore18_opt_0.sw_tg_opt_1.bot.t3 oa_sar8_acore18_opt_0.sw_bitcell_opt_b7_1.bot.t78 cap_cmim l=2.14u w=2.14u
X2123 VDD.t144 VSS.t773 VDD.t4 VDD.t0 sg13_lv_pmos ad=0.19p pd=1.38u as=0 ps=0 w=1u l=1u
X2124 a_31298_43922# sar_ctrl_async_phys_0.sg13g2_dfrbpq_1_9.RESET_B VSS.t263 VSS.t314 sg13_lv_nmos ad=37.8f pd=0.6u as=79.8f ps=0.8u w=0.42u l=0.13u
X2125 a_32054_37861# sar_ctrl_async_phys_0.sg13g2_buf_1_2.A.t6 VSS.t471 VSS.t472 sg13_lv_nmos ad=37.8f pd=0.6u as=0.1701p ps=1.65u w=0.42u l=0.13u
X2126 oa_sar8_acore18_opt_0.sw_tg_opt_0.bot.t3 oa_sar8_acore18_opt_0.sw_bitcell_opt_b7_0.bot.t110 cap_cmim l=2.14u w=2.14u
X2127 sar_ctrl_async_phys_0.sg13g2_nor2_1_4.Y sar_ctrl_async_phys_0.sg13g2_nor2_1_3.A VSS.t144 VSS.t1284 sg13_lv_nmos ad=0.1406p pd=1.12u as=0.2516p ps=2.16u w=0.74u l=0.13u
X2128 VDD.t68 a_26364_45710# sar_ctrl_async_phys_0.sg13g2_buf_1_29.A VDD.t29 sg13_lv_pmos ad=0.2114p pd=1.54u as=0.42p ps=2.99u w=1.12u l=0.13u
X2129 oa_sar8_acore18_opt_0.sw_tg_opt_1.bot.t3 oa_sar8_acore18_opt_0.sw_bitcell_opt_b5_1.bot.t1 cap_cmim l=2.14u w=2.14u
X2130 a_29236_38952# a_29755_38959# a_30495_39309# VSS.t207 sg13_lv_nmos ad=0.3473p pd=2.71u as=0.12665p ps=1.145u w=0.74u l=0.13u
X2131 a_29276_37436# sar_ctrl_async_phys_0.sg13g2_nor2_1_7.B sar_ctrl_async_phys_0.sg13g2_nor2_1_7.Y VDD.t13 sg13_lv_pmos ad=0.1176p pd=1.33u as=0.3808p ps=2.92u w=1.12u l=0.13u
X2132 a_35664_37695# sar_ctrl_async_phys_0.sg13g2_buf_1_6.A a_35801_37784# VSS.t118 sg13_lv_nmos ad=0.2176p pd=1.96u as=0.1216p ps=1.02u w=0.64u l=0.13u
X2133 VDD.t33 VSS.t129 VDD.t33 VDD.t29 sg13_lv_pmos ad=0.34p pd=2.68u as=0 ps=0 w=1u l=1u
X2134 VDD.t8 a_26454_41972# a_26566_41996# VDD.t5 sg13_lv_pmos ad=0.2254p pd=1.53u as=0.34p ps=2.68u w=1u l=0.5u
X2135 a_35952_39901# sar_ctrl_async_phys_0.sg13g2_a21oi_1_3.A2 VDD.t384 VDD.t311 sg13_lv_pmos ad=0.1596p pd=1.22u as=0.1918p ps=1.5u w=0.84u l=0.13u
X2136 VDD.t56 VSS.t115 VDD.t56 VDD.t54 sg13_lv_pmos ad=0.34p pd=2.68u as=0 ps=0 w=1u l=1u
X2137 a_33460_41210# sar_ctrl_async_phys_0.sg13g2_nor2_1_15.Y a_33366_41210# VSS.t1105 sg13_lv_nmos ad=60.89999f pd=0.71u as=0.1428p ps=1.52u w=0.42u l=0.13u
X2138 sar_ctrl_async_phys_0.dac_code_n[4] a_35672_47296# VDD.t345 VDD.t15 sg13_lv_pmos ad=0.42p pd=2.99u as=0.2114p ps=1.54u w=1.12u l=0.13u
X2139 sar_ctrl_async_phys_0.sg13g2_nor2_1_0.Y sar_ctrl_async_phys_0.sg13g2_a22oi_1_3.A2 a_32442_38484# VDD.t162 sg13_lv_pmos ad=0.3808p pd=2.92u as=0.1176p ps=1.33u w=1.12u l=0.13u
X2140 sar_ctrl_async_phys_0.sg13g2_a22oi_1_1.Y sar_ctrl_async_phys_0.sg13g2_a22oi_1_1.B2 a_31823_33292# VSS.t6 sg13_lv_nmos ad=0.2664p pd=1.46u as=0.13875p ps=1.115u w=0.74u l=0.13u
X2141 a_33183_32215# a_32341_32117# a_31924_32456# VDD.t118 sg13_lv_pmos ad=0.2048p pd=1.63u as=0.34p ps=2.68u w=1u l=0.13u
X2142 VSS.t346 VDD.t366 VSS.t346 VSS.t810 sg13_lv_nmos ad=0.1428p pd=1.52u as=0 ps=0 w=0.42u l=1u
X2143 VSS.t237 sar_ctrl_async_phys_0.sg13g2_nand3_1_0.A a_26184_39702# VSS.t89 sg13_lv_nmos ad=79.8f pd=0.8u as=0.1428p ps=1.52u w=0.42u l=0.13u
X2144 oa_sar8_acore18_opt_0.sw_tg_opt_0.bot.t3 oa_sar8_acore18_opt_0.sw_bitcell_opt_b7_0.bot.t47 cap_cmim l=2.14u w=2.14u
X2145 a_32687_32876# sar_ctrl_async_phys_0.sg13g2_buf_1_9.A sar_ctrl_async_phys_0.sg13g2_inv_1_1.A VDD.t118 sg13_lv_pmos ad=0.2744p pd=1.61u as=0.2128p ps=1.5u w=1.12u l=0.13u
X2146 VSS.t144 sar_ctrl_async_phys_0.sg13g2_nor2_1_3.B sar_ctrl_async_phys_0.sg13g2_nor2_1_3.Y VSS.t512 sg13_lv_nmos ad=0.2516p pd=2.16u as=0.1406p ps=1.12u w=0.74u l=0.13u
X2147 VDD.t79 VSS.t312 VDD.t79 VDD.t69 sg13_lv_pmos ad=0.34p pd=2.68u as=0 ps=0 w=1u l=1u
X2148 VSS.t75 sar_ctrl_async_phys_0.sg13g2_a21oi_1_6.B1 a_35672_47296# VSS.t61 sg13_lv_nmos ad=0.14875p pd=1.16u as=0.187p ps=1.78u w=0.55u l=0.13u
X2149 oa_sar8_acore18_opt_0.sw_tg_opt_0.bot.t3 oa_sar8_acore18_opt_0.sw_bitcell_opt_b6_0.bot.t65 cap_cmim l=2.14u w=2.14u
X2150 VSS.t5 VDD.t197 VSS.t5 VSS.t934 sg13_lv_nmos ad=0.1428p pd=1.52u as=0 ps=0 w=0.42u l=1u
X2151 VSS.t154 sar_ctrl_async_phys_0.sg13g2_nor2_1_6.A sar_ctrl_async_phys_0.sg13g2_nand2_1_0.B VSS.t382 sg13_lv_nmos ad=0.2516p pd=2.16u as=0.1406p ps=1.12u w=0.74u l=0.13u
X2152 oa_sar8_acore18_opt_0.sw_tg_opt_1.bot.t3 oa_sar8_acore18_opt_0.sw_bitcell_opt_b6_1.bot.t21 cap_cmim l=2.14u w=2.14u
X2153 VSS.t834 VDD.t10 VSS.t60 VSS.t835 sg13_lv_nmos ad=79.8f pd=0.8u as=0 ps=0 w=0.42u l=1u
X2154 VSS.t144 sar_ctrl_async_phys_0.sg13g2_nor2_1_3.A a_26630_37814# VSS.t1283 sg13_lv_nmos ad=0.1406p pd=1.12u as=0.2516p ps=2.16u w=0.74u l=0.15u
X2155 VDD.t13 a_35360_36894# a_35305_36989# VDD.t13 sg13_lv_pmos ad=2.48357p pd=16.205u as=93.45f ps=0.865u w=0.42u l=0.13u
X2156 VDD.t56 sar_ctrl_async_phys_0.sg13g2_buf_1_13.X sar_ctrl_async_phys_0.sg13g2_a22oi_1_2.B1 VDD.t54 sg13_lv_pmos ad=0.3808p pd=2.92u as=0.2128p ps=1.5u w=1.12u l=0.13u
X2157 a_33410_35162# sar_ctrl_async_phys_0.sg13g2_buf_1_2.X.t4 VSS.t5 VSS.t228 sg13_lv_nmos ad=37.8f pd=0.6u as=79.8f ps=0.8u w=0.42u l=0.13u
X2158 VDD.t33 sar_ctrl_async_phys_0.sg13g2_o21ai_1_1.B1 a_32666_45969# VDD.t29 sg13_lv_pmos ad=0.1563p pd=1.22u as=0.147p ps=1.54u w=0.42u l=0.13u
X2159 oa_sar8_acore18_opt_0.sw_tg_opt_0.bot.t3 oa_sar8_acore18_opt_0.sw_bitcell_opt_b6_0.bot.t55 cap_cmim l=2.14u w=2.14u
X2160 a_28505_36720# sar_ctrl_async_phys_0.sg13g2_nand2_1_0.B VSS.t277 VSS.t569 sg13_lv_nmos ad=0.1216p pd=1.02u as=0.1331p ps=1.12u w=0.64u l=0.13u
X2161 oa_sar8_acore18_opt_0.sw_tg_opt_1.bot.t3 oa_sar8_acore18_opt_0.sw_bitcell_opt_b7_1.bot.t68 cap_cmim l=2.14u w=2.14u
X2162 a_35810_33338# sar_ctrl_async_phys_0.sg13g2_buf_1_2.X VSS.t148 VSS.t152 sg13_lv_nmos ad=37.8f pd=0.6u as=79.8f ps=0.8u w=0.42u l=0.13u
X2163 VDD.t40 VSS.t1070 VDD.t40 VDD.t39 sg13_lv_pmos ad=0.19p pd=1.38u as=0 ps=0 w=1u l=1u
X2164 VSS.t178 sar_ctrl_async_phys_0.sg13g2_nand2_1_2.B a_35018_42726# VSS.t180 sg13_lv_nmos ad=0.2516p pd=2.16u as=0.1406p ps=1.12u w=0.74u l=0.13u
X2165 VDD.t191 sar_ctrl_async_phys_0.sg13g2_buf_1_13.X sar_ctrl_async_phys_0.sg13g2_nor2_1_3.B VDD.t13 sg13_lv_pmos ad=0.3808p pd=2.92u as=0.2128p ps=1.5u w=1.12u l=0.15u
X2166 VDD.t36 VSS.t346 VDD.t36 VDD.t5 sg13_lv_pmos ad=0.19p pd=1.38u as=0 ps=0 w=1u l=1u
X2167 VDD.t428 a_35772_41936# sar_ctrl_async_phys_0.sg13g2_nand2_1_3.A VDD.t5 sg13_lv_pmos ad=0.2114p pd=1.54u as=0.42p ps=2.99u w=1.12u l=0.13u
X2168 VSS.t72 a_26570_42690# a_26289_42912# VSS.t629 sg13_lv_nmos ad=79.8f pd=0.8u as=0.1428p ps=1.52u w=0.42u l=0.5u
X2169 oa_sar8_acore18_opt_0.sw_tg_opt_1.bot.t3 oa_sar8_acore18_opt_0.sw_bitcell_opt_b7_1.bot.t21 cap_cmim l=2.14u w=2.14u
X2170 a_33654_44234# sar_ctrl_async_phys_0.sg13g2_nor2_1_2.Y VDD.t415 VDD.t69 sg13_lv_pmos ad=79.8f pd=0.8u as=0.1428p ps=1.52u w=0.42u l=0.13u
X2171 a_31830_40898# sar_ctrl_async_phys_0.sg13g2_dfrbpq_1_11.D VDD.t328 VDD.t311 sg13_lv_pmos ad=79.8f pd=0.8u as=0.1428p ps=1.52u w=0.42u l=0.13u
X2172 VDD.t340 a_33440_32358# a_33385_32453# VDD.t118 sg13_lv_pmos ad=1.96315p pd=12.675u as=93.45f ps=0.865u w=0.42u l=0.13u
X2173 sar_ctrl_async_phys_0.sg13g2_a21oi_1_1.B1 a_35245_45266# VDD.t415 VDD.t69 sg13_lv_pmos ad=0.2128p pd=1.5u as=0.3808p ps=2.92u w=1.12u l=0.13u
X2174 a_35028_n9612# oa_sar8_acore18_opt_0.sw_bitcell_opt_term_0.trkb.t7 VSS.t544 VSS.t543 sg13_lv_nmos ad=0.19p pd=1.38u as=0.345p ps=2.69u w=1u l=0.15u
X2175 VSS.t972 VDD.t227 VSS.t974 VSS.t973 sg13_lv_nmos ad=79.8f pd=0.8u as=0 ps=0 w=0.42u l=1u
X2176 a_31935_36285# a_31093_35935# a_31841_36285# VSS.t371 sg13_lv_nmos ad=0.12665p pd=1.145u as=0.1428p ps=1.52u w=0.42u l=0.13u
X2177 VDD.t36 VSS.t843 VDD.t36 VDD.t5 sg13_lv_pmos ad=0.19p pd=1.38u as=0 ps=0 w=1u l=1u
X2178 a_30964_46512# a_30938_46476# VDD.t114 VDD.t29 sg13_lv_pmos ad=0.34p pd=2.68u as=0.36237p ps=2.605u w=1u l=0.13u
X2179 oa_sar8_acore18_opt_0.sw_tg_opt_1.bot.t3 oa_sar8_acore18_opt_0.sw_bitcell_opt_b6_1.bot.t41 cap_cmim l=2.14u w=2.14u
X2180 a_29306_32361# a_29749_32117# a_29046_32138# VSS.t67 sg13_lv_nmos ad=79.8f pd=0.8u as=0.1296p ps=1.52u w=0.42u l=0.13u
X2181 VDD.t568 sar_ctrl_async_phys_0.sg13g2_nand2_1_3.A sar_ctrl_async_phys_0.sg13g2_a21oi_1_0.B1 VDD.t69 sg13_lv_pmos ad=0.2198p pd=1.53u as=0.2128p ps=1.5u w=1.12u l=0.13u
X2182 oa_sar8_acore18_opt_0.sw_bitcell_opt_b5_1.bot.t0 oa_sar8_acore18_opt_0.bstrap_opt_w2_c1200_1.gb oa_sar8_acore18_opt_0.bstrap_opt_w2_c1200_1.out VSS.t1095 sg13_lv_nmos ad=0.195p pd=1.39u as=0.35p ps=2.7u w=1u l=0.13u
X2183 VDD.t44 VSS.t464 VDD.t44 VDD.t39 sg13_lv_pmos ad=0.34p pd=2.68u as=0 ps=0 w=1u l=1u
X2184 a_34132_36687# a_33844_36992# a_34070_36687# VSS.t596 sg13_lv_nmos ad=0.1428p pd=1.52u as=37.8f ps=0.6u w=0.42u l=0.13u
X2185 oa_sar8_acore18_opt_0.sw_tg_opt_0.bot.t3 oa_sar8_acore18_opt_0.sw_bitcell_opt_b2_0.bot.t8 cap_cmim l=2.14u w=2.14u
X2186 oa_sar8_acore18_opt_0.sw_tg_opt_1.bot.t3 oa_sar8_acore18_opt_0.sw_bitcell_opt_b7_1.bot.t115 cap_cmim l=2.14u w=2.14u
X2187 a_29620_43488# a_29594_43452# VDD.t528 VDD.t0 sg13_lv_pmos ad=0.34p pd=2.68u as=0.36237p ps=2.605u w=1u l=0.13u
X2188 sar_ctrl_async_phys_0.sg13g2_buf_1_26.X a_25496_31388# VSS.t18 VSS.t17 sg13_lv_nmos ad=0.2886p pd=2.26u as=0.14875p ps=1.16u w=0.74u l=0.13u
X2189 VSS.t11 sar_ctrl_async_phys_0.sg13g2_a22oi_1_3.A2 a_32958_33292# VSS.t6 sg13_lv_nmos ad=0.2516p pd=2.16u as=96.2f ps=1u w=0.74u l=0.13u
X2190 oa_sar8_acore18_opt_0.sw_tg_opt_1.bot.t3 oa_sar8_acore18_opt_0.sw_bitcell_opt_b7_1.bot.t52 cap_cmim l=2.14u w=2.14u
X2191 VSS.t101 a_35103_36751# a_35770_36972# VSS.t597 sg13_lv_nmos ad=0.1406p pd=1.12u as=0.2516p ps=2.16u w=0.74u l=0.13u
X2192 VDD.t350 sar_ctrl_async_phys_0.sg13g2_buf_1_6.A sar_ctrl_async_phys_0.sg13g2_buf_1_21.A VDD.t162 sg13_lv_pmos ad=0.3808p pd=2.92u as=0.2128p ps=1.5u w=1.12u l=0.13u
X2193 oa_sar8_acore18_opt_0.sw_bitcell_opt_term_0.VSS sar_ctrl_async_phys_0.hold_req VSS.t220 VSS.t222 sg13_lv_nmos ad=0.39p pd=2.39u as=0.7p ps=4.7u w=2u l=0.13u
X2194 VDD.t426 a_36156_45710# sar_ctrl_async_phys_0.sg13g2_nand2_1_2.A VDD.t29 sg13_lv_pmos ad=0.2114p pd=1.54u as=0.42p ps=2.99u w=1.12u l=0.13u
X2195 a_26454_41972# a_26184_42013# VSS.t72 VSS.t481 sg13_lv_nmos ad=0.1428p pd=1.52u as=79.8f ps=0.8u w=0.42u l=0.5u
X2196 oa_sar8_acore18_opt_0.sw_bitcell_opt_b6_0.bot.t1 oa_sar8_acore18_opt_0.sw_bitcell_opt_term_0.trkb.t20 oa_sar8_acore18_opt_0.sw_bitcell_opt_term_0.vin VDD.t969 sg13_lv_pmos ad=0.39p pd=2.39u as=0.7p ps=4.7u w=2u l=0.13u
X2197 oa_sar8_acore18_opt_0.bstrap_opt_w2_c1200_1.out oa_sar8_acore18_opt_0.sw_bitcell_opt_term_0.trkb.t27 oa_sar8_acore18_opt_0.sw_bitcell_opt_b2_1.bot.t0 VDD.t640 sg13_lv_pmos ad=0.7p pd=4.7u as=0.39p ps=2.39u w=2u l=0.13u
X2198 VSS.t434 a_35557_31435# a_34636_31749# VSS.t433 sg13_lv_nmos ad=0.1626p pd=1.415u as=0.2516p ps=2.16u w=0.74u l=0.13u
X2199 sar_ctrl_async_phys_0.sg13g2_a22oi_1_5.Y sar_ctrl_async_phys_0.sg13g2_a22oi_1_0.B1 a_30671_32876# VDD.t118 sg13_lv_pmos ad=0.2128p pd=1.5u as=0.2716p ps=1.605u w=1.12u l=0.13u
X2200 VDD.t40 sar_ctrl_async_phys_0.sg13g2_a22oi_1_1.Y sar_ctrl_async_phys_0.sg13g2_dfrbpq_1_17.D VDD.t39 sg13_lv_pmos ad=0.3808p pd=2.92u as=0.3808p ps=2.92u w=1.12u l=0.13u
X2201 sar_ctrl_async_phys_0.sg13g2_dlygate4sd3_1_3.A a_28774_41278# VSS.t133 VSS.t132 sg13_lv_nmos ad=0.2516p pd=2.16u as=0.1426p ps=1.16u w=0.74u l=0.13u
X2202 oa_sar8_acore18_opt_0.sw_tg_opt_1.bot.t3 oa_sar8_acore18_opt_0.sw_bitcell_opt_b3_1.bot.t10 cap_cmim l=2.14u w=2.14u
X2203 a_31081_43607# a_30139_43495# a_30879_43845# VDD.t0 sg13_lv_pmos ad=93.45f pd=0.865u as=0.2048p ps=1.63u w=0.42u l=0.13u
X2204 VSS.t113 sar_ctrl_async_phys_0.sg13g2_nor2b_1_1.B_N a_34808_35200# VSS.t284 sg13_lv_nmos ad=0.14875p pd=1.16u as=0.187p ps=1.78u w=0.55u l=0.13u
X2205 VSS.t837 VDD.t187 VSS.t42 VSS.t838 sg13_lv_nmos ad=79.8f pd=0.8u as=0 ps=0 w=0.42u l=1u
X2206 oa_sar8_acore18_opt_0.sw_tg_opt_1.bot.t3 oa_sar8_acore18_opt_0.sw_bitcell_opt_b6_1.bot.t69 cap_cmim l=2.14u w=2.14u
X2207 oa_sar8_acore18_opt_0.sw_tg_opt_0.bot.t3 oa_sar8_acore18_opt_0.sw_bitcell_opt_b7_0.bot.t73 cap_cmim l=2.14u w=2.14u
X2208 oa_sar8_acore18_opt_0.sw_tg_opt_1.bot.t3 oa_sar8_acore18_opt_0.sw_bitcell_opt_b2_1.bot.t2 cap_cmim l=2.14u w=2.14u
X2209 oa_sar8_acore18_opt_0.sw_tg_opt_0.bot.t2 oa_sar8_acore18_opt_0.sw_bitcell_opt_b7_0.bot.t162 cap_cmim l=2.14u w=2.14u
X2210 result[4] a_33752_33688# VSS.t11 VSS.t126 sg13_lv_nmos ad=0.2886p pd=2.26u as=0.14875p ps=1.16u w=0.74u l=0.13u
X2211 VSS.t88 sar_ctrl_async_phys_0.sg13g2_and2_1_0.B a_34833_37784# VSS.t118 sg13_lv_nmos ad=0.2516p pd=2.16u as=0.1406p ps=1.12u w=0.74u l=0.13u
X2212 VDD.t101 VSS.t672 VDD.t101 VDD.t15 sg13_lv_pmos ad=0.34p pd=2.68u as=0 ps=0 w=1u l=1u
X2213 a_35135_40830# a_35053_40730# sar_ctrl_async_phys_0.sg13g2_nand2b_1_1.Y VSS.t584 sg13_lv_nmos ad=0.1406p pd=1.12u as=0.333p ps=2.38u w=0.74u l=0.13u
X2214 VDD.t315 a_30495_39309# a_30752_39190# VDD.t162 sg13_lv_pmos ad=3.62845p pd=23.965u as=79.8f ps=0.8u w=0.42u l=0.13u
X2215 a_34262_36349# sar_ctrl_async_phys_0.sg13g2_buf_1_2.A VSS.t184 VSS.t451 sg13_lv_nmos ad=37.8f pd=0.6u as=0.1701p ps=1.65u w=0.42u l=0.13u
X2216 oa_sar8_acore18_opt_0.sw_bitcell_opt_term_0.bot.t0 oa_sar8_acore18_opt_0.sw_bitcell_opt_term_0.gb.t4 oa_sar8_acore18_opt_0.sw_bitcell_opt_term_0.vin VSS.t607 sg13_lv_nmos ad=0.195p pd=1.39u as=0.35p ps=2.7u w=1u l=0.13u
X2217 a_31924_32456# a_31898_32361# VDD.t343 VDD.t118 sg13_lv_pmos ad=0.34p pd=2.68u as=0.36237p ps=2.605u w=1u l=0.13u
X2218 a_31958_35175# sar_ctrl_async_phys_0.sg13g2_buf_1_2.X.t5 VSS.t115 VSS.t225 sg13_lv_nmos ad=37.8f pd=0.6u as=0.1701p ps=1.65u w=0.42u l=0.13u
X2219 oa_sar8_acore18_opt_0.sw_tg_opt_0.bot.t3 oa_sar8_acore18_opt_0.sw_bitcell_opt_b6_0.bot.t50 cap_cmim l=2.14u w=2.14u
X2220 sar_ctrl_async_phys_0.sg13g2_a21oi_1_6.A2 a_32890_46508# VSS.t129 VSS.t91 sg13_lv_nmos ad=0.2516p pd=2.16u as=0.1406p ps=1.12u w=0.74u l=0.13u
X2221 VSS.t125 sar_ctrl_async_phys_0.sg13g2_dfrbpq_1_0.CLK.t2 a_34767_31359# VSS.t1210 sg13_lv_nmos ad=3.35542p pd=21.09u as=0.2516p ps=2.16u w=0.74u l=0.13u
X2222 VSS.t174 sar_ctrl_async_phys_0.sg13g2_nand2_1_3.A a_35327_45366# VSS.t647 sg13_lv_nmos ad=0.14505p pd=1.15u as=0.1406p ps=1.12u w=0.74u l=0.13u
X2223 sar_ctrl_async_phys_0.sg13g2_a21oi_1_2.A2 a_31162_38948# VSS.t190 VSS.t1079 sg13_lv_nmos ad=0.2516p pd=2.16u as=0.1406p ps=1.12u w=0.74u l=0.13u
X2224 oa_sar8_acore18_opt_0.sw_tg_opt_1.bot.t3 oa_sar8_acore18_opt_0.sw_bitcell_opt_b0_1.bot.t2 cap_cmim l=2.14u w=2.14u
X2225 sar_ctrl_async_phys_0.sg13g2_nand2_1_2.B a_35866_44532# VSS.t616 VSS.t252 sg13_lv_nmos ad=0.2516p pd=2.16u as=0.1406p ps=1.12u w=0.74u l=0.13u
X2226 VSS.t129 VDD.t33 VSS.t129 VSS.t91 sg13_lv_nmos ad=0.1428p pd=1.52u as=0 ps=0 w=0.42u l=1u
X2227 VDD.t346 a_32149_45007# a_32251_45007# VDD.t69 sg13_lv_pmos ad=1.96315p pd=12.675u as=0.3864p ps=2.93u w=1.12u l=0.13u
X2228 oa_sar8_acore18_opt_0.sw_tg_opt_1.bot.t3 oa_sar8_acore18_opt_0.sw_bitcell_opt_b7_1.bot.t52 cap_cmim l=2.14u w=2.14u
X2229 a_35522_43922# sar_ctrl_async_phys_0.sg13g2_dfrbpq_1_9.RESET_B VSS.t253 VSS.t321 sg13_lv_nmos ad=37.8f pd=0.6u as=79.8f ps=0.8u w=0.42u l=0.13u
X2230 a_26454_41972# a_26184_42013# VDD.t8 VDD.t5 sg13_lv_pmos ad=0.34p pd=2.68u as=0.1523p ps=1.38u w=1u l=0.5u
X2231 sar_ctrl_async_phys_0.sg13g2_buf_1_3.A a_32696_30664# VSS.t592 VSS.t591 sg13_lv_nmos ad=0.2886p pd=2.26u as=0.14875p ps=1.16u w=0.74u l=0.13u
X2232 a_31189_31399# sar_ctrl_async_phys_0.sg13g2_dfrbpq_1_0.CLK.t3 VSS.t125 VSS.t1208 sg13_lv_nmos ad=0.2516p pd=2.16u as=3.35542p ps=21.09u w=0.74u l=0.13u
X2233 VSS.t779 VDD.t79 VSS.t780 VSS.t185 sg13_lv_nmos ad=79.8f pd=0.8u as=0 ps=0 w=0.42u l=1u
X2234 oa_sar8_acore18_opt_0.sw_tg_opt_0.bot.t3 oa_sar8_acore18_opt_0.sw_bitcell_opt_b5_0.bot.t5 cap_cmim l=2.14u w=2.14u
X2235 VDD.t194 sar_ctrl_async_phys_0.cmp_p a_25496_31388# VDD.t39 sg13_lv_pmos ad=0.2114p pd=1.54u as=0.2856p ps=2.36u w=0.84u l=0.13u
X2236 VSS.t72 VDD.t1 VSS.t72 VSS.t798 sg13_lv_nmos ad=0.1428p pd=1.52u as=0 ps=0 w=0.42u l=1u
X2237 VDD.t36 VSS.t840 VDD.t36 VDD.t5 sg13_lv_pmos ad=0.34p pd=2.68u as=0 ps=0 w=1u l=1u
X2238 sar_ctrl_async_phys_0.sg13g2_nand2_1_0.Y sar_ctrl_async_phys_0.sg13g2_buf_1_2.A.t7 a_28874_37806# VSS.t418 sg13_lv_nmos ad=0.2516p pd=2.16u as=0.1406p ps=1.12u w=0.74u l=0.13u
X2239 oa_sar8_acore18_opt_0.sw_tg_opt_0.bot.t3 oa_sar8_acore18_opt_0.sw_bitcell_opt_b7_0.bot.t57 cap_cmim l=2.14u w=2.14u
X2240 VDD.t428 sar_ctrl_async_phys_0.sg13g2_nand2_1_3.A sar_ctrl_async_phys_0.sg13g2_buf_1_33.A VDD.t5 sg13_lv_pmos ad=0.3808p pd=2.92u as=0.2128p ps=1.5u w=1.12u l=0.13u
X2241 done a_35288_33688# VDD.t338 VDD.t54 sg13_lv_pmos ad=0.42p pd=2.99u as=0.2114p ps=1.54u w=1.12u l=0.13u
X2242 VDD.t382 a_34308_37400# a_34266_37436# VDD.t13 sg13_lv_pmos ad=0.2618p pd=1.63u as=0.1176p ps=1.33u w=1.12u l=0.13u
X2243 VSS.t241 sar_ctrl_async_phys_0.sample oa_sar8_acore18_opt_0.sw_bitcell_opt_term_0.trkb.t3 VSS.t240 sg13_lv_nmos ad=0.35p pd=2.7u as=0.195p ps=1.39u w=1u l=0.13u
X2244 VSS.t769 VDD.t133 VSS.t768 VSS.t185 sg13_lv_nmos ad=0.1428p pd=1.52u as=0 ps=0 w=0.42u l=1u
X2245 a_31286_44247# sar_ctrl_async_phys_0.sg13g2_dfrbpq_1_9.RESET_B VSS.t263 VSS.t316 sg13_lv_nmos ad=37.8f pd=0.6u as=0.1701p ps=1.65u w=0.42u l=0.13u
X2246 VSS.t432 a_26454_39702# a_26566_39766# VSS.t89 sg13_lv_nmos ad=0.1426p pd=1.16u as=0.1428p ps=1.52u w=0.42u l=0.5u
X2247 a_30027_39996# sar_ctrl_async_phys_0.sg13g2_a21oi_1_2.B1 sar_ctrl_async_phys_0.sg13g2_nor2_1_10.B VDD.t311 sg13_lv_pmos ad=0.2128p pd=1.5u as=0.3808p ps=2.92u w=1.12u l=0.13u
X2248 VDD.t70 VSS.t769 VDD.t70 VDD.t69 sg13_lv_pmos ad=0.34p pd=2.68u as=0 ps=0 w=1u l=1u
X2249 VSS.t217 sar_ctrl_async_phys_0.hold_req oa_sar8_acore18_opt_0.sw_bitcell_opt_b7_1.VSS VSS.t216 sg13_lv_nmos ad=0.7p pd=4.7u as=0.39p ps=2.39u w=2u l=0.13u
X2250 oa_sar8_acore18_opt_0.sw_tg_opt_0.bot.t2 oa_sar8_acore18_opt_0.sw_bitcell_opt_b7_0.bot.t167 cap_cmim l=2.14u w=2.14u
X2251 oa_sar8_acore18_opt_0.sw_bitcell_opt_term_0.VSS sar_ctrl_async_phys_0.hold_req VSS.t220 VSS.t219 sg13_lv_nmos ad=0.39p pd=2.39u as=0.7p ps=4.7u w=2u l=0.13u
X2252 VSS.t148 sar_ctrl_async_phys_0.sg13g2_buf_1_1.A a_35288_33688# VSS.t63 sg13_lv_nmos ad=0.14875p pd=1.16u as=0.187p ps=1.78u w=0.55u l=0.13u
X2253 oa_sar8_acore18_opt_0.sw_tg_opt_0.bot.t3 oa_sar8_acore18_opt_0.sw_bitcell_opt_b7_0.bot.t141 cap_cmim l=2.14u w=2.14u
X2254 a_33276_42686# sar_ctrl_async_phys_0.sg13g2_buf_1_13.A VDD.t366 VDD.t0 sg13_lv_pmos ad=0.2856p pd=2.36u as=0.2114p ps=1.54u w=0.84u l=0.13u
X2255 oa_sar8_acore18_opt_0.sw_tg_opt_1.bot.t3 oa_sar8_acore18_opt_0.sw_bitcell_opt_b4_1.bot.t9 cap_cmim l=2.14u w=2.14u
X2256 VSS.t1034 VDD.t182 VSS.t1036 VSS.t1035 sg13_lv_nmos ad=79.8f pd=0.8u as=0 ps=0 w=0.42u l=1u
X2257 VSS.t166 sar_ctrl_async_phys_0.sg13g2_nand2_1_3.Y a_36056_38948# VSS.t567 sg13_lv_nmos ad=0.14875p pd=1.16u as=0.187p ps=1.78u w=0.55u l=0.13u
X2258 sar_ctrl_async_phys_0.sg13g2_nand3b_1_0.Y sar_ctrl_async_phys_0.sg13g2_buf_1_2.A.t4 VDD.t14 VDD.t13 sg13_lv_pmos ad=0.2128p pd=1.5u as=0.2128p ps=1.5u w=1.12u l=0.13u
X2259 VSS.t115 sar_ctrl_async_phys_0.sg13g2_buf_1_16.A a_30507_35204# VSS.t114 sg13_lv_nmos ad=0.18945p pd=1.27u as=0.187p ps=1.78u w=0.55u l=0.13u
X2260 a_33940_41223# a_34171_41332# a_33626_41433# VSS.t1102 sg13_lv_nmos ad=0.2373p pd=1.97u as=79.8f ps=0.8u w=0.42u l=0.13u
X2261 oa_sar8_acore18_opt_0.sw_tg_opt_1.bot.t4 oa_sar8_acore18_opt_0.sw_bitcell_opt_b7_1.bot.t14 cap_cmim l=2.14u w=2.14u
X2262 VDD.t457 sar_ctrl_async_phys_0.sg13g2_buf_1_2.X.t5 a_31706_35385# VDD.t37 sg13_lv_pmos ad=0.1563p pd=1.22u as=0.147p ps=1.54u w=0.42u l=0.13u
X2263 a_33846_30626# a_34651_30748# a_34106_30849# VDD.t39 sg13_lv_pmos ad=0.1428p pd=1.52u as=79.8f ps=0.8u w=0.42u l=0.13u
X2264 a_34895_32460# sar_ctrl_async_phys_0.sg13g2_a22oi_1_0.A1.t3 VDD.t342 VDD.t118 sg13_lv_pmos ad=0.2716p pd=1.605u as=0.3808p ps=2.92u w=1.12u l=0.13u
X2265 oa_sar8_acore18_opt_0.sw_tg_opt_1.bot.t3 oa_sar8_acore18_opt_0.sw_bitcell_opt_b6_1.bot.t1 cap_cmim l=2.14u w=2.14u
X2266 VSS.t343 sar_ctrl_async_phys_0.sg13g2_a22oi_1_5.Y sar_ctrl_async_phys_0.sg13g2_inv_1_6.Y VSS.t398 sg13_lv_nmos ad=0.2516p pd=2.16u as=0.2516p ps=2.16u w=0.74u l=0.13u
X2267 sar_ctrl_async_phys_0.sg13g2_inv_1_5.A sar_ctrl_async_phys_0.sg13g2_a22oi_1_0.B1 a_31247_32876# VDD.t118 sg13_lv_pmos ad=0.2128p pd=1.5u as=0.2716p ps=1.605u w=1.12u l=0.13u
X2268 a_32090_40428# a_32533_40471# a_32473_40507# VDD.t311 sg13_lv_pmos ad=79.8f pd=0.8u as=63f ps=0.72u w=0.42u l=0.13u
X2269 oa_sar8_acore18_opt_0.sw_tg_opt_0.bot.t3 oa_sar8_acore18_opt_0.sw_bitcell_opt_b5_0.bot.t22 cap_cmim l=2.14u w=2.14u
X2270 VDD.t389 sar_ctrl_async_phys_0.sg13g2_nand2_1_3.A sar_ctrl_async_phys_0.sg13g2_nand2_1_3.Y VDD.t0 sg13_lv_pmos ad=0.3808p pd=2.92u as=0.2128p ps=1.5u w=1.12u l=0.13u
X2271 oa_sar8_acore18_opt_0.sw_tg_opt_1.bot.t3 oa_sar8_acore18_opt_0.sw_bitcell_opt_b5_1.bot.t34 cap_cmim l=2.14u w=2.14u
X2272 VDD.t8 VSS.t72 VDD.t6 VDD.t5 sg13_lv_pmos ad=0.19p pd=1.38u as=0 ps=0 w=1u l=1u
X2273 VDD.t209 sar_ctrl_async_phys_0.sg13g2_a21oi_1_0.A1 a_31947_41508# VDD.t5 sg13_lv_pmos ad=0.2128p pd=1.5u as=0.2128p ps=1.5u w=1.12u l=0.13u
X2274 a_29908_43909# a_30139_43495# a_29594_43452# VSS.t300 sg13_lv_nmos ad=0.2373p pd=1.97u as=79.8f ps=0.8u w=0.42u l=0.13u
X2275 a_33973_39677# sar_ctrl_async_phys_0.sg13g2_dfrbpq_1_0.CLK.t17 VDD.t311 VDD.t311 sg13_lv_pmos ad=0.4088p pd=2.97u as=1.55472p ps=9.945u w=1.12u l=0.13u
X2276 sar_ctrl_async_phys_0.sg13g2_buf_1_44.A sar_ctrl_async_phys_0.sg13g2_nand2_1_6.B VDD.t35 VDD.t29 sg13_lv_pmos ad=0.2128p pd=1.5u as=0.3808p ps=2.92u w=1.12u l=0.13u
X2277 VSS.t741 VDD.t116 VSS.t485 VSS.t742 sg13_lv_nmos ad=79.8f pd=0.8u as=0 ps=0 w=0.42u l=1u
X2278 VSS.t144 sar_ctrl_async_phys_0.sg13g2_buf_1_26.X sar_ctrl_async_phys_0.sg13g2_nor2_1_4.Y VSS.t145 sg13_lv_nmos ad=0.2516p pd=2.16u as=0.1406p ps=1.12u w=0.74u l=0.13u
X2279 oa_sar8_acore18_opt_0.sw_tg_opt_0.bot.t3 oa_sar8_acore18_opt_0.sw_bitcell_opt_b7_0.bot.t68 cap_cmim l=2.14u w=2.14u
X2280 a_33558_36674# a_34363_36796# a_33818_36897# VDD.t13 sg13_lv_pmos ad=0.1428p pd=1.52u as=79.8f ps=0.8u w=0.42u l=0.13u
X2281 VDD.t186 sar_ctrl_async_phys_0.sg13g2_dlygate4sd3_1_3.A a_28968_42013# VDD.t5 sg13_lv_pmos ad=0.1523p pd=1.38u as=0.1428p ps=1.52u w=0.42u l=0.13u
X2282 VDD.t209 VSS.t346 VDD.t209 VDD.t5 sg13_lv_pmos ad=0.19p pd=1.38u as=0 ps=0 w=1u l=1u
X2283 oa_sar8_acore18_opt_0.sw_tg_opt_1.bot.t3 oa_sar8_acore18_opt_0.sw_bitcell_opt_b7_1.bot.t131 cap_cmim l=2.14u w=2.14u
X2284 a_30964_39711# a_31195_39820# a_30650_39921# VSS.t348 sg13_lv_nmos ad=0.2373p pd=1.97u as=79.8f ps=0.8u w=0.42u l=0.13u
X2285 oa_sar8_acore18_opt_0.sw_tg_opt_0.bot.t3 oa_sar8_acore18_opt_0.sw_bitcell_opt_b7_0.bot.t99 cap_cmim l=2.14u w=2.14u
X2286 a_32281_32529# a_31924_32456# VDD.t343 VDD.t118 sg13_lv_pmos ad=63f pd=0.72u as=0.1563p ps=1.22u w=0.42u l=0.13u
X2287 VDD.t311 a_35072_39918# a_35017_40013# VDD.t311 sg13_lv_pmos ad=1.6658p pd=10.66u as=93.45f ps=0.865u w=0.42u l=0.13u
X2288 VDD.t54 a_35648_34654# a_35593_34535# VDD.t54 sg13_lv_pmos ad=2.2076p pd=14.4u as=93.45f ps=0.865u w=0.42u l=0.13u
X2289 VDD.t165 VSS.t471 VDD.t165 VDD.t162 sg13_lv_pmos ad=0.34p pd=2.68u as=0 ps=0 w=1u l=1u
X2290 oa_sar8_acore18_opt_0.sw_tg_opt_1.bot.t3 oa_sar8_acore18_opt_0.sw_bitcell_opt_b5_1.bot.t9 cap_cmim l=2.14u w=2.14u
X2291 VSS.t1064 VDD.t44 VSS.t1066 VSS.t1065 sg13_lv_nmos ad=79.8f pd=0.8u as=0 ps=0 w=0.42u l=1u
X2292 VSS.t848 VDD.t209 VSS.t293 VSS.t628 sg13_lv_nmos ad=0.1428p pd=1.52u as=0 ps=0 w=0.42u l=1u
X2293 a_34106_32868# a_34549_32911# a_33846_33338# VSS.t149 sg13_lv_nmos ad=79.8f pd=0.8u as=0.1296p ps=1.52u w=0.42u l=0.13u
X2294 a_29812_40885# a_30043_40471# a_29498_40428# VSS.t390 sg13_lv_nmos ad=0.2373p pd=1.97u as=79.8f ps=0.8u w=0.42u l=0.13u
X2295 a_33109_45725# sar_ctrl_async_phys_0.sg13g2_dfrbpq_1_0.CLK VSS.t515 VSS.t514 sg13_lv_nmos ad=0.2516p pd=2.16u as=5.02618p ps=31.995u w=0.74u l=0.13u
X2296 a_30591_32215# a_29749_32117# a_29332_32456# VDD.t118 sg13_lv_pmos ad=0.2048p pd=1.63u as=0.34p ps=2.68u w=1u l=0.13u
X2297 VDD.t209 VSS.t123 VDD.t209 VDD.t5 sg13_lv_pmos ad=0.19p pd=1.38u as=0 ps=0 w=1u l=1u
X2298 VDD.t144 VSS.t801 VDD.t174 VDD.t0 sg13_lv_pmos ad=0.19p pd=1.38u as=0 ps=0 w=1u l=1u
X2299 VSS.t123 VDD.t209 VSS.t346 VSS.t827 sg13_lv_nmos ad=0.1428p pd=1.52u as=0 ps=0 w=0.42u l=1u
X2300 VDD.t117 sar_ctrl_async_phys_0.sg13g2_dfrbpq_1_9.RESET_B a_31034_44457# VDD.t69 sg13_lv_pmos ad=0.1563p pd=1.22u as=0.147p ps=1.54u w=0.42u l=0.13u
X2301 sar_ctrl_async_phys_0.dac_code[0] a_36056_46508# VDD.t426 VDD.t29 sg13_lv_pmos ad=0.42p pd=2.99u as=0.2114p ps=1.54u w=1.12u l=0.13u
X2302 sar_ctrl_async_phys_0.sg13g2_nor2b_1_4.Y sar_ctrl_async_phys_0.sg13g2_nor2b_1_0.A VSS.t103 VSS.t102 sg13_lv_nmos ad=0.1406p pd=1.12u as=0.2516p ps=2.16u w=0.74u l=0.13u
X2303 VSS.t62 a_34236_46472# sar_ctrl_async_phys_0.sg13g2_dfrbpq_1_9.RESET_B VSS.t91 sg13_lv_nmos ad=0.14875p pd=1.16u as=0.2886p ps=2.26u w=0.74u l=0.13u
X2304 VDD.t8 VSS.t66 VDD.t8 VDD.t5 sg13_lv_pmos ad=0.34p pd=2.68u as=0 ps=0 w=1u l=1u
X2305 VSS.t626 VDD.t14 VSS.t626 VSS.t882 sg13_lv_nmos ad=0.1428p pd=1.52u as=0 ps=0 w=0.42u l=1u
X2306 oa_sar8_acore18_opt_0.sw_tg_opt_1.bot.t2 oa_sar8_acore18_opt_0.sw_bitcell_opt_b7_1.bot.t148 cap_cmim l=2.14u w=2.14u
X2307 sar_ctrl_async_phys_0.sg13g2_a21oi_1_7.A2 a_32602_39996# VDD.t328 VDD.t311 sg13_lv_pmos ad=0.3808p pd=2.92u as=0.2128p ps=1.5u w=1.12u l=0.13u
X2308 oa_sar8_acore18_opt_0.sw_bitcell_opt_b7_1.VSS sar_ctrl_async_phys_0.dac_code_n[6] oa_sar8_acore18_opt_0.sw_bitcell_opt_b6_1.bot.t0 VSS.t611 sg13_lv_nmos ad=1.05p pd=6.7u as=0.585p ps=3.39u w=3u l=0.13u
X2309 w_39600_n9960# oa_sar8_acore18_opt_0.sw_bitcell_opt_term_0.trkb.t5 oa_sar8_acore18_opt_0.sw_bitcell_opt_term_0.gb.t1 w_39600_n9960# sg13_lv_pmos ad=0.7p pd=4.7u as=0.7p ps=4.7u w=2u l=0.13u
X2310 VSS.t926 VDD.t192 VSS.t926 VSS.t114 sg13_lv_nmos ad=79.8f pd=0.8u as=0 ps=0 w=0.42u l=1u
X2311 a_31542_37874# sar_ctrl_async_phys_0.sg13g2_nor2_1_0.A VDD.t14 VDD.t13 sg13_lv_pmos ad=79.8f pd=0.8u as=0.1428p ps=1.52u w=0.42u l=0.13u
X2312 a_31644_36638# sar_ctrl_async_phys_0.sg13g2_buf_1_13.A VSS.t368 VSS.t367 sg13_lv_nmos ad=0.187p pd=1.78u as=0.14875p ps=1.16u w=0.55u l=0.13u
X2313 oa_sar8_acore18_opt_0.sw_tg_opt_0.bot.t3 oa_sar8_acore18_opt_0.sw_bitcell_opt_b4_0.bot.t22 cap_cmim l=2.14u w=2.14u
X2314 oa_sar8_acore18_opt_0.sw_tg_opt_1.bot.t3 oa_sar8_acore18_opt_0.sw_bitcell_opt_b7_1.bot.t89 cap_cmim l=2.14u w=2.14u
X2315 a_34036_35928# a_34010_35892# VSS.t184 VSS.t183 sg13_lv_nmos ad=0.2516p pd=2.16u as=0.1626p ps=1.415u w=0.74u l=0.13u
X2316 VDD.t311 a_30783_40821# a_31040_40702# VDD.t311 sg13_lv_pmos ad=1.6658p pd=10.66u as=79.8f ps=0.8u w=0.42u l=0.13u
X2317 oa_sar8_acore18_opt_0.sw_tg_opt_1.bot.t4 oa_sar8_acore18_opt_0.sw_bitcell_opt_b7_1.bot.t4 cap_cmim l=2.14u w=2.14u
X2318 VDD.t342 sar_ctrl_async_phys_0.sg13g2_buf_1_2.X a_34106_32868# VDD.t118 sg13_lv_pmos ad=0.1563p pd=1.22u as=0.147p ps=1.54u w=0.42u l=0.13u
X2319 VDD.t38 VSS.t111 VDD.t38 VDD.t37 sg13_lv_pmos ad=0.19p pd=1.38u as=0 ps=0 w=1u l=1u
X2320 VDD.t339 a_25878_40460# a_25990_40484# VDD.t311 sg13_lv_pmos ad=0.2254p pd=1.53u as=0.34p ps=2.68u w=1u l=0.5u
X2321 oa_sar8_acore18_opt_0.sw_tg_opt_0.bot.t3 oa_sar8_acore18_opt_0.sw_bitcell_opt_b4_0.bot.t4 cap_cmim l=2.14u w=2.14u
X2322 VSS.t677 VDD.t120 VSS.t677 VSS.t680 sg13_lv_nmos ad=79.8f pd=0.8u as=0 ps=0 w=0.42u l=1u
X2323 a_32692_46064# a_32666_45969# VSS.t22 VSS.t1224 sg13_lv_nmos ad=0.2516p pd=2.16u as=0.1626p ps=1.415u w=0.74u l=0.13u
X2324 VSS.t214 sar_ctrl_async_phys_0.hold_req oa_sar8_acore18_opt_0.sw_bitcell_opt_b7_1.VSS VSS.t213 sg13_lv_nmos ad=0.7p pd=4.7u as=0.39p ps=2.39u w=2u l=0.13u
X2325 VSS.t1003 VDD.t189 VSS.t1003 VSS.t17 sg13_lv_nmos ad=79.8f pd=0.8u as=0 ps=0 w=0.42u l=1u
X2326 sar_ctrl_async_phys_0.sg13g2_nand2b_1_2.A_N a_35578_41508# VDD.t428 VDD.t5 sg13_lv_pmos ad=0.3808p pd=2.92u as=0.2128p ps=1.5u w=1.12u l=0.13u
X2327 sar_ctrl_async_phys_0.sg13g2_dlygate4sd3_1_7.X a_26566_41996# VSS.t72 VSS.t1292 sg13_lv_nmos ad=0.2516p pd=2.16u as=0.1426p ps=1.16u w=0.74u l=0.13u
X2328 VDD.t176 VSS.t801 VDD.t177 VDD.t5 sg13_lv_pmos ad=0.19p pd=1.38u as=0 ps=0 w=1u l=1u
X2329 a_34009_41601# a_33652_41528# VDD.t209 VDD.t5 sg13_lv_pmos ad=63f pd=0.72u as=0.1563p ps=1.22u w=0.42u l=0.13u
X2330 a_26666_38912# sar_ctrl_async_phys_0.sg13g2_dlygate4sd3_1_9.X VDD.t351 VDD.t162 sg13_lv_pmos ad=0.1428p pd=1.52u as=0.1523p ps=1.38u w=0.42u l=0.13u
X2331 a_32480_46750# sar_ctrl_async_phys_0.sg13g2_dfrbpq_1_9.RESET_B VDD.t323 VDD.t29 sg13_lv_pmos ad=79.8f pd=0.8u as=2.2076p ps=14.4u w=0.42u l=0.13u
X2332 VSS.t72 VDD.t10 VSS.t72 VSS.t814 sg13_lv_nmos ad=0.1428p pd=1.52u as=0 ps=0 w=0.42u l=1u
X2333 a_28368_36877# sar_ctrl_async_phys_0.sg13g2_dlygate4sd3_1_1.X a_28505_36720# VSS.t247 sg13_lv_nmos ad=0.2176p pd=1.96u as=0.1216p ps=1.02u w=0.64u l=0.13u
X2334 oa_sar8_acore18_opt_0.sw_bitcell_opt_b0_0.bot.t0 sar_ctrl_async_phys_0.dac_code[0] oa_sar8_acore18_opt_0.sw_bitcell_opt_term_0.VSS VSS.t482 sg13_lv_nmos ad=0.2925p pd=1.89u as=0.525p ps=3.7u w=1.5u l=0.13u
X2335 VDD.t119 VSS.t1003 VDD.t119 VDD.t118 sg13_lv_pmos ad=0.19p pd=1.38u as=0 ps=0 w=1u l=1u
X2336 VSS.t174 sar_ctrl_async_phys_0.sg13g2_nand2_1_3.A a_35327_45750# VSS.t647 sg13_lv_nmos ad=0.14505p pd=1.15u as=0.1406p ps=1.12u w=0.74u l=0.13u
X2337 oa_sar8_acore18_opt_0.sw_tg_opt_0.bot.t3 oa_sar8_acore18_opt_0.sw_bitcell_opt_b7_0.bot.t136 cap_cmim l=2.14u w=2.14u
X2338 VSS.t962 VDD.t119 VSS.t961 VSS.t960 sg13_lv_nmos ad=0.1428p pd=1.52u as=0 ps=0 w=0.42u l=1u
X2339 VDD.t70 VSS.t722 VDD.t70 VDD.t69 sg13_lv_pmos ad=0.19p pd=1.38u as=0 ps=0 w=1u l=1u
X2340 sar_ctrl_async_phys_0.sg13g2_nor2_1_3.B sar_ctrl_async_phys_0.sg13g2_buf_1_13.X a_26630_37814# VSS.t297 sg13_lv_nmos ad=0.2516p pd=2.16u as=0.1406p ps=1.12u w=0.74u l=0.15u
X2341 oa_sar8_acore18_opt_0.sw_tg_opt_1.bot.t3 oa_sar8_acore18_opt_0.sw_bitcell_opt_b7_1.bot.t85 cap_cmim l=2.14u w=2.14u
X2342 sar_ctrl_async_phys_0.bit_active[7] a_35672_38224# VSS.t88 VSS.t87 sg13_lv_nmos ad=0.2886p pd=2.26u as=0.14875p ps=1.16u w=0.74u l=0.13u
X2343 VSS.t88 sar_ctrl_async_phys_0.sg13g2_buf_1_21.A a_36056_38224# VSS.t87 sg13_lv_nmos ad=0.14875p pd=1.16u as=0.187p ps=1.78u w=0.55u l=0.13u
X2344 a_33654_44234# a_34459_44356# a_33914_44457# VDD.t69 sg13_lv_pmos ad=0.1428p pd=1.52u as=79.8f ps=0.8u w=0.42u l=0.13u
X2345 VDD.t254 VSS.t956 VDD.t254 VDD.t54 sg13_lv_pmos ad=0.34p pd=2.68u as=0 ps=0 w=1u l=1u
X2346 sar_ctrl_async_phys_0.sg13g2_inv_1_0.A sar_ctrl_async_phys_0.sg13g2_a22oi_1_2.B1 a_33359_32876# VDD.t118 sg13_lv_pmos ad=0.2128p pd=1.5u as=0.2716p ps=1.605u w=1.12u l=0.13u
X2347 VDD.t340 a_30848_32358# a_30793_32453# VDD.t118 sg13_lv_pmos ad=1.96315p pd=12.675u as=93.45f ps=0.865u w=0.42u l=0.13u
X2348 a_35305_43607# a_34363_43495# a_35103_43845# VDD.t0 sg13_lv_pmos ad=93.45f pd=0.865u as=0.2048p ps=1.63u w=0.42u l=0.13u
X2349 oa_sar8_acore18_opt_0.sw_tg_opt_0.bot.t3 oa_sar8_acore18_opt_0.sw_bitcell_opt_b6_0.bot.t70 cap_cmim l=2.14u w=2.14u
X2350 VSS.t926 VDD.t244 VSS.t926 VSS.t114 sg13_lv_nmos ad=0.1428p pd=1.52u as=0 ps=0 w=0.42u l=1u
X2351 VSS.t144 VDD.t354 VSS.t144 VSS.t863 sg13_lv_nmos ad=0.1428p pd=1.52u as=0 ps=0 w=0.42u l=1u
X2352 a_32116_37861# a_32347_37447# a_31802_37404# VSS.t504 sg13_lv_nmos ad=0.2373p pd=1.97u as=79.8f ps=0.8u w=0.42u l=0.13u
X2353 oa_sar8_acore18_opt_0.sw_tg_opt_1.bot.t3 oa_sar8_acore18_opt_0.sw_bitcell_opt_b5_1.bot.t9 cap_cmim l=2.14u w=2.14u
X2354 a_34526_31511# a_34268_31826# VDD.t39 VDD.t39 sg13_lv_pmos ad=93.45f pd=0.865u as=1.96315p ps=12.675u w=0.42u l=0.13u
X2355 oa_sar8_acore18_opt_0.sw_bitcell_opt_b2_1.bot.t0 oa_sar8_acore18_opt_0.sw_bitcell_opt_term_0.trkb.t27 oa_sar8_acore18_opt_0.bstrap_opt_w2_c1200_1.out VDD.t640 sg13_lv_pmos ad=0.39p pd=2.39u as=0.7p ps=4.7u w=2u l=0.13u
X2356 oa_sar8_acore18_opt_0.sw_tg_opt_0.bot.t2 oa_sar8_acore18_opt_0.sw_bitcell_opt_b7_0.bot.t157 cap_cmim l=2.14u w=2.14u
X2357 VSS.t770 VDD.t70 VSS.t769 VSS.t185 sg13_lv_nmos ad=0.1428p pd=1.52u as=0 ps=0 w=0.42u l=1u
X2358 a_33114_41508# sar_ctrl_async_phys_0.sg13g2_nor2b_1_3.Y VDD.t209 VDD.t5 sg13_lv_pmos ad=0.1176p pd=1.33u as=0.4032p ps=2.96u w=1.12u l=0.13u
X2359 VSS.t154 sar_ctrl_async_phys_0.sg13g2_nor2_1_7.Y sar_ctrl_async_phys_0.sg13g2_nor2_1_7.B VSS.t281 sg13_lv_nmos ad=0.2516p pd=2.16u as=0.1406p ps=1.12u w=0.74u l=0.13u
X2360 oa_sar8_acore18_opt_0.sw_tg_opt_1.bot.t3 oa_sar8_acore18_opt_0.sw_bitcell_opt_b7_1.bot.t25 cap_cmim l=2.14u w=2.14u
X2361 VSS.t129 VDD.t22 VSS.t129 VSS.t61 sg13_lv_nmos ad=79.8f pd=0.8u as=0 ps=0 w=0.42u l=1u
X2362 VDD.t117 sar_ctrl_async_phys_0.sg13g2_dfrbpq_1_9.RESET_B a_31706_44964# VDD.t69 sg13_lv_pmos ad=0.1563p pd=1.22u as=0.147p ps=1.54u w=0.42u l=0.13u
X2363 oa_sar8_acore18_opt_0.sw_tg_opt_0.bot.t3 oa_sar8_acore18_opt_0.sw_bitcell_opt_b5_0.bot.t15 cap_cmim l=2.14u w=2.14u
X2364 a_35557_31435# a_34615_31475# a_35463_31435# VDD.t39 sg13_lv_pmos ad=79.8f pd=0.8u as=0.1428p ps=1.52u w=0.42u l=0.13u
X2365 VDD.t144 VSS.t774 VDD.t146 VDD.t0 sg13_lv_pmos ad=0.34p pd=2.68u as=0 ps=0 w=1u l=1u
X2366 a_29620_32151# a_29851_32260# a_29306_32361# VSS.t168 sg13_lv_nmos ad=0.2373p pd=1.97u as=79.8f ps=0.8u w=0.42u l=0.13u
X2367 oa_sar8_acore18_opt_0.sw_tg_opt_1.bot.t3 oa_sar8_acore18_opt_0.sw_bitcell_opt_b6_1.bot.t49 cap_cmim l=2.14u w=2.14u
X2368 VDD.t42 VSS.t86 VDD.t42 VDD.t37 sg13_lv_pmos ad=0.34p pd=2.68u as=0 ps=0 w=1u l=1u
X2369 VSS.t178 a_35772_41936# sar_ctrl_async_phys_0.sg13g2_nand2_1_3.A VSS.t1236 sg13_lv_nmos ad=0.14875p pd=1.16u as=0.2886p ps=2.26u w=0.74u l=0.13u
X2370 sar_ctrl_async_phys_0.sg13g2_a21oi_1_0.A2 a_35770_36972# VSS.t101 VSS.t597 sg13_lv_nmos ad=0.2516p pd=2.16u as=0.1406p ps=1.12u w=0.74u l=0.13u
X2371 VSS.t779 VDD.t79 VSS.t778 VSS.t185 sg13_lv_nmos ad=0.1428p pd=1.52u as=0 ps=0 w=0.42u l=1u
X2372 VDD.t79 VSS.t739 VDD.t117 VDD.t69 sg13_lv_pmos ad=0.19p pd=1.38u as=0 ps=0 w=1u l=1u
X2373 a_32692_46064# a_33211_45868# a_33951_45823# VSS.t1114 sg13_lv_nmos ad=0.3473p pd=2.71u as=0.12665p ps=1.145u w=0.74u l=0.13u
X2374 a_33818_43452# a_34261_43495# a_34201_43531# VDD.t0 sg13_lv_pmos ad=79.8f pd=0.8u as=63f ps=0.72u w=0.42u l=0.13u
X2375 VDD.t489 sar_ctrl_async_phys_0.sg13g2_a22oi_1_0.B2 a_33464_30664# VDD.t39 sg13_lv_pmos ad=0.2114p pd=1.54u as=0.2856p ps=2.36u w=0.84u l=0.13u
X2376 VSS.t772 VDD.t4 VSS.t771 VSS.t185 sg13_lv_nmos ad=0.1428p pd=1.52u as=0 ps=0 w=0.42u l=1u
X2377 oa_sar8_acore18_opt_0.sw_tg_opt_1.bot.t3 oa_sar8_acore18_opt_0.sw_bitcell_opt_b6_1.bot.t34 cap_cmim l=2.14u w=2.14u
X2378 a_30671_32876# sar_ctrl_async_phys_0.sg13g2_buf_1_25.A sar_ctrl_async_phys_0.sg13g2_a22oi_1_5.Y VDD.t118 sg13_lv_pmos ad=0.2744p pd=1.61u as=0.2128p ps=1.5u w=1.12u l=0.13u
X2379 a_35327_42342# a_35245_42242# sar_ctrl_async_phys_0.sg13g2_nand2b_1_2.Y VSS.t211 sg13_lv_nmos ad=0.1406p pd=1.12u as=0.333p ps=2.38u w=0.74u l=0.13u
X2380 VSS.t66 sar_ctrl_async_phys_0.sg13g2_dlygate4sd3_1_5.A a_25608_40501# VSS.t65 sg13_lv_nmos ad=79.8f pd=0.8u as=0.1428p ps=1.52u w=0.42u l=0.13u
X2381 VSS.t129 a_32223_46869# a_32890_46508# VSS.t91 sg13_lv_nmos ad=0.1406p pd=1.12u as=0.2516p ps=2.16u w=0.74u l=0.13u
X2382 VDD.t89 VSS.t772 VDD.t70 VDD.t69 sg13_lv_pmos ad=0.34p pd=2.68u as=0 ps=0 w=1u l=1u
X2383 sar_ctrl_async_phys_0.dac_code_n[1].t0 a_34520_46508# VDD.t35 VDD.t29 sg13_lv_pmos ad=0.42p pd=2.99u as=0.2114p ps=1.54u w=1.12u l=0.13u
X2384 VSS.t137 VDD.t139 VSS.t137 VSS.t808 sg13_lv_nmos ad=0.1428p pd=1.52u as=0 ps=0 w=0.42u l=1u
X2385 sar_ctrl_async_phys_0.sg13g2_nand2b_1_0.A_N sar_ctrl_async_phys_0.sg13g2_nor2_1_12.A VSS.t60 VSS.t501 sg13_lv_nmos ad=0.1406p pd=1.12u as=0.2516p ps=2.16u w=0.74u l=0.13u
X2386 oa_sar8_acore18_opt_0.sw_tg_opt_1.bot.t3 oa_sar8_acore18_opt_0.sw_bitcell_opt_b6_1.bot.t49 cap_cmim l=2.14u w=2.14u
X2387 oa_sar8_acore18_opt_0.sw_tg_opt_0.bot.t3 oa_sar8_acore18_opt_0.sw_bitcell_opt_b7_0.bot.t107 cap_cmim l=2.14u w=2.14u
X2388 VDD.t342 sar_ctrl_async_phys_0.sg13g2_a22oi_1_0.A2 a_34895_32460# VDD.t118 sg13_lv_pmos ad=0.3808p pd=2.92u as=0.2744p ps=1.61u w=1.12u l=0.13u
X2389 a_35305_36989# a_34363_36796# a_35103_36751# VDD.t13 sg13_lv_pmos ad=93.45f pd=0.865u as=0.2048p ps=1.63u w=0.42u l=0.13u
X2390 VDD.t22 VSS.t129 VDD.t22 VDD.t15 sg13_lv_pmos ad=0.34p pd=2.68u as=0 ps=0 w=1u l=1u
X2391 oa_sar8_acore18_opt_0.sw_tg_opt_1.bot.t3 oa_sar8_acore18_opt_0.sw_bitcell_opt_b7_1.bot.t120 cap_cmim l=2.14u w=2.14u
X2392 VSS.t106 a_29941_40471# a_30043_40471# VSS.t1244 sg13_lv_nmos ad=5.25845p pd=33.575u as=0.2516p ps=2.16u w=0.74u l=0.13u
X2393 sar_ctrl_async_phys_0.sg13g2_nor2b_1_3.Y sar_ctrl_async_phys_0.sg13g2_nor2b_1_0.A VSS.t27 VSS.t74 sg13_lv_nmos ad=0.1406p pd=1.12u as=0.2516p ps=2.16u w=0.74u l=0.13u
X2394 oa_sar8_acore18_opt_0.sw_tg_opt_1.bot.t3 oa_sar8_acore18_opt_0.sw_bitcell_opt_b4_1.bot.t19 cap_cmim l=2.14u w=2.14u
X2395 oa_sar8_acore18_opt_0.sw_tg_opt_1.bot.t3 oa_sar8_acore18_opt_0.sw_bitcell_opt_b7_1.bot.t73 cap_cmim l=2.14u w=2.14u
X2396 VSS.t1039 VDD.t182 VSS.t1041 VSS.t1040 sg13_lv_nmos ad=79.8f pd=0.8u as=0 ps=0 w=0.42u l=1u
X2397 VDD.t163 VSS.t471 VDD.t163 VDD.t162 sg13_lv_pmos ad=0.34p pd=2.68u as=0 ps=0 w=1u l=1u
X2398 VDD.t54 a_34549_34423# a_34651_34423# VDD.t54 sg13_lv_pmos ad=2.2076p pd=14.4u as=0.3864p ps=2.93u w=1.12u l=0.13u
X2399 sar_ctrl_async_phys_0.sg13g2_dfrbpq_1_9.Q a_33658_44996# VSS.t25 VSS.t1175 sg13_lv_nmos ad=0.2516p pd=2.16u as=0.1406p ps=1.12u w=0.74u l=0.13u
X2400 VSS.t27 sar_ctrl_async_phys_0.sg13g2_buf_1_6.A a_35135_40830# VSS.t1262 sg13_lv_nmos ad=0.14505p pd=1.15u as=0.1406p ps=1.12u w=0.74u l=0.13u
X2401 VDD.t191 VSS.t891 VDD.t191 VDD.t13 sg13_lv_pmos ad=0.34p pd=2.68u as=0 ps=0 w=1u l=1u
X2402 oa_sar8_acore18_opt_0.sw_tg_opt_0.bot.t3 oa_sar8_acore18_opt_0.sw_bitcell_opt_b2_0.bot.t4 cap_cmim l=2.14u w=2.14u
X2403 oa_sar8_acore18_opt_0.sw_tg_opt_0.bot.t3 oa_sar8_acore18_opt_0.sw_bitcell_opt_b7_0.bot.t78 cap_cmim l=2.14u w=2.14u
X2404 oa_sar8_acore18_opt_0.sw_tg_opt_0.bot.t3 oa_sar8_acore18_opt_0.sw_bitcell_opt_b6_0.bot.t70 cap_cmim l=2.14u w=2.14u
X2405 oa_sar8_acore18_opt_0.bstrap_opt_w2_c1200_1.out oa_sar8_acore18_opt_0.bstrap_opt_w2_c1200_1.gb oa_sar8_acore18_opt_0.sw_bitcell_opt_b1_1.bot.t0 VSS.t1091 sg13_lv_nmos ad=0.35p pd=2.7u as=0.195p ps=1.39u w=1u l=0.13u
X2406 VSS.t11 VDD.t198 VSS.t11 VSS.t126 sg13_lv_nmos ad=0.1428p pd=1.52u as=0 ps=0 w=0.42u l=1u
X2407 oa_sar8_acore18_opt_0.sw_bitcell_opt_term_0.trkb.t4 sar_ctrl_async_phys_0.sample VSS.t239 VSS.t238 sg13_lv_nmos ad=0.195p pd=1.39u as=0.35p ps=2.7u w=1u l=0.13u
X2408 VDD.t205 sar_ctrl_async_phys_0.sg13g2_buf_1_2.X a_29306_32361# VDD.t118 sg13_lv_pmos ad=0.1563p pd=1.22u as=0.147p ps=1.54u w=0.42u l=0.13u
X2409 sar_ctrl_async_phys_0.dac_code[2] a_35672_42760# VSS.t178 VSS.t1203 sg13_lv_nmos ad=0.2886p pd=2.26u as=0.14875p ps=1.16u w=0.74u l=0.13u
X2410 VDD.t35 sar_ctrl_async_phys_0.sg13g2_nand2b_1_2.Y a_34904_46508# VDD.t29 sg13_lv_pmos ad=0.2114p pd=1.54u as=0.2856p ps=2.36u w=0.84u l=0.13u
X2411 a_27134_39887# a_27249_39888# VSS.t90 VSS.t89 sg13_lv_nmos ad=0.1428p pd=1.52u as=0.1426p ps=1.16u w=0.42u l=0.5u
X2412 a_33385_32453# a_32443_32260# a_33183_32215# VDD.t118 sg13_lv_pmos ad=93.45f pd=0.865u as=0.2048p ps=1.63u w=0.42u l=0.13u
X2413 a_31328_33870# sar_ctrl_async_phys_0.sg13g2_buf_1_2.X.t2 VDD.t54 VDD.t54 sg13_lv_pmos ad=79.8f pd=0.8u as=2.2076p ps=14.4u w=0.42u l=0.13u
X2414 a_34208_45966# sar_ctrl_async_phys_0.sg13g2_o21ai_1_1.B1 VDD.t323 VDD.t29 sg13_lv_pmos ad=79.8f pd=0.8u as=2.2076p ps=14.4u w=0.42u l=0.13u
X2415 sar_ctrl_async_phys_0.sg13g2_a21oi_1_6.B1 a_34765_45266# VDD.t415 VDD.t69 sg13_lv_pmos ad=0.2128p pd=1.5u as=0.3808p ps=2.92u w=1.12u l=0.13u
X2416 a_28008_23477# sar_ctrl_async_phys_0.cmp_fire VSS.t645 VSS.t644 sg13_lv_nmos ad=0.285p pd=1.88u as=0.5175p ps=3.69u w=1.5u l=0.3u
X2417 sar_ctrl_async_phys_0.sg13g2_nor2_1_13.Y sar_ctrl_async_phys_0.sg13g2_inv_1_9.Y VSS.t72 VSS.t71 sg13_lv_nmos ad=0.1406p pd=1.12u as=0.2516p ps=2.16u w=0.74u l=0.13u
X2418 VSS.t37 a_30752_39190# a_30401_39309# VSS.t201 sg13_lv_nmos ad=79.8f pd=0.8u as=0.1428p ps=1.52u w=0.42u l=0.13u
X2419 VSS.t429 sar_ctrl_async_phys_0.sg13g2_dfrbpq_1_2.Q a_34520_38224# VSS.t87 sg13_lv_nmos ad=0.14875p pd=1.16u as=0.187p ps=1.78u w=0.55u l=0.13u
X2420 VSS.t957 VDD.t119 VSS.t959 VSS.t958 sg13_lv_nmos ad=79.8f pd=0.8u as=0 ps=0 w=0.42u l=1u
X2421 VSS.t101 a_35295_36285# a_35962_35924# VSS.t164 sg13_lv_nmos ad=0.1406p pd=1.12u as=0.2516p ps=2.16u w=0.74u l=0.13u
X2422 a_34010_35892# a_34453_35935# a_33750_36362# VSS.t424 sg13_lv_nmos ad=79.8f pd=0.8u as=0.1296p ps=1.52u w=0.42u l=0.13u
X2423 oa_sar8_acore18_opt_0.sw_tg_opt_1.bot.t3 oa_sar8_acore18_opt_0.sw_bitcell_opt_b6_1.bot.t74 cap_cmim l=2.14u w=2.14u
X2424 a_31732_32138# sar_ctrl_async_phys_0.sg13g2_inv_1_1.Y a_31638_32138# VSS.t1132 sg13_lv_nmos ad=60.89999f pd=0.71u as=0.1428p ps=1.52u w=0.42u l=0.13u
X2425 VDD.t198 sar_ctrl_async_phys_0.sg13g2_a22oi_1_1.B2 a_33752_33688# VDD.t54 sg13_lv_pmos ad=0.2114p pd=1.54u as=0.2856p ps=2.36u w=0.84u l=0.13u
X2426 oa_sar8_acore18_opt_0.sw_tg_opt_1.bot.t3 oa_sar8_acore18_opt_0.sw_bitcell_opt_b7_1.bot.t57 cap_cmim l=2.14u w=2.14u
X2427 VSS.t1003 VDD.t119 VSS.t18 VSS.t17 sg13_lv_nmos ad=0.1428p pd=1.52u as=0 ps=0 w=0.42u l=1u
X2428 VDD.t343 a_30591_32215# a_31258_32436# VDD.t118 sg13_lv_pmos ad=0.2128p pd=1.5u as=0.3864p ps=2.93u w=1.12u l=0.13u
X2429 a_34106_34380# a_34549_34423# a_34489_34459# VDD.t54 sg13_lv_pmos ad=79.8f pd=0.8u as=63f ps=0.72u w=0.42u l=0.13u
X2430 VDD.t810 sar_ctrl_async_phys_0.dac_code_n[4] oa_sar8_acore18_opt_0.sw_bitcell_opt_b4_1.bot.t33 VDD.t809 sg13_lv_pmos ad=1.68p pd=10.3u as=0.936p ps=5.19u w=4.8u l=0.13u
X2431 a_29524_40464# a_29498_40428# VSS.t33 VSS.t355 sg13_lv_nmos ad=0.2516p pd=2.16u as=0.1626p ps=1.415u w=0.74u l=0.13u
X2432 a_30390_39698# sar_ctrl_async_phys_0.sg13g2_dfrbpq_1_22.D VDD.t312 VDD.t311 sg13_lv_pmos ad=79.8f pd=0.8u as=0.1428p ps=1.52u w=0.42u l=0.13u
X2433 oa_sar8_acore18_opt_0.sw_tg_opt_0.bot.t3 oa_sar8_acore18_opt_0.sw_bitcell_opt_b7_0.bot.t89 cap_cmim l=2.14u w=2.14u
X2434 VDD.t182 VSS.t1003 VDD.t182 VDD.t39 sg13_lv_pmos ad=0.34p pd=2.68u as=0 ps=0 w=1u l=1u
X2435 sar_ctrl_async_phys_0.sg13g2_buf_1_9.A a_33850_32436# VDD.t342 VDD.t118 sg13_lv_pmos ad=0.3808p pd=2.92u as=0.2128p ps=1.5u w=1.12u l=0.13u
X2436 sar_ctrl_async_phys_0.sg13g2_nor2_1_10.B sar_ctrl_async_phys_0.sg13g2_a21oi_1_2.B1 VSS.t37 VSS.t571 sg13_lv_nmos ad=0.1406p pd=1.12u as=0.2516p ps=2.16u w=0.74u l=0.13u
X2437 VSS.t125 a_31189_31399# a_31291_31399# VSS.t589 sg13_lv_nmos ad=4.0265p pd=25.31u as=0.2516p ps=2.16u w=0.74u l=0.13u
X2438 a_32442_38484# sar_ctrl_async_phys_0.sg13g2_nor2_1_0.A VDD.t247 VDD.t162 sg13_lv_pmos ad=0.1176p pd=1.33u as=0.4032p ps=2.96u w=1.12u l=0.13u
X2439 oa_sar8_acore18_opt_0.sw_tg_opt_1.bot.t3 oa_sar8_acore18_opt_0.sw_bitcell_opt_b6_1.bot.t21 cap_cmim l=2.14u w=2.14u
X2440 a_35648_30846# a_35391_30703# a_35810_30626# VSS.t1146 sg13_lv_nmos ad=0.1428p pd=1.52u as=37.8f ps=0.6u w=0.42u l=0.13u
X2441 a_35810_34850# sar_ctrl_async_phys_0.sg13g2_buf_1_2.A VSS.t113 VSS.t199 sg13_lv_nmos ad=37.8f pd=0.6u as=79.8f ps=0.8u w=0.42u l=0.13u
X2442 sar_ctrl_async_phys_0.sg13g2_and2_1_0.B a_35962_35924# VDD.t447 VDD.t37 sg13_lv_pmos ad=0.3808p pd=2.92u as=0.2128p ps=1.5u w=1.12u l=0.13u
X2443 VDD.t247 VSS.t853 VDD.t247 VDD.t162 sg13_lv_pmos ad=0.19p pd=1.38u as=0 ps=0 w=1u l=1u
X2444 VSS.t672 VDD.t101 VSS.t672 VSS.t671 sg13_lv_nmos ad=0.1428p pd=1.52u as=0 ps=0 w=0.42u l=1u
X2445 oa_sar8_acore18_opt_0.sw_bitcell_opt_term_0.vin oa_sar8_acore18_opt_0.sw_bitcell_opt_term_0.gb.t6 oa_sar8_acore18_opt_0.sw_bitcell_opt_b1_0.bot.t0 VSS.t542 sg13_lv_nmos ad=0.35p pd=2.7u as=0.195p ps=1.39u w=1u l=0.13u
X2446 VSS.t113 sar_ctrl_async_phys_0.sg13g2_buf_1_16.A a_34424_35200# VSS.t112 sg13_lv_nmos ad=0.14875p pd=1.16u as=0.187p ps=1.78u w=0.55u l=0.13u
X2447 a_34549_34423# sar_ctrl_async_phys_0.sg13g2_dfrbpq_1_0.CLK.t8 VSS.t393 VSS.t392 sg13_lv_nmos ad=0.2516p pd=2.16u as=4.70937p ps=30.235u w=0.74u l=0.13u
X2448 a_35295_36285# a_34453_35935# a_35201_36285# VSS.t164 sg13_lv_nmos ad=0.12665p pd=1.145u as=0.1428p ps=1.52u w=0.42u l=0.13u
X2449 a_31828_37440# a_31802_37404# VDD.t14 VDD.t13 sg13_lv_pmos ad=0.34p pd=2.68u as=0.36237p ps=2.605u w=1u l=0.13u
X2450 a_35552_36166# sar_ctrl_async_phys_0.sg13g2_buf_1_2.A VDD.t37 VDD.t37 sg13_lv_pmos ad=79.8f pd=0.8u as=1.66112p ps=10.725u w=0.42u l=0.13u
X2451 a_35360_36894# a_35103_36751# a_35522_36674# VSS.t100 sg13_lv_nmos ad=0.1428p pd=1.52u as=37.8f ps=0.6u w=0.42u l=0.13u
X2452 a_28506_37436# sar_ctrl_async_phys_0.sg13g2_nand2_1_0.Y VDD.t471 VDD.t13 sg13_lv_pmos ad=0.1176p pd=1.33u as=0.4032p ps=2.96u w=1.12u l=0.13u
X2453 oa_sar8_acore18_opt_0.sw_bitcell_opt_b1_1.bot.t0 sar_ctrl_async_phys_0.dac_code_n[1].t1 oa_sar8_acore18_opt_0.sw_bitcell_opt_b7_1.VSS VSS.t1232 sg13_lv_nmos ad=0.3315p pd=2.09u as=0.595p ps=4.1u w=1.7u l=0.13u
X2454 a_30037_43495# sar_ctrl_async_phys_0.sg13g2_dfrbpq_1_0.CLK VSS.t78 VSS.t1205 sg13_lv_nmos ad=0.2516p pd=2.16u as=3.64875p ps=22.56u w=0.74u l=0.13u
X2455 oa_sar8_acore18_opt_0.sw_tg_opt_1.bot.t2 oa_sar8_acore18_opt_0.sw_bitcell_opt_b7_1.bot.t157 cap_cmim l=2.14u w=2.14u
X2456 VSS.t5 VDD.t198 VSS.t5 VSS.t951 sg13_lv_nmos ad=0.1428p pd=1.52u as=0 ps=0 w=0.42u l=1u
X2457 a_30390_36362# sar_ctrl_async_phys_0.sg13g2_a22oi_1_0.B1 VDD.t185 VDD.t37 sg13_lv_pmos ad=79.8f pd=0.8u as=0.1428p ps=1.52u w=0.42u l=0.13u
X2458 oa_sar8_acore18_opt_0.sw_tg_opt_0.bot.t4 oa_sar8_acore18_opt_0.sw_bitcell_opt_b7_0.bot.t5 cap_cmim l=2.14u w=2.14u
X2459 oa_sar8_acore18_opt_0.sw_bitcell_opt_b0_1.bot.t0 oa_sar8_acore18_opt_0.bstrap_opt_w2_c1200_1.gb oa_sar8_acore18_opt_0.bstrap_opt_w2_c1200_1.out VSS.t1090 sg13_lv_nmos ad=0.195p pd=1.39u as=0.35p ps=2.7u w=1u l=0.13u
X2460 VDD.t198 sar_ctrl_async_phys_0.sg13g2_buf_1_2.A a_33846_34850# VDD.t54 sg13_lv_pmos ad=0.36237p pd=2.605u as=79.8f ps=0.8u w=0.42u l=0.13u
X2461 VSS.t801 VDD.t176 VSS.t801 VSS.t817 sg13_lv_nmos ad=79.8f pd=0.8u as=0 ps=0 w=0.42u l=1u
X2462 sar_ctrl_async_phys_0.sg13g2_dfrbpq_1_0.CLK.t0 a_29350_41996# VDD.t187 VDD.t5 sg13_lv_pmos ad=0.4256p pd=3u as=0.2254p ps=1.53u w=1.12u l=0.13u
X2463 vinn oa_sar8_acore18_opt_0.sw_bitcell_opt_term_0.gb.t3 oa_sar8_acore18_opt_0.sw_bitcell_opt_term_0.vin VSS.t210 sg13_lv_nmos ad=0.35p pd=2.7u as=0.195p ps=1.39u w=1u l=0.13u
X2464 sar_ctrl_async_phys_0.sg13g2_buf_1_5.A a_31738_33948# VSS.t11 VSS.t126 sg13_lv_nmos ad=0.2516p pd=2.16u as=0.1406p ps=1.12u w=0.74u l=0.13u
X2465 a_33913_40089# a_33556_40016# VDD.t314 VDD.t311 sg13_lv_pmos ad=63f pd=0.72u as=0.1563p ps=1.22u w=0.42u l=0.13u
X2466 VDD.t119 VSS.t1008 VDD.t119 VDD.t118 sg13_lv_pmos ad=0.19p pd=1.38u as=0 ps=0 w=1u l=1u
X2467 a_32404_40885# a_32635_40471# a_32090_40428# VSS.t495 sg13_lv_nmos ad=0.2373p pd=1.97u as=79.8f ps=0.8u w=0.42u l=0.13u
X2468 VDD.t70 VSS.t724 VDD.t70 VDD.t69 sg13_lv_pmos ad=0.19p pd=1.38u as=0 ps=0 w=1u l=1u
X2469 oa_sar8_acore18_opt_0.sw_tg_opt_1.bot.t3 oa_sar8_acore18_opt_0.sw_bitcell_opt_b6_1.bot.t1 cap_cmim l=2.14u w=2.14u
X2470 VSS.t82 a_33951_45823# a_34618_46044# VSS.t81 sg13_lv_nmos ad=0.1406p pd=1.12u as=0.2516p ps=2.16u w=0.74u l=0.13u
X2471 VSS.t9 sar_ctrl_async_phys_0.sg13g2_buf_1_2.X a_34362_31826# VSS.t14 sg13_lv_nmos ad=79.8f pd=0.8u as=37.8f ps=0.6u w=0.42u l=0.13u
X2472 result[7] a_34904_33688# VDD.t556 VDD.t54 sg13_lv_pmos ad=0.42p pd=2.99u as=0.2114p ps=1.54u w=1.12u l=0.13u
X2473 a_30733_35166# sar_ctrl_async_phys_0.sg13g2_buf_1_16.A VSS.t115 VSS.t114 sg13_lv_nmos ad=0.13135p pd=1.095u as=0.18945p ps=1.27u w=0.74u l=0.13u
X2474 VSS.t82 sar_ctrl_async_phys_0.sg13g2_nand2_1_3.A a_34847_45366# VSS.t648 sg13_lv_nmos ad=0.14505p pd=1.15u as=0.1406p ps=1.12u w=0.74u l=0.13u
X2475 VDD.t311 a_33973_39677# a_34075_39820# VDD.t311 sg13_lv_pmos ad=1.6658p pd=10.66u as=0.3864p ps=2.93u w=1.12u l=0.13u
X2476 oa_sar8_acore18_opt_0.sw_tg_opt_0.bot.t3 oa_sar8_acore18_opt_0.sw_bitcell_opt_b5_0.bot.t35 cap_cmim l=2.14u w=2.14u
X2477 oa_sar8_acore18_opt_0.sw_tg_opt_1.bot.t3 oa_sar8_acore18_opt_0.sw_bitcell_opt_b7_1.bot.t136 cap_cmim l=2.14u w=2.14u
X2478 oa_sar8_acore18_opt_0.sw_tg_opt_0.bot.t3 oa_sar8_acore18_opt_0.sw_bitcell_opt_b7_0.bot.t73 cap_cmim l=2.14u w=2.14u
X2479 oa_sar8_acore18_opt_0.sw_tg_opt_1.bot.t3 oa_sar8_acore18_opt_0.sw_bitcell_opt_b7_1.bot.t47 cap_cmim l=2.14u w=2.14u
X2480 sar_ctrl_async_phys_0.sg13g2_dlygate4sd3_1_8.A a_26662_41278# VSS.t58 VSS.t613 sg13_lv_nmos ad=0.2516p pd=2.16u as=0.1426p ps=1.16u w=0.74u l=0.13u
X2481 a_34420_33325# a_34651_32911# a_34106_32868# VSS.t666 sg13_lv_nmos ad=0.2373p pd=1.97u as=79.8f ps=0.8u w=0.42u l=0.13u
X2482 VSS.t892 VDD.t46 VSS.t894 VSS.t893 sg13_lv_nmos ad=79.8f pd=0.8u as=0 ps=0 w=0.42u l=1u
X2483 VSS.t137 sar_ctrl_async_phys_0.sg13g2_dlygate4sd3_1_3.A a_28968_42013# VSS.t502 sg13_lv_nmos ad=79.8f pd=0.8u as=0.1428p ps=1.52u w=0.42u l=0.13u
X2484 a_33846_33338# sar_ctrl_async_phys_0.sg13g2_inv_1_2.Y VDD.t342 VDD.t118 sg13_lv_pmos ad=79.8f pd=0.8u as=0.1428p ps=1.52u w=0.42u l=0.13u
X2485 VDD.t238 VSS.t920 VDD.t238 VDD.t54 sg13_lv_pmos ad=0.19p pd=1.38u as=0 ps=0 w=1u l=1u
X2486 VSS.t920 VDD.t46 VSS.t920 VSS.t114 sg13_lv_nmos ad=0.1428p pd=1.52u as=0 ps=0 w=0.42u l=1u
X2487 oa_sar8_acore18_opt_0.sw_bitcell_opt_b5_0.bot.t0 sar_ctrl_async_phys_0.dac_code[5] oa_sar8_acore18_opt_0.sw_bitcell_opt_term_0.VSS VSS.t1197 sg13_lv_nmos ad=0.5265p pd=3.09u as=0.945p ps=6.1u w=2.7u l=0.13u
X2488 VDD.t242 VSS.t976 VDD.t244 VDD.t54 sg13_lv_pmos ad=0.34p pd=2.68u as=0 ps=0 w=1u l=1u
X2489 VDD.t191 VSS.t889 VDD.t191 VDD.t13 sg13_lv_pmos ad=0.19p pd=1.38u as=0 ps=0 w=1u l=1u
X2490 VSS.t103 a_32580_43448# sar_ctrl_async_phys_0.sg13g2_nor2b_1_4.Y VSS.t590 sg13_lv_nmos ad=0.17255p pd=1.25u as=0.1406p ps=1.12u w=0.74u l=0.13u
X2491 VSS.t144 VDD.t191 VSS.t144 VSS.t861 sg13_lv_nmos ad=0.1428p pd=1.52u as=0 ps=0 w=0.42u l=1u
X2492 a_34596_40424# sar_ctrl_async_phys_0.sg13g2_buf_1_14.A VDD.t314 VDD.t311 sg13_lv_pmos ad=0.2856p pd=2.36u as=0.2618p ps=1.63u w=0.84u l=0.13u
X2493 VSS.t515 a_33109_45725# a_33211_45868# VSS.t1117 sg13_lv_nmos ad=6.70155p pd=42.66u as=0.2516p ps=2.16u w=0.74u l=0.13u
X2494 VSS.t782 VDD.t79 VSS.t312 VSS.t781 sg13_lv_nmos ad=0.1428p pd=1.52u as=0 ps=0 w=0.42u l=1u
X2495 oa_sar8_acore18_opt_0.sw_bitcell_opt_term_0.vin oa_sar8_acore18_opt_0.sw_bitcell_opt_term_0.trkb.t16 oa_sar8_acore18_opt_0.sw_bitcell_opt_b2_0.bot.t0 VDD.t704 sg13_lv_pmos ad=0.7p pd=4.7u as=0.39p ps=2.39u w=2u l=0.13u
X2496 VDD.t212 VSS.t926 VDD.t211 VDD.t54 sg13_lv_pmos ad=0.19p pd=1.38u as=0 ps=0 w=1u l=1u
X2497 a_32537_41256# sar_ctrl_async_phys_0.sg13g2_buf_1_6.A VSS.t48 VSS.t1263 sg13_lv_nmos ad=0.1216p pd=1.02u as=0.1331p ps=1.12u w=0.64u l=0.13u
X2498 oa_sar8_acore18_opt_0.sw_tg_opt_1.bot.t2 oa_sar8_acore18_opt_0.sw_bitcell_opt_b7_1.bot.t162 cap_cmim l=2.14u w=2.14u
X2499 oa_sar8_acore18_opt_0.sw_tg_opt_1.bot.t3 oa_sar8_acore18_opt_0.sw_bitcell_opt_b7_1.bot.t136 cap_cmim l=2.14u w=2.14u
X2500 a_33248_45238# sar_ctrl_async_phys_0.sg13g2_dfrbpq_1_9.RESET_B VDD.t346 VDD.t69 sg13_lv_pmos ad=79.8f pd=0.8u as=1.79957p ps=11.62u w=0.42u l=0.13u
X2501 oa_sar8_acore18_opt_0.sw_tg_opt_1.bot.t3 oa_sar8_acore18_opt_0.sw_bitcell_opt_b5_1.bot.t21 cap_cmim l=2.14u w=2.14u
X2502 oa_sar8_acore18_opt_0.sw_tg_opt_1.bot.t3 oa_sar8_acore18_opt_0.sw_bitcell_opt_b3_1.bot.t4 cap_cmim l=2.14u w=2.14u
X2503 oa_sar8_acore18_opt_0.sw_tg_opt_1.bot.t3 oa_sar8_acore18_opt_0.sw_bitcell_opt_b7_1.bot.t94 cap_cmim l=2.14u w=2.14u
X2504 a_33109_45725# sar_ctrl_async_phys_0.sg13g2_dfrbpq_1_0.CLK VDD.t323 VDD.t29 sg13_lv_pmos ad=0.4088p pd=2.97u as=1.98685p ps=12.96u w=1.12u l=0.13u
X2505 VDD.t389 sar_ctrl_async_phys_0.sg13g2_nand2_1_2.B sar_ctrl_async_phys_0.sg13g2_nand2_1_2.Y VDD.t0 sg13_lv_pmos ad=0.3808p pd=2.92u as=0.2128p ps=1.5u w=1.12u l=0.13u
X2506 VDD.t163 VSS.t154 VDD.t163 VDD.t162 sg13_lv_pmos ad=0.19p pd=1.38u as=0 ps=0 w=1u l=1u
X2507 oa_sar8_acore18_opt_0.sw_tg_opt_1.bot.t4 oa_sar8_acore18_opt_0.sw_bitcell_opt_b7_1.bot.t9 cap_cmim l=2.14u w=2.14u
X2508 a_31706_35385# a_32149_35141# a_32089_35553# VDD.t37 sg13_lv_pmos ad=79.8f pd=0.8u as=63f ps=0.72u w=0.42u l=0.13u
X2509 oa_sar8_acore18_opt_0.sw_tg_opt_0.bot.t3 oa_sar8_acore18_opt_0.sw_bitcell_opt_b4_0.bot.t12 cap_cmim l=2.14u w=2.14u
X2510 sar_ctrl_async_phys_0.sg13g2_buf_1_8.A a_36058_32900# VSS.t64 VSS.t152 sg13_lv_nmos ad=0.2516p pd=2.16u as=0.1406p ps=1.12u w=0.74u l=0.13u
X2511 VSS.t7 sar_ctrl_async_phys_0.sg13g2_a22oi_1_5.A2 a_30942_33292# VSS.t6 sg13_lv_nmos ad=0.2516p pd=2.16u as=96.2f ps=1u w=0.74u l=0.13u
X2512 VDD.t86 VSS.t727 VDD.t94 VDD.t29 sg13_lv_pmos ad=0.19p pd=1.38u as=0 ps=0 w=1u l=1u
X2513 VDD.t44 VSS.t1061 VDD.t44 VDD.t39 sg13_lv_pmos ad=0.19p pd=1.38u as=0 ps=0 w=1u l=1u
X2514 a_29428_43922# sar_ctrl_async_phys_0.sg13g2_nor2_1_11.A a_29334_43922# VSS.t185 sg13_lv_nmos ad=60.89999f pd=0.71u as=0.1428p ps=1.52u w=0.42u l=0.13u
X2515 sar_ctrl_async_phys_0.sg13g2_a22oi_1_0.B1 a_31832_34412# VSS.t115 VSS.t1179 sg13_lv_nmos ad=0.2886p pd=2.26u as=0.14875p ps=1.16u w=0.74u l=0.13u
X2516 VDD.t22 VSS.t129 VDD.t22 VDD.t15 sg13_lv_pmos ad=0.19p pd=1.38u as=0 ps=0 w=1u l=1u
X2517 a_35245_45936# sar_ctrl_async_phys_0.sg13g2_nand2_1_6.B VSS.t174 VSS.t179 sg13_lv_nmos ad=0.187p pd=1.78u as=0.14505p ps=1.15u w=0.55u l=0.13u
X2518 VSS.t1068 VDD.t40 VSS.t1070 VSS.t1069 sg13_lv_nmos ad=79.8f pd=0.8u as=0 ps=0 w=0.42u l=1u
X2519 a_32116_40464# a_32090_40428# VSS.t35 VSS.t1252 sg13_lv_nmos ad=0.2516p pd=2.16u as=0.1626p ps=1.415u w=0.74u l=0.13u
X2520 a_32116_40464# a_32635_40471# a_33375_40821# VSS.t496 sg13_lv_nmos ad=0.3473p pd=2.71u as=0.12665p ps=1.145u w=0.74u l=0.13u
X2521 VDD.t198 sar_ctrl_async_phys_0.sg13g2_a22oi_1_0.B1 sar_ctrl_async_phys_0.sg13g2_buf_1_16.A VDD.t54 sg13_lv_pmos ad=0.3808p pd=2.92u as=0.3808p ps=2.92u w=1.12u l=0.13u
X2522 VSS.t50 VDD.t350 VSS.t50 VSS.t860 sg13_lv_nmos ad=0.1428p pd=1.52u as=0 ps=0 w=0.42u l=1u
X2523 a_35456_44454# sar_ctrl_async_phys_0.sg13g2_dfrbpq_1_9.RESET_B VDD.t346 VDD.t69 sg13_lv_pmos ad=79.8f pd=0.8u as=1.79957p ps=11.62u w=0.42u l=0.13u
X2524 oa_sar8_acore18_opt_0.bstrap_opt_w2_c1200_1.out oa_sar8_acore18_opt_0.bstrap_opt_w2_c1200_1.gb oa_sar8_acore18_opt_0.sw_bitcell_opt_b3_1.bot.t0 VSS.t1093 sg13_lv_nmos ad=0.35p pd=2.7u as=0.195p ps=1.39u w=1u l=0.13u
X2525 VDD.t547 sar_ctrl_async_phys_0.sg13g2_inv_1_0.Y a_35463_31435# VDD.t39 sg13_lv_pmos ad=0.1428p pd=1.52u as=79.8f ps=0.8u w=0.42u l=0.13u
X2526 VSS.t72 a_26174_42911# sar_ctrl_async_phys_0.sg13g2_dlygate4sd3_1_6.X VSS.t426 sg13_lv_nmos ad=0.1426p pd=1.16u as=0.2516p ps=2.16u w=0.74u l=0.13u
X2527 a_31898_32361# a_32341_32117# a_31638_32138# VSS.t97 sg13_lv_nmos ad=79.8f pd=0.8u as=0.1296p ps=1.52u w=0.42u l=0.13u
X2528 VDD.t247 VSS.t172 VDD.t247 VDD.t162 sg13_lv_pmos ad=0.34p pd=2.68u as=0 ps=0 w=1u l=1u
X2529 oa_sar8_acore18_opt_0.sw_tg_opt_0.bot.t3 oa_sar8_acore18_opt_0.sw_bitcell_opt_b7_0.bot.t52 cap_cmim l=2.14u w=2.14u
X2530 VDD.t194 VSS.t1028 VDD.t194 VDD.t39 sg13_lv_pmos ad=0.34p pd=2.68u as=0 ps=0 w=1u l=1u
X2531 a_34132_32904# a_34651_32911# a_35391_33261# VSS.t152 sg13_lv_nmos ad=0.3473p pd=2.71u as=0.12665p ps=1.145u w=0.74u l=0.13u
X2532 VSS.t75 sar_ctrl_async_phys_0.sg13g2_nand2b_1_1.Y a_35672_46508# VSS.t91 sg13_lv_nmos ad=0.14875p pd=1.16u as=0.187p ps=1.78u w=0.55u l=0.13u
X2533 oa_sar8_acore18_opt_0.sw_tg_opt_1.bot.t3 oa_sar8_acore18_opt_0.sw_bitcell_opt_b5_1.bot.t14 cap_cmim l=2.14u w=2.14u
X2534 sar_ctrl_async_phys_0.sg13g2_nor2_1_0.A sar_ctrl_async_phys_0.sg13g2_nor2b_1_0.A.t3 VSS.t1233 VSS.t85 sg13_lv_nmos ad=0.1406p pd=1.12u as=0.2516p ps=2.16u w=0.74u l=0.13u
X2535 a_35593_34535# a_34651_34423# a_35391_34773# VDD.t54 sg13_lv_pmos ad=93.45f pd=0.865u as=0.2048p ps=1.63u w=0.42u l=0.13u
X2536 VDD.t169 VSS.t22 VDD.t169 VDD.t29 sg13_lv_pmos ad=0.19p pd=1.38u as=0 ps=0 w=1u l=1u
X2537 oa_sar8_acore18_opt_0.sw_tg_opt_0.bot.t3 oa_sar8_acore18_opt_0.sw_bitcell_opt_b5_0.bot.t30 cap_cmim l=2.14u w=2.14u
X2538 a_32958_33292# sar_ctrl_async_phys_0.sg13g2_a22oi_1_0.A1.t11 sar_ctrl_async_phys_0.sg13g2_inv_1_1.A VSS.t6 sg13_lv_nmos ad=96.2f pd=1u as=0.2664p ps=1.46u w=0.74u l=0.13u
X2539 VDD.t40 VSS.t592 VDD.t40 VDD.t39 sg13_lv_pmos ad=0.19p pd=1.38u as=0 ps=0 w=1u l=1u
X2540 sar_ctrl_async_phys_0.sg13g2_nor2_1_6.A sar_ctrl_async_phys_0.sg13g2_buf_1_13.X VDD.t163 VDD.t162 sg13_lv_pmos ad=0.3808p pd=2.92u as=0.3808p ps=2.92u w=1.12u l=0.13u
X2541 VSS.t154 sar_ctrl_async_phys_0.sg13g2_nor2_1_7.A sar_ctrl_async_phys_0.sg13g2_nor2_1_7.Y VSS.t153 sg13_lv_nmos ad=0.2516p pd=2.16u as=0.1406p ps=1.12u w=0.74u l=0.13u
X2542 a_33248_45238# a_32991_45357# a_33410_45434# VSS.t1277 sg13_lv_nmos ad=0.1428p pd=1.52u as=37.8f ps=0.6u w=0.42u l=0.13u
X2543 VSS.t331 a_32533_40471# a_32635_40471# VSS.t330 sg13_lv_nmos ad=5.25845p pd=33.575u as=0.2516p ps=2.16u w=0.74u l=0.13u
X2544 VSS.t144 VDD.t361 VSS.t144 VSS.t865 sg13_lv_nmos ad=0.1428p pd=1.52u as=0 ps=0 w=0.42u l=1u
X2545 a_31071_33727# a_30229_33629# a_30977_33727# VSS.t126 sg13_lv_nmos ad=0.12665p pd=1.145u as=0.1428p ps=1.52u w=0.42u l=0.13u
X2546 VDD.t389 sar_ctrl_async_phys_0.sg13g2_dfrbpq_1_9.RESET_B a_33818_43452# VDD.t0 sg13_lv_pmos ad=0.1563p pd=1.22u as=0.147p ps=1.54u w=0.42u l=0.13u
X2547 VDD.t182 VSS.t1008 VDD.t182 VDD.t39 sg13_lv_pmos ad=0.34p pd=2.68u as=0 ps=0 w=1u l=1u
X2548 a_26558_40727# a_26673_40726# VSS.t58 VSS.t636 sg13_lv_nmos ad=0.1428p pd=1.52u as=0.1426p ps=1.16u w=0.42u l=0.5u
X2549 oa_sar8_acore18_opt_0.sw_tg_opt_1.bot.t4 oa_sar8_acore18_opt_0.sw_bitcell_opt_b7_1.bot.t9 cap_cmim l=2.14u w=2.14u
X2550 sar_ctrl_async_phys_0.sg13g2_inv_1_10.Y sar_ctrl_async_phys_0.sg13g2_dfrbpq_1_0.CLK VSS.t60 VSS.t520 sg13_lv_nmos ad=0.2516p pd=2.16u as=0.2516p ps=2.16u w=0.74u l=0.13u
X2551 a_28130_40838# sar_ctrl_async_phys_0.sg13g2_inv_1_10.Y VSS.t60 VSS.t373 sg13_lv_nmos ad=0.2516p pd=2.16u as=0.1406p ps=1.12u w=0.74u l=0.15u
X2552 a_33750_36362# a_34555_35935# a_34010_35892# VDD.t37 sg13_lv_pmos ad=0.1428p pd=1.52u as=79.8f ps=0.8u w=0.42u l=0.13u
X2553 VDD.t22 sar_ctrl_async_phys_0.sg13g2_nor2_1_4.Y a_34136_47296# VDD.t15 sg13_lv_pmos ad=0.2114p pd=1.54u as=0.2856p ps=2.36u w=0.84u l=0.13u
X2554 oa_sar8_acore18_opt_0.sw_tg_opt_0.bot.t3 oa_sar8_acore18_opt_0.sw_bitcell_opt_b6_0.bot.t25 cap_cmim l=2.14u w=2.14u
X2555 VSS.t1008 VDD.t230 VSS.t1008 VSS.t17 sg13_lv_nmos ad=0.1428p pd=1.52u as=0 ps=0 w=0.42u l=1u
X2556 oa_sar8_acore18_opt_0.sw_tg_opt_0.bot.t4 oa_sar8_acore18_opt_0.sw_bitcell_opt_b7_0.bot.t15 cap_cmim l=2.14u w=2.14u
X2557 VSS.t920 VDD.t46 VSS.t920 VSS.t114 sg13_lv_nmos ad=79.8f pd=0.8u as=0 ps=0 w=0.42u l=1u
X2558 VSS.t151 a_34549_32911# a_34651_32911# VSS.t150 sg13_lv_nmos ad=5.99755p pd=39.725u as=0.2516p ps=2.16u w=0.74u l=0.13u
X2559 a_30390_39698# a_31195_39820# a_30650_39921# VDD.t311 sg13_lv_pmos ad=0.1428p pd=1.52u as=79.8f ps=0.8u w=0.42u l=0.13u
X2560 VDD.t44 VSS.t464 VDD.t44 VDD.t39 sg13_lv_pmos ad=0.34p pd=2.68u as=0 ps=0 w=1u l=1u
X2561 sar_ctrl_async_phys_0.sg13g2_nor2_1_3.B sar_ctrl_async_phys_0.sg13g2_buf_1_26.X a_26728_37416# VDD.t13 sg13_lv_pmos ad=0.2128p pd=1.5u as=0.2128p ps=1.5u w=1.12u l=0.15u
X2562 oa_sar8_acore18_opt_0.sw_tg_opt_1.bot.t3 oa_sar8_acore18_opt_0.sw_bitcell_opt_b6_1.bot.t54 cap_cmim l=2.14u w=2.14u
X2563 a_32149_35141# sar_ctrl_async_phys_0.sg13g2_dfrbpq_1_0.CLK.t9 VSS.t393 VSS.t553 sg13_lv_nmos ad=0.2516p pd=2.16u as=4.70937p ps=30.235u w=0.74u l=0.13u
X2564 sar_ctrl_async_phys_0.sg13g2_a21oi_1_3.A2 a_35482_39996# VSS.t166 VSS.t1245 sg13_lv_nmos ad=0.2516p pd=2.16u as=0.1406p ps=1.12u w=0.74u l=0.13u
X2565 VSS.t677 VDD.t16 VSS.t677 VSS.t681 sg13_lv_nmos ad=0.1428p pd=1.52u as=0 ps=0 w=0.42u l=1u
X2566 oa_sar8_acore18_opt_0.sw_bitcell_opt_b4_1.bot.t33 sar_ctrl_async_phys_0.dac_code_n[4] VDD.t811 VDD.t809 sg13_lv_pmos ad=0.936p pd=5.19u as=1.68p ps=10.3u w=4.8u l=0.13u
X2567 a_35245_45936# sar_ctrl_async_phys_0.sg13g2_nand2_1_6.B VDD.t35 VDD.t29 sg13_lv_pmos ad=0.2856p pd=2.36u as=0.2198p ps=1.53u w=0.84u l=0.13u
X2568 oa_sar8_acore18_opt_0.sw_tg_opt_1.bot.t3 oa_sar8_acore18_opt_0.sw_bitcell_opt_b7_1.bot.t78 cap_cmim l=2.14u w=2.14u
X2569 oa_sar8_acore18_opt_0.sw_tg_opt_0.bot.t3 oa_sar8_acore18_opt_0.sw_bitcell_opt_b7_0.bot.t120 cap_cmim l=2.14u w=2.14u
X2570 VSS.t7 sar_ctrl_async_phys_0.sg13g2_a21oi_1_7.Y a_31518_33292# VSS.t6 sg13_lv_nmos ad=0.2516p pd=2.16u as=96.2f ps=1u w=0.74u l=0.13u
X2571 VDD.t434 a_25596_43448# sar_ctrl_async_phys_0.sample VDD.t0 sg13_lv_pmos ad=0.2114p pd=1.54u as=0.42p ps=2.99u w=1.12u l=0.13u
X2572 sar_ctrl_async_phys_0.sg13g2_a21oi_1_7.Y sar_ctrl_async_phys_0.sg13g2_nand2b_1_1.Y VSS.t35 VSS.t628 sg13_lv_nmos ad=0.1406p pd=1.12u as=0.2516p ps=2.16u w=0.74u l=0.13u
X2573 oa_sar8_acore18_opt_0.sw_tg_opt_0.bot.t3 oa_sar8_acore18_opt_0.sw_bitcell_opt_b3_0.bot.t8 cap_cmim l=2.14u w=2.14u
X2574 VDD.t428 sar_ctrl_async_phys_0.sg13g2_buf_1_34.A a_36056_41972# VDD.t5 sg13_lv_pmos ad=0.2114p pd=1.54u as=0.2856p ps=2.36u w=0.84u l=0.13u
X2575 oa_sar8_acore18_opt_0.sw_tg_opt_1.bot.t3 oa_sar8_acore18_opt_0.sw_bitcell_opt_b5_1.bot.t1 cap_cmim l=2.14u w=2.14u
X2576 a_34261_43495# sar_ctrl_async_phys_0.sg13g2_dfrbpq_1_0.CLK VSS.t78 VSS.t1206 sg13_lv_nmos ad=0.2516p pd=2.16u as=3.64875p ps=22.56u w=0.74u l=0.13u
X2577 a_32027_43832# sar_ctrl_async_phys_0.sg13g2_a21oi_1_4.A2 a_31933_43832# VSS.t1260 sg13_lv_nmos ad=0.1216p pd=1.02u as=0.2176p ps=1.96u w=0.64u l=0.13u
X2578 a_21332_n9711# VDD.t1091 oa_sar8_acore18_opt_0.bstrap_opt_w2_c1200_1.gb VSS.t1077 sg13_lv_nmos ad=0.345p pd=2.69u as=0.19p ps=1.38u w=1u l=0.15u
X2579 VDD.t342 a_33183_32215# a_33850_32436# VDD.t118 sg13_lv_pmos ad=0.2128p pd=1.5u as=0.3864p ps=2.93u w=1.12u l=0.13u
X2580 a_30793_32453# a_29851_32260# a_30591_32215# VDD.t118 sg13_lv_pmos ad=93.45f pd=0.865u as=0.2048p ps=1.63u w=0.42u l=0.13u
X2581 a_35211_37436# sar_ctrl_async_phys_0.sg13g2_a21oi_1_0.B1 sar_ctrl_async_phys_0.sg13g2_a22oi_1_0.A2 VDD.t13 sg13_lv_pmos ad=0.2128p pd=1.5u as=0.3808p ps=2.92u w=1.12u l=0.13u
X2582 result[4] a_33752_33688# VDD.t198 VDD.t54 sg13_lv_pmos ad=0.42p pd=2.99u as=0.2114p ps=1.54u w=1.12u l=0.13u
X2583 oa_sar8_acore18_opt_0.sw_tg_opt_1.bot.t3 oa_sar8_acore18_opt_0.sw_bitcell_opt_b7_1.bot.t35 cap_cmim l=2.14u w=2.14u
X2584 a_31706_44964# a_32149_45007# a_32089_45043# VDD.t69 sg13_lv_pmos ad=79.8f pd=0.8u as=63f ps=0.72u w=0.42u l=0.13u
X2585 VDD.t14 sar_ctrl_async_phys_0.sg13g2_nand3b_1_0.Y a_29660_37436# VDD.t13 sg13_lv_pmos ad=0.4032p pd=2.96u as=0.1176p ps=1.33u w=1.12u l=0.13u
X2586 VSS.t727 VDD.t89 VSS.t727 VSS.t754 sg13_lv_nmos ad=79.8f pd=0.8u as=0 ps=0 w=0.42u l=1u
X2587 a_25596_43448# sar_ctrl_async_phys_0.sg13g2_nor2_1_13.Y VDD.t434 VDD.t0 sg13_lv_pmos ad=0.2856p pd=2.36u as=0.2114p ps=1.54u w=0.84u l=0.13u
X2588 VDD.t198 VSS.t5 VDD.t198 VDD.t54 sg13_lv_pmos ad=0.19p pd=1.38u as=0 ps=0 w=1u l=1u
X2589 oa_sar8_acore18_opt_0.sw_tg_opt_0.bot.t3 oa_sar8_acore18_opt_0.sw_bitcell_opt_b4_0.bot.t18 cap_cmim l=2.14u w=2.14u
X2590 oa_sar8_acore18_opt_0.sw_tg_opt_1.bot.t3 oa_sar8_acore18_opt_0.sw_bitcell_opt_b4_1.bot.t27 cap_cmim l=2.14u w=2.14u
X2591 a_31518_33292# sar_ctrl_async_phys_0.sg13g2_a22oi_1_0.A1.t13 sar_ctrl_async_phys_0.sg13g2_inv_1_5.A VSS.t6 sg13_lv_nmos ad=96.2f pd=1u as=0.2664p ps=1.46u w=0.74u l=0.13u
X2592 VDD.t192 VSS.t896 VDD.t46 VDD.t37 sg13_lv_pmos ad=0.34p pd=2.68u as=0 ps=0 w=1u l=1u
X2593 VDD.t366 sar_ctrl_async_phys_0.sg13g2_dfrbpq_1_9.RESET_B a_33558_43922# VDD.t0 sg13_lv_pmos ad=0.36237p pd=2.605u as=79.8f ps=0.8u w=0.42u l=0.13u
X2594 VSS.t11 sar_ctrl_async_phys_0.sg13g2_a22oi_1_1.B2 a_33752_33688# VSS.t126 sg13_lv_nmos ad=0.14875p pd=1.16u as=0.187p ps=1.78u w=0.55u l=0.13u
X2595 VSS.t897 VDD.t192 VSS.t899 VSS.t898 sg13_lv_nmos ad=79.8f pd=0.8u as=0 ps=0 w=0.42u l=1u
X2596 VSS.t103 a_32576_44454# a_32225_44311# VSS.t288 sg13_lv_nmos ad=79.8f pd=0.8u as=0.1428p ps=1.52u w=0.42u l=0.13u
X2597 a_31477_44213# sar_ctrl_async_phys_0.sg13g2_dfrbpq_1_0.CLK VSS.t78 VSS.t519 sg13_lv_nmos ad=0.2516p pd=2.16u as=3.64875p ps=22.56u w=0.74u l=0.13u
X2598 VDD.t150 VSS.t765 VDD.t155 VDD.t0 sg13_lv_pmos ad=0.34p pd=2.68u as=0 ps=0 w=1u l=1u
X2599 a_33846_34850# a_34651_34423# a_34106_34380# VDD.t54 sg13_lv_pmos ad=0.1428p pd=1.52u as=79.8f ps=0.8u w=0.42u l=0.13u
X2600 VSS.t129 VDD.t22 VSS.t129 VSS.t61 sg13_lv_nmos ad=0.1428p pd=1.52u as=0 ps=0 w=0.42u l=1u
X2601 VDD.t136 VSS.t137 VDD.t135 VDD.t0 sg13_lv_pmos ad=0.34p pd=2.68u as=0 ps=0 w=1u l=1u
X2602 VDD.t312 sar_ctrl_async_phys_0.sg13g2_o21ai_1_1.B1 a_30390_39698# VDD.t311 sg13_lv_pmos ad=0.36237p pd=2.605u as=79.8f ps=0.8u w=0.42u l=0.13u
X2603 oa_sar8_acore18_opt_0.sw_tg_opt_0.bot.t3 oa_sar8_acore18_opt_0.sw_bitcell_opt_b7_0.bot.t47 cap_cmim l=2.14u w=2.14u
X2604 a_34297_44625# a_33940_44552# VDD.t415 VDD.t69 sg13_lv_pmos ad=63f pd=0.72u as=0.1563p ps=1.22u w=0.42u l=0.13u
X2605 oa_sar8_acore18_opt_0.sw_tg_opt_1.bot.t3 oa_sar8_acore18_opt_0.sw_bitcell_opt_b7_1.bot.t110 cap_cmim l=2.14u w=2.14u
X2606 VDD.t13 sar_ctrl_async_phys_0.sg13g2_buf_1_6.A a_35664_37695# VDD.t13 sg13_lv_pmos ad=0.2856p pd=2.36u as=0.1596p ps=1.22u w=0.84u l=0.13u
X2607 oa_sar8_acore18_opt_0.sw_tg_opt_0.bot.t3 oa_sar8_acore18_opt_0.sw_bitcell_opt_b6_0.bot.t75 cap_cmim l=2.14u w=2.14u
X2608 VSS.t40 VDD.t247 VSS.t854 VSS.t196 sg13_lv_nmos ad=0.1428p pd=1.52u as=0 ps=0 w=0.42u l=1u
X2609 a_33276_42686# sar_ctrl_async_phys_0.sg13g2_buf_1_13.A VSS.t123 VSS.t365 sg13_lv_nmos ad=0.187p pd=1.78u as=0.14875p ps=1.16u w=0.55u l=0.13u
X2610 VSS.t905 VDD.t14 VSS.t905 VSS.t904 sg13_lv_nmos ad=0.1428p pd=1.52u as=0 ps=0 w=0.42u l=1u
X2611 oa_sar8_acore18_opt_0.sw_tg_opt_1.bot.t3 oa_sar8_acore18_opt_0.sw_bitcell_opt_b6_1.bot.t29 cap_cmim l=2.14u w=2.14u
X2612 VDD.t37 a_35295_36285# a_35552_36166# VDD.t37 sg13_lv_pmos ad=1.79957p pd=11.62u as=79.8f ps=0.8u w=0.42u l=0.13u
X2613 oa_sar8_acore18_opt_0.sw_bitcell_opt_b5_0.bot.t0 oa_sar8_acore18_opt_0.sw_bitcell_opt_term_0.gb.t10 oa_sar8_acore18_opt_0.sw_bitcell_opt_term_0.vin VSS.t0 sg13_lv_nmos ad=0.195p pd=1.39u as=0.35p ps=2.7u w=1u l=0.13u
X2614 VDD.t56 VSS.t115 VDD.t55 VDD.t54 sg13_lv_pmos ad=0.19p pd=1.38u as=0 ps=0 w=1u l=1u
X2615 VDD.t79 VSS.t784 VDD.t79 VDD.t69 sg13_lv_pmos ad=0.34p pd=2.68u as=0 ps=0 w=1u l=1u
X2616 VDD.t227 VSS.t974 VDD.t228 VDD.t118 sg13_lv_pmos ad=0.19p pd=1.38u as=0 ps=0 w=1u l=1u
X2617 a_32687_32876# sar_ctrl_async_phys_0.sg13g2_a22oi_1_0.A1.t6 VDD.t343 VDD.t118 sg13_lv_pmos ad=0.2716p pd=1.605u as=0.3808p ps=2.92u w=1.12u l=0.13u
X2618 oa_sar8_acore18_opt_0.sw_tg_opt_0.bot.t3 oa_sar8_acore18_opt_0.sw_bitcell_opt_b6_0.bot.t42 cap_cmim l=2.14u w=2.14u
X2619 a_34847_42342# a_34765_42242# sar_ctrl_async_phys_0.sg13g2_nand2b_1_3.Y VSS.t1125 sg13_lv_nmos ad=0.1406p pd=1.12u as=0.333p ps=2.38u w=0.74u l=0.13u
X2620 oa_sar8_acore18_opt_0.sw_tg_opt_1.bot.t3 oa_sar8_acore18_opt_0.sw_bitcell_opt_b7_1.bot.t68 cap_cmim l=2.14u w=2.14u
X2621 a_28130_40838# sar_ctrl_async_phys_0.sg13g2_o21ai_1_1.B1 sar_ctrl_async_phys_0.sg13g2_nor2_1_12.A VSS.t29 sg13_lv_nmos ad=0.1406p pd=1.12u as=0.2516p ps=2.16u w=0.74u l=0.15u
X2622 VDD.t185 sar_ctrl_async_phys_0.sg13g2_buf_1_2.A.t1 a_30390_36362# VDD.t37 sg13_lv_pmos ad=0.36237p pd=2.605u as=79.8f ps=0.8u w=0.42u l=0.13u
X2623 a_34765_45266# sar_ctrl_async_phys_0.sg13g2_dfrbpq_1_9.Q VDD.t415 VDD.t69 sg13_lv_pmos ad=0.2856p pd=2.36u as=0.2198p ps=1.53u w=0.84u l=0.13u
X2624 VSS.t186 a_25596_43448# sar_ctrl_async_phys_0.sample VSS.t185 sg13_lv_nmos ad=0.14875p pd=1.16u as=0.2886p ps=2.26u w=0.74u l=0.13u
X2625 VDD.t306 sar_ctrl_async_phys_0.dac_code[6].t2 oa_sar8_acore18_opt_0.sw_bitcell_opt_b6_0.bot.t0 VDD.t305 sg13_lv_pmos ad=2.1p pd=12.7u as=1.17p ps=6.39u w=6u l=0.13u
X2626 a_34362_31826# a_34055_31352# a_34268_31826# VSS.t14 sg13_lv_nmos ad=37.8f pd=0.6u as=0.1428p ps=1.52u w=0.42u l=0.13u
X2627 oa_sar8_acore18_opt_0.sw_tg_opt_1.bot.t3 oa_sar8_acore18_opt_0.sw_bitcell_opt_b6_1.bot.t61 cap_cmim l=2.14u w=2.14u
X2628 oa_sar8_acore18_opt_0.sw_tg_opt_1.bot.t3 oa_sar8_acore18_opt_0.sw_bitcell_opt_b7_1.bot.t25 cap_cmim l=2.14u w=2.14u
X2629 VDD.t556 sar_ctrl_async_phys_0.sg13g2_buf_1_0.A a_34904_33688# VDD.t54 sg13_lv_pmos ad=0.2114p pd=1.54u as=0.2856p ps=2.36u w=0.84u l=0.13u
X2630 oa_sar8_acore18_opt_0.sw_tg_opt_0.bot.t3 oa_sar8_acore18_opt_0.sw_bitcell_opt_b5_0.bot.t10 cap_cmim l=2.14u w=2.14u
X2631 oa_sar8_acore18_opt_0.sw_bitcell_opt_b2_0.bot.t0 oa_sar8_acore18_opt_0.sw_bitcell_opt_term_0.trkb.t16 oa_sar8_acore18_opt_0.sw_bitcell_opt_term_0.vin VDD.t704 sg13_lv_pmos ad=0.39p pd=2.39u as=0.7p ps=4.7u w=2u l=0.13u
X2632 a_34236_46472# sar_ctrl_async_phys_0.sg13g2_buf_1_3.A.t3 VDD.t35 VDD.t29 sg13_lv_pmos ad=0.2856p pd=2.36u as=0.2114p ps=1.54u w=0.84u l=0.13u
X2633 a_30169_34041# a_29812_33968# VDD.t56 VDD.t54 sg13_lv_pmos ad=63f pd=0.72u as=0.1563p ps=1.22u w=0.42u l=0.13u
X2634 a_25596_43448# sar_ctrl_async_phys_0.sg13g2_nor2_1_13.Y VSS.t186 VSS.t185 sg13_lv_nmos ad=0.187p pd=1.78u as=0.14875p ps=1.16u w=0.55u l=0.13u
X2635 VSS.t11 sar_ctrl_async_phys_0.sg13g2_a22oi_1_2.A2 a_33630_33292# VSS.t6 sg13_lv_nmos ad=0.2516p pd=2.16u as=96.2f ps=1u w=0.74u l=0.13u
X2636 a_32991_35239# a_32149_35141# a_31732_35480# VDD.t37 sg13_lv_pmos ad=0.2048p pd=1.63u as=0.34p ps=2.68u w=1u l=0.13u
X2637 a_34895_32120# sar_ctrl_async_phys_0.sg13g2_a22oi_1_0.B1 VSS.t9 VSS.t8 sg13_lv_nmos ad=0.13875p pd=1.115u as=0.2553p ps=2.17u w=0.74u l=0.13u
X2638 oa_sar8_acore18_opt_0.sw_tg_opt_0.bot.t3 oa_sar8_acore18_opt_0.sw_bitcell_opt_b7_0.bot.t115 cap_cmim l=2.14u w=2.14u
X2639 a_31477_44213# sar_ctrl_async_phys_0.sg13g2_dfrbpq_1_0.CLK VDD.t346 VDD.t69 sg13_lv_pmos ad=0.4088p pd=2.97u as=1.79957p ps=11.62u w=1.12u l=0.13u
X2640 oa_sar8_acore18_opt_0.sw_tg_opt_1.bot.t3 oa_sar8_acore18_opt_0.sw_bitcell_opt_b6_1.bot.t61 cap_cmim l=2.14u w=2.14u
X2641 oa_sar8_acore18_opt_0.sw_tg_opt_1.bot.t3 oa_sar8_acore18_opt_0.sw_bitcell_opt_b7_1.bot.t64 cap_cmim l=2.14u w=2.14u
X2642 oa_sar8_acore18_opt_0.sw_bitcell_opt_b4_0.bot.t0 oa_sar8_acore18_opt_0.sw_bitcell_opt_term_0.gb.t9 oa_sar8_acore18_opt_0.sw_bitcell_opt_term_0.vin VSS.t540 sg13_lv_nmos ad=0.195p pd=1.39u as=0.35p ps=2.7u w=1u l=0.13u
X2643 a_30733_35460# sar_ctrl_async_phys_0.sg13g2_buf_1_16.A VDD.t185 VDD.t37 sg13_lv_pmos ad=0.3325p pd=1.665u as=0.253p ps=1.53u w=1u l=0.13u
X2644 oa_sar8_acore18_opt_0.bstrap_opt_w2_c1200_1.gb VDD.t1091 a_21332_n9711# VSS.t1077 sg13_lv_nmos ad=0.19p pd=1.38u as=0.345p ps=2.69u w=1u l=0.15u
X2645 oa_sar8_acore18_opt_0.sw_tg_opt_1.bot.t3 oa_sar8_acore18_opt_0.sw_bitcell_opt_b6_1.bot.t29 cap_cmim l=2.14u w=2.14u
X2646 sar_ctrl_async_phys_0.sg13g2_nor2_1_3.Y sar_ctrl_async_phys_0.sg13g2_nor2_1_3.B a_27354_37436# VDD.t13 sg13_lv_pmos ad=0.3808p pd=2.92u as=0.1176p ps=1.33u w=1.12u l=0.13u
X2647 sar_ctrl_async_phys_0.sg13g2_buf_1_20.A a_31933_43832# VDD.t366 VDD.t0 sg13_lv_pmos ad=0.3808p pd=2.92u as=0.1918p ps=1.5u w=1.12u l=0.13u
X2648 VDD.t312 sar_ctrl_async_phys_0.sg13g2_o21ai_1_1.B1 a_29238_40898# VDD.t311 sg13_lv_pmos ad=0.36237p pd=2.605u as=79.8f ps=0.8u w=0.42u l=0.13u
X2649 VDD.t62 VSS.t1048 VDD.t61 VDD.t39 sg13_lv_pmos ad=0.34p pd=2.68u as=0 ps=0 w=1u l=1u
X2650 oa_sar8_acore18_opt_0.sw_tg_opt_0.bot.t3 oa_sar8_acore18_opt_0.sw_bitcell_opt_b6_0.bot.t35 cap_cmim l=2.14u w=2.14u
X2651 VDD.t176 VSS.t60 VDD.t10 VDD.t5 sg13_lv_pmos ad=0.19p pd=1.38u as=0 ps=0 w=1u l=1u
X2652 oa_sar8_acore18_opt_0.sw_bitcell_opt_b7_1.bot.t0 oa_sar8_acore18_opt_0.bstrap_opt_w2_c1200_1.gb oa_sar8_acore18_opt_0.bstrap_opt_w2_c1200_1.out VSS.t1098 sg13_lv_nmos ad=0.195p pd=1.39u as=0.35p ps=2.7u w=1u l=0.13u
X2653 a_33818_36897# a_34261_36653# a_33558_36674# VSS.t191 sg13_lv_nmos ad=79.8f pd=0.8u as=0.1296p ps=1.52u w=0.42u l=0.13u
X2654 VDD.t419 a_27530_39666# a_27249_39888# VDD.t311 sg13_lv_pmos ad=0.1523p pd=1.38u as=0.34p ps=2.68u w=1u l=0.5u
X2655 oa_sar8_acore18_opt_0.sw_tg_opt_1.bot.t3 oa_sar8_acore18_opt_0.sw_bitcell_opt_b7_1.bot.t141 cap_cmim l=2.14u w=2.14u
X2656 VSS.t471 VDD.t14 VSS.t471 VSS.t883 sg13_lv_nmos ad=0.1428p pd=1.52u as=0 ps=0 w=0.42u l=1u
X2657 oa_sar8_acore18_opt_0.sw_tg_opt_1.bot.t3 oa_sar8_acore18_opt_0.sw_bitcell_opt_b5_1.bot.t29 cap_cmim l=2.14u w=2.14u
X2658 sar_ctrl_async_phys_0.sg13g2_a22oi_1_1.Y sar_ctrl_async_phys_0.sg13g2_a22oi_1_0.B1 a_31823_32876# VDD.t118 sg13_lv_pmos ad=0.2128p pd=1.5u as=0.2716p ps=1.605u w=1.12u l=0.13u
X2659 a_35417_35208# sar_ctrl_async_phys_0.sg13g2_and2_1_0.B VSS.t113 VSS.t203 sg13_lv_nmos ad=0.1216p pd=1.02u as=0.1331p ps=1.12u w=0.64u l=0.13u
X2660 a_31446_35162# a_32251_35284# a_31706_35385# VDD.t37 sg13_lv_pmos ad=0.1428p pd=1.52u as=79.8f ps=0.8u w=0.42u l=0.13u
X2661 oa_sar8_acore18_opt_0.sw_tg_opt_0.bot.t3 oa_sar8_acore18_opt_0.sw_bitcell_opt_b7_0.bot.t78 cap_cmim l=2.14u w=2.14u
X2662 VSS.t982 VDD.t205 VSS.t984 VSS.t983 sg13_lv_nmos ad=79.8f pd=0.8u as=0 ps=0 w=0.42u l=1u
X2663 oa_sar8_acore18_opt_0.sw_tg_opt_1.bot.t3 oa_sar8_acore18_opt_0.sw_bitcell_opt_b2_1.bot.t4 cap_cmim l=2.14u w=2.14u
X2664 VDD.t323 a_33109_45725# a_33211_45868# VDD.t29 sg13_lv_pmos ad=2.2076p pd=14.4u as=0.3864p ps=2.93u w=1.12u l=0.13u
X2665 VDD.t871 VDD.t869 oa_sar8_acore18_opt_0.sw_bitcell_opt_term_1.bot.t3 VDD.t870 sg13_lv_pmos ad=1.05p pd=6.7u as=0.585p ps=3.39u w=3u l=0.13u
X2666 a_30580_31826# sar_ctrl_async_phys_0.sg13g2_dfrbpq_1_17.D a_30486_31826# VSS.t398 sg13_lv_nmos ad=60.89999f pd=0.71u as=0.1428p ps=1.52u w=0.42u l=0.13u
X2667 VDD.t54 a_30229_33629# a_30331_33772# VDD.t54 sg13_lv_pmos ad=2.2076p pd=14.4u as=0.3864p ps=2.93u w=1.12u l=0.13u
X2668 VDD.t37 a_33248_35382# a_33193_35477# VDD.t37 sg13_lv_pmos ad=1.79957p pd=11.62u as=93.45f ps=0.865u w=0.42u l=0.13u
X2669 a_29524_40464# a_30043_40471# a_30783_40821# VSS.t44 sg13_lv_nmos ad=0.3473p pd=2.71u as=0.12665p ps=1.145u w=0.74u l=0.13u
X2670 a_31202_40898# sar_ctrl_async_phys_0.sg13g2_o21ai_1_1.B1 VSS.t45 VSS.t44 sg13_lv_nmos ad=37.8f pd=0.6u as=79.8f ps=0.8u w=0.42u l=0.13u
X2671 VSS.t94 a_29653_38959# a_29755_38959# VSS.t93 sg13_lv_nmos ad=5.61045p pd=35.775u as=0.2516p ps=2.16u w=0.74u l=0.13u
X2672 VSS.t369 VDD.t247 VSS.t853 VSS.t196 sg13_lv_nmos ad=79.8f pd=0.8u as=0 ps=0 w=0.42u l=1u
X2673 VSS.t684 VDD.t16 VSS.t684 VSS.t683 sg13_lv_nmos ad=0.1428p pd=1.52u as=0 ps=0 w=0.42u l=1u
X2674 oa_sar8_acore18_opt_0.sw_tg_opt_1.bot.t3 oa_sar8_acore18_opt_0.sw_bitcell_opt_b6_1.bot.t14 cap_cmim l=2.14u w=2.14u
X2675 a_33846_30626# sar_ctrl_async_phys_0.sg13g2_inv_1_3.Y VDD.t573 VDD.t39 sg13_lv_pmos ad=79.8f pd=0.8u as=0.1428p ps=1.52u w=0.42u l=0.13u
X2676 VDD.t31 VSS.t736 VDD.t32 VDD.t29 sg13_lv_pmos ad=0.34p pd=2.68u as=0 ps=0 w=1u l=1u
X2677 oa_sar8_acore18_opt_0.sw_tg_opt_1.bot.t3 oa_sar8_acore18_opt_0.sw_bitcell_opt_b5_1.bot.t29 cap_cmim l=2.14u w=2.14u
X2678 VSS.t129 a_32480_46750# a_32129_46869# VSS.t91 sg13_lv_nmos ad=79.8f pd=0.8u as=0.1428p ps=1.52u w=0.42u l=0.13u
X2679 sar_ctrl_async_phys_0.sg13g2_nor2_1_10.Y sar_ctrl_async_phys_0.sg13g2_nor2_1_10.B a_29562_39996# VDD.t311 sg13_lv_pmos ad=0.3808p pd=2.92u as=0.1176p ps=1.33u w=1.12u l=0.13u
X2680 VSS.t172 a_33344_37678# a_32993_37797# VSS.t118 sg13_lv_nmos ad=79.8f pd=0.8u as=0.1428p ps=1.52u w=0.42u l=0.13u
X2681 oa_sar8_acore18_opt_0.sw_tg_opt_0.bot.t3 oa_sar8_acore18_opt_0.sw_bitcell_opt_b7_0.bot.t86 cap_cmim l=2.14u w=2.14u
X2682 oa_sar8_acore18_opt_0.sw_tg_opt_1.bot.t3 oa_sar8_acore18_opt_0.sw_bitcell_opt_b7_1.bot.t99 cap_cmim l=2.14u w=2.14u
X2683 oa_sar8_acore18_opt_0.sw_tg_opt_1.bot.t3 oa_sar8_acore18_opt_0.sw_bitcell_opt_b7_1.bot.t52 cap_cmim l=2.14u w=2.14u
X2684 oa_sar8_acore18_opt_0.sw_bitcell_opt_b0_0.bot.t0 oa_sar8_acore18_opt_0.sw_bitcell_opt_term_0.gb.t5 oa_sar8_acore18_opt_0.sw_bitcell_opt_term_0.vin VSS.t608 sg13_lv_nmos ad=0.195p pd=1.39u as=0.35p ps=2.7u w=1u l=0.13u
X2685 a_31732_45000# a_31706_44964# VSS.t22 VSS.t1148 sg13_lv_nmos ad=0.2516p pd=2.16u as=0.1626p ps=1.415u w=0.74u l=0.13u
X2686 VSS.t20 sar_ctrl_async_phys_0.sg13g2_o21ai_1_1.B1 a_33460_41210# VSS.t19 sg13_lv_nmos ad=0.1626p pd=1.415u as=60.89999f ps=0.71u w=0.42u l=0.13u
X2687 a_34731_37436# sar_ctrl_async_phys_0.sg13g2_and2_1_0.B VDD.t382 VDD.t13 sg13_lv_pmos ad=0.3808p pd=2.92u as=0.2128p ps=1.5u w=1.12u l=0.13u
X2688 VSS.t372 a_32580_36642# sar_ctrl_async_phys_0.sg13g2_nor2_1_0.A VSS.t85 sg13_lv_nmos ad=0.17255p pd=1.25u as=0.1406p ps=1.12u w=0.74u l=0.13u
X2689 a_33558_36674# sar_ctrl_async_phys_0.sg13g2_nor2_1_1.A VDD.t500 VDD.t13 sg13_lv_pmos ad=79.8f pd=0.8u as=0.1428p ps=1.52u w=0.42u l=0.13u
X2690 oa_sar8_acore18_opt_0.sw_tg_opt_0.bot.t3 oa_sar8_acore18_opt_0.sw_bitcell_opt_b5_0.bot.t5 cap_cmim l=2.14u w=2.14u
X2691 VSS.t724 VDD.t86 VSS.t727 VSS.t726 sg13_lv_nmos ad=79.8f pd=0.8u as=0 ps=0 w=0.42u l=1u
X2692 oa_sar8_acore18_opt_0.sw_tg_opt_0.bot.t3 oa_sar8_acore18_opt_0.sw_bitcell_opt_b7_0.bot.t57 cap_cmim l=2.14u w=2.14u
X2693 oa_sar8_acore18_opt_0.sw_bitcell_opt_b3_0.bot.t0 oa_sar8_acore18_opt_0.sw_bitcell_opt_term_0.gb.t8 oa_sar8_acore18_opt_0.sw_bitcell_opt_term_0.vin VSS.t2 sg13_lv_nmos ad=0.195p pd=1.39u as=0.35p ps=2.7u w=1u l=0.13u
X2694 a_35245_45266# sar_ctrl_async_phys_0.sg13g2_nand2_1_2.B VDD.t415 VDD.t69 sg13_lv_pmos ad=0.2856p pd=2.36u as=0.2198p ps=1.53u w=0.84u l=0.13u
X2695 VDD.t350 sar_ctrl_async_phys_0.sg13g2_buf_1_21.A a_36056_38224# VDD.t162 sg13_lv_pmos ad=0.2114p pd=1.54u as=0.2856p ps=2.36u w=0.84u l=0.13u
X2696 a_32185_37483# a_31828_37440# VDD.t14 VDD.t13 sg13_lv_pmos ad=63f pd=0.72u as=0.1563p ps=1.22u w=0.42u l=0.13u
X2697 VSS.t645 sar_ctrl_async_phys_0.cmp_fire a_28008_23477# VSS.t644 sg13_lv_nmos ad=0.5175p pd=3.69u as=0.285p ps=1.88u w=1.5u l=0.3u
X2698 sar_ctrl_async_phys_0.dac_code_n[3] a_34904_46508# VSS.t62 VSS.t91 sg13_lv_nmos ad=0.2886p pd=2.26u as=0.14875p ps=1.16u w=0.74u l=0.13u
X2699 VSS.t277 VDD.t361 VSS.t277 VSS.t900 sg13_lv_nmos ad=0.1428p pd=1.52u as=0 ps=0 w=0.42u l=1u
X2700 a_29332_32456# a_29306_32361# VSS.t464 VSS.t1116 sg13_lv_nmos ad=0.2516p pd=2.16u as=0.1626p ps=1.415u w=0.74u l=0.13u
X2701 oa_sar8_acore18_opt_0.sw_tg_opt_0.bot.t3 oa_sar8_acore18_opt_0.sw_bitcell_opt_b7_0.bot.t128 cap_cmim l=2.14u w=2.14u
X2702 VSS.t88 sar_ctrl_async_phys_0.sg13g2_buf_1_20.A a_36056_37436# VSS.t118 sg13_lv_nmos ad=0.14875p pd=1.16u as=0.187p ps=1.78u w=0.55u l=0.13u
X2703 VDD.t343 sar_ctrl_async_phys_0.sg13g2_a22oi_1_3.A2 a_32687_32876# VDD.t118 sg13_lv_pmos ad=0.3808p pd=2.92u as=0.2744p ps=1.61u w=1.12u l=0.13u
X2704 VSS.t5 a_32991_35239# a_33658_35460# VSS.t622 sg13_lv_nmos ad=0.1406p pd=1.12u as=0.2516p ps=2.16u w=0.74u l=0.13u
X2705 a_29236_38952# a_29210_38916# VSS.t54 VSS.t337 sg13_lv_nmos ad=0.2516p pd=2.16u as=0.1626p ps=1.415u w=0.74u l=0.13u
X2706 a_33748_44234# sar_ctrl_async_phys_0.sg13g2_nor2_1_2.Y a_33654_44234# VSS.t188 sg13_lv_nmos ad=60.89999f pd=0.71u as=0.1428p ps=1.52u w=0.42u l=0.13u
X2707 oa_sar8_acore18_opt_0.sw_tg_opt_1.bot.t3 oa_sar8_acore18_opt_0.sw_bitcell_opt_b4_1.bot.t11 cap_cmim l=2.14u w=2.14u
X2708 a_33951_45823# a_33109_45725# a_33857_45823# VSS.t1118 sg13_lv_nmos ad=0.12665p pd=1.145u as=0.1428p ps=1.52u w=0.42u l=0.13u
X2709 VSS.t773 VDD.t89 VSS.t772 VSS.t185 sg13_lv_nmos ad=0.1428p pd=1.52u as=0 ps=0 w=0.42u l=1u
X2710 VDD.t36 VSS.t42 VDD.t187 VDD.t5 sg13_lv_pmos ad=0.19p pd=1.38u as=0 ps=0 w=1u l=1u
X2711 VSS.t133 sar_ctrl_async_phys_0.sg13g2_nor2_1_6.A sar_ctrl_async_phys_0.sg13g2_nor4_1_0.Y VSS.t381 sg13_lv_nmos ad=0.2516p pd=2.16u as=0.1406p ps=1.12u w=0.74u l=0.13u
X2712 VDD.t14 VSS.t902 VDD.t14 VDD.t13 sg13_lv_pmos ad=0.34p pd=2.68u as=0 ps=0 w=1u l=1u
X2713 oa_sar8_acore18_opt_0.sw_tg_opt_1.bot.t4 oa_sar8_acore18_opt_0.sw_bitcell_opt_b7_1.bot.t14 cap_cmim l=2.14u w=2.14u
X2714 sar_ctrl_async_phys_0.sg13g2_buf_1_32.A sar_ctrl_async_phys_0.sg13g2_nand2b_1_7.A_N VDD.t415 VDD.t69 sg13_lv_pmos ad=0.2128p pd=1.5u as=0.3808p ps=2.92u w=1.12u l=0.13u
X2715 a_26630_37814# sar_ctrl_async_phys_0.sg13g2_buf_1_26.X VSS.t144 VSS.t143 sg13_lv_nmos ad=0.1406p pd=1.12u as=0.1406p ps=1.12u w=0.74u l=0.15u
X2716 oa_sar8_acore18_opt_0.sw_tg_opt_0.bot.t3 oa_sar8_acore18_opt_0.sw_bitcell_opt_b6_0.bot.t65 cap_cmim l=2.14u w=2.14u
X2717 VSS.t22 VDD.t169 VSS.t22 VSS.t744 sg13_lv_nmos ad=79.8f pd=0.8u as=0 ps=0 w=0.42u l=1u
X2718 oa_sar8_acore18_opt_0.sw_tg_opt_1.bot.t3 oa_sar8_acore18_opt_0.sw_bitcell_opt_b6_1.bot.t1 cap_cmim l=2.14u w=2.14u
X2719 VSS.t115 VDD.t56 VSS.t115 VSS.t114 sg13_lv_nmos ad=79.8f pd=0.8u as=0 ps=0 w=0.42u l=1u
X2720 VSS.t787 VDD.t150 VSS.t767 VSS.t185 sg13_lv_nmos ad=79.8f pd=0.8u as=0 ps=0 w=0.42u l=1u
X2721 a_35053_40730# sar_ctrl_async_phys_0.sg13g2_nand2_1_1.B VDD.t314 VDD.t311 sg13_lv_pmos ad=0.2856p pd=2.36u as=0.2198p ps=1.53u w=0.84u l=0.13u
X2722 a_33252_36642# sar_ctrl_async_phys_0.sg13g2_nor2b_1_1.B_N VSS.t283 VSS.t85 sg13_lv_nmos ad=0.187p pd=1.78u as=0.17255p ps=1.25u w=0.55u l=0.13u
X2723 VSS.t892 VDD.t191 VSS.t891 VSS.t890 sg13_lv_nmos ad=0.1428p pd=1.52u as=0 ps=0 w=0.42u l=1u
X2724 oa_sar8_acore18_opt_0.sw_bitcell_opt_term_0.VSS sar_ctrl_async_phys_0.dac_code[4] oa_sar8_acore18_opt_0.sw_bitcell_opt_b4_0.bot.t0 VSS.t416 sg13_lv_nmos ad=0.84p pd=5.5u as=0.468p ps=2.79u w=2.4u l=0.13u
X2725 VDD.t94 VSS.t677 VDD.t94 VDD.t29 sg13_lv_pmos ad=0.19p pd=1.38u as=0 ps=0 w=1u l=1u
X2726 a_25914_38948# track VDD.t351 VDD.t162 sg13_lv_pmos ad=0.1176p pd=1.33u as=0.4032p ps=2.96u w=1.12u l=0.13u
X2727 a_30938_46476# a_31381_46519# a_31321_46555# VDD.t29 sg13_lv_pmos ad=79.8f pd=0.8u as=63f ps=0.72u w=0.42u l=0.13u
X2728 VDD.t70 VSS.t768 VDD.t70 VDD.t69 sg13_lv_pmos ad=0.19p pd=1.38u as=0 ps=0 w=1u l=1u
X2729 oa_sar8_acore18_opt_0.sw_bitcell_opt_b7_0.bot.t0 oa_sar8_acore18_opt_0.sw_bitcell_opt_term_0.gb.t12 oa_sar8_acore18_opt_0.sw_bitcell_opt_term_0.vin VSS.t1 sg13_lv_nmos ad=0.195p pd=1.39u as=0.35p ps=2.7u w=1u l=0.13u
X2730 VSS.t231 VDD.t70 VSS.t749 VSS.t748 sg13_lv_nmos ad=0.1428p pd=1.52u as=0 ps=0 w=0.42u l=1u
X2731 VSS.t801 VDD.t99 VSS.t805 VSS.t804 sg13_lv_nmos ad=79.8f pd=0.8u as=0 ps=0 w=0.42u l=1u
X2732 oa_sar8_acore18_opt_0.sw_tg_opt_0.bot.t3 oa_sar8_acore18_opt_0.sw_bitcell_opt_b7_0.bot.t68 cap_cmim l=2.14u w=2.14u
X2733 VSS.t9 sar_ctrl_async_phys_0.sg13g2_a22oi_1_0.A2 a_35166_32120# VSS.t171 sg13_lv_nmos ad=0.2516p pd=2.16u as=96.2f ps=1u w=0.74u l=0.13u
X2734 a_36074_41214# sar_ctrl_async_phys_0.sg13g2_nand2b_1_2.A_N VSS.t260 VSS.t477 sg13_lv_nmos ad=0.1406p pd=1.12u as=0.2516p ps=2.16u w=0.74u l=0.13u
X2735 sar_ctrl_async_phys_0.sg13g2_a22oi_1_0.B2 a_36058_30924# VSS.t325 VSS.t1193 sg13_lv_nmos ad=0.2516p pd=2.16u as=0.1406p ps=1.12u w=0.74u l=0.13u
X2736 VSS.t103 a_32319_44311# a_32986_44532# VSS.t139 sg13_lv_nmos ad=0.1406p pd=1.12u as=0.2516p ps=2.16u w=0.74u l=0.13u
X2737 oa_sar8_acore18_opt_0.sw_bitcell_opt_b0_1.bot.t0 sar_ctrl_async_phys_0.dac_code_n[0] oa_sar8_acore18_opt_0.sw_bitcell_opt_b7_1.VSS VSS.t356 sg13_lv_nmos ad=0.2925p pd=1.89u as=0.525p ps=3.7u w=1.5u l=0.13u
X2738 a_31446_45434# a_32251_45007# a_31706_44964# VDD.t69 sg13_lv_pmos ad=0.1428p pd=1.52u as=79.8f ps=0.8u w=0.42u l=0.13u
X2739 VDD.t185 sar_ctrl_async_phys_0.sg13g2_buf_1_2.A.t1 a_30650_35892# VDD.t37 sg13_lv_pmos ad=0.1563p pd=1.22u as=0.147p ps=1.54u w=0.42u l=0.13u
X2740 VSS.t260 sar_ctrl_async_phys_0.sg13g2_a21oi_1_3.A2 a_35697_40808# VSS.t259 sg13_lv_nmos ad=0.2516p pd=2.16u as=0.1406p ps=1.12u w=0.74u l=0.13u
X2741 oa_sar8_acore18_opt_0.sw_tg_opt_1.bot.t3 oa_sar8_acore18_opt_0.sw_bitcell_opt_b4_1.bot.t1 cap_cmim l=2.14u w=2.14u
X2742 oa_sar8_acore18_opt_0.sw_tg_opt_0.bot.t3 oa_sar8_acore18_opt_0.sw_bitcell_opt_b7_0.bot.t25 cap_cmim l=2.14u w=2.14u
X2743 VDD.t39 a_32288_31630# a_32233_31511# VDD.t39 sg13_lv_pmos ad=1.96315p pd=12.675u as=93.45f ps=0.865u w=0.42u l=0.13u
X2744 VDD.t56 VSS.t115 VDD.t56 VDD.t54 sg13_lv_pmos ad=0.19p pd=1.38u as=0 ps=0 w=1u l=1u
X2745 VDD.t600 sar_ctrl_async_phys_0.sg13g2_buf_1_33.A a_36056_42760# VDD.t0 sg13_lv_pmos ad=0.2114p pd=1.54u as=0.2856p ps=2.36u w=0.84u l=0.13u
X2746 VDD.t343 sar_ctrl_async_phys_0.sg13g2_buf_1_2.X.t1 a_31638_32138# VDD.t118 sg13_lv_pmos ad=0.36237p pd=2.605u as=79.8f ps=0.8u w=0.42u l=0.13u
X2747 VDD.t38 sar_ctrl_async_phys_0.sg13g2_dlygate4sd3_1_0.A a_28488_35965# VDD.t37 sg13_lv_pmos ad=0.1523p pd=1.38u as=0.1428p ps=1.52u w=0.42u l=0.13u
X2748 VDD.t345 sar_ctrl_async_phys_0.sg13g2_a21oi_1_1.B1 a_35288_47296# VDD.t15 sg13_lv_pmos ad=0.2114p pd=1.54u as=0.2856p ps=2.36u w=0.84u l=0.13u
X2749 oa_sar8_acore18_opt_0.sw_bitcell_opt_b6_0.bot.t0 sar_ctrl_async_phys_0.dac_code[6].t2 VDD.t307 VDD.t305 sg13_lv_pmos ad=1.17p pd=6.39u as=2.1p ps=12.7u w=6u l=0.13u
X2750 VSS.t273 sar_ctrl_async_phys_0.sg13g2_buf_1_34.A a_36056_41972# VSS.t400 sg13_lv_nmos ad=0.14875p pd=1.16u as=0.187p ps=1.78u w=0.55u l=0.13u
X2751 VDD.t576 a_30037_43495# a_30139_43495# VDD.t0 sg13_lv_pmos ad=2.48357p pd=16.205u as=0.3864p ps=2.93u w=1.12u l=0.13u
X2752 VDD.t119 VSS.t961 VDD.t119 VDD.t118 sg13_lv_pmos ad=0.34p pd=2.68u as=0 ps=0 w=1u l=1u
X2753 VSS.t972 VDD.t238 VSS.t974 VSS.t973 sg13_lv_nmos ad=79.8f pd=0.8u as=0 ps=0 w=0.42u l=1u
X2754 sar_ctrl_async_phys_0.sg13g2_dfrbpq_1_0.CLK a_29350_41996# VSS.t137 VSS.t136 sg13_lv_nmos ad=0.2516p pd=2.16u as=0.1426p ps=1.16u w=0.74u l=0.13u
X2755 a_25878_40460# a_25608_40501# VDD.t339 VDD.t311 sg13_lv_pmos ad=0.34p pd=2.68u as=0.1523p ps=1.38u w=1u l=0.5u
X2756 a_26364_45710# sar_ctrl_async_phys_0.sg13g2_buf_1_13.X.t2 VDD.t68 VDD.t29 sg13_lv_pmos ad=0.2856p pd=2.36u as=0.2114p ps=1.54u w=0.84u l=0.13u
X2757 VDD.t339 a_26558_40727# sar_ctrl_async_phys_0.sg13g2_nand3_1_0.A VDD.t311 sg13_lv_pmos ad=0.2254p pd=1.53u as=0.4256p ps=3u w=1.12u l=0.13u
X2758 oa_sar8_acore18_opt_0.sw_tg_opt_1.bot.t3 oa_sar8_acore18_opt_0.sw_bitcell_opt_b6_1.bot.t41 cap_cmim l=2.14u w=2.14u
X2759 VSS.t1003 VDD.t182 VSS.t1003 VSS.t17 sg13_lv_nmos ad=79.8f pd=0.8u as=0 ps=0 w=0.42u l=1u
X2760 VSS.t739 VDD.t79 VSS.t736 VSS.t761 sg13_lv_nmos ad=0.1428p pd=1.52u as=0 ps=0 w=0.42u l=1u
X2761 oa_sar8_acore18_opt_0.sw_tg_opt_0.bot.t3 oa_sar8_acore18_opt_0.sw_bitcell_opt_b2_0.bot.t6 cap_cmim l=2.14u w=2.14u
X2762 VDD.t55 sar_ctrl_async_phys_0.sg13g2_buf_1_2.X.t3 a_29526_33650# VDD.t54 sg13_lv_pmos ad=0.36237p pd=2.605u as=79.8f ps=0.8u w=0.42u l=0.13u
X2763 oa_sar8_acore18_opt_0.sw_tg_opt_1.bot.t3 oa_sar8_acore18_opt_0.sw_bitcell_opt_b7_1.bot.t115 cap_cmim l=2.14u w=2.14u
X2764 a_32980_45759# a_32692_46064# a_32918_45759# VSS.t23 sg13_lv_nmos ad=0.1428p pd=1.52u as=37.8f ps=0.6u w=0.42u l=0.13u
X2765 oa_sar8_acore18_opt_0.sw_tg_opt_0.bot.t3 oa_sar8_acore18_opt_0.sw_bitcell_opt_b7_0.bot.t52 cap_cmim l=2.14u w=2.14u
X2766 oa_sar8_acore18_opt_0.sw_tg_opt_1.bot.t4 oa_sar8_acore18_opt_0.sw_bitcell_opt_b7_1.bot.t4 cap_cmim l=2.14u w=2.14u
X2767 VSS.t98 a_33440_32358# a_33089_32215# VSS.t8 sg13_lv_nmos ad=79.8f pd=0.8u as=0.1428p ps=1.52u w=0.42u l=0.13u
X2768 VSS.t967 VDD.t119 VSS.t966 VSS.t965 sg13_lv_nmos ad=0.1428p pd=1.52u as=0 ps=0 w=0.42u l=1u
X2769 oa_sar8_acore18_opt_0.sw_tg_opt_0.bot.t3 oa_sar8_acore18_opt_0.sw_bitcell_opt_b4_0.bot.t6 cap_cmim l=2.14u w=2.14u
X2770 sar_ctrl_async_phys_0.sg13g2_buf_1_32.A sar_ctrl_async_phys_0.sg13g2_nand2_1_2.A a_34442_45366# VSS.t499 sg13_lv_nmos ad=0.2516p pd=2.16u as=0.1406p ps=1.12u w=0.74u l=0.13u
X2771 VSS.t346 VDD.t209 VSS.t346 VSS.t826 sg13_lv_nmos ad=79.8f pd=0.8u as=0 ps=0 w=0.42u l=1u
X2772 a_30998_31813# sar_ctrl_async_phys_0.sg13g2_buf_1_2.X VSS.t343 VSS.t442 sg13_lv_nmos ad=37.8f pd=0.6u as=0.1701p ps=1.65u w=0.42u l=0.13u
X2773 VSS.t464 VDD.t44 VSS.t464 VSS.t17 sg13_lv_nmos ad=79.8f pd=0.8u as=0 ps=0 w=0.42u l=1u
X2774 VDD.t805 sar_ctrl_async_phys_0.dac_code_n[6] oa_sar8_acore18_opt_0.sw_bitcell_opt_b6_1.bot.t81 VDD.t804 sg13_lv_pmos ad=2.1p pd=12.7u as=1.17p ps=6.39u w=6u l=0.13u
X2775 a_33179_43832# sar_ctrl_async_phys_0.sg13g2_buf_1_35.A a_33085_43832# VSS.t175 sg13_lv_nmos ad=0.1216p pd=1.02u as=0.2176p ps=1.96u w=0.64u l=0.13u
X2776 VDD.t350 sar_ctrl_async_phys_0.sg13g2_dfrbpq_1_2.Q a_34520_38224# VDD.t162 sg13_lv_pmos ad=0.2114p pd=1.54u as=0.2856p ps=2.36u w=0.84u l=0.13u
X2777 VDD.t366 VSS.t346 VDD.t366 VDD.t0 sg13_lv_pmos ad=0.34p pd=2.68u as=0 ps=0 w=1u l=1u
X2778 a_34070_43909# sar_ctrl_async_phys_0.sg13g2_dfrbpq_1_9.RESET_B VSS.t205 VSS.t320 sg13_lv_nmos ad=37.8f pd=0.6u as=0.1701p ps=1.65u w=0.42u l=0.13u
X2779 sar_ctrl_async_phys_0.sg13g2_inv_1_10.Y sar_ctrl_async_phys_0.sg13g2_dfrbpq_1_0.CLK VDD.t176 VDD.t5 sg13_lv_pmos ad=0.3808p pd=2.92u as=0.3808p ps=2.92u w=1.12u l=0.13u
X2780 a_32031_31749# a_31189_31399# a_31937_31749# VSS.t236 sg13_lv_nmos ad=0.12665p pd=1.145u as=0.1428p ps=1.52u w=0.42u l=0.13u
X2781 VSS.t982 VDD.t205 VSS.t981 VSS.t980 sg13_lv_nmos ad=0.1428p pd=1.52u as=0 ps=0 w=0.42u l=1u
X2782 a_26558_40727# a_26673_40726# VDD.t339 VDD.t311 sg13_lv_pmos ad=0.34p pd=2.68u as=0.2254p ps=1.53u w=1u l=0.5u
X2783 VDD.t40 a_32031_31749# a_32698_31388# VDD.t39 sg13_lv_pmos ad=0.2128p pd=1.5u as=0.3864p ps=2.93u w=1.12u l=0.13u
X2784 oa_sar8_acore18_opt_0.sw_tg_opt_1.bot.t3 oa_sar8_acore18_opt_0.sw_bitcell_opt_b7_1.bot.t115 cap_cmim l=2.14u w=2.14u
X2785 sar_ctrl_async_phys_0.sg13g2_nand3_1_0.Y sar_ctrl_async_phys_0.sg13g2_nand3_1_0.C VDD.t339 VDD.t311 sg13_lv_pmos ad=0.2128p pd=1.5u as=0.3808p ps=2.92u w=1.12u l=0.13u
X2786 oa_sar8_acore18_opt_0.sw_tg_opt_1.bot.t3 oa_sar8_acore18_opt_0.sw_bitcell_opt_b2_1.bot.t8 cap_cmim l=2.14u w=2.14u
X2787 a_35234_39698# sar_ctrl_async_phys_0.sg13g2_o21ai_1_1.B1 VSS.t50 VSS.t49 sg13_lv_nmos ad=37.8f pd=0.6u as=79.8f ps=0.8u w=0.42u l=0.13u
X2788 VSS.t350 sar_ctrl_async_phys_0.sg13g2_buf_1_0.A a_34904_33688# VSS.t349 sg13_lv_nmos ad=0.14875p pd=1.16u as=0.187p ps=1.78u w=0.55u l=0.13u
X2789 oa_sar8_acore18_opt_0.sw_tg_opt_1.bot.t3 oa_sar8_acore18_opt_0.sw_bitcell_opt_b5_1.bot.t9 cap_cmim l=2.14u w=2.14u
X2790 oa_sar8_acore18_opt_0.sw_tg_opt_1.bot.t3 oa_sar8_acore18_opt_0.sw_bitcell_opt_b6_1.bot.t69 cap_cmim l=2.14u w=2.14u
X2791 VSS.t672 VDD.t101 VSS.t672 VSS.t674 sg13_lv_nmos ad=0.1428p pd=1.52u as=0 ps=0 w=0.42u l=1u
X2792 a_34765_42242# sar_ctrl_async_phys_0.sg13g2_a21oi_1_2.B1 VDD.t450 VDD.t5 sg13_lv_pmos ad=0.2856p pd=2.36u as=0.2198p ps=1.53u w=0.84u l=0.13u
X2793 a_34132_32904# a_34106_32868# VSS.t11 VSS.t1275 sg13_lv_nmos ad=0.2516p pd=2.16u as=0.1626p ps=1.415u w=0.74u l=0.13u
X2794 oa_sar8_acore18_opt_0.sw_tg_opt_1.bot.t3 oa_sar8_acore18_opt_0.sw_bitcell_opt_b7_1.bot.t30 cap_cmim l=2.14u w=2.14u
X2795 VSS.t166 sar_ctrl_async_phys_0.sg13g2_nand2_1_1.Y a_35672_38948# VSS.t523 sg13_lv_nmos ad=0.14875p pd=1.16u as=0.187p ps=1.78u w=0.55u l=0.13u
X2796 oa_sar8_acore18_opt_0.sw_tg_opt_0.bot.t3 oa_sar8_acore18_opt_0.sw_bitcell_opt_b5_0.bot.t15 cap_cmim l=2.14u w=2.14u
X2797 sar_ctrl_async_phys_0.sg13g2_buf_1_5.A a_31738_33948# VDD.t198 VDD.t54 sg13_lv_pmos ad=0.3808p pd=2.92u as=0.2128p ps=1.5u w=1.12u l=0.13u
X2798 a_34420_34837# a_34132_34416# a_34358_34837# VSS.t575 sg13_lv_nmos ad=0.1428p pd=1.52u as=37.8f ps=0.6u w=0.42u l=0.13u
X2799 a_35786_45750# sar_ctrl_async_phys_0.sg13g2_nand2_1_6.B VSS.t174 VSS.t655 sg13_lv_nmos ad=0.1406p pd=1.12u as=0.2516p ps=2.16u w=0.74u l=0.13u
X2800 VSS.t926 VDD.t38 VSS.t931 VSS.t114 sg13_lv_nmos ad=79.8f pd=0.8u as=0 ps=0 w=0.42u l=1u
X2801 a_32991_45357# a_32149_45007# a_32897_45357# VSS.t559 sg13_lv_nmos ad=0.12665p pd=1.145u as=0.1428p ps=1.52u w=0.42u l=0.13u
X2802 oa_sar8_acore18_opt_0.sw_tg_opt_0.bot.t3 oa_sar8_acore18_opt_0.sw_bitcell_opt_b6_0.bot.t45 cap_cmim l=2.14u w=2.14u
X2803 a_28782_40460# sar_ctrl_async_phys_0.sg13g2_dfrbpq_1_0.CLK.t21 a_28680_40460# VDD.t311 sg13_lv_pmos ad=0.2128p pd=1.5u as=0.2128p ps=1.5u w=1.12u l=0.13u
X2804 a_29210_38916# a_29653_38959# a_28950_39386# VSS.t92 sg13_lv_nmos ad=79.8f pd=0.8u as=0.1296p ps=1.52u w=0.42u l=0.13u
X2805 sar_ctrl_async_phys_0.sg13g2_dlygate4sd3_1_9.X a_26566_39766# VDD.t339 VDD.t311 sg13_lv_pmos ad=0.4256p pd=3u as=0.2254p ps=1.53u w=1.12u l=0.13u
X2806 VSS.t887 VDD.t191 VSS.t889 VSS.t888 sg13_lv_nmos ad=79.8f pd=0.8u as=0 ps=0 w=0.42u l=1u
X2807 oa_sar8_acore18_opt_0.sw_bitcell_opt_term_1.bot.t3 VDD.t869 VDD.t873 VDD.t870 sg13_lv_pmos ad=0.585p pd=3.39u as=1.05p ps=6.7u w=3u l=0.13u
X2808 a_32400_41413# sar_ctrl_async_phys_0.sg13g2_buf_1_6.A VDD.t209 VDD.t5 sg13_lv_pmos ad=0.1596p pd=1.22u as=0.1918p ps=1.5u w=0.84u l=0.13u
X2809 VSS.t718 VDD.t70 VSS.t720 VSS.t719 sg13_lv_nmos ad=79.8f pd=0.8u as=0 ps=0 w=0.42u l=1u
X2810 VSS.t926 VDD.t238 VSS.t926 VSS.t114 sg13_lv_nmos ad=79.8f pd=0.8u as=0 ps=0 w=0.42u l=1u
X2811 VSS.t510 sar_ctrl_async_phys_0.sg13g2_a22oi_1_1.Y sar_ctrl_async_phys_0.sg13g2_dfrbpq_1_17.D VSS.t509 sg13_lv_nmos ad=0.2516p pd=2.16u as=0.2516p ps=2.16u w=0.74u l=0.13u
X2812 VDD.t163 VSS.t626 VDD.t163 VDD.t162 sg13_lv_pmos ad=0.34p pd=2.68u as=0 ps=0 w=1u l=1u
X2813 VDD.t192 VSS.t926 VDD.t192 VDD.t37 sg13_lv_pmos ad=0.19p pd=1.38u as=0 ps=0 w=1u l=1u
X2814 VSS.t421 sar_ctrl_async_phys_0.sg13g2_buf_1_2.X a_33940_30626# VSS.t420 sg13_lv_nmos ad=0.1626p pd=1.415u as=60.89999f ps=0.71u w=0.42u l=0.13u
X2815 oa_sar8_acore18_opt_0.sw_tg_opt_0.bot.t4 oa_sar8_acore18_opt_0.sw_bitcell_opt_b7_0.bot.t10 cap_cmim l=2.14u w=2.14u
X2816 VSS.t129 VDD.t16 VSS.t129 VSS.t688 sg13_lv_nmos ad=0.1428p pd=1.52u as=0 ps=0 w=0.42u l=1u
X2817 VDD.t389 sar_ctrl_async_phys_0.sg13g2_buf_1_32.A a_34520_42760# VDD.t0 sg13_lv_pmos ad=0.2114p pd=1.54u as=0.2856p ps=2.36u w=0.84u l=0.13u
X2818 oa_sar8_acore18_opt_0.sw_tg_opt_1.bot.t3 oa_sar8_acore18_opt_0.sw_bitcell_opt_b6_1.bot.t34 cap_cmim l=2.14u w=2.14u
X2819 sar_ctrl_async_phys_0.sg13g2_dfrbpq_1_2.Q a_33754_37436# VSS.t172 VSS.t118 sg13_lv_nmos ad=0.2516p pd=2.16u as=0.1406p ps=1.12u w=0.74u l=0.13u
X2820 a_34055_31352# a_34615_31475# a_34526_31511# VDD.t39 sg13_lv_pmos ad=0.2048p pd=1.63u as=93.45f ps=0.865u w=0.42u l=0.13u
X2821 VDD.t16 VSS.t677 VDD.t120 VDD.t15 sg13_lv_pmos ad=0.19p pd=1.38u as=0 ps=0 w=1u l=1u
X2822 a_30632_22281# oa_sar8_acore18_opt_0.sw_tg_opt_0.bot.t5 a_28008_23477# VSS.t1204 sg13_lv_nmos ad=0.19p pd=1.38u as=0.345p ps=2.69u w=1u l=0.15u
X2823 VDD.t340 a_34549_32911# a_34651_32911# VDD.t118 sg13_lv_pmos ad=1.96315p pd=12.675u as=0.3864p ps=2.93u w=1.12u l=0.13u
X2824 a_33794_40898# sar_ctrl_async_phys_0.sg13g2_o21ai_1_1.B1 VSS.t20 VSS.t46 sg13_lv_nmos ad=37.8f pd=0.6u as=79.8f ps=0.8u w=0.42u l=0.13u
X2825 VSS.t144 VDD.t163 VSS.t154 VSS.t868 sg13_lv_nmos ad=79.8f pd=0.8u as=0 ps=0 w=0.42u l=1u
X2826 sar_ctrl_async_phys_0.bit_active[4] a_36056_35200# VSS.t113 VSS.t203 sg13_lv_nmos ad=0.2886p pd=2.26u as=0.14875p ps=1.16u w=0.74u l=0.13u
X2827 oa_sar8_acore18_opt_0.sw_tg_opt_0.bot.t3 oa_sar8_acore18_opt_0.sw_bitcell_opt_b4_0.bot.t30 cap_cmim l=2.14u w=2.14u
X2828 oa_sar8_acore18_opt_0.sw_tg_opt_1.bot.t3 oa_sar8_acore18_opt_0.sw_bitcell_opt_b7_1.bot.t73 cap_cmim l=2.14u w=2.14u
X2829 sar_ctrl_async_phys_0.dac_code_n[6] a_35672_46508# VDD.t35 VDD.t29 sg13_lv_pmos ad=0.42p pd=2.99u as=0.2114p ps=1.54u w=1.12u l=0.13u
X2830 VSS.t776 VDD.t79 VSS.t777 VSS.t185 sg13_lv_nmos ad=79.8f pd=0.8u as=0 ps=0 w=0.42u l=1u
X2831 VDD.t238 VSS.t926 VDD.t238 VDD.t54 sg13_lv_pmos ad=0.19p pd=1.38u as=0 ps=0 w=1u l=1u
X2832 VSS.t1059 VDD.t44 VSS.t1061 VSS.t1060 sg13_lv_nmos ad=79.8f pd=0.8u as=0 ps=0 w=0.42u l=1u
X2833 VSS.t677 VDD.t94 VSS.t677 VSS.t705 sg13_lv_nmos ad=79.8f pd=0.8u as=0 ps=0 w=0.42u l=1u
X2834 oa_sar8_acore18_opt_0.sw_tg_opt_0.bot.t3 oa_sar8_acore18_opt_0.sw_bitcell_opt_b3_0.bot.t2 cap_cmim l=2.14u w=2.14u
X2835 VDD.t119 VSS.t959 VDD.t119 VDD.t118 sg13_lv_pmos ad=0.19p pd=1.38u as=0 ps=0 w=1u l=1u
X2836 oa_sar8_acore18_opt_0.sw_tg_opt_0.bot.t3 oa_sar8_acore18_opt_0.sw_bitcell_opt_b7_0.bot.t83 cap_cmim l=2.14u w=2.14u
X2837 a_36156_45710# sar_ctrl_async_phys_0.sg13g2_buf_1_35.A VDD.t426 VDD.t29 sg13_lv_pmos ad=0.2856p pd=2.36u as=0.2114p ps=1.54u w=0.84u l=0.13u
X2838 oa_sar8_acore18_opt_0.sw_tg_opt_1.bot.t2 oa_sar8_acore18_opt_0.sw_bitcell_opt_b7_1.bot.t148 cap_cmim l=2.14u w=2.14u
X2839 sar_ctrl_async_phys_0.cmp_fault a_34136_47296# VDD.t22 VDD.t15 sg13_lv_pmos ad=0.42p pd=2.99u as=0.2114p ps=1.54u w=1.12u l=0.13u
X2840 a_31034_44457# a_31477_44213# a_31417_44625# VDD.t69 sg13_lv_pmos ad=79.8f pd=0.8u as=63f ps=0.72u w=0.42u l=0.13u
X2841 VDD.t196 VSS.t144 VDD.t354 VDD.t162 sg13_lv_pmos ad=0.19p pd=1.38u as=0 ps=0 w=1u l=1u
X2842 oa_sar8_acore18_opt_0.sw_tg_opt_1.bot.t3 oa_sar8_acore18_opt_0.sw_bitcell_opt_b7_1.bot.t30 cap_cmim l=2.14u w=2.14u
X2843 a_34549_34423# sar_ctrl_async_phys_0.sg13g2_dfrbpq_1_0.CLK.t8 VDD.t54 VDD.t54 sg13_lv_pmos ad=0.4088p pd=2.97u as=1.98685p ps=12.96u w=1.12u l=0.13u
X2844 VDD.t70 VSS.t771 VDD.t70 VDD.t69 sg13_lv_pmos ad=0.19p pd=1.38u as=0 ps=0 w=1u l=1u
X2845 oa_sar8_acore18_opt_0.sw_tg_opt_0.bot.t3 oa_sar8_acore18_opt_0.sw_bitcell_opt_b6_0.bot.t5 cap_cmim l=2.14u w=2.14u
X2846 VDD.t471 a_28368_36877# sar_ctrl_async_phys_0.sg13g2_nor2_1_7.A VDD.t13 sg13_lv_pmos ad=0.1918p pd=1.5u as=0.3808p ps=2.92u w=1.12u l=0.13u
X2847 VDD.t349 a_29258_36642# a_28977_36864# VDD.t13 sg13_lv_pmos ad=0.1523p pd=1.38u as=0.34p ps=2.68u w=1u l=0.5u
X2848 VSS.t137 VDD.t135 VSS.t137 VSS.t807 sg13_lv_nmos ad=79.8f pd=0.8u as=0 ps=0 w=0.42u l=1u
X2849 a_33506_37874# sar_ctrl_async_phys_0.sg13g2_buf_1_2.A.t5 VSS.t172 VSS.t118 sg13_lv_nmos ad=37.8f pd=0.6u as=79.8f ps=0.8u w=0.42u l=0.13u
X2850 oa_sar8_acore18_opt_0.sw_tg_opt_0.bot.t3 oa_sar8_acore18_opt_0.sw_bitcell_opt_b7_0.bot.t35 cap_cmim l=2.14u w=2.14u
X2851 sar_ctrl_async_phys_0.bit_active[0] a_34424_35200# VSS.t113 VSS.t508 sg13_lv_nmos ad=0.2886p pd=2.26u as=0.14875p ps=1.16u w=0.74u l=0.13u
X2852 VDD.t22 VSS.t129 VDD.t22 VDD.t15 sg13_lv_pmos ad=0.19p pd=1.38u as=0 ps=0 w=1u l=1u
X2853 VSS.t98 sar_ctrl_async_phys_0.sg13g2_buf_1_8.A a_33080_31388# VSS.t14 sg13_lv_nmos ad=0.14875p pd=1.16u as=0.187p ps=1.78u w=0.55u l=0.13u
X2854 VSS.t11 VDD.t198 VSS.t11 VSS.t126 sg13_lv_nmos ad=79.8f pd=0.8u as=0 ps=0 w=0.42u l=1u
X2855 a_34370_45746# sar_ctrl_async_phys_0.sg13g2_o21ai_1_1.B1 VSS.t25 VSS.t24 sg13_lv_nmos ad=37.8f pd=0.6u as=79.8f ps=0.8u w=0.42u l=0.13u
X2856 sar_ctrl_async_phys_0.sg13g2_buf_1_14.A a_33085_43832# VDD.t366 VDD.t0 sg13_lv_pmos ad=0.3808p pd=2.92u as=0.1918p ps=1.5u w=1.12u l=0.13u
X2857 oa_sar8_acore18_opt_0.sw_tg_opt_1.bot.t3 oa_sar8_acore18_opt_0.sw_bitcell_opt_b5_1.bot.t34 cap_cmim l=2.14u w=2.14u
X2858 VSS.t1029 VDD.t194 VSS.t1028 VSS.t1027 sg13_lv_nmos ad=0.1428p pd=1.52u as=0 ps=0 w=0.42u l=1u
X2859 VSS.t62 sar_ctrl_async_phys_0.sg13g2_nor2_1_4.Y a_34136_47296# VSS.t61 sg13_lv_nmos ad=0.14875p pd=1.16u as=0.187p ps=1.78u w=0.55u l=0.13u
X2860 a_34106_32868# a_34549_32911# a_34489_32947# VDD.t118 sg13_lv_pmos ad=79.8f pd=0.8u as=63f ps=0.72u w=0.42u l=0.13u
X2861 sar_ctrl_async_phys_0.sg13g2_nor2_1_5.Y sar_ctrl_async_phys_0.sg13g2_nor2_1_3.Y VSS.t277 VSS.t338 sg13_lv_nmos ad=0.1406p pd=1.12u as=0.2516p ps=2.16u w=0.74u l=0.13u
X2862 a_31136_43726# sar_ctrl_async_phys_0.sg13g2_dfrbpq_1_9.RESET_B VDD.t485 VDD.t0 sg13_lv_pmos ad=79.8f pd=0.8u as=2.2076p ps=14.4u w=0.42u l=0.13u
X2863 a_33844_39711# a_33556_40016# a_33782_39711# VSS.t1135 sg13_lv_nmos ad=0.1428p pd=1.52u as=37.8f ps=0.6u w=0.42u l=0.13u
X2864 oa_sar8_acore18_opt_0.sw_tg_opt_1.bot.t3 oa_sar8_acore18_opt_0.sw_bitcell_opt_b7_1.bot.t57 cap_cmim l=2.14u w=2.14u
X2865 a_35814_31813# a_34636_31749# a_35418_31668# VSS.t335 sg13_lv_nmos ad=37.8f pd=0.6u as=0.1428p ps=1.52u w=0.42u l=0.13u
X2866 VDD.t36 VSS.t45 VDD.t36 VDD.t5 sg13_lv_pmos ad=0.19p pd=1.38u as=0 ps=0 w=1u l=1u
X2867 VSS.t88 sar_ctrl_async_phys_0.sg13g2_buf_1_22.A a_35672_38224# VSS.t87 sg13_lv_nmos ad=0.14875p pd=1.16u as=0.187p ps=1.78u w=0.55u l=0.13u
X2868 oa_sar8_acore18_opt_0.sw_tg_opt_1.bot.t3 oa_sar8_acore18_opt_0.sw_bitcell_opt_b7_1.bot.t127 cap_cmim l=2.14u w=2.14u
X2869 VDD.t185 sar_ctrl_async_phys_0.sg13g2_buf_1_16.A a_30507_35204# VDD.t37 sg13_lv_pmos ad=0.253p pd=1.53u as=0.2856p ps=2.36u w=0.84u l=0.13u
X2870 oa_sar8_acore18_opt_0.sw_tg_opt_0.bot.t3 oa_sar8_acore18_opt_0.sw_bitcell_opt_b7_0.bot.t99 cap_cmim l=2.14u w=2.14u
X2871 oa_sar8_acore18_opt_0.bstrap_opt_w2_c1200_1.out oa_sar8_acore18_opt_0.bstrap_opt_w2_c1200_1.gb oa_sar8_acore18_opt_0.sw_bitcell_opt_term_1.bot.t0 VSS.t1089 sg13_lv_nmos ad=0.35p pd=2.7u as=0.195p ps=1.39u w=1u l=0.13u
X2872 sar_ctrl_async_phys_0.sg13g2_nand3_1_0.Y sar_ctrl_async_phys_0.sg13g2_nand3_1_0.A a_25896_39706# VSS.t89 sg13_lv_nmos ad=0.2516p pd=2.16u as=0.1406p ps=1.12u w=0.74u l=0.13u
X2873 oa_sar8_acore18_opt_0.sw_tg_opt_0.bot.t3 oa_sar8_acore18_opt_0.sw_bitcell_opt_b5_0.bot.t10 cap_cmim l=2.14u w=2.14u
X2874 VDD.t568 a_35199_44311# a_35866_44532# VDD.t69 sg13_lv_pmos ad=0.2128p pd=1.5u as=0.3864p ps=2.93u w=1.12u l=0.13u
X2875 oa_sar8_acore18_opt_0.sw_tg_opt_1.bot.t3 oa_sar8_acore18_opt_0.sw_bitcell_opt_b6_1.bot.t21 cap_cmim l=2.14u w=2.14u
X2876 VSS.t37 sar_ctrl_async_phys_0.sg13g2_nor2_1_10.B sar_ctrl_async_phys_0.sg13g2_nor2_1_10.Y VSS.t254 sg13_lv_nmos ad=0.2516p pd=2.16u as=0.1406p ps=1.12u w=0.74u l=0.13u
X2877 VDD.t384 a_34815_39775# a_35482_39996# VDD.t311 sg13_lv_pmos ad=0.2128p pd=1.5u as=0.3864p ps=2.93u w=1.12u l=0.13u
X2878 VDD.t676 a_32580_36642# a_32538_36972# VDD.t13 sg13_lv_pmos ad=0.2618p pd=1.63u as=0.1176p ps=1.33u w=1.12u l=0.13u
X2879 VDD.t340 a_35648_33142# a_35593_33023# VDD.t118 sg13_lv_pmos ad=1.96315p pd=12.675u as=93.45f ps=0.865u w=0.42u l=0.13u
X2880 a_26954_40424# sar_ctrl_async_phys_0.sg13g2_dlygate4sd3_1_8.A VSS.t58 VSS.t161 sg13_lv_nmos ad=0.1428p pd=1.52u as=79.8f ps=0.8u w=0.42u l=0.13u
X2881 VSS.t736 VDD.t32 VSS.t736 VSS.t737 sg13_lv_nmos ad=0.1428p pd=1.52u as=0 ps=0 w=0.42u l=1u
X2882 sar_ctrl_async_phys_0.bit_active[2] a_34808_35200# VDD.t447 VDD.t37 sg13_lv_pmos ad=0.42p pd=2.99u as=0.2114p ps=1.54u w=1.12u l=0.13u
X2883 VDD.t68 VSS.t717 VDD.t68 VDD.t29 sg13_lv_pmos ad=0.34p pd=2.68u as=0 ps=0 w=1u l=1u
X2884 VDD.t68 VSS.t672 VDD.t68 VDD.t29 sg13_lv_pmos ad=0.34p pd=2.68u as=0 ps=0 w=1u l=1u
X2885 a_35245_42242# sar_ctrl_async_phys_0.sg13g2_nand2b_1_2.A_N VDD.t450 VDD.t5 sg13_lv_pmos ad=0.2856p pd=2.36u as=0.2198p ps=1.53u w=0.84u l=0.13u
X2886 oa_sar8_acore18_opt_0.bstrap_opt_w2_c1200_1.out oa_sar8_acore18_opt_0.sw_bitcell_opt_term_0.trkb.t30 oa_sar8_acore18_opt_0.sw_bitcell_opt_term_1.bot.t0 VDD.t708 sg13_lv_pmos ad=0.7p pd=4.7u as=0.39p ps=2.39u w=2u l=0.13u
X2887 VDD.t447 sar_ctrl_async_phys_0.sg13g2_buf_1_14.A a_36056_35200# VDD.t37 sg13_lv_pmos ad=0.2114p pd=1.54u as=0.2856p ps=2.36u w=0.84u l=0.13u
X2888 VDD.t485 a_34261_43495# a_34363_43495# VDD.t0 sg13_lv_pmos ad=2.48357p pd=16.205u as=0.3864p ps=2.93u w=1.12u l=0.13u
X2889 a_35168_41430# sar_ctrl_async_phys_0.sg13g2_o21ai_1_1.B1 VDD.t325 VDD.t5 sg13_lv_pmos ad=79.8f pd=0.8u as=3.62845p ps=23.965u w=0.42u l=0.13u
X2890 oa_sar8_acore18_opt_0.sw_tg_opt_1.bot.t2 oa_sar8_acore18_opt_0.sw_bitcell_opt_b7_1.bot.t152 cap_cmim l=2.14u w=2.14u
X2891 a_35028_n9612# VDD.t1090 oa_sar8_acore18_opt_0.sw_bitcell_opt_term_0.gb.t0 VSS.t1078 sg13_lv_nmos ad=0.345p pd=2.69u as=0.19p ps=1.38u w=1u l=0.15u
X2892 a_30632_22281# sar_ctrl_async_phys_0.cmp_fire VDD.t843 VDD.t842 sg13_lv_pmos ad=0.7p pd=4.7u as=0.7p ps=4.7u w=2u l=0.13u
X2893 sar_ctrl_async_phys_0.sg13g2_nor2_1_1.A sar_ctrl_async_phys_0.sg13g2_nor2b_1_0.A.t2 VSS.t86 VSS.t85 sg13_lv_nmos ad=0.1406p pd=1.12u as=0.2516p ps=2.16u w=0.74u l=0.13u
X2894 a_34765_45266# sar_ctrl_async_phys_0.sg13g2_dfrbpq_1_9.Q VSS.t82 VSS.t157 sg13_lv_nmos ad=0.187p pd=1.78u as=0.14505p ps=1.15u w=0.55u l=0.13u
X2895 VDD.t314 sar_ctrl_async_phys_0.sg13g2_o21ai_1_1.B1 a_33530_39921# VDD.t311 sg13_lv_pmos ad=0.1563p pd=1.22u as=0.147p ps=1.54u w=0.42u l=0.13u
X2896 oa_sar8_acore18_opt_0.sw_tg_opt_0.bot.t4 oa_sar8_acore18_opt_0.sw_bitcell_opt_b7_0.bot.t5 cap_cmim l=2.14u w=2.14u
X2897 VDD.t182 VSS.t1003 VDD.t189 VDD.t39 sg13_lv_pmos ad=0.19p pd=1.38u as=0 ps=0 w=1u l=1u
X2898 VDD.t2 VSS.t72 VDD.t1 VDD.t0 sg13_lv_pmos ad=0.34p pd=2.68u as=0 ps=0 w=1u l=1u
X2899 VDD.t209 VSS.t346 VDD.t209 VDD.t5 sg13_lv_pmos ad=0.34p pd=2.68u as=0 ps=0 w=1u l=1u
X2900 oa_sar8_acore18_opt_0.sw_tg_opt_1.bot.t3 oa_sar8_acore18_opt_0.sw_bitcell_opt_b7_1.bot.t89 cap_cmim l=2.14u w=2.14u
X2901 VSS.t1024 VDD.t44 VSS.t1026 VSS.t1025 sg13_lv_nmos ad=79.8f pd=0.8u as=0 ps=0 w=0.42u l=1u
X2902 a_33193_35477# a_32251_35284# a_32991_35239# VDD.t37 sg13_lv_pmos ad=93.45f pd=0.865u as=0.2048p ps=1.63u w=0.42u l=0.13u
X2903 VDD.t169 sar_ctrl_async_phys_0.sg13g2_dfrbpq_1_9.RESET_B a_30938_46476# VDD.t29 sg13_lv_pmos ad=0.1563p pd=1.22u as=0.147p ps=1.54u w=0.42u l=0.13u
X2904 oa_sar8_acore18_opt_0.sw_tg_opt_1.bot.t3 oa_sar8_acore18_opt_0.sw_bitcell_opt_b6_1.bot.t9 cap_cmim l=2.14u w=2.14u
X2905 VSS.t7 VDD.t205 VSS.t1000 VSS.t226 sg13_lv_nmos ad=0.1428p pd=1.52u as=0 ps=0 w=0.42u l=1u
X2906 a_28008_23477# oa_sar8_acore18_opt_0.sw_tg_opt_0.bot.t5 a_30632_22281# VSS.t1204 sg13_lv_nmos ad=0.345p pd=2.69u as=0.19p ps=1.38u w=1u l=0.15u
X2907 VDD.t79 VSS.t736 VDD.t79 VDD.t69 sg13_lv_pmos ad=0.19p pd=1.38u as=0 ps=0 w=1u l=1u
X2908 sar_ctrl_async_phys_0.sg13g2_a22oi_1_5.A2 sar_ctrl_async_phys_0.sg13g2_a21oi_1_4.B1 VSS.t346 VSS.t1251 sg13_lv_nmos ad=0.1406p pd=1.12u as=0.2516p ps=2.16u w=0.74u l=0.13u
X2909 VDD.t205 sar_ctrl_async_phys_0.sg13g2_inv_1_5.A sar_ctrl_async_phys_0.sg13g2_inv_1_5.Y VDD.t118 sg13_lv_pmos ad=0.3808p pd=2.92u as=0.3808p ps=2.92u w=1.12u l=0.13u
X2910 sar_ctrl_async_phys_0.sg13g2_buf_1_33.A sar_ctrl_async_phys_0.sg13g2_nand2_1_3.A a_36074_41214# VSS.t406 sg13_lv_nmos ad=0.2516p pd=2.16u as=0.1406p ps=1.12u w=0.74u l=0.13u
X2911 sar_ctrl_async_phys_0.sg13g2_dfrbpq_1_11.D sar_ctrl_async_phys_0.sg13g2_a21oi_1_7.Y VSS.t190 VSS.t196 sg13_lv_nmos ad=0.1406p pd=1.12u as=0.2516p ps=2.16u w=0.74u l=0.13u
X2912 oa_sar8_acore18_opt_0.sw_tg_opt_0.bot.t3 oa_sar8_acore18_opt_0.sw_bitcell_opt_b7_0.bot.t131 cap_cmim l=2.14u w=2.14u
X2913 VSS.t920 VDD.t192 VSS.t920 VSS.t114 sg13_lv_nmos ad=0.1428p pd=1.52u as=0 ps=0 w=0.42u l=1u
X2914 VDD.t346 a_32319_44311# a_32576_44454# VDD.t69 sg13_lv_pmos ad=1.96315p pd=12.675u as=79.8f ps=0.8u w=0.42u l=0.13u
X2915 oa_sar8_acore18_opt_0.sw_tg_opt_0.bot.t3 oa_sar8_acore18_opt_0.sw_bitcell_opt_b5_0.bot.t22 cap_cmim l=2.14u w=2.14u
X2916 result[0] a_33080_30664# VDD.t40 VDD.t39 sg13_lv_pmos ad=0.42p pd=2.99u as=0.2114p ps=1.54u w=1.12u l=0.13u
X2917 VSS.t962 VDD.t238 VSS.t961 VSS.t960 sg13_lv_nmos ad=0.1428p pd=1.52u as=0 ps=0 w=0.42u l=1u
X2918 sar_ctrl_async_phys_0.sg13g2_nor4_1_0.Y sar_ctrl_async_phys_0.sg13g2_nand2b_1_0.Y VSS.t60 VSS.t289 sg13_lv_nmos ad=0.1406p pd=1.12u as=0.23757p ps=2.16u w=0.74u l=0.13u
X2919 oa_sar8_acore18_opt_0.sw_tg_opt_0.bot.t3 oa_sar8_acore18_opt_0.sw_bitcell_opt_b7_0.bot.t73 cap_cmim l=2.14u w=2.14u
X2920 oa_sar8_acore18_opt_0.sw_bitcell_opt_b7_1.VSS VDD.t1093 oa_sar8_acore18_opt_0.sw_bitcell_opt_term_1.bot.t0 VSS.t1075 sg13_lv_nmos ad=0.525p pd=3.7u as=0.2925p ps=1.89u w=1.5u l=0.13u
X2921 VSS.t677 VDD.t101 VSS.t672 VSS.t676 sg13_lv_nmos ad=0.1428p pd=1.52u as=0 ps=0 w=0.42u l=1u
X2922 oa_sar8_acore18_opt_0.sw_tg_opt_1.bot.t3 oa_sar8_acore18_opt_0.sw_bitcell_opt_b7_1.bot.t47 cap_cmim l=2.14u w=2.14u
X2923 a_31136_43726# a_30879_43845# a_31298_43922# VSS.t1109 sg13_lv_nmos ad=0.1428p pd=1.52u as=37.8f ps=0.6u w=0.42u l=0.13u
X2924 a_29524_40464# a_29498_40428# VDD.t312 VDD.t311 sg13_lv_pmos ad=0.34p pd=2.68u as=0.36237p ps=2.605u w=1u l=0.13u
X2925 VDD.t633 sar_ctrl_async_phys_0.dac_code[3] oa_sar8_acore18_opt_0.sw_bitcell_opt_b3_0.bot.t1 VDD.t632 sg13_lv_pmos ad=1.47p pd=9.1u as=0.819p ps=4.59u w=4.2u l=0.13u
X2926 VDD.t10 VSS.t72 VDD.t8 VDD.t5 sg13_lv_pmos ad=0.34p pd=2.68u as=0 ps=0 w=1u l=1u
X2927 oa_sar8_acore18_opt_0.sw_bitcell_opt_b6_1.bot.t81 sar_ctrl_async_phys_0.dac_code_n[6] VDD.t806 VDD.t804 sg13_lv_pmos ad=1.17p pd=6.39u as=2.1p ps=12.7u w=6u l=0.13u
X2928 VDD.t44 VSS.t1063 VDD.t44 VDD.t39 sg13_lv_pmos ad=0.34p pd=2.68u as=0 ps=0 w=1u l=1u
X2929 a_33632_40702# a_33375_40821# a_33794_40898# VSS.t446 sg13_lv_nmos ad=0.1428p pd=1.52u as=37.8f ps=0.6u w=0.42u l=0.13u
X2930 VDD.t119 VSS.t18 VDD.t119 VDD.t118 sg13_lv_pmos ad=0.34p pd=2.68u as=0 ps=0 w=1u l=1u
X2931 VDD.t888 oa_sar8_acore18_opt_0.bstrap_opt_w2_c1200_1.gb w_16692_n9960# w_16692_n9960# sg13_lv_pmos ad=0.7p pd=4.7u as=0.7p ps=4.7u w=2u l=0.13u
X2932 VSS.t926 VDD.t38 VSS.t926 VSS.t114 sg13_lv_nmos ad=0.1428p pd=1.52u as=0 ps=0 w=0.42u l=1u
X2933 VSS.t271 sar_ctrl_async_phys_0.sg13g2_buf_1_9.A a_33080_30664# VSS.t1191 sg13_lv_nmos ad=0.14875p pd=1.16u as=0.187p ps=1.78u w=0.55u l=0.13u
X2934 VDD.t70 VSS.t717 VDD.t70 VDD.t69 sg13_lv_pmos ad=0.34p pd=2.68u as=0 ps=0 w=1u l=1u
X2935 oa_sar8_acore18_opt_0.sw_tg_opt_0.bot.t3 oa_sar8_acore18_opt_0.sw_bitcell_opt_b6_0.bot.t30 cap_cmim l=2.14u w=2.14u
R0 VDD.n388 VDD.n387 42.1996
R1 VDD.n368 VDD.n367 25.0383
R2 VDD.n321 VDD.t874 22.1806
R3 VDD.n421 VDD.t869 22.1806
R4 VDD.n360 VDD.t1091 22.1289
R5 VDD.n355 VDD.t1090 22.1286
R6 VDD.n321 VDD.t1092 21.1066
R7 VDD.n421 VDD.t1093 21.1066
R8 VDD.n322 VDD.n321 20.8627
R9 VDD.n360 VDD.t888 19.8644
R10 VDD.n355 VDD.t800 19.8644
R11 VDD.t576 VDD.t485 0.00198379
R12 VDD.t340 VDD.n270 17.0005
R13 VDD.t37 VDD.n209 5.64879
R14 VDD.n260 VDD.t315 17.0005
R15 VDD.n254 VDD.n252 17.0005
R16 VDD.n99 VDD.t146 17.0005
R17 VDD.n134 VDD.n99 4.17719
R18 VDD.n121 VDD.n138 4.17719
R19 VDD.n386 VDD.t839 15.5072
R20 VDD.n384 VDD.t841 15.5072
R21 VDD.n377 VDD.t843 15.5072
R22 VDD.n375 VDD.t845 15.5072
R23 VDD.n422 VDD.n421 14.3209
R24 VDD.n427 VDD.n426 13.349
R25 VDD.n382 VDD.n381 9.6902
R26 VDD.n380 VDD.n379 9.6902
R27 VDD.n319 VDD.n318 9.6462
R28 VDD.n325 VDD.n324 9.6462
R29 VDD.n329 VDD.n328 9.6462
R30 VDD.n333 VDD.n332 9.6462
R31 VDD.n337 VDD.n336 9.6462
R32 VDD.n341 VDD.n340 9.6462
R33 VDD.n345 VDD.n344 9.6462
R34 VDD.n349 VDD.n348 9.6462
R35 VDD.n353 VDD.n352 9.6462
R36 VDD.n363 VDD.n362 9.6462
R37 VDD.n391 VDD.n390 9.6462
R38 VDD.n395 VDD.n394 9.6462
R39 VDD.n399 VDD.n398 9.6462
R40 VDD.n403 VDD.n402 9.6462
R41 VDD.n407 VDD.n406 9.6462
R42 VDD.n411 VDD.n410 9.6462
R43 VDD.n415 VDD.n414 9.6462
R44 VDD.n419 VDD.n418 9.6462
R45 VDD.n424 VDD.n423 9.6462
R46 VDD.t485 VDD.n231 0.338889
R47 VDD.n136 VDD.n135 3.36443
R48 VDD.t426 VDD.n4 8.6008
R49 VDD.n156 VDD.t428 8.58496
R50 VDD.t614 VDD.n158 0.405824
R51 VDD.n106 VDD.t875 0.355435
R52 VDD.t497 VDD.n330 1.53361
R53 VDD.n161 VDD.n162 0.00170812
R54 VDD.n150 VDD.n161 0.00207877
R55 VDD.t478 VDD.n131 0.416114
R56 VDD.n163 VDD.n165 0.00172462
R57 VDD.n164 VDD.n163 0.00209117
R58 VDD.n145 VDD.n167 0.00205508
R59 VDD.t983 VDD.n76 0.321344
R60 VDD.n133 VDD.n93 0.00638425
R61 VDD.n80 VDD.n79 0.00388115
R62 VDD.n80 VDD.n100 0.00762926
R63 VDD.t616 VDD.n389 1.62191
R64 VDD.t1020 VDD.n73 0.341548
R65 VDD.t710 VDD.n393 1.62173
R66 VDD.n96 VDD.t804 0.355728
R67 VDD.n173 VDD.n172 0.00166658
R68 VDD.t804 VDD.n173 2.83417
R69 VDD.t804 VDD.n97 1.41711
R70 VDD.n125 VDD.n116 0.0013491
R71 VDD.n175 VDD.n177 0.0019168
R72 VDD.t618 VDD.n175 0.945916
R73 VDD.n42 VDD.n40 0.00217072
R74 VDD.t703 VDD.n181 0.405824
R75 VDD.t587 VDD.n184 0.487639
R76 VDD.n62 VDD.n186 0.00278948
R77 VDD.t595 VDD.n62 0.68087
R78 VDD.t1001 VDD.n85 0.387198
R79 VDD.t510 VDD.n45 0.407819
R80 VDD.t559 VDD.n191 1.06352
R81 VDD.t970 VDD.n366 1.62191
R82 VDD.n56 VDD.n55 0.00237824
R83 VDD.t709 VDD.n56 0.405427
R84 VDD.t713 VDD.n198 0.405824
R85 VDD.t467 VDD.n39 0.405384
R86 VDD.n39 VDD.n38 0.00230494
R87 VDD.t842 VDD.n9 0.448321
R88 VDD.t844 VDD.n14 0.448321
R89 VDD.t870 VDD.n422 1.55057
R90 VDD.n204 VDD.t118 0.150259
R91 VDD.t198 VDD.n208 0.503162
R92 VDD.t185 VDD.n209 0.0296542
R93 VDD.t197 VDD.n153 0.91815
R94 VDD.t247 VDD.n213 0.336824
R95 VDD.n212 VDD.t165 0.620818
R96 VDD.t163 VDD.n211 0.356246
R97 VDD.t5 VDD.n216 0.448427
R98 VDD.n229 VDD.n230 0.00274975
R99 VDD.t0 VDD.n229 2.12578
R100 VDD.t0 VDD.n22 1.21486
R101 VDD.t0 VDD.n19 0.248277
R102 VDD.n22 VDD.n99 0.00371291
R103 VDD.t0 VDD.n227 1.88952
R104 VDD.n225 VDD.n226 0.00166658
R105 VDD.n224 VDD.n225 0.00170812
R106 VDD.t0 VDD.n135 1.2142
R107 VDD.n233 VDD.t69 0.150411
R108 VDD.t169 VDD.n238 0.646198
R109 VDD.n373 VDD.n12 8.47815
R110 VDD.n374 VDD.n17 8.47815
R111 VDD.n93 VDD.n94 0.73089
R112 VDD.n294 VDD.n172 8.47188
R113 VDD.n101 VDD.n100 1.08203
R114 VDD.n122 VDD.n78 2.29811
R115 VDD.n66 VDD.n122 1.78175
R116 VDD.t228 VDD.n203 0.635702
R117 VDD.t237 VDD.n5 0.119605
R118 VDD.t54 VDD.n5 4.177
R119 VDD.n26 VDD.t54 4.177
R120 VDD.n206 VDD.t54 4.177
R121 VDD.t301 VDD.n206 0.119605
R122 VDD.t242 VDD.n26 0.119605
R123 VDD.n207 VDD.t54 4.177
R124 VDD.n2 VDD.t13 0.745314
R125 VDD.n7 VDD.t349 0.235242
R126 VDD.t13 VDD.n7 2.72093
R127 VDD.t13 VDD.n139 3.30696
R128 VDD.t179 VDD.n217 8.47111
R129 VDD.t177 VDD.n215 8.47111
R130 VDD.n24 VDD.n23 2.72093
R131 VDD.n219 VDD.t99 0.119605
R132 VDD.n220 VDD.n18 4.177
R133 VDD.t137 VDD.n220 0.119605
R134 VDD.t528 VDD.n230 8.47111
R135 VDD.t135 VDD.n20 8.47111
R136 VDD.t136 VDD.n21 8.47111
R137 VDD.n219 VDD.n21 4.177
R138 VDD.t1089 VDD.t576 8.47111
R139 VDD.n221 VDD.n18 3.32534
R140 VDD.n99 VDD.n222 4.177
R141 VDD.n222 VDD.t4 0.119605
R142 VDD.t2 VDD.n25 8.47111
R143 VDD.n223 VDD.n25 4.177
R144 VDD.t132 VDD.n223 0.119605
R145 VDD.t151 VDD.n226 8.47111
R146 VDD.t150 VDD.n225 8.47111
R147 VDD.n249 VDD.n224 8.47111
R148 VDD.t155 VDD.n136 0.125015
R149 VDD.t79 VDD.n234 8.47111
R150 VDD.t96 VDD.n232 0.635702
R151 VDD.t94 VDD.n121 8.47111
R152 VDD.n128 VDD.n121 3.30688
R153 VDD.t81 VDD.t323 8.47111
R154 VDD.t32 VDD.n237 0.234996
R155 VDD.n6 VDD.t323 4.177
R156 VDD.t30 VDD.n6 0.119605
R157 VDD.n88 VDD.n124 0.0748485
R158 VDD.n147 VDD.n146 2.72136
R159 VDD.n171 VDD.n79 0.0594057
R160 VDD.n74 VDD.n75 3.30711
R161 VDD.n41 VDD.n47 1.78457
R162 VDD.n187 VDD.n59 0.675794
R163 VDD.n188 VDD.n189 4.17681
R164 VDD.n160 VDD.n316 8.4706
R165 VDD.n312 VDD.n162 8.4706
R166 VDD.n151 VDD.n152 3.305
R167 VDD.n309 VDD.n165 8.4706
R168 VDD.n169 VDD.n102 0.186763
R169 VDD.n102 VDD.n149 3.3054
R170 VDD.n174 VDD.n67 0.186763
R171 VDD.n70 VDD.n71 3.3054
R172 VDD.n183 VDD.n286 8.4706
R173 VDD.n54 VDD.n28 0.08873
R174 VDD.n281 VDD.n186 8.4706
R175 VDD.n30 VDD.n29 2.29503
R176 VDD.n85 VDD.n86 3.30579
R177 VDD.n193 VDD.n194 2.71906
R178 VDD.n200 VDD.n357 8.4706
R179 VDD.n201 VDD.n38 0.186763
R180 VDD.n38 VDD.n61 3.30675
R181 VDD.n69 VDD.n105 1.63245
R182 VDD.n245 VDD.t120 8.36235
R183 VDD.n275 VDD.t61 8.3005
R184 VDD.n271 VDD.t229 8.3005
R185 VDD.n268 VDD.t244 8.3005
R186 VDD.n267 VDD.t192 8.3005
R187 VDD.n264 VDD.t361 8.3005
R188 VDD.n261 VDD.t276 8.3005
R189 VDD.n258 VDD.t319 8.3005
R190 VDD.n255 VDD.t176 8.3005
R191 VDD.n251 VDD.t174 8.3005
R192 VDD.n248 VDD.t97 8.3005
R193 VDD.n245 VDD.n242 8.3005
R194 VDD.n388 VDD.n368 7.5905
R195 VDD.n362 VDD.t469 6.20712
R196 VDD.n362 VDD.t468 6.01855
R197 VDD.n205 VDD.t340 0.442393
R198 VDD.n210 VDD.t37 1.58883
R199 VDD.n214 VDD.t311 0.108771
R200 VDD.n218 VDD.t325 1.41018
R201 VDD.n235 VDD.t346 0.896707
R202 VDD.n107 VDD.n106 0.00120845
R203 VDD.t615 VDD.n323 1.6205
R204 VDD.t617 VDD.n327 1.6205
R205 VDD.t478 VDD.n150 1.54581
R206 VDD.t632 VDD.n164 1.30792
R207 VDD.t621 VDD.n31 0.296326
R208 VDD.t983 VDD.n145 1.8894
R209 VDD.t305 VDD.n133 0.299317
R210 VDD.t305 VDD.n168 1.8894
R211 VDD.n103 VDD.n102 0.00187666
R212 VDD.t386 VDD.n80 0.24376
R213 VDD.n77 VDD.n65 0.00522267
R214 VDD.t1020 VDD.n77 0.850392
R215 VDD.n97 VDD.n63 0.0037489
R216 VDD.t1012 VDD.n111 2.83414
R217 VDD.t1012 VDD.n116 0.304933
R218 VDD.n175 VDD.n70 0.00308251
R219 VDD.t809 VDD.n42 0.293717
R220 VDD.t587 VDD.n118 0.895475
R221 VDD.n35 VDD.n34 0.00312994
R222 VDD.n84 VDD.n83 0.00182929
R223 VDD.t1001 VDD.n83 2.83414
R224 VDD.n155 VDD.n369 0.00291646
R225 VDD.n115 VDD.n113 0.00566574
R226 VDD.t708 VDD.n425 1.62076
R227 VDD.n156 VDD.t325 0.00276684
R228 VDD.n22 VDD.n21 0.0037839
R229 VDD.n227 VDD.n228 0.00316617
R230 VDD.t29 VDD.n120 0.516921
R231 VDD.n4 VDD.t323 0.00717583
R232 VDD.n19 VDD.n18 0.00476797
R233 VDD.t139 VDD.n221 0.103492
R234 VDD.n64 VDD.n63 2.29956
R235 VDD.n302 VDD.n301 5.61547
R236 VDD.n98 VDD.n95 1.97842
R237 VDD.n304 VDD.n167 5.61509
R238 VDD.n298 VDD.n297 5.61509
R239 VDD.n132 VDD.n298 0.534172
R240 VDD.n79 VDD.n132 2.7212
R241 VDD.n65 VDD.n66 0.0430991
R242 VDD.n108 VDD.n72 2.7212
R243 VDD.n112 VDD.n111 2.72147
R244 VDD.n291 VDD.n154 5.61509
R245 VDD.n292 VDD.n290 5.61509
R246 VDD.n130 VDD.n292 0.58948
R247 VDD.t471 VDD.n139 0.118193
R248 VDD.t13 VDD.n262 5.61485
R249 VDD.n21 VDD.t161 5.61485
R250 VDD.t144 VDD.n134 0.0599544
R251 VDD.n228 VDD.t1 5.61485
R252 VDD.t128 VDD.n138 0.0599544
R253 VDD.t78 VDD.n128 0.118323
R254 VDD.n127 VDD.n3 2.72098
R255 VDD.t67 VDD.n127 0.175395
R256 VDD.n89 VDD.n107 5.61471
R257 VDD.n192 VDD.n190 5.61471
R258 VDD.n370 VDD.n155 5.61471
R259 VDD.n371 VDD.n369 5.61471
R260 VDD.n114 VDD.n113 0.858781
R261 VDD.n124 VDD.n32 1.92017
R262 VDD.n88 VDD.n87 5.61434
R263 VDD.n179 VDD.n178 5.61434
R264 VDD.n47 VDD.n46 2.29624
R265 VDD.n141 VDD.n84 0.124834
R266 VDD.n83 VDD.n109 2.71962
R267 VDD.n159 VDD.n157 5.61396
R268 VDD.n103 VDD.n170 5.61698
R269 VDD.n177 VDD.n176 5.61396
R270 VDD.n182 VDD.n180 5.61396
R271 VDD.n43 VDD.n57 5.61396
R272 VDD.n196 VDD.n195 5.61396
R273 VDD.n199 VDD.n197 5.61396
R274 VDD.n313 VDD.n161 5.61359
R275 VDD.n69 VDD.n68 3.30434
R276 VDD.n163 VDD.n310 5.61321
R277 VDD.n105 VDD.n104 0.0950864
R278 VDD.n129 VDD.n69 0.728858
R279 VDD.n367 VDD.n355 5.11917
R280 VDD.t346 VDD.n236 0.27343
R281 VDD.n418 VDD.t561 4.32323
R282 VDD.n423 VDD.t873 4.32323
R283 VDD.n318 VDD.t878 4.30984
R284 VDD.n324 VDD.t682 4.30984
R285 VDD.n381 VDD.t950 4.29172
R286 VDD.n379 VDD.t474 4.29172
R287 VDD.n76 VDD.n166 4.17741
R288 VDD.n117 VDD.n130 2.2982
R289 VDD.n237 VDD.t323 2.72109
R290 VDD.t39 VDD.t62 4.17712
R291 VDD.n243 VDD.n137 4.17712
R292 VDD.n92 VDD.n90 1.72251
R293 VDD.n34 VDD.n33 4.17595
R294 VDD.n308 VDD.n307 4.17491
R295 VDD.n119 VDD.n129 2.29406
R296 VDD.n318 VDD.t876 4.12127
R297 VDD.n324 VDD.t681 4.12127
R298 VDD.n381 VDD.t952 4.12127
R299 VDD.n379 VDD.t475 4.12127
R300 VDD.n418 VDD.t560 4.12127
R301 VDD.n423 VDD.t871 4.12127
R302 VDD.n414 VDD.t1003 3.922
R303 VDD.n328 VDD.t499 3.90861
R304 VDD.n328 VDD.t498 3.72004
R305 VDD.n414 VDD.t1002 3.72004
R306 VDD.n361 VDD.n360 3.47008
R307 VDD.n410 VDD.t597 3.46484
R308 VDD.n332 VDD.t480 3.45146
R309 VDD.n406 VDD.t589 3.38128
R310 VDD.n336 VDD.t634 3.3679
R311 VDD.n382 VDD.n380 3.35367
R312 VDD.n332 VDD.t479 3.26288
R313 VDD.n410 VDD.t596 3.26288
R314 VDD.n336 VDD.t633 3.17933
R315 VDD.n406 VDD.t588 3.17933
R316 VDD.n402 VDD.t811 3.01965
R317 VDD.n340 VDD.t623 3.00627
R318 VDD.n398 VDD.t1014 2.91844
R319 VDD.n344 VDD.t985 2.90513
R320 VDD.n340 VDD.t622 2.81769
R321 VDD.n402 VDD.t810 2.81769
R322 VDD.n394 VDD.t806 2.77627
R323 VDD.n348 VDD.t307 2.76289
R324 VDD.n344 VDD.t984 2.71656
R325 VDD.n398 VDD.t1013 2.71648
R326 VDD.n366 VDD.n365 2.67717
R327 VDD.n352 VDD.t388 2.62121
R328 VDD.n390 VDD.t1022 2.62121
R329 VDD.n365 VDD.n364 2.60383
R330 VDD.n348 VDD.t306 2.57431
R331 VDD.n394 VDD.t805 2.57431
R332 VDD.n368 VDD.n354 2.55158
R333 VDD.n352 VDD.t387 2.43265
R334 VDD.n390 VDD.t1021 2.43264
R335 VDD.n391 VDD.n389 2.00892
R336 VDD.n353 VDD.n351 2.00892
R337 VDD.t311 VDD.t605 1.99822
R338 VDD.t39 VDD.n272 1.97641
R339 VDD.n256 VDD.t311 1.97636
R340 VDD.n218 VDD.t428 0.574024
R341 VDD.n395 VDD.n393 1.86225
R342 VDD.n349 VDD.n347 1.86225
R343 VDD.n427 VDD.n275 1.84532
R344 VDD.n303 VDD.n144 1.12765
R345 VDD.n319 VDD.n317 1.83169
R346 VDD.n295 VDD.n110 1.14277
R347 VDD.n305 VDD.n37 1.14472
R348 VDD.n293 VDD.n126 1.11159
R349 VDD.n123 VDD.n213 1.40958
R350 VDD.n314 VDD.n148 1.1077
R351 VDD.n288 VDD.n41 1.14333
R352 VDD.n399 VDD.n397 1.75225
R353 VDD.n345 VDD.n343 1.75225
R354 VDD.n311 VDD.n82 1.12989
R355 VDD.n285 VDD.n105 1.11031
R356 VDD.n315 VDD.n140 1.0469
R357 VDD.n403 VDD.n401 1.64225
R358 VDD.n341 VDD.n339 1.64225
R359 VDD.n378 VDD.t473 1.62365
R360 VDD.n114 VDD.n372 0.670166
R361 VDD.t12 VDD.n254 1.5434
R362 VDD.n317 VDD.n49 1.05966
R363 VDD.n287 VDD.n51 1.05966
R364 VDD.n44 VDD.n278 1.4011
R365 VDD.n356 VDD.n60 1.00924
R366 VDD.n358 VDD.n53 1.05966
R367 VDD.n407 VDD.n405 1.53225
R368 VDD.n337 VDD.n335 1.53225
R369 VDD.n411 VDD.n409 1.45892
R370 VDD.n333 VDD.n331 1.45892
R371 VDD.n191 VDD.n58 0.0019687
R372 VDD.t949 VDD.n115 0.35505
R373 VDD.t312 VDD.t334 1.39943
R374 VDD.n415 VDD.n413 1.38558
R375 VDD.n329 VDD.n327 1.38558
R376 VDD.t350 VDD.n123 1.38119
R377 VDD.n142 VDD.n370 1.27196
R378 VDD.n37 VDD.n36 0.0549972
R379 VDD.n41 VDD.n40 0.0591738
R380 VDD.n283 VDD.n185 1.75687
R381 VDD.n44 VDD.n43 0.145558
R382 VDD.n194 VDD.n60 1.55847
R383 VDD.n389 VDD.n388 1.32508
R384 VDD.n419 VDD.n417 1.31225
R385 VDD.n325 VDD.n323 1.31225
R386 VDD.n425 VDD.n424 1.31225
R387 VDD.t457 VDD.t185 1.30969
R388 VDD.n417 VDD.n416 1.3095
R389 VDD.n413 VDD.n412 1.3095
R390 VDD.n409 VDD.n408 1.3095
R391 VDD.n405 VDD.n404 1.3095
R392 VDD.n401 VDD.n400 1.3095
R393 VDD.n397 VDD.n396 1.3095
R394 VDD.n393 VDD.n392 1.3095
R395 VDD.n351 VDD.n350 1.3095
R396 VDD.n347 VDD.n346 1.3095
R397 VDD.n343 VDD.n342 1.3095
R398 VDD.n339 VDD.n338 1.3095
R399 VDD.n335 VDD.n334 1.3095
R400 VDD.n331 VDD.n330 1.3095
R401 VDD.n327 VDD.n326 1.3095
R402 VDD.t640 VDD.n35 0.406738
R403 VDD.t315 VDD.n211 1.0519
R404 VDD.t328 VDD.n214 1.01056
R405 VDD.n11 VDD.n10 1.13756
R406 VDD.n16 VDD.n15 1.13756
R407 VDD.t13 VDD.t676 0.429888
R408 VDD.t230 VDD.t205 1.17812
R409 VDD.t426 VDD.n244 1.16841
R410 VDD.t54 VDD.t238 1.16056
R411 VDD.t415 VDD.n235 0.577165
R412 VDD.t363 VDD.t419 1.15305
R413 VDD.n250 VDD.t389 1.1447
R414 VDD.n236 VDD.t415 1.19919
R415 VDD.n364 VDD.n363 1.12892
R416 VDD.n269 VDD.t343 1.12851
R417 VDD.t42 VDD.t457 1.11913
R418 VDD.t54 VDD.n208 0.930271
R419 VDD.n375 VDD.n15 1.11486
R420 VDD.n253 VDD.t209 1.11479
R421 VDD.t189 VDD.t182 1.10678
R422 VDD.n241 VDD.t22 1.103
R423 VDD.t314 VDD.t384 1.09655
R424 VDD.n89 VDD.n140 1.41639
R425 VDD.n276 VDD.n187 1.87547
R426 VDD.n113 VDD.n142 0.335766
R427 VDD.n148 VDD.n131 0.0956969
R428 VDD.t230 VDD.n27 0.0341399
R429 VDD.n426 VDD.n425 1.08926
R430 VDD.n257 VDD.t328 1.07248
R431 VDD.n323 VDD.n322 1.06842
R432 VDD.n246 VDD.t401 1.06535
R433 VDD.t319 VDD.t312 1.06171
R434 VDD.t22 VDD.t337 1.05596
R435 VDD.n246 VDD.t117 1.05112
R436 VDD.n273 VDD.t40 1.04823
R437 VDD.n231 VDD.t389 1.08111
R438 VDD.t55 VDD.t54 0.94095
R439 VDD.t163 VDD.n259 1.03983
R440 VDD.t8 VDD.t10 1.03946
R441 VDD.n253 VDD.t36 1.0363
R442 VDD.t573 VDD.t489 1.03571
R443 VDD.t86 VDD.t68 1.03237
R444 VDD.n244 VDD.t35 1.0286
R445 VDD.t43 VDD.t40 1.0275
R446 VDD.n378 VDD.n377 1.02625
R447 VDD.n384 VDD.n383 1.02442
R448 VDD.t354 VDD.t196 1.02326
R449 VDD.t43 VDD.t44 1.02241
R450 VDD.n247 VDD.t117 1.02052
R451 VDD.t556 VDD.t371 1.01466
R452 VDD.t38 VDD.n265 1.01101
R453 VDD.t36 VDD.t187 1.00992
R454 VDD.n241 VDD.t16 1.00905
R455 VDD.n250 VDD.t366 1.00447
R456 VDD.n240 VDD.t16 1.00368
R457 VDD.t13 VDD.n0 0.381414
R458 VDD.n274 VDD.t573 1.00081
R459 VDD.n266 VDD.t192 0.977762
R460 VDD.t198 VDD.n1 1.06534
R461 VDD.t254 VDD.t54 0.974884
R462 VDD.n259 VDD.t276 0.972931
R463 VDD.n231 VDD.t600 0.839896
R464 VDD.t187 VDD.t186 0.966014
R465 VDD.t668 VDD.t450 0.96455
R466 VDD.t120 VDD.n239 0.964328
R467 VDD.n247 VDD.t79 0.960256
R468 VDD.n274 VDD.t547 0.955989
R469 VDD.t323 VDD.t116 0.946665
R470 VDD.t611 VDD.t485 0.945615
R471 VDD.n205 VDD.t647 0.755594
R472 VDD.t120 VDD.n240 0.931488
R473 VDD.t568 VDD.n236 0.720097
R474 VDD.n212 VDD.t162 0.773731
R475 VDD.t382 VDD.n0 0.298329
R476 VDD.t819 VDD.t13 0.765724
R477 VDD.n376 VDD.n375 0.879583
R478 VDD.n386 VDD.n385 0.87775
R479 VDD.t668 VDD.t209 0.871587
R480 VDD.t194 VDD.t189 0.861151
R481 VDD.t611 VDD.t1089 0.849816
R482 VDD.n153 VDD.t447 0.780812
R483 VDD.t361 VDD.n263 0.843242
R484 VDD.t351 VDD.t354 0.815229
R485 VDD.t116 VDD.t114 0.814601
R486 VDD.t838 VDD.n387 1.95552
R487 VDD.t840 VDD.n385 1.95552
R488 VDD.n277 VDD.n276 0.805837
R489 VDD.t192 VDD.n265 0.804113
R490 VDD.t6 VDD.t8 0.792806
R491 VDD.n376 VDD.n10 0.783944
R492 VDD.n284 VDD.n283 0.780359
R493 VDD.n158 VDD.n48 0.00215473
R494 VDD.n181 VDD.n50 0.00215473
R495 VDD.n35 VDD.n185 0.810653
R496 VDD.n198 VDD.n52 0.00215473
R497 VDD.n367 VDD.n366 0.76775
R498 VDD.n238 VDD.t33 0.0571707
R499 VDD.n212 VDD.t247 0.824204
R500 VDD.n266 VDD.t46 0.755655
R501 VDD.n238 VDD.t323 0.63011
R502 VDD.t227 VDD.n203 0.0461335
R503 VDD.t89 VDD.n232 0.0461335
R504 VDD.t33 VDD.t35 0.723433
R505 VDD.t101 VDD.n239 0.720706
R506 VDD.t56 VDD.n1 0.23468
R507 VDD.t556 VDD.t338 0.716112
R508 VDD.n257 VDD.t334 0.71071
R509 VDD.t511 VDD.n335 1.62264
R510 VDD.t641 VDD.n103 0.405746
R511 VDD.t618 VDD.n67 0.709286
R512 VDD.t371 VDD.n208 0.772914
R513 VDD.t339 VDD.t363 0.703219
R514 VDD.t169 VDD.t116 0.687508
R515 VDD.t559 VDD.n59 0.532639
R516 VDD.n155 VDD.n115 0.00290547
R517 VDD.t337 VDD.t345 0.67751
R518 VDD.n254 VDD.t8 0.663291
R519 VDD.t325 VDD.t668 0.662615
R520 VDD.t818 VDD.t165 0.646501
R521 VDD.n204 VDD.n203 0.523599
R522 VDD.n233 VDD.n232 0.523986
R523 VDD.t595 VDD.n28 0.630586
R524 VDD.n120 VDD.n137 0.00292462
R525 VDD.t632 VDD.n81 0.415717
R526 VDD.n184 VDD.n104 0.00171462
R527 VDD.t366 VDD.t611 0.603338
R528 VDD.n383 VDD.n372 0.593278
R529 VDD.n269 VDD.t342 0.590649
R530 VDD.n235 VDD.t401 0.449768
R531 VDD.t325 VDD.t187 0.574475
R532 VDD.t37 VDD.n265 0.573435
R533 VDD.n372 VDD.n142 0.993288
R534 VDD.t311 VDD.t363 0.568216
R535 VDD.n263 VDD.t13 0.61234
R536 VDD.n12 VDD.n9 0.00149102
R537 VDD.n17 VDD.n14 0.00149102
R538 VDD.n254 VDD.n216 0.00184211
R539 VDD.t39 VDD.t189 0.552929
R540 VDD.n205 VDD.t343 1.09938
R541 VDD.n320 VDD.n315 0.519944
R542 VDD.n334 VDD.n314 0.519944
R543 VDD.n338 VDD.n311 0.519944
R544 VDD.n342 VDD.n306 0.519944
R545 VDD.n346 VDD.n305 0.519944
R546 VDD.n350 VDD.n303 0.519944
R547 VDD.n351 VDD.n300 0.519944
R548 VDD.n354 VDD.n299 0.519944
R549 VDD.n392 VDD.n296 0.519944
R550 VDD.n396 VDD.n295 0.519944
R551 VDD.n397 VDD.t613 1.62441
R552 VDD.n400 VDD.n293 0.519944
R553 VDD.n401 VDD.n289 0.519944
R554 VDD.n404 VDD.n288 0.519944
R555 VDD.n405 VDD.n287 0.519944
R556 VDD.n408 VDD.n285 0.519944
R557 VDD.n409 VDD.n284 0.519944
R558 VDD.n412 VDD.n282 0.519944
R559 VDD.n416 VDD.n280 0.519944
R560 VDD.n417 VDD.n279 0.519944
R561 VDD.n420 VDD.n277 0.519944
R562 VDD.n365 VDD.n356 0.519944
R563 VDD.n364 VDD.n358 0.519944
R564 VDD.n361 VDD.n359 0.519944
R565 VDD.n371 VDD.n114 0.912322
R566 VDD.n137 VDD.t68 0.509632
R567 VDD.t319 VDD.n256 0.506228
R568 VDD.t61 VDD.n272 0.506211
R569 VDD.n246 VDD.t346 0.505405
R570 VDD.n49 VDD.n48 0.14595
R571 VDD.n343 VDD.t971 1.62145
R572 VDD.n51 VDD.n50 0.14595
R573 VDD.n283 VDD.n34 0.505076
R574 VDD.n279 VDD.n44 1.05907
R575 VDD.n60 VDD.n55 0.202336
R576 VDD.n53 VDD.n52 0.14595
R577 VDD.t337 VDD.t15 0.469527
R578 VDD.t413 VDD.t350 0.46606
R579 VDD.t384 VDD.t605 0.465745
R580 VDD.n140 VDD.n91 0.158108
R581 VDD.n276 VDD.n58 0.464754
R582 VDD.n210 VDD.t197 0.535965
R583 VDD.t311 VDD.n257 0.431478
R584 VDD.n310 VDD.n307 0.431057
R585 VDD.t54 VDD.t556 0.430386
R586 VDD.n211 VDD.t818 0.053623
R587 VDD.t176 VDD.t12 0.423936
R588 VDD.n213 VDD.t413 0.0709855
R589 VDD.t450 VDD.n218 0.301837
R590 VDD.t12 VDD.t10 0.422018
R591 VDD.t29 VDD.n4 0.207987
R592 VDD.t311 VDD.t312 0.387721
R593 VDD.n247 VDD.t346 0.378473
R594 VDD.n250 VDD.t485 0.374327
R595 VDD.t39 VDD.t43 0.367439
R596 VDD.t42 VDD.n210 0.254527
R597 VDD.n109 VDD.n141 1.64547
R598 VDD.n371 VDD.n370 0.36174
R599 VDD.n262 VDD.t471 0.360811
R600 VDD.t67 VDD.t78 0.360811
R601 VDD.t51 VDD.n127 0.175395
R602 VDD.t94 VDD.n243 0.36005
R603 VDD.n298 VDD.n101 0.894384
R604 VDD.n108 VDD.n122 0.765048
R605 VDD.t114 VDD.n237 0.116379
R606 VDD.n291 VDD.n112 0.533632
R607 VDD.n292 VDD.n291 0.358894
R608 VDD.n126 VDD.n112 1.65433
R609 VDD.n147 VDD.n166 0.591877
R610 VDD.n94 VDD.n301 1.04791
R611 VDD.t182 VDD.n272 0.347119
R612 VDD.t325 VDD.n253 0.343008
R613 VDD.n266 VDD.t37 0.338886
R614 VDD.t15 VDD.n239 0.335542
R615 VDD.n387 VDD.n386 0.33325
R616 VDD.n385 VDD.n384 0.33325
R617 VDD.n377 VDD.n376 0.331417
R618 VDD.t315 VDD.t354 0.330597
R619 VDD.t315 VDD.n259 0.324395
R620 VDD.n310 VDD.n309 0.30923
R621 VDD.n313 VDD.n152 0.487937
R622 VDD.n313 VDD.n312 0.306948
R623 VDD.t323 VDD.n244 0.305908
R624 VDD.n316 VDD.n157 0.305817
R625 VDD.n170 VDD.n149 0.486383
R626 VDD.n169 VDD.n170 1.40304
R627 VDD.n176 VDD.n71 0.486383
R628 VDD.n174 VDD.n176 1.40304
R629 VDD.n286 VDD.n180 0.305817
R630 VDD.n185 VDD.n33 1.07419
R631 VDD.n278 VDD.n57 0.305817
R632 VDD.n194 VDD.n195 0.544742
R633 VDD.n357 VDD.n197 0.305817
R634 VDD.n202 VDD.n61 0.486383
R635 VDD.n201 VDD.n202 1.40304
R636 VDD.n109 VDD.n86 0.661353
R637 VDD.n47 VDD.n178 0.597895
R638 VDD.n90 VDD.n89 0.702076
R639 VDD.n189 VDD.n190 0.420958
R640 VDD.n187 VDD.n189 1.13462
R641 VDD.t1 VDD.t2 0.301114
R642 VDD.t349 VDD.n2 0.548857
R643 VDD.t173 VDD.t144 0.301114
R644 VDD.t161 VDD.t99 0.301114
R645 VDD.t77 VDD.t128 0.301114
R646 VDD.n128 VDD.t77 0.17801
R647 VDD.t81 VDD.t51 0.301114
R648 VDD.t1 VDD.t4 0.300775
R649 VDD.n2 VDD.t14 0.0408085
R650 VDD.n139 VDD.t766 0.177814
R651 VDD.t340 VDD.n27 0.258774
R652 VDD.n108 VDD.n75 0.651408
R653 VDD.t44 VDD.t62 0.300023
R654 VDD.n82 VDD.n81 0.0743125
R655 VDD.n304 VDD.n37 1.5422
R656 VDD.n94 VDD.n144 2.19291
R657 VDD.n95 VDD.n64 0.864654
R658 VDD.n256 VDD.t419 0.28706
R659 VDD.n240 VDD.t15 0.270337
R660 VDD.t736 VDD.n221 0.154919
R661 VDD.n306 VDD.n124 1.12645
R662 VDD.n309 VDD.n82 1.4852
R663 VDD.n312 VDD.n148 1.45129
R664 VDD.n316 VDD.n49 1.40039
R665 VDD.n286 VDD.n51 1.40039
R666 VDD.n30 VDD.n281 0.543369
R667 VDD.n281 VDD.n54 1.46159
R668 VDD.n282 VDD.n54 1.11611
R669 VDD.n357 VDD.n53 1.40039
R670 VDD.n87 VDD.n32 0.759417
R671 VDD.n322 VDD.n320 0.241583
R672 VDD.t315 VDD.t162 0.00160081
R673 VDD.t100 VDD.n219 0.119605
R674 VDD.t1089 VDD.t736 0.241078
R675 VDD.n207 VDD.t211 0.360183
R676 VDD.t211 VDD.n206 0.119605
R677 VDD.t301 VDD.t242 0.241078
R678 VDD.t212 VDD.n207 0.119605
R679 VDD.t55 VDD.t212 0.241078
R680 VDD.t299 VDD.n5 0.119605
R681 VDD.t625 VDD.n7 0.235599
R682 VDD.t625 VDD.t766 0.241078
R683 VDD.t179 VDD.t177 0.241078
R684 VDD.n24 VDD.t179 0.475819
R685 VDD.t186 VDD.n24 0.235599
R686 VDD.t137 VDD.t528 0.241078
R687 VDD.t135 VDD.t136 0.241078
R688 VDD.t136 VDD.t100 0.241078
R689 VDD.t528 VDD.t135 0.241078
R690 VDD.n222 VDD.t173 0.119605
R691 VDD.t2 VDD.t133 0.241078
R692 VDD.n249 VDD.t155 0.241078
R693 VDD.t150 VDD.n249 0.241078
R694 VDD.t151 VDD.t150 0.241078
R695 VDD.t132 VDD.t151 0.241078
R696 VDD.t133 VDD.n223 0.119605
R697 VDD.t30 VDD.t81 0.241078
R698 VDD.t31 VDD.n6 0.119605
R699 VDD.t32 VDD.t31 0.241078
R700 VDD.t146 VDD.t161 0.240486
R701 VDD.n138 VDD.t76 0.179511
R702 VDD.n101 VDD.n171 2.04992
R703 VDD.n147 VDD.n304 0.533671
R704 VDD.n294 VDD.n110 1.4679
R705 VDD.t70 VDD.t89 0.236792
R706 VDD.t119 VDD.t227 0.236792
R707 VDD.n64 VDD.n294 0.523935
R708 VDD.t5 VDD.n156 0.22507
R709 VDD.t39 VDD.n274 0.233468
R710 VDD.t39 VDD.n273 0.233444
R711 VDD.n241 VDD.t15 0.231885
R712 VDD.n300 VDD.n169 1.02359
R713 VDD.n289 VDD.n174 1.02359
R714 VDD.n359 VDD.n201 1.02359
R715 VDD.n126 VDD.n125 0.0888544
R716 VDD.n426 VDD.n420 0.216597
R717 VDD.t191 VDD.n263 0.210005
R718 VDD.n311 VDD.n307 0.208116
R719 VDD.n285 VDD.n129 0.384519
R720 VDD.t489 VDD.n273 0.206865
R721 VDD.n331 VDD.t704 1.62053
R722 VDD.n284 VDD.n33 0.20388
R723 VDD.n12 VDD.n11 0.173133
R724 VDD.n17 VDD.n16 0.173133
R725 VDD.n315 VDD.n90 0.482202
R726 VDD.n326 VDD.t680 1.55148
R727 VDD.t61 VDD.t62 0.199761
R728 VDD.n305 VDD.n166 0.198808
R729 VDD.n293 VDD.n130 0.370045
R730 VDD.n269 VDD.t340 0.188321
R731 VDD.n144 VDD.n143 0.0703424
R732 VDD.n110 VDD.n96 0.0555373
R733 VDD.n373 VDD.n8 0.183979
R734 VDD.n374 VDD.n13 0.183979
R735 VDD.t177 VDD.n252 0.180789
R736 VDD.n243 VDD.t86 0.180023
R737 VDD.t229 VDD.t228 0.160789
R738 VDD.t244 VDD.t237 0.160789
R739 VDD.t97 VDD.t96 0.160789
R740 VDD.n242 VDD.t94 0.160789
R741 VDD.n280 VDD.n141 1.08155
R742 VDD.n296 VDD.n66 1.15705
R743 VDD.n314 VDD.n152 0.26544
R744 VDD.n282 VDD.n30 0.380888
R745 VDD.n317 VDD.n157 0.143453
R746 VDD.n339 VDD.t512 1.62406
R747 VDD.n347 VDD.t969 1.6227
R748 VDD.n300 VDD.n149 0.263065
R749 VDD.n289 VDD.n71 0.263065
R750 VDD.n287 VDD.n180 0.143453
R751 VDD.n413 VDD.t661 1.62406
R752 VDD.n280 VDD.n86 0.262408
R753 VDD.n279 VDD.n57 0.143453
R754 VDD.n356 VDD.n195 0.143453
R755 VDD.n358 VDD.n197 0.143453
R756 VDD.n359 VDD.n61 0.263065
R757 VDD.n306 VDD.n87 0.142889
R758 VDD.n288 VDD.n178 0.142889
R759 VDD.n277 VDD.n190 0.141758
R760 VDD.n262 VDD.t361 0.140825
R761 VDD.n299 VDD.n132 0.314171
R762 VDD.n296 VDD.n75 0.257037
R763 VDD.n303 VDD.n301 0.136626
R764 VDD.n295 VDD.n95 0.418154
R765 VDD.n10 VDD.n373 0.132266
R766 VDD.n15 VDD.n374 0.132266
R767 VDD.n260 VDD.t196 0.11925
R768 VDD VDD.n427 0.116367
R769 VDD.t139 VDD.n220 0.226703
R770 VDD.n214 VDD.t314 0.023454
R771 VDD.n270 VDD.t647 0.1055
R772 VDD.t276 VDD.n260 0.1005
R773 VDD.t174 VDD.n134 0.279511
R774 VDD.n209 VDD.t38 0.0695551
R775 VDD.n420 VDD.n419 0.0820833
R776 VDD.n416 VDD.n415 0.0820833
R777 VDD.n412 VDD.n411 0.0820833
R778 VDD.n408 VDD.n407 0.0820833
R779 VDD.n404 VDD.n403 0.0820833
R780 VDD.n400 VDD.n399 0.0820833
R781 VDD.n396 VDD.n395 0.0820833
R782 VDD.n392 VDD.n391 0.0820833
R783 VDD.n354 VDD.n353 0.0820833
R784 VDD.n350 VDD.n349 0.0820833
R785 VDD.n346 VDD.n345 0.0820833
R786 VDD.n342 VDD.n341 0.0820833
R787 VDD.n338 VDD.n337 0.0820833
R788 VDD.n334 VDD.n333 0.0820833
R789 VDD.n330 VDD.n329 0.0820833
R790 VDD.n326 VDD.n325 0.0820833
R791 VDD.n320 VDD.n319 0.0820833
R792 VDD.n363 VDD.n361 0.0820833
R793 VDD.n383 VDD.n382 0.0820833
R794 VDD.n380 VDD.n378 0.0820833
R795 VDD.n424 VDD.n422 0.0820833
R796 VDD.t229 VDD.n27 1.01687
R797 VDD.t244 VDD.n26 0.199894
R798 VDD.t97 VDD.t79 0.080789
R799 VDD.n299 VDD.n171 1.14132
R800 VDD.n275 VDD.n271 0.0623545
R801 VDD.n271 VDD.n268 0.0623545
R802 VDD.n268 VDD.n267 0.0623545
R803 VDD.n267 VDD.n264 0.0623545
R804 VDD.n264 VDD.n261 0.0623545
R805 VDD.n261 VDD.n258 0.0623545
R806 VDD.n258 VDD.n255 0.0623545
R807 VDD.n255 VDD.n251 0.0623545
R808 VDD.n251 VDD.n248 0.0623545
R809 VDD.n248 VDD.n245 0.0623545
R810 VDD.t299 VDD.t238 0.060789
R811 VDD.n136 VDD.t434 0.100111
R812 VDD.t176 VDD.n252 0.0205
R813 VDD.n242 VDD.t76 0.0205
R814 VDD.t146 VDD.t174 0.0205
R815 VDD.t205 VDD.n270 0.018
R816 VDD.t323 VDD.n3 0.00620097
R817 VDD.n215 VDD.n217 0.00483237
R818 VDD.n233 VDD.n234 0.0022437
R819 VDD.n92 VDD.n91 0.00371001
R820 VDD.n308 VDD.n81 0.00373116
R821 VDD.n117 VDD.n116 0.00390254
R822 VDD.n119 VDD.n118 0.00247281
R823 VDD.n234 VDD.t346 0.0024763
R824 VDD.n229 VDD.n20 0.00274942
R825 VDD.n216 VDD.n215 0.00215706
R826 VDD.n159 VDD.n158 0.00284308
R827 VDD.n302 VDD.n143 0.00187498
R828 VDD.n98 VDD.n96 0.00283669
R829 VDD.n182 VDD.n181 0.00284308
R830 VDD.n192 VDD.n191 0.00203094
R831 VDD.n199 VDD.n198 0.00284308
R832 VDD.n151 VDD.n150 0.00504346
R833 VDD.n164 VDD.n308 0.00580417
R834 VDD.n146 VDD.n145 0.00427681
R835 VDD.n168 VDD.n302 0.00427681
R836 VDD.n78 VDD.n77 0.00227359
R837 VDD.n290 VDD.n154 0.00166667
R838 VDD.n23 VDD.t325 0.00166667
R839 VDD.n227 VDD.n25 0.00333242
R840 VDD.n16 VDD.n13 1.23417
R841 VDD.n11 VDD.n8 1.23417
R842 VDD.n123 VDD.t162 0.0048656
R843 VDD.n153 VDD.t37 0.371358
R844 VDD.t37 VDD.t457 0.165342
R845 VDD.n121 VDD.n3 0.00749962
R846 VDD.n31 VDD.n88 0.00437597
R847 VDD.n168 VDD.n93 0.00872157
R848 VDD.n100 VDD.n297 0.00849871
R849 VDD.n76 VDD.n36 0.00701907
R850 VDD.n79 VDD.n297 0.00696035
R851 VDD.n106 VDD.n92 0.00679042
R852 VDD.n98 VDD.n97 0.00674891
R853 VDD.n32 VDD.n31 1.51829
R854 VDD.n78 VDD.n72 0.0064993
R855 VDD.n165 VDD.n81 0.00614292
R856 VDD.n125 VDD.n111 0.0060767
R857 VDD.n121 VDD.n120 0.00607398
R858 VDD.n228 VDD.n99 0.00599991
R859 VDD.n133 VDD.n143 0.0042258
R860 VDD.n224 VDD.n135 0.00387226
R861 VDD.n62 VDD.n29 0.00541105
R862 VDD.n172 VDD.n96 0.00566273
R863 VDD.n118 VDD.n104 0.00552583
R864 VDD.n113 VDD.n369 0.00549986
R865 VDD.n119 VDD.n68 0.00549986
R866 VDD.n117 VDD.n290 0.00549986
R867 VDD.n76 VDD.n146 0.00549963
R868 VDD.n85 VDD.n84 0.00338422
R869 VDD.n74 VDD.n72 0.00549963
R870 VDD.n111 VDD.n154 0.00549963
R871 VDD.n162 VDD.n131 0.00547154
R872 VDD.n107 VDD.n91 0.00528563
R873 VDD.n199 VDD.n200 0.00483237
R874 VDD.n193 VDD.n55 0.00384577
R875 VDD.n59 VDD.n188 0.00518628
R876 VDD.n45 VDD.n278 8.47243
R877 VDD.n46 VDD.n42 0.00880793
R878 VDD.n179 VDD.n46 0.00549993
R879 VDD.n179 VDD.n40 0.00549861
R880 VDD.n182 VDD.n183 0.00483237
R881 VDD.n159 VDD.n160 0.00483237
R882 VDD.n173 VDD.n63 0.00433305
R883 VDD.n59 VDD.n58 0.00431264
R884 VDD.n184 VDD.n68 0.00428461
R885 VDD.n73 VDD.n65 0.00425014
R886 VDD.n74 VDD.n73 0.00424897
R887 VDD.n151 VDD.n131 0.00419419
R888 VDD.n196 VDD.n56 0.00476773
R889 VDD.n200 VDD.n52 0.00416655
R890 VDD.n183 VDD.n50 0.00416655
R891 VDD.n160 VDD.n48 0.00416655
R892 VDD.n70 VDD.n67 0.00399996
R893 VDD.n39 VDD.n202 5.61658
R894 VDD.n29 VDD.n28 0.00494436
R895 VDD.n167 VDD.n36 0.00463709
R896 VDD.t576 VDD.n19 0.00184337
R897 VDD.n21 VDD.n20 0.00399997
R898 VDD.n186 VDD.n28 0.00384516
R899 VDD.n230 VDD.n18 0.00339995
R900 VDD.n217 VDD.n23 0.00316655
R901 VDD.n204 VDD.t340 0.00310973
R902 VDD.n226 VDD.n25 0.00299997
R903 VDD.n45 VDD.n43 0.00190266
R904 VDD.n196 VDD.n193 0.00299994
R905 VDD.n192 VDD.n188 0.00299994
R906 VDD.n67 VDD.n177 0.0029999
R907 VDD.n14 VDD.n13 8.48079
R908 VDD.n9 VDD.n8 8.48079
R909 VDD.n0 VDD.t500 0.349224
R910 VDD.t54 VDD.n1 1.05893
R911 VSS.t91 VSS.n1416 258112
R912 VSS.t662 VSS.t537 54734.6
R913 VSS.n1792 VSS.n963 53822.3
R914 VSS.t376 VSS.n1090 46775.5
R915 VSS.n1253 VSS.t95 46775.5
R916 VSS.t70 VSS.n997 46757.2
R917 VSS.t1287 VSS.t194 44304.3
R918 VSS.n1848 VSS.n743 40030.7
R919 VSS.n1321 VSS.t332 37453.8
R920 VSS.n1063 VSS.n1059 22494.4
R921 VSS.n1665 VSS.n1663 17263.5
R922 VSS.n1947 VSS.n1889 17263.5
R923 VSS.n963 VSS.n743 14604.8
R924 VSS.t163 VSS.n1214 14365.6
R925 VSS.n1847 VSS.n963 12083.7
R926 VSS.n1800 VSS.n963 12083.7
R927 VSS.t644 VSS.n743 11896.1
R928 VSS.t559 VSS.n1127 11816.4
R929 VSS.n1447 VSS.n949 11755.7
R930 VSS.n1849 VSS.n743 10382.4
R931 VSS.n1973 VSS.n743 8742.86
R932 VSS.n1874 VSS.n1873 7500
R933 VSS.n1975 VSS.n804 7500
R934 VSS.n1975 VSS.n803 7500
R935 VSS.n1976 VSS.n1975 7500
R936 VSS.n1975 VSS.n783 7500
R937 VSS.n1975 VSS.n782 7500
R938 VSS.n1975 VSS.n781 7500
R939 VSS.n1975 VSS.n780 7500
R940 VSS.n1975 VSS.n779 7500
R941 VSS.n1812 VSS.n1811 7500
R942 VSS.n1781 VSS.n987 7500
R943 VSS.n1779 VSS.n989 7500
R944 VSS.n1777 VSS.n991 7500
R945 VSS.n1775 VSS.n993 7500
R946 VSS.n1772 VSS.n1501 7500
R947 VSS.n1770 VSS.n1503 7500
R948 VSS.n1768 VSS.n1505 7500
R949 VSS.n1766 VSS.n1507 7500
R950 VSS.n1011 VSS.t537 7250
R951 VSS.n1800 VSS.n1799 6613.64
R952 VSS.n1447 VSS.n1446 6613.64
R953 VSS.n1663 VSS.n1662 6555.52
R954 VSS.n1975 VSS.n825 5739.13
R955 VSS.n1975 VSS.n824 5739.13
R956 VSS.n1975 VSS.n823 5739.13
R957 VSS.n1975 VSS.n822 5739.13
R958 VSS.n1975 VSS.n821 5739.13
R959 VSS.n1975 VSS.n778 5739.13
R960 VSS.n1975 VSS.n805 5739.13
R961 VSS.n1782 VSS.n986 5739.13
R962 VSS.n1780 VSS.n988 5739.13
R963 VSS.n1778 VSS.n990 5739.13
R964 VSS.n1776 VSS.n992 5739.13
R965 VSS.n1774 VSS.n994 5739.13
R966 VSS.n1771 VSS.n1502 5739.13
R967 VSS.n1769 VSS.n1504 5739.13
R968 VSS.n1767 VSS.n1506 5739.13
R969 VSS.t17 VSS.n574 5478.26
R970 VSS.t114 VSS.n1002 5478.26
R971 VSS.n1237 VSS.n1002 5478.26
R972 VSS.t89 VSS.n1237 5478.26
R973 VSS.n1281 VSS.t89 5478.26
R974 VSS.n1281 VSS.n1046 5478.26
R975 VSS.t185 VSS.n1046 5478.26
R976 VSS.n512 VSS.t185 5478.26
R977 VSS.n1416 VSS.n512 5478.26
R978 VSS.n1449 VSS.n1447 4546.88
R979 VSS.n574 VSS.n1442 4413.04
R980 VSS.n1091 VSS.t376 4262.19
R981 VSS.t95 VSS.n1252 4262.19
R982 VSS.n1483 VSS.t70 4262.19
R983 VSS.n1008 VSS.t194 3625
R984 VSS.n949 VSS.n743 3484.29
R985 VSS.n1973 VSS.t1096 3428.57
R986 VSS.n1122 VSS.t1113 2714.25
R987 VSS.t496 VSS.n1320 2319.23
R988 VSS.n1442 VSS.n949 2242.58
R989 VSS.n1850 VSS.n1849 1534.88
R990 VSS.n1880 VSS.n1849 1352.46
R991 VSS.n1873 VSS.n1850 1304.35
R992 VSS.n1975 VSS.n948 1191.19
R993 VSS.t1096 VSS.n1972 1189.29
R994 VSS.n1442 VSS.t114 1065.22
R995 VSS.n1873 VSS.n958 1026.43
R996 VSS.n1975 VSS.n949 980.226
R997 VSS.n1974 VSS.n161 961.135
R998 VSS.n1766 VSS.n1765 905.765
R999 VSS.t23 VSS.n1121 876.155
R1000 VSS.n1128 VSS.t308 859.519
R1001 VSS.t1113 VSS.t23 804.067
R1002 VSS.t1096 VSS.n645 725.606
R1003 VSS.n1975 VSS.n1974 613.384
R1004 VSS.n1877 VSS.n1850 613.236
R1005 VSS.n1880 VSS.n1879 602.727
R1006 VSS.t1096 VSS.n951 577.934
R1007 VSS.n1877 VSS.n1876 522.712
R1008 VSS.n1969 VSS.n1968 499.043
R1009 VSS.n1881 VSS.n1880 462.399
R1010 VSS.n1416 VSS.n1045 427.132
R1011 VSS.n511 VSS.n1104 427.755
R1012 VSS.n1374 VSS.n1046 427.132
R1013 VSS.n1418 VSS.n1010 427.132
R1014 VSS.n1419 VSS.n1009 427.132
R1015 VSS.n463 VSS.n1281 427.132
R1016 VSS.n1420 VSS.n130 427.132
R1017 VSS.n1237 VSS.n1236 427.132
R1018 VSS.n358 VSS.t890 252.065
R1019 VSS.n1198 VSS.n442 427.755
R1020 VSS.n564 VSS.n1199 427.755
R1021 VSS.t958 VSS.n353 243.494
R1022 VSS.n1170 VSS.n428 427.755
R1023 VSS.t968 VSS.n101 243.494
R1024 VSS.n1171 VSS.n427 427.755
R1025 VSS.n104 VSS.t980 252.065
R1026 VSS.n1187 VSS.n1186 427.132
R1027 VSS.n327 VSS.t625 422.846
R1028 VSS.t1251 VSS.n1394 418.56
R1029 VSS.t328 VSS.n1328 418.56
R1030 VSS.n484 VSS.t162 87.1413
R1031 VSS.t571 VSS.n1247 414.952
R1032 VSS.n508 VSS.t655 414.274
R1033 VSS.n1407 VSS.t180 414.274
R1034 VSS.n1303 VSS.t477 414.274
R1035 VSS.t406 VSS.n1009 414.274
R1036 VSS.n360 VSS.n1877 414.241
R1037 VSS.t4 VSS.n1435 411.526
R1038 VSS.n1417 VSS.n509 411.43
R1039 VSS.n513 VSS.n512 427.132
R1040 VSS.n473 VSS.t750 242.846
R1041 VSS.n493 VSS.t752 242.846
R1042 VSS.n84 VSS.t754 242.846
R1043 VSS.n492 VSS.t756 242.846
R1044 VSS.n1142 VSS.n1141 411.43
R1045 VSS.t760 VSS.n491 242.846
R1046 VSS.n565 VSS.n1002 427.132
R1047 VSS.t83 VSS.n440 169.989
R1048 VSS.n350 VSS.n574 427.132
R1049 VSS.t1201 VSS.n1149 407.144
R1050 VSS.n1297 VSS.t1216 407.144
R1051 VSS.n1138 VSS.n1137 400
R1052 VSS.t1114 VSS.n1118 398.572
R1053 VSS.t499 VSS.n1117 398.572
R1054 VSS.n1078 VSS.t352 398.572
R1055 VSS.t1103 VSS.n1325 398.572
R1056 VSS.t378 VSS.n1274 398.572
R1057 VSS.n1277 VSS.t573 398.572
R1058 VSS.n1168 VSS.t570 398.572
R1059 VSS.n1430 VSS.t249 398.572
R1060 VSS.n1386 VSS.t502 397.755
R1061 VSS.n1250 VSS.t401 395.416
R1062 VSS.n1396 VSS.t120 394.286
R1063 VSS.n1400 VSS.t96 394.286
R1064 VSS.t526 VSS.n1347 394.286
R1065 VSS.n1882 VSS.n1848 388.161
R1066 VSS.n1080 VSS.t1293 386.587
R1067 VSS.n1070 VSS.t357 385.714
R1068 VSS.n1279 VSS.t385 385.714
R1069 VSS.n1165 VSS.t1142 385.714
R1070 VSS.t1172 VSS.n1224 385.714
R1071 VSS.t1136 VSS.n1196 385.714
R1072 VSS.t1261 VSS.n1353 384.274
R1073 VSS.t259 VSS.n1303 384.274
R1074 VSS.n1753 VSS.n1752 381.443
R1075 VSS.t167 VSS.n1285 381.43
R1076 VSS.n1293 VSS.t161 381.43
R1077 VSS.t362 VSS.n1147 381.43
R1078 VSS.t330 VSS.n1317 377.351
R1079 VSS.n94 VSS.t1219 377.351
R1080 VSS.n1083 VSS.t77 376.724
R1081 VSS.t1087 VSS.n1258 376.724
R1082 VSS.n1435 VSS.t1255 376.724
R1083 VSS.t589 VSS.n459 376.724
R1084 VSS.n1315 VSS.t131 375
R1085 VSS.n1313 VSS.t278 374.002
R1086 VSS.n1178 VSS.t1200 373.926
R1087 VSS.n1136 VSS.t344 372.858
R1088 VSS.n1105 VSS.t1133 372.858
R1089 VSS.t595 VSS.n1346 372.858
R1090 VSS.n1404 VSS.t467 372.858
R1091 VSS.n1405 VSS.t122 372.858
R1092 VSS.n1412 VSS.t272 372.858
R1093 VSS.t670 VSS.n1267 372.858
R1094 VSS.t165 VSS.n1264 372.858
R1095 VSS.t332 VSS.t496 369.231
R1096 VSS.n1402 VSS.t586 368.572
R1097 VSS.n1008 VSS.t100 365.279
R1098 VSS.n1296 VSS.t289 364.286
R1099 VSS.n1183 VSS.t233 362.5
R1100 VSS.n1057 VSS.t1295 362.07
R1101 VSS.n1014 VSS.t1228 361.033
R1102 VSS.n1051 VSS.t375 361.033
R1103 VSS.t93 VSS.n1248 361.033
R1104 VSS.n1228 VSS.t1168 361.033
R1105 VSS.t534 VSS.n1003 361.033
R1106 VSS.n1071 VSS.t1162 360
R1107 VSS.t619 VSS.n1153 360
R1108 VSS.t484 VSS.n1139 355.714
R1109 VSS.t232 VSS.n1373 355.714
R1110 VSS.n1391 VSS.t1299 355.714
R1111 VSS.n1294 VSS.t501 355.714
R1112 VSS.n340 VSS.t1284 57.6353
R1113 VSS.n1167 VSS.t275 355.714
R1114 VSS.t382 VSS.n1159 355.714
R1115 VSS.t153 VSS.n1157 355.714
R1116 VSS.t197 VSS.n1156 355.714
R1117 VSS.t338 VSS.n1197 355.714
R1118 VSS.n249 VSS.n987 354.812
R1119 VSS.n1498 VSS.t322 352.437
R1120 VSS.n1130 VSS.t1118 351.43
R1121 VSS.n1132 VSS.t1276 351.43
R1122 VSS.n1079 VSS.t79 351.43
R1123 VSS.t267 VSS.n1306 351.43
R1124 VSS.t1131 VSS.n1268 351.43
R1125 VSS.t1245 VSS.n1265 351.43
R1126 VSS.n1431 VSS.t1256 351.43
R1127 VSS.n1425 VSS.t455 351.43
R1128 VSS.n339 VSS.t1234 350.613
R1129 VSS.n1127 VSS.t1117 348.139
R1130 VSS.n1076 VSS.t590 347.144
R1131 VSS.n1131 VSS.t1196 347.144
R1132 VSS.t288 VSS.n1074 347.144
R1133 VSS.t411 VSS.n1356 347.144
R1134 VSS.t268 VSS.n1266 347.144
R1135 VSS.n465 VSS.t492 346.327
R1136 VSS.n334 VSS.t512 346.327
R1137 VSS.n1245 VSS.t380 345.834
R1138 VSS.t1119 VSS.n1229 345.834
R1139 VSS.n85 VSS.t561 345.704
R1140 VSS.n1059 VSS.n1058 343.75
R1141 VSS.t65 VSS.t453 342.858
R1142 VSS.n1073 VSS.t139 342.041
R1143 VSS.n1084 VSS.t1115 341.668
R1144 VSS.t1079 VSS.n1257 341.668
R1145 VSS.t1108 VSS.n995 341.668
R1146 VSS.n1011 VSS.t321 339.664
R1147 VSS.n1388 VSS.t136 338.572
R1148 VSS.t1226 VSS.n1284 338.572
R1149 VSS.n1288 VSS.t1217 338.572
R1150 VSS.t613 VSS.n1290 338.572
R1151 VSS.t132 VSS.n1145 338.572
R1152 VSS.n1200 VSS.t1290 338.572
R1153 VSS.n1202 VSS.t1145 338.572
R1154 VSS.t634 VSS.n1194 338.572
R1155 VSS.t262 VSS.n1087 337.5
R1156 VSS.n1254 VSS.t201 337.5
R1157 VSS.t454 VSS.n996 337.5
R1158 VSS.n1082 VSS.t1260 335.245
R1159 VSS.n1133 VSS.t198 334.286
R1160 VSS.t280 VSS.n1114 334.286
R1161 VSS.n1135 VSS.t364 334.286
R1162 VSS.n1072 VSS.t175 334.286
R1163 VSS.t1291 VSS.n1345 334.286
R1164 VSS.t1125 VSS.n1341 334.286
R1165 VSS.t1236 VSS.t1203 334.286
R1166 VSS.n1327 VSS.t584 334.286
R1167 VSS.t1141 VSS.t119 334.286
R1168 VSS.t247 VSS.n1195 334.286
R1169 VSS.t1224 VSS.n1124 330.084
R1170 VSS.n1179 VSS.t349 330.074
R1171 VSS.n1375 VSS.t71 330
R1172 VSS.t632 VSS.n1357 330
R1173 VSS.t145 VSS.n1164 330
R1174 VSS.n1166 VSS.t297 330
R1175 VSS.t281 VSS.n1160 330
R1176 VSS.n1169 VSS.t524 330
R1177 VSS.n1221 VSS.t480 330
R1178 VSS.t302 VSS.t569 330
R1179 VSS.n1020 VSS.t128 329.168
R1180 VSS.n1110 VSS.t1148 329.168
R1181 VSS.t1124 VSS.n1048 329.168
R1182 VSS.t497 VSS.n1088 329.168
R1183 VSS.t355 VSS.n1298 329.168
R1184 VSS.n1310 VSS.t633 329.168
R1185 VSS.t337 VSS.n1242 329.168
R1186 VSS.n1241 VSS.t1289 329.168
R1187 VSS.t162 VSS.n1262 329.168
R1188 VSS.n1235 VSS.t1222 329.168
R1189 VSS.n1207 VSS.t181 329.168
R1190 VSS.n1422 VSS.t1221 329.168
R1191 VSS.n1441 VSS.t578 329.168
R1192 VSS.n1185 VSS.t1275 329.168
R1193 VSS.n1484 VSS.t342 329.168
R1194 VSS.n1000 VSS.t1116 329.168
R1195 VSS.n14 VSS.n989 330
R1196 VSS.t660 VSS.n1228 328.714
R1197 VSS.t1249 VSS.n1043 328.56
R1198 VSS.t365 VSS.n1349 328.56
R1199 VSS.t431 VSS.n1409 328.56
R1200 VSS.n1411 VSS.t177 328.56
R1201 VSS.t400 VSS.n1411 328.56
R1202 VSS.t333 VSS.n1490 326.649
R1203 VSS.t81 VSS.n1117 325.714
R1204 VSS.n1329 VSS.t594 325.714
R1205 VSS.t29 VSS.t520 325.714
R1206 VSS.n1426 VSS.t622 325.714
R1207 VSS.n429 VSS.t284 324.695
R1208 VSS.t548 VSS.n1259 322.351
R1209 VSS.n1077 VSS.t102 321.43
R1210 VSS.n1392 VSS.t547 321.43
R1211 VSS.t505 VSS.t211 321.43
R1212 VSS.n1069 VSS.t600 320.613
R1213 VSS.n467 VSS.t16 320.613
R1214 VSS.n1067 VSS.t1139 320.271
R1215 VSS.t183 VSS.n1210 320.271
R1216 VSS.n1186 VSS.t187 319.99
R1217 VSS.t1111 VSS.n457 319.86
R1218 VSS.n1440 VSS.t1188 319.836
R1219 VSS.n1847 VSS.n1846 319.385
R1220 VSS.t418 VSS.t1211 317.144
R1221 VSS.t173 VSS.n509 312.858
R1222 VSS.t230 VSS.n1102 312.858
R1223 VSS.n1403 VSS.t394 312.858
R1224 VSS.t612 VSS.n1343 312.858
R1225 VSS.t353 VSS.n1150 312.858
R1226 VSS.n1275 VSS.t1081 312.858
R1227 VSS.t1265 VSS.t640 312.858
R1228 VSS.n1278 VSS.t523 312.858
R1229 VSS.t188 VSS.t319 312.5
R1230 VSS.t1252 VSS.t556 312.5
R1231 VSS.t648 VSS.n1115 308.572
R1232 VSS.n1134 VSS.t647 308.572
R1233 VSS.t650 VSS.n1112 308.572
R1234 VSS.t358 VSS.t426 308.572
R1235 VSS.t1292 VSS.t73 308.572
R1236 VSS.t176 VSS.n1344 308.572
R1237 VSS.t652 VSS.n1338 308.572
R1238 VSS.t1262 VSS.n1305 308.572
R1239 VSS.t1175 VSS.n1119 305.159
R1240 VSS.t1176 VSS.n1050 305.159
R1241 VSS.n1332 VSS.t628 305.159
R1242 VSS.t195 VSS.n1251 305.159
R1243 VSS.t196 VSS.n1261 305.159
R1244 VSS.n1226 VSS.t87 305.159
R1245 VSS.t203 VSS.n1007 305.159
R1246 VSS.n1432 VSS.t952 305.159
R1247 VSS.n1176 VSS.t63 305.159
R1248 VSS.t1241 VSS.n1173 305.159
R1249 VSS.t14 VSS.n1492 305.159
R1250 VSS.n1499 VSS.t1132 305.159
R1251 VSS.n1225 VSS.t1120 304.286
R1252 VSS.t405 VSS.n1217 304.286
R1253 VSS.n1424 VSS.t117 304.286
R1254 VSS.n1005 VSS.t112 304.168
R1255 VSS.n1184 VSS.t1240 304.168
R1256 VSS.n1717 VSS.n991 303.265
R1257 VSS.t500 VSS.t653 295.714
R1258 VSS.t1264 VSS.t246 295.714
R1259 VSS.n457 VSS.t171 295.062
R1260 VSS.n1377 VSS.t140 291.43
R1261 VSS.t1199 VSS.n1370 291.43
R1262 VSS.n1388 VSS.t1194 291.43
R1263 VSS.n1284 VSS.t1288 291.43
R1264 VSS.t636 VSS.n1288 291.43
R1265 VSS.n1290 VSS.t57 291.43
R1266 VSS.t1088 VSS.n1145 291.43
R1267 VSS.n1200 VSS.t292 291.43
R1268 VSS.n1295 VSS.t1121 287.144
R1269 VSS.n1174 VSS.t10 283.668
R1270 VSS.n1206 VSS.t110 278.572
R1271 VSS.n1206 VSS.t155 278.572
R1272 VSS.n1609 VSS.n993 277.491
R1273 VSS.t1206 VSS.n1055 275.863
R1274 VSS.n1889 VSS.n804 275.774
R1275 VSS.n1497 VSS.t1210 275.072
R1276 VSS.t517 VSS.n1012 275.072
R1277 VSS.t1205 VSS.n1050 275.072
R1278 VSS.n1332 VSS.t105 275.072
R1279 VSS.n1319 VSS.t1235 275.072
R1280 VSS.n1251 VSS.t107 275.072
R1281 VSS.t551 VSS.n1208 275.072
R1282 VSS.n1007 VSS.t392 275.072
R1283 VSS.t553 VSS.n1432 275.072
R1284 VSS.t555 VSS.n1176 275.072
R1285 VSS.t604 VSS.n1172 275.072
R1286 VSS.n1492 VSS.t258 275.072
R1287 VSS.n502 VSS.t157 273.471
R1288 VSS.t179 VSS.n508 272.846
R1289 VSS.n501 VSS.t668 272.846
R1290 VSS.n1378 VSS.t481 272.846
R1291 VSS.t629 VSS.n1378 272.846
R1292 VSS.t601 VSS.n1363 272.846
R1293 VSS.n1409 VSS.t476 272.846
R1294 VSS.t1155 VSS.n434 272.846
R1295 VSS.n436 VSS.t276 272.846
R1296 VSS.t83 VSS.n437 272.846
R1297 VSS.n195 VSS.n1872 271.973
R1298 VSS.t516 VSS.n1123 267.409
R1299 VSS.t24 VSS.t80 265.714
R1300 VSS.t313 VSS.t138 265.714
R1301 VSS.t639 VSS.t49 265.714
R1302 VSS.t228 VSS.t621 265.714
R1303 VSS.t261 VSS.t567 261.43
R1304 VSS.n1641 VSS.n1501 260.31
R1305 VSS.t1274 VSS.n1496 258.334
R1306 VSS.t461 VSS.t335 258.334
R1307 VSS.t306 VSS.t1242 258.334
R1308 VSS.t599 VSS.t303 258.334
R1309 VSS.t311 VSS.t341 258.334
R1310 VSS.t374 VSS.n1092 258.334
R1311 VSS.t76 VSS.n1085 258.334
R1312 VSS.t41 VSS.t290 258.334
R1313 VSS.n1299 VSS.t1243 258.334
R1314 VSS.t581 VSS.t47 258.334
R1315 VSS.n1316 VSS.t329 258.334
R1316 VSS.t46 VSS.t446 258.334
R1317 VSS.t130 VSS.t28 258.334
R1318 VSS.t1154 VSS.t51 258.334
R1319 VSS.n1246 VSS.t92 258.334
R1320 VSS.n1256 VSS.t1086 258.334
R1321 VSS.t1135 VSS.t55 258.334
R1322 VSS.n1271 VSS.t1129 258.334
R1323 VSS.t472 VSS.t580 258.334
R1324 VSS.t1167 VSS.n1231 258.334
R1325 VSS.t1085 VSS.t445 258.334
R1326 VSS.t575 VSS.t458 258.334
R1327 VSS.t225 VSS.t269 258.334
R1328 VSS.t1254 VSS.n1437 258.334
R1329 VSS.t489 VSS.t399 258.334
R1330 VSS.n1485 VSS.t588 258.334
R1331 VSS.t1152 VSS.t463 258.334
R1332 VSS.n1481 VSS.t67 258.334
R1333 VSS.t691 VSS.n1014 257.88
R1334 VSS.n1051 VSS.t785 257.88
R1335 VSS.n1174 VSS.t141 257.88
R1336 VSS.n1490 VSS.t236 257.88
R1337 VSS.t572 VSS.n1340 257.144
R1338 VSS.n470 VSS.t334 272.846
R1339 VSS.n1287 VSS.t285 257.144
R1340 VSS.t212 VSS.n1291 257.144
R1341 VSS.n1022 VSS.t688 252.065
R1342 VSS.n1390 VSS.t821 252.065
R1343 VSS.n335 VSS.t867 252.065
R1344 VSS.n1380 VSS.t798 252.041
R1345 VSS.t800 VSS.n1368 252.041
R1346 VSS.n1384 VSS.t803 252.041
R1347 VSS.t827 VSS.n1351 252.041
R1348 VSS.n334 VSS.t865 252.041
R1349 VSS.n337 VSS.t883 252.041
R1350 VSS.n95 VSS.t901 252.041
R1351 VSS.n81 VSS.t751 251.417
R1352 VSS.n80 VSS.t753 251.417
R1353 VSS.n77 VSS.t755 251.417
R1354 VSS.n76 VSS.t757 251.417
R1355 VSS.n88 VSS.t759 251.417
R1356 VSS.n89 VSS.t761 251.417
R1357 VSS.n85 VSS.t743 251.417
R1358 VSS.t812 VSS.n1374 251.417
R1359 VSS.n1361 VSS.t808 251.417
R1360 VSS.n1360 VSS.t819 251.417
R1361 VSS.n1353 VSS.t825 251.417
R1362 VSS.n1236 VSS.t861 251.417
R1363 VSS.t863 VSS.n331 251.417
R1364 VSS.t869 VSS.n336 251.417
R1365 VSS.t320 VSS.t1137 251.351
R1366 VSS.t304 VSS.t1237 251.351
R1367 VSS.t596 VSS.t404 251.351
R1368 VSS.n1216 VSS.t424 251.351
R1369 VSS.n1021 VSS.t307 250.952
R1370 VSS.t310 VSS.n1109 250.952
R1371 VSS.t470 VSS.n1152 250.952
R1372 VSS.t444 VSS.n1204 250.952
R1373 VSS.n1423 VSS.t457 250.952
R1374 VSS.n1317 VSS.t495 249.643
R1375 VSS.n94 VSS.t602 249.643
R1376 VSS.t308 VSS.t384 249.538
R1377 VSS.n504 VSS.t383 249.523
R1378 VSS.n1674 VSS.n988 249.142
R1379 VSS.n1702 VSS.n990 249.142
R1380 VSS.n1551 VSS.n992 249.142
R1381 VSS.n1612 VSS.n994 249.142
R1382 VSS.n1652 VSS.n1502 249.142
R1383 VSS.n1592 VSS.n1504 249.142
R1384 VSS.n1731 VSS.n1506 249.142
R1385 VSS.t1158 VSS.n1015 249.002
R1386 VSS.n487 VSS.t300 249.002
R1387 VSS.n1247 VSS.t206 249.002
R1388 VSS.t1126 VSS.n429 249.002
R1389 VSS.t168 VSS.n496 249.002
R1390 VSS.t373 VSS.n1147 244.286
R1391 VSS.n332 VSS.t862 109.987
R1392 VSS.n1390 VSS.t820 243.494
R1393 VSS.t828 VSS.n1350 243.494
R1394 VSS.n335 VSS.t866 243.494
R1395 VSS.t811 VSS.n1351 243.47
R1396 VSS.n1386 VSS.t804 243.47
R1397 VSS.n1384 VSS.t817 243.47
R1398 VSS.t815 VSS.n1368 243.47
R1399 VSS.t813 VSS.n1372 243.47
R1400 VSS.n339 VSS.t884 243.47
R1401 VSS.n337 VSS.t872 243.47
R1402 VSS.t870 VSS.n328 243.47
R1403 VSS.n1582 VSS.n1503 243.127
R1404 VSS.n82 VSS.t723 242.846
R1405 VSS.n79 VSS.t726 242.846
R1406 VSS.n78 VSS.t729 242.846
R1407 VSS.n75 VSS.t732 242.846
R1408 VSS.n87 VSS.t735 242.846
R1409 VSS.n90 VSS.t738 242.846
R1410 VSS.n1389 VSS.t809 242.846
R1411 VSS.t97 VSS.n1487 241.935
R1412 VSS.t689 VSS.n1018 236.502
R1413 VSS.n1012 VSS.t692 236.391
R1414 VSS.n1434 VSS.t951 236.391
R1415 VSS.n1042 VSS.t671 235.714
R1416 VSS.n1039 VSS.t674 235.714
R1417 VSS.n1036 VSS.t676 235.714
R1418 VSS.n1033 VSS.t679 235.714
R1419 VSS.n1030 VSS.t681 235.714
R1420 VSS.n1027 VSS.t683 235.714
R1421 VSS.n1024 VSS.t686 235.714
R1422 VSS.n513 VSS.t716 251.417
R1423 VSS.n511 VSS.t748 252.041
R1424 VSS.n473 VSS.t721 251.417
R1425 VSS.n493 VSS.t725 251.417
R1426 VSS.n84 VSS.t728 251.417
R1427 VSS.n492 VSS.t731 251.417
R1428 VSS.n1141 VSS.t734 235.714
R1429 VSS.n491 VSS.t737 251.417
R1430 VSS.n91 VSS.t740 251.417
R1431 VSS.t814 VSS.n1369 235.714
R1432 VSS.n1383 VSS.t816 235.714
R1433 VSS.t806 VSS.n1364 235.714
R1434 VSS.t810 VSS.n1352 235.714
R1435 VSS.n1293 VSS.t833 235.714
R1436 VSS.t59 VSS.t637 235.714
R1437 VSS.n1223 VSS.t871 235.714
R1438 VSS.n565 VSS.t885 251.417
R1439 VSS.n442 VSS.t895 252.041
R1440 VSS.n350 VSS.t955 251.417
R1441 VSS.n353 VSS.t960 252.065
R1442 VSS.n428 VSS.t965 252.041
R1443 VSS.n101 VSS.t970 252.065
R1444 VSS.n427 VSS.t975 252.041
R1445 VSS.t15 VSS.n1495 233.333
R1446 VSS.t433 VSS.t1239 233.333
R1447 VSS.n1272 VSS.t377 233.333
R1448 VSS.t504 VSS.n1230 233.333
R1449 VSS.t248 VSS.n1436 233.333
R1450 VSS.n1049 VSS.t781 229.167
R1451 VSS.t856 VSS.n1269 229.167
R1452 VSS.t1023 VSS.n999 229.167
R1453 VSS.t699 VSS.n1042 227.143
R1454 VSS.t701 VSS.n1039 227.143
R1455 VSS.t703 VSS.n1036 227.143
R1456 VSS.t705 VSS.n1033 227.143
R1457 VSS.t707 VSS.n1030 227.143
R1458 VSS.t709 VSS.n1027 227.143
R1459 VSS.t712 VSS.n1024 227.143
R1460 VSS.n1104 VSS.t719 227.143
R1461 VSS.n1142 VSS.t758 227.143
R1462 VSS.n91 VSS.t762 242.846
R1463 VSS.n1140 VSS.t742 227.143
R1464 VSS.n1382 VSS.t799 227.143
R1465 VSS.t802 VSS.n1366 227.143
R1466 VSS.t807 VSS.n1362 227.143
R1467 VSS.n1392 VSS.t822 227.143
R1468 VSS.t824 VSS.n1355 227.143
R1469 VSS.n1398 VSS.t826 227.143
R1470 VSS.n485 VSS.t835 242.846
R1471 VSS.t864 VSS.n1162 227.143
R1472 VSS.n1168 VSS.t868 227.143
R1473 VSS.n358 VSS.t888 243.494
R1474 VSS.n1198 VSS.t893 227.143
R1475 VSS.n1199 VSS.t898 227.143
R1476 VSS.n1218 VSS.t915 227.143
R1477 VSS.t954 VSS.n1426 227.143
R1478 VSS.n1170 VSS.t963 227.143
R1479 VSS.n1171 VSS.t973 227.143
R1480 VSS.n104 VSS.t978 243.494
R1481 VSS.n1187 VSS.t983 227.143
R1482 VSS.t661 VSS.n1061 227.028
R1483 VSS.t479 VSS.n1060 227.028
R1484 VSS.n1215 VSS.t1286 227.028
R1485 VSS.n1538 VSS.n1505 225.946
R1486 VSS.n1740 VSS.n1507 225.946
R1487 VSS.t519 VSS.t296 223.496
R1488 VSS.t1105 VSS.t286 223.496
R1489 VSS.t713 VSS.n1022 222.065
R1490 VSS.n95 VSS.t916 222.042
R1491 VSS.t882 VSS.n328 222.041
R1492 VSS.n1385 VSS.t818 221.417
R1493 VSS.n338 VSS.t873 221.417
R1494 VSS.n1138 VSS.t744 220.833
R1495 VSS.n1093 VSS.t783 220.833
R1496 VSS.n1334 VSS.t838 220.833
R1497 VSS.n1273 VSS.t859 220.833
R1498 VSS.n432 VSS.t903 236.502
R1499 VSS.t508 VSS.t533 220.833
R1500 VSS.n1480 VSS.t1025 220.833
R1501 VSS.t830 VSS.t1212 218.571
R1502 VSS.t874 VSS.n1233 215.669
R1503 VSS.n430 VSS.t934 215.669
R1504 VSS.t415 VSS.n1493 210.602
R1505 VSS.t189 VSS.t294 210.602
R1506 VSS.t448 VSS.n1172 210.602
R1507 VSS.t143 VSS.t1281 210
R1508 VSS.t314 VSS.t142 208.333
R1509 VSS.t135 VSS.t38 208.333
R1510 VSS.t1181 VSS.t466 208.333
R1511 VSS.n1058 VSS.t536 206.898
R1512 VSS.t85 VSS.t367 206.304
R1513 VSS.t818 VSS.n1365 205.714
R1514 VSS.t831 VSS.n470 221.417
R1515 VSS.n1283 VSS.t831 205.714
R1516 VSS.n1223 VSS.t882 205.714
R1517 VSS.t873 VSS.n1154 205.714
R1518 VSS.n564 VSS.t900 222.041
R1519 VSS.t913 VSS.t574 205.714
R1520 VSS.t916 VSS.n1205 205.714
R1521 VSS.n1782 VSS.n1781 202.661
R1522 VSS.n1494 VSS.t415 202.006
R1523 VSS.t1277 VSS.n1128 202.006
R1524 VSS.t593 VSS.t407 201.429
R1525 VSS.n193 VSS.n1947 202.817
R1526 VSS.t842 VSS.n1300 201.135
R1527 VSS.n1041 VSS.t673 200.613
R1528 VSS.n1040 VSS.t701 200.613
R1529 VSS.n1038 VSS.t675 200.613
R1530 VSS.n1037 VSS.t703 200.613
R1531 VSS.n1035 VSS.t678 200.613
R1532 VSS.n1034 VSS.t705 200.613
R1533 VSS.n1032 VSS.t680 200.613
R1534 VSS.n1031 VSS.t707 200.613
R1535 VSS.n1029 VSS.t682 200.613
R1536 VSS.n1028 VSS.t709 200.613
R1537 VSS.n1026 VSS.t685 200.613
R1538 VSS.n1025 VSS.t712 200.613
R1539 VSS.n1023 VSS.t687 200.613
R1540 VSS.n514 VSS.t719 200.613
R1541 VSS.t742 VSS.n86 200.613
R1542 VSS.t866 VSS.n330 200.613
R1543 VSS.t888 VSS.n354 200.613
R1544 VSS.t893 VSS.n356 200.613
R1545 VSS.n441 VSS.t898 200.613
R1546 VSS.t958 VSS.n349 200.613
R1547 VSS.t963 VSS.n351 200.613
R1548 VSS.t968 VSS.n99 200.613
R1549 VSS.t973 VSS.n97 200.613
R1550 VSS.t978 VSS.n103 200.613
R1551 VSS.t983 VSS.n102 200.613
R1552 VSS.t745 VSS.n1125 200
R1553 VSS.n1234 VSS.t874 200
R1554 VSS.n1209 VSS.t904 200
R1555 VSS.n1421 VSS.t934 200
R1556 VSS.n1043 VSS.t699 199.989
R1557 VSS.n82 VSS.t752 199.989
R1558 VSS.n79 VSS.t754 199.989
R1559 VSS.n78 VSS.t756 199.989
R1560 VSS.t758 VSS.n75 199.989
R1561 VSS.t760 VSS.n87 199.989
R1562 VSS.t762 VSS.n90 199.989
R1563 VSS.t799 VSS.n1381 199.989
R1564 VSS.n1367 VSS.t802 199.989
R1565 VSS.t804 VSS.n1385 199.989
R1566 VSS.n1363 VSS.t807 199.989
R1567 VSS.t820 VSS.n1389 199.989
R1568 VSS.t826 VSS.n1397 199.989
R1569 VSS.n1349 VSS.t830 199.989
R1570 VSS.t835 VSS.n464 199.989
R1571 VSS.t884 VSS.n338 199.989
R1572 VSS.n1427 VSS.t954 199.989
R1573 VSS.t1258 VSS.t8 197.708
R1574 VSS.t1198 VSS.t698 197.143
R1575 VSS.t829 VSS.t491 197.143
R1576 VSS.t666 VSS.t1178 195.833
R1577 VSS.t838 VSS.n545 194.835
R1578 VSS.n1874 VSS.n197 195.124
R1579 VSS.t146 VSS.t1283 192.857
R1580 VSS.n1123 VSS.n1122 192.202
R1581 VSS.t686 VSS.n1023 192.042
R1582 VSS.t710 VSS.n1025 192.042
R1583 VSS.t683 VSS.n1026 192.042
R1584 VSS.t708 VSS.n1028 192.042
R1585 VSS.t681 VSS.n1029 192.042
R1586 VSS.t706 VSS.n1031 192.042
R1587 VSS.t679 VSS.n1032 192.042
R1588 VSS.t704 VSS.n1034 192.042
R1589 VSS.t676 VSS.n1035 192.042
R1590 VSS.t702 VSS.n1037 192.042
R1591 VSS.t674 VSS.n1038 192.042
R1592 VSS.t700 VSS.n1040 192.042
R1593 VSS.t671 VSS.n1041 192.042
R1594 VSS.n86 VSS.t740 192.042
R1595 VSS.t716 VSS.n514 192.042
R1596 VSS.t865 VSS.n330 192.042
R1597 VSS.n333 VSS.t863 192.042
R1598 VSS.n332 VSS.t861 192.054
R1599 VSS.n438 VSS.t913 192.042
R1600 VSS.t895 VSS.n441 192.042
R1601 VSS.t890 VSS.n356 192.042
R1602 VSS.t885 VSS.n354 192.042
R1603 VSS.t980 VSS.n102 192.042
R1604 VSS.t975 VSS.n103 192.042
R1605 VSS.t970 VSS.n97 192.042
R1606 VSS.t965 VSS.n99 192.042
R1607 VSS.t960 VSS.n351 192.042
R1608 VSS.t955 VSS.n349 192.042
R1609 VSS.n1780 VSS.n1779 191.474
R1610 VSS.t721 VSS.n81 191.417
R1611 VSS.t725 VSS.n80 191.417
R1612 VSS.t728 VSS.n77 191.417
R1613 VSS.t731 VSS.n76 191.417
R1614 VSS.n88 VSS.t734 191.417
R1615 VSS.n89 VSS.t737 191.417
R1616 VSS.n1381 VSS.t814 191.417
R1617 VSS.t816 VSS.n1367 191.417
R1618 VSS.t808 VSS.n1360 191.417
R1619 VSS.n1394 VSS.t823 191.417
R1620 VSS.n1397 VSS.t810 191.417
R1621 VSS.t871 VSS.n327 191.417
R1622 VSS.t514 VSS.t1278 189.113
R1623 VSS.n1300 VSS.t839 187.143
R1624 VSS.t781 VSS.n489 186.502
R1625 VSS.n495 VSS.t1023 186.502
R1626 VSS.n1974 VSS.n1973 185.846
R1627 VSS.n1102 VSS.t750 184.286
R1628 VSS.t723 VSS.n1101 184.286
R1629 VSS.t726 VSS.n1100 184.286
R1630 VSS.t729 VSS.n1099 184.286
R1631 VSS.t732 VSS.n1098 184.286
R1632 VSS.t735 VSS.n1106 184.286
R1633 VSS.t738 VSS.n1107 184.286
R1634 VSS.n1376 VSS.t813 184.286
R1635 VSS.n1382 VSS.t815 184.286
R1636 VSS.t817 VSS.n1366 184.286
R1637 VSS.t809 VSS.n1359 184.286
R1638 VSS.t822 VSS.n1357 184.286
R1639 VSS.n1395 VSS.t824 184.286
R1640 VSS.n1398 VSS.t811 184.286
R1641 VSS.n1335 VSS.t836 184.286
R1642 VSS.t868 VSS.n1160 184.286
R1643 VSS.n1222 VSS.t870 184.286
R1644 VSS.t872 VSS.n1155 184.286
R1645 VSS.n1778 VSS.n1777 180.287
R1646 VSS.n1019 VSS.t689 179.167
R1647 VSS.t744 VSS.n1108 179.167
R1648 VSS.t783 VSS.n1047 179.167
R1649 VSS.t859 VSS.n1272 179.167
R1650 VSS.t903 VSS.n1203 179.167
R1651 VSS.n1001 VSS.t1025 179.167
R1652 VSS.t384 VSS.t559 177.45
R1653 VSS.n803 VSS.n802 176.769
R1654 VSS.t1244 VSS.t842 176.219
R1655 VSS.t875 VSS.n1226 176.219
R1656 VSS.t951 VSS.n1433 176.219
R1657 VSS.t698 VSS.n1044 175.714
R1658 VSS.t748 VSS.n1103 175.714
R1659 VSS.t751 VSS.n1101 175.714
R1660 VSS.t753 VSS.n1100 175.714
R1661 VSS.t755 VSS.n1099 175.714
R1662 VSS.t757 VSS.n1098 175.714
R1663 VSS.t759 VSS.n1106 175.714
R1664 VSS.t761 VSS.n1107 175.714
R1665 VSS.n1375 VSS.t812 175.714
R1666 VSS.t798 VSS.n1369 175.714
R1667 VSS.n1383 VSS.t800 175.714
R1668 VSS.t803 VSS.n1365 175.714
R1669 VSS.n1387 VSS.t806 175.714
R1670 VSS.t819 VSS.n1359 175.714
R1671 VSS.t821 VSS.n1358 175.714
R1672 VSS.t825 VSS.n1352 175.714
R1673 VSS.n1401 VSS.t829 175.714
R1674 VSS.t833 VSS.n1149 175.714
R1675 VSS.t867 VSS.n1161 175.714
R1676 VSS.n1221 VSS.t869 175.714
R1677 VSS.t883 VSS.n1154 175.714
R1678 VSS.t900 VSS.t550 175.714
R1679 VSS.t953 VSS.n1428 175.714
R1680 VSS.t447 VSS.t264 175
R1681 VSS.t1102 VSS.t170 175
R1682 VSS.t535 VSS.n1063 174.325
R1683 VSS.t192 VSS.t163 171.875
R1684 VSS.t299 VSS.t1128 171.429
R1685 VSS.t326 VSS.t953 171.429
R1686 VSS.t690 VSS.n1016 170.833
R1687 VSS.n1322 VSS.n1321 170.833
R1688 VSS.n1270 VSS.t856 170.833
R1689 VSS.t285 VSS.n1286 169.989
R1690 VSS.n1292 VSS.t212 169.989
R1691 VSS.n435 VSS.t1155 169.989
R1692 VSS.n1776 VSS.n1775 169.101
R1693 VSS.t1207 VSS.n1054 168.103
R1694 VSS.t345 VSS.t827 167.143
R1695 VSS.n1295 VSS.t373 167.143
R1696 VSS.t1283 VSS.n1163 167.143
R1697 VSS.n1016 VSS.t1158 166.667
R1698 VSS.t383 VSS.n1125 166.667
R1699 VSS.n1092 VSS.t300 166.667
R1700 VSS.n1085 VSS.t351 166.667
R1701 VSS.t390 VSS.n1299 166.667
R1702 VSS.n1321 VSS.t507 166.667
R1703 VSS.n1324 VSS.t1102 166.667
R1704 VSS.t206 VSS.n1246 166.667
R1705 VSS.t348 VSS.n1256 166.667
R1706 VSS.t377 VSS.n1271 166.667
R1707 VSS.n1231 VSS.t504 166.667
R1708 VSS.t602 VSS.n1209 166.667
R1709 VSS.n1006 VSS.t1126 166.667
R1710 VSS.n1437 VSS.t248 166.667
R1711 VSS.n1180 VSS.t666 166.667
R1712 VSS.n1485 VSS.t235 166.667
R1713 VSS.n1481 VSS.t168 166.667
R1714 VSS.n1015 VSS.t691 165.669
R1715 VSS.t785 VSS.n487 165.669
R1716 VSS.t74 VSS.n1307 165.669
R1717 VSS.t398 VSS.n496 165.669
R1718 VSS.n1976 VSS.n659 162.923
R1719 VSS.t823 VSS.t1080 162.857
R1720 VSS.t149 VSS.t104 162.5
R1721 VSS.n1061 VSS.t479 162.162
R1722 VSS.t494 VSS.t506 158.571
R1723 VSS.n1691 VSS.n988 158.077
R1724 VSS.n1716 VSS.n990 158.077
R1725 VSS.n1608 VSS.n992 158.077
R1726 VSS.n1637 VSS.n994 158.077
R1727 VSS.n1528 VSS.n1504 158.077
R1728 VSS.n1746 VSS.n1506 158.077
R1729 VSS.n456 VSS.t1274 157.335
R1730 VSS.n1017 VSS.t1227 157.335
R1731 VSS.n505 VSS.t557 157.335
R1732 VSS.n1086 VSS.t76 157.335
R1733 VSS.n1333 VSS.t1243 157.335
R1734 VSS.t264 VSS.n1323 157.335
R1735 VSS.t1086 VSS.n1255 157.335
R1736 VSS.n1232 VSS.t1167 157.335
R1737 VSS.n1438 VSS.t1254 157.335
R1738 VSS.n1181 VSS.t149 157.335
R1739 VSS.t588 VSS.n460 157.335
R1740 VSS.t371 VSS.t402 156.25
R1741 VSS.t157 VSS.n1115 154.286
R1742 VSS.n1134 VSS.t179 154.286
R1743 VSS.t668 VSS.n1112 154.286
R1744 VSS.t481 VSS.n1371 154.286
R1745 VSS.n1379 VSS.t629 154.286
R1746 VSS.n1387 VSS.t601 154.286
R1747 VSS.t506 VSS.n1344 154.286
R1748 VSS.n1406 VSS.t572 154.286
R1749 VSS.n1150 VSS.t334 154.286
R1750 VSS.t637 VSS.n1146 154.286
R1751 VSS.t276 VSS.n1195 154.286
R1752 VSS.n1771 VSS.n1770 154.186
R1753 VSS.t460 VSS.n1500 154.167
R1754 VSS.t307 VSS.n1020 154.167
R1755 VSS.n1110 VSS.t310 154.167
R1756 VSS.n1048 VSS.t318 154.167
R1757 VSS.n1298 VSS.t32 154.167
R1758 VSS.n1311 VSS.t34 154.167
R1759 VSS.t19 VSS.n1310 154.167
R1760 VSS.n1242 VSS.t53 154.167
R1761 VSS.n1262 VSS.t39 154.167
R1762 VSS.n1235 VSS.t470 154.167
R1763 VSS.n1207 VSS.t444 154.167
R1764 VSS.t457 VSS.n1422 154.167
R1765 VSS.t224 VSS.n1441 154.167
R1766 VSS.t487 VSS.n1185 154.167
R1767 VSS.t465 VSS.n1000 154.167
R1768 VSS.n1013 VSS.t517 153.243
R1769 VSS.n506 VSS.t514 153.243
R1770 VSS.n488 VSS.t1205 153.243
R1771 VSS.n1227 VSS.t605 153.243
R1772 VSS.t392 VSS.n431 153.243
R1773 VSS.n1662 VSS.n1661 151.203
R1774 VSS.t351 VSS.t1110 150
R1775 VSS.t1272 VSS.t348 150
R1776 VSS.t860 VSS.n1273 150
R1777 VSS.n1210 VSS.t450 150
R1778 VSS.t576 VSS.t191 150
R1779 VSS.t235 VSS.t642 150
R1780 VSS.n665 VSS.n783 149.077
R1781 VSS.n1769 VSS.n1768 146.728
R1782 VSS.n1767 VSS.n1766 146.728
R1783 VSS.n1060 VSS.n1059 145.946
R1784 VSS.t163 VSS.n1216 145.946
R1785 VSS.t1084 VSS.t152 143.763
R1786 VSS.t199 VSS.t152 143.763
R1787 VSS.t199 VSS.t164 143.763
R1788 VSS.t164 VSS.t118 143.763
R1789 VSS.t118 VSS.n1420 143.763
R1790 VSS.n1420 VSS.n1419 143.763
R1791 VSS.n1419 VSS.n1418 143.763
R1792 VSS.n1418 VSS.t252 143.763
R1793 VSS.t252 VSS.n1417 143.763
R1794 VSS.n1417 VSS.t91 143.763
R1795 VSS.n1093 VSS.t374 141.667
R1796 VSS.t301 VSS.t305 141.667
R1797 VSS.t43 VSS.t207 141.667
R1798 VSS.t1129 VSS.n1270 141.667
R1799 VSS.n96 VSS.t1218 157.335
R1800 VSS.t533 VSS.n1004 141.667
R1801 VSS.t169 VSS.t441 141.667
R1802 VSS.t67 VSS.n1480 141.667
R1803 VSS.t1161 VSS.t828 141.429
R1804 VSS.t476 VSS.t651 141.429
R1805 VSS.n892 VSS.n782 139.846
R1806 VSS.n1056 VSS.t1206 137.931
R1807 VSS.n1055 VSS.t1207 137.931
R1808 VSS.n1064 VSS.t535 137.839
R1809 VSS.n1062 VSS.t1294 137.839
R1810 VSS.t424 VSS.n1215 137.839
R1811 VSS.n191 VSS.n1957 137.835
R1812 VSS.t1210 VSS.n1493 137.536
R1813 VSS.n1081 VSS.t519 137.536
R1814 VSS.t105 VSS.n472 153.243
R1815 VSS.t294 VSS.n1260 137.536
R1816 VSS.n1433 VSS.t553 137.536
R1817 VSS.n1177 VSS.t555 137.536
R1818 VSS.n1175 VSS.t604 137.536
R1819 VSS.t258 VSS.n1491 137.536
R1820 VSS.t1208 VSS.n1486 137.536
R1821 VSS.n1963 VSS.n213 136.364
R1822 VSS.n1869 VSS.n1868 136.364
R1823 VSS.n1871 VSS.n1870 136.364
R1824 VSS.n395 VSS.n1874 135.124
R1825 VSS.n940 VSS.n825 133.846
R1826 VSS.n11 VSS.n824 134.583
R1827 VSS.n904 VSS.n823 133.846
R1828 VSS.n864 VSS.n822 133.846
R1829 VSS.n843 VSS.n821 133.846
R1830 VSS.n1985 VSS.n778 133.846
R1831 VSS.n1940 VSS.n805 133.846
R1832 VSS.n1126 VSS.t516 133.706
R1833 VSS.n1217 VSS.t110 132.857
R1834 VSS.t155 VSS.n1205 132.857
R1835 VSS.n907 VSS.n781 130.615
R1836 VSS.t158 VSS.t15 129.167
R1837 VSS.t1282 VSS.t864 128.571
R1838 VSS.n1811 VSS.n1782 128.084
R1839 VSS.n1781 VSS.n1780 128.084
R1840 VSS.n1779 VSS.n1778 128.084
R1841 VSS.n1777 VSS.n1776 128.084
R1842 VSS.n1775 VSS.n1774 128.084
R1843 VSS.n1772 VSS.n1771 128.084
R1844 VSS.n1770 VSS.n1769 128.084
R1845 VSS.n1768 VSS.n1767 128.084
R1846 VSS.t1121 VSS.n1148 124.287
R1847 VSS.n1166 VSS.t143 124.287
R1848 VSS.n160 VSS.t187 122.564
R1849 VSS.t600 VSS.n1068 121.496
R1850 VSS.n834 VSS.n779 121.385
R1851 VSS.n930 VSS.n780 121.385
R1852 VSS.t140 VSS.n1371 120.001
R1853 VSS.n1379 VSS.t1199 120.001
R1854 VSS.t1194 VSS.n1362 120.001
R1855 VSS.t1288 VSS.n1283 120.001
R1856 VSS.n1289 VSS.t636 120.001
R1857 VSS.t57 VSS.n1289 120.001
R1858 VSS.n1202 VSS.t299 120.001
R1859 VSS.t1128 VSS.n1194 120.001
R1860 VSS.t335 VSS.n456 119.835
R1861 VSS.t1242 VSS.n1017 119.835
R1862 VSS.n505 VSS.t599 119.835
R1863 VSS.t290 VSS.n1333 119.835
R1864 VSS.n1323 VSS.t130 119.835
R1865 VSS.t580 VSS.n1232 119.835
R1866 VSS.t399 VSS.n1181 119.835
R1867 VSS.n1214 VSS.n1213 117.569
R1868 VSS.n1212 VSS.t596 116.987
R1869 VSS.n1773 VSS.n1772 115.594
R1870 VSS.n1773 VSS.t1084 110.484
R1871 VSS.n1497 VSS.t1258 107.451
R1872 VSS.n1175 VSS.t1241 107.451
R1873 VSS.t1132 VSS.n1486 107.451
R1874 VSS.t483 VSS.n1021 107.144
R1875 VSS.n1130 VSS.t1175 107.144
R1876 VSS.t1157 VSS.n1109 107.144
R1877 VSS.t74 VSS.n1306 107.144
R1878 VSS.t16 VSS.n1335 107.144
R1879 VSS.t860 VSS.n1268 107.144
R1880 VSS.t1120 VSS.n1152 107.144
R1881 VSS.n1218 VSS.t405 107.144
R1882 VSS.t3 VSS.n1204 107.144
R1883 VSS.t952 VSS.n1431 107.144
R1884 VSS.t117 VSS.n1423 107.144
R1885 VSS.t21 VSS.t558 104.457
R1886 VSS.n1122 VSS.n1121 104.457
R1887 VSS.t341 VSS.n1047 104.168
R1888 VSS.n1314 VSS.t581 104.168
R1889 VSS.n1244 VSS.t1154 104.168
R1890 VSS.n1269 VSS.t1135 104.168
R1891 VSS.n96 VSS.t1085 119.835
R1892 VSS.n1005 VSS.t575 104.168
R1893 VSS.n1001 VSS.t1152 104.168
R1894 VSS.n1133 VSS.t648 102.858
R1895 VSS.t647 VSS.n1114 102.858
R1896 VSS.n1345 VSS.t176 102.858
R1897 VSS.t653 VSS.n1341 102.858
R1898 VSS.n1408 VSS.t652 102.858
R1899 VSS.t915 VSS.t379 102.858
R1900 VSS.t1137 VSS.n1065 101.352
R1901 VSS.t1237 VSS.n1064 101.352
R1902 VSS.n1213 VSS.t576 101.352
R1903 VSS.t191 VSS.t451 101.352
R1904 VSS.t605 VSS.t875 98.8544
R1905 VSS.t1166 VSS.t551 98.8544
R1906 VSS.t367 VSS.n1208 98.8544
R1907 VSS.t284 VSS.n1003 98.8544
R1908 VSS.n1044 VSS.t1249 98.5719
R1909 VSS.n1136 VSS.t173 98.5719
R1910 VSS.n1105 VSS.t230 98.5719
R1911 VSS.n1401 VSS.t365 98.5719
R1912 VSS.t394 VSS.n1346 98.5719
R1913 VSS.n1404 VSS.t494 98.5719
R1914 VSS.n1405 VSS.t612 98.5719
R1915 VSS.n1410 VSS.t431 98.5719
R1916 VSS.t177 VSS.n1337 98.5719
R1917 VSS.n1412 VSS.t400 98.5719
R1918 VSS.n1282 VSS.t353 98.5719
R1919 VSS.t1081 VSS.n1267 98.5719
R1920 VSS.t523 VSS.n1264 98.5719
R1921 VSS.t567 VSS.n1263 98.5719
R1922 VSS.n465 VSS.t29 97.755
R1923 VSS.t379 VSS.n438 97.755
R1924 VSS.t297 VSS.n331 97.1319
R1925 VSS.n1993 VSS.n1992 96.9574
R1926 VSS.n1495 VSS.t1111 95.8338
R1927 VSS.n1500 VSS.t1239 95.8338
R1928 VSS.t112 VSS.n1004 95.8338
R1929 VSS.t1188 VSS.n1439 95.8338
R1930 VSS.t1240 VSS.n1183 95.8338
R1931 VSS.t104 VSS.n1180 95.8338
R1932 VSS.t107 VSS.t618 94.5564
R1933 VSS.t6 VSS.t448 94.5564
R1934 VSS.n1761 VSS.n1760 94.5022
R1935 VSS.n502 VSS.t280 93.4693
R1936 VSS.n1342 VSS.t1125 92.8462
R1937 VSS.t211 VSS.n1407 92.8462
R1938 VSS.t584 VSS.n1326 92.8462
R1939 VSS.n1664 VSS.n987 91.9249
R1940 VSS.n1694 VSS.n989 91.9249
R1941 VSS.n1542 VSS.n991 91.9249
R1942 VSS.n1618 VSS.n993 91.9249
R1943 VSS.n1644 VSS.n1501 91.9249
R1944 VSS.n1583 VSS.n1503 91.9249
R1945 VSS.n1723 VSS.n1505 91.9249
R1946 VSS.n1751 VSS.n1507 91.9249
R1947 VSS.n1907 VSS.n804 91.9249
R1948 VSS.t329 VSS.t1263 91.6672
R1949 VSS.t495 VSS.t279 91.6672
R1950 VSS.n1260 VSS.t548 90.2584
R1951 VSS.n1131 VSS.t24 90.0005
R1952 VSS.t498 VSS.t650 90.0005
R1953 VSS.t102 VSS.n1076 90.0005
R1954 VSS.t547 VSS.n1356 90.0005
R1955 VSS.t26 VSS.n1305 90.0005
R1956 VSS.t381 VSS.t1088 90.0005
R1957 VSS.t49 VSS.n1266 90.0005
R1958 VSS.n1428 VSS.t228 90.0005
R1959 VSS.n1380 VSS.t1292 89.1846
R1960 VSS.n467 VSS.t132 89.1846
R1961 VSS.t426 VSS.n1372 89.1836
R1962 VSS.t136 VSS.n1361 88.5605
R1963 VSS.t1080 VSS.n1393 88.5605
R1964 VSS.t1290 VSS.n433 88.5605
R1965 VSS.t1145 VSS.n436 88.5605
R1966 VSS.n437 VSS.t634 88.5605
R1967 VSS.t1227 VSS.t690 87.5005
R1968 VSS.n1322 VSS.t46 87.5005
R1969 VSS.n1243 VSS.t337 87.1423
R1970 VSS.n455 VSS.t433 87.1413
R1971 VSS.n1089 VSS.t497 86.5025
R1972 VSS.n545 VSS.t355 86.5025
R1973 VSS.t1289 VSS.n1240 86.5025
R1974 VSS.t578 VSS.n1440 86.5025
R1975 VSS.t342 VSS.n461 86.5025
R1976 VSS.t1278 VSS.n1119 85.9604
R1977 VSS.n1132 VSS.t81 85.7148
R1978 VSS.t139 VSS.n1072 85.7148
R1979 VSS.t594 VSS.n1304 85.7148
R1980 VSS.t640 VSS.n1265 85.7148
R1981 VSS.t622 VSS.n1425 85.7148
R1982 VSS.n929 VSS.n825 84.9236
R1983 VSS.n891 VSS.n823 84.9236
R1984 VSS.n860 VSS.n822 84.9236
R1985 VSS.n821 VSS.n820 84.9236
R1986 VSS.n788 VSS.n778 84.9236
R1987 VSS.n652 VSS.n805 84.9236
R1988 VSS.t1139 VSS.n1066 84.5541
R1989 VSS.t1110 VSS.n1084 83.3338
R1990 VSS.n1324 VSS.t447 83.3338
R1991 VSS.n1257 VSS.t1272 83.3338
R1992 VSS.t642 VSS.n995 83.3338
R1993 VSS.t171 VSS.t1273 81.6624
R1994 VSS.t1235 VSS.t1214 81.6624
R1995 VSS.t286 VSS.n1319 81.6624
R1996 VSS.n1139 VSS.t561 81.4291
R1997 VSS.t71 VSS.n1373 81.4291
R1998 VSS.n1391 VSS.t632 81.4291
R1999 VSS.t492 VSS.n1294 81.4291
R2000 VSS.n340 VSS.t145 95.0254
R2001 VSS.t512 VSS.n1162 81.4291
R2002 VSS.n1167 VSS.t281 81.4291
R2003 VSS.t1211 VSS.n1159 81.4291
R2004 VSS.t524 VSS.n1157 81.4291
R2005 VSS.t480 VSS.n1156 81.4291
R2006 VSS.t624 VSS.n1197 81.4291
R2007 VSS.t315 VSS.t204 81.0816
R2008 VSS.t1196 VSS.n503 80.6121
R2009 VSS.n1429 VSS.t326 80.6121
R2010 VSS.n1393 VSS.t411 79.9891
R2011 VSS.n718 VSS.n1828 81.218
R2012 VSS.t254 VSS.n1245 79.1672
R2013 VSS.n1229 VSS.t660 79.1672
R2014 VSS.n1902 VSS.n1889 79.0383
R2015 VSS.t1260 VSS.n1081 77.3644
R2016 VSS.t10 VSS.t1280 77.3644
R2017 VSS.t198 VSS.n1116 77.1434
R2018 VSS.t364 VSS.n1113 77.1434
R2019 VSS.n1403 VSS.t1291 77.1434
R2020 VSS.n1263 VSS.t1264 77.1434
R2021 VSS.t1281 VSS.n1163 77.1434
R2022 VSS.t1234 VSS.n1153 77.1434
R2023 VSS.n1201 VSS.t247 77.1434
R2024 VSS.n1063 VSS.n1062 77.0275
R2025 VSS.t100 VSS.t597 75.4129
R2026 VSS.t279 VSS.n1316 75.0005
R2027 VSS.t1115 VSS.n1083 74.0263
R2028 VSS.n1258 VSS.t1079 74.0263
R2029 VSS.n459 VSS.t1108 74.0263
R2030 VSS.t170 VSS.n1307 74.0025
R2031 VSS.n954 VSS.n687 12.641
R2032 VSS.n1074 VSS.t1267 72.8576
R2033 VSS.n1285 VSS.t1226 72.8576
R2034 VSS.t1217 VSS.n1287 72.8576
R2035 VSS.n1291 VSS.t613 72.8576
R2036 VSS.n340 VSS.t606 2.75541
R2037 VSS.n1848 VSS.n1847 72.0543
R2038 VSS.t138 VSS.n1073 72.0417
R2039 VSS.n333 VSS.t1282 72.0407
R2040 VSS.t1214 VSS.n1318 71.5807
R2041 VSS.n1328 VSS.t593 71.4177
R2042 VSS.n336 VSS.t153 71.4177
R2043 VSS.n434 VSS.t338 71.4177
R2044 VSS.t621 VSS.n1427 71.4177
R2045 VSS.n1126 VSS.t1224 71.0311
R2046 VSS.t128 VSS.n1019 70.8338
R2047 VSS.t1148 VSS.n1108 70.8338
R2048 VSS.n1049 VSS.t1124 70.8338
R2049 VSS.n1312 VSS.t1252 70.8338
R2050 VSS.t633 VSS.n1309 70.8338
R2051 VSS.t1222 VSS.n1234 70.8338
R2052 VSS.t181 VSS.n1203 70.8338
R2053 VSS.t1221 VSS.n1421 70.8338
R2054 VSS.t1275 VSS.n1184 70.8338
R2055 VSS.t1116 VSS.n999 70.8338
R2056 VSS.t321 VSS.t615 70.1247
R2057 VSS.t1109 VSS.n1086 69.8359
R2058 VSS.n1255 VSS.t1271 69.8359
R2059 VSS.n460 VSS.t641 69.8359
R2060 VSS.t204 VSS.n1067 68.9194
R2061 VSS.n1211 VSS.t183 68.9194
R2062 VSS.t692 VSS.t61 68.7684
R2063 VSS.t688 VSS.t483 68.5719
R2064 VSS.t743 VSS.t1157 68.5719
R2065 VSS.t901 VSS.t3 68.5719
R2066 VSS.t1228 VSS.n1013 67.2827
R2067 VSS.t1117 VSS.n506 67.2827
R2068 VSS.t375 VSS.n488 67.2827
R2069 VSS.n1318 VSS.t330 67.2827
R2070 VSS.t1168 VSS.n1227 67.2827
R2071 VSS.t1219 VSS.n93 67.2827
R2072 VSS.t598 VSS.t21 66.8529
R2073 VSS.t1084 VSS.t460 66.6672
R2074 VSS.t185 VSS.t318 66.6672
R2075 VSS.n1091 VSS.t305 66.6672
R2076 VSS.t32 VSS.t836 66.6672
R2077 VSS.t44 VSS.t34 66.6672
R2078 VSS.n1320 VSS.t19 66.6672
R2079 VSS.t89 VSS.t53 66.6672
R2080 VSS.n1252 VSS.t43 66.6672
R2081 VSS.t39 VSS.t30 66.6672
R2082 VSS.t114 VSS.t224 66.6672
R2083 VSS.t269 VSS.t1179 66.6672
R2084 VSS.t126 VSS.t487 66.6672
R2085 VSS.t441 VSS.n1483 66.6672
R2086 VSS.t17 VSS.t465 66.6672
R2087 VSS.t319 VSS.t315 64.8654
R2088 VSS.t450 VSS.t402 64.8654
R2089 VSS.n1261 VSS.t189 64.4704
R2090 VSS.t590 VSS.n1075 64.2862
R2091 VSS.n1075 VSS.t288 64.2862
R2092 VSS.n1327 VSS.t1160 64.2862
R2093 VSS.t407 VSS.t26 64.2862
R2094 VSS.n1276 VSS.t268 64.2862
R2095 VSS.t839 VSS.t390 62.5005
R2096 VSS.t507 VSS.n1309 62.5005
R2097 VSS.t92 VSS.t254 62.5005
R2098 VSS.n1121 VSS.n1120 60.9987
R2099 VSS.n227 VSS.n986 60.9641
R2100 VSS.t322 VSS.n1491 60.1724
R2101 VSS.t1118 VSS.n1118 60.0005
R2102 VSS.t1276 VSS.n1116 60.0005
R2103 VSS.t79 VSS.n1078 60.0005
R2104 VSS.t610 VSS.n1071 60.0005
R2105 VSS.n1325 VSS.t267 60.0005
R2106 VSS.n1330 VSS.t1141 60.0005
R2107 VSS.n1274 VSS.t1131 60.0005
R2108 VSS.n1278 VSS.t1245 60.0005
R2109 VSS.t1256 VSS.n1430 60.0005
R2110 VSS.t455 VSS.n1424 60.0005
R2111 VSS.t557 VSS.t745 58.3338
R2112 VSS.t904 VSS.t1218 58.3338
R2113 VSS.n1129 VSS.t1277 55.8744
R2114 VSS.t218 VSS.n689 55.7148
R2115 VSS.t216 VSS.n689 55.7148
R2116 VSS.n1140 VSS.t484 55.7148
R2117 VSS.n1376 VSS.t232 55.7148
R2118 VSS.t1299 VSS.n1358 55.7148
R2119 VSS.t501 VSS.n485 71.4177
R2120 VSS.n1277 VSS.t639 55.7148
R2121 VSS.t275 VSS.n1161 55.7148
R2122 VSS.n1169 VSS.t382 55.7148
R2123 VSS.n1222 VSS.t197 55.7148
R2124 VSS.t491 VSS.n1350 54.9227
R2125 VSS.n93 VSS.t1166 54.3887
R2126 VSS.n431 VSS.t1101 54.3887
R2127 VSS.n1045 VSS.t1198 54.2748
R2128 VSS.t344 VSS.n501 54.2748
R2129 VSS.t122 VSS.n1342 54.2748
R2130 VSS.t272 VSS.n1010 54.2748
R2131 VSS.t453 VSS.n463 54.2748
R2132 VSS.n129 VSS.t165 54.2748
R2133 VSS.t246 VSS.n130 54.2748
R2134 VSS.t446 VSS.n1308 54.1672
R2135 VSS.t380 VSS.n1244 54.1672
R2136 VSS.n1230 VSS.t1119 54.1672
R2137 VSS.t1178 VSS.n1179 53.8094
R2138 VSS.t51 VSS.n1243 53.8079
R2139 VSS.n1018 VSS.t306 53.1692
R2140 VSS.n489 VSS.t311 53.1692
R2141 VSS.t47 VSS.n1313 53.1692
R2142 VSS.t55 VSS.n484 53.8089
R2143 VSS.n1233 VSS.t472 53.1692
R2144 VSS.t458 VSS.n430 53.1692
R2145 VSS.t1179 VSS.n1438 53.1692
R2146 VSS.t463 VSS.n495 53.1692
R2147 VSS.n1811 VSS.n1810 53.1362
R2148 VSS.n1066 VSS.t320 52.1217
R2149 VSS.t451 VSS.n1212 52.1217
R2150 VSS.t536 VSS.n1057 51.7246
R2151 VSS.t1295 VSS.n1056 51.7246
R2152 VSS.t1273 VSS.n1494 51.5764
R2153 VSS.t77 VSS.n1082 51.5764
R2154 VSS.t296 VSS.n1080 51.5764
R2155 VSS.n472 VSS.t1244 67.2827
R2156 VSS.n1249 VSS.t93 51.5764
R2157 VSS.n1259 VSS.t1087 51.5764
R2158 VSS.t1255 VSS.n1434 51.5764
R2159 VSS.t150 VSS.n1178 51.5764
R2160 VSS.t1280 VSS.n1173 51.5764
R2161 VSS.n1498 VSS.t124 51.5764
R2162 VSS.n1499 VSS.t589 51.5764
R2163 VSS.t673 VSS.t700 51.4291
R2164 VSS.t675 VSS.t702 51.4291
R2165 VSS.t678 VSS.t704 51.4291
R2166 VSS.t680 VSS.t706 51.4291
R2167 VSS.t682 VSS.t708 51.4291
R2168 VSS.t685 VSS.t710 51.4291
R2169 VSS.t1162 VSS.n1070 51.4291
R2170 VSS.n1279 VSS.t261 51.4291
R2171 VSS.n1165 VSS.t146 51.4291
R2172 VSS.n1224 VSS.t619 51.4291
R2173 VSS.t569 VSS.n1196 51.4291
R2174 VSS.t558 VSS.n1124 50.1398
R2175 VSS.t316 VSS.t314 50.0005
R2176 VSS.t142 VSS.t1109 50.0005
R2177 VSS.t1263 VSS.n1315 50.0005
R2178 VSS.t38 VSS.t36 50.0005
R2179 VSS.t1271 VSS.t135 50.0005
R2180 VSS.t466 VSS.t442 50.0005
R2181 VSS.t641 VSS.t1181 50.0005
R2182 VSS.n932 VSS.n779 49.3851
R2183 VSS.n911 VSS.n780 49.3851
R2184 VSS.n895 VSS.n781 49.3851
R2185 VSS.n870 VSS.n782 49.3851
R2186 VSS.n835 VSS.n783 49.3851
R2187 VSS.n1977 VSS.n1976 49.3851
R2188 VSS.n1933 VSS.n803 49.3851
R2189 VSS.n1992 VSS.n1991 47.7744
R2190 VSS.t349 VSS.t150 47.2784
R2191 VSS.n1487 VSS.t1208 47.2784
R2192 VSS.t289 VSS.n1146 47.1434
R2193 VSS.n1774 VSS.n1773 46.0511
R2194 VSS.n1286 VSS.t167 45.7034
R2195 VSS.t161 VSS.n1292 45.7034
R2196 VSS.t550 VSS.n435 45.7034
R2197 VSS.n1489 VSS.t97 45.021
R2198 VSS.n1090 VSS.n1089 44.8359
R2199 VSS.n1253 VSS.n1240 44.8359
R2200 VSS.n997 VSS.n461 44.8359
R2201 VSS.t1286 VSS.n1214 44.5951
R2202 VSS.t618 VSS.n1250 42.9804
R2203 VSS.t80 VSS.t667 42.8576
R2204 VSS.n1396 VSS.t1261 42.8576
R2205 VSS.n1400 VSS.t1161 42.8576
R2206 VSS.t586 VSS.n1347 42.8576
R2207 VSS.n1330 VSS.t259 42.8576
R2208 VSS.t357 VSS.n1069 42.0417
R2209 VSS.t278 VSS.n1312 41.6672
R2210 VSS.t385 VSS.n129 41.4177
R2211 VSS.n433 VSS.t1136 41.4177
R2212 VSS.t125 VSS.n1487 41.194
R2213 VSS.n1879 VSS.n359 40.1107
R2214 VSS.n1876 VSS.n394 40.1101
R2215 VSS.n190 VSS.n774 39.4956
R2216 VSS.t1200 VSS.n1177 38.6824
R2217 VSS.t1133 VSS.n1103 38.5719
R2218 VSS.n1402 VSS.t595 38.5719
R2219 VSS.t467 VSS.n1343 38.5719
R2220 VSS.n1410 VSS.t1236 38.5719
R2221 VSS.t1203 VSS.n1337 38.5719
R2222 VSS.t1160 VSS.t1262 38.5719
R2223 VSS.n1276 VSS.t670 38.5719
R2224 VSS.t292 VSS.t624 38.5719
R2225 VSS.t1032 VSS.n240 29.2298
R2226 VSS.n1479 VSS.n246 41.3471
R2227 VSS.t1060 VSS.n243 27.7128
R2228 VSS.n243 VSS.n268 41.3471
R2229 VSS.t1069 VSS.n242 27.7128
R2230 VSS.n242 VSS.n1790 41.3471
R2231 VSS.t1074 VSS.n241 27.7128
R2232 VSS.n1496 VSS.t158 37.5005
R2233 VSS.n1137 VSS.t303 37.5005
R2234 VSS.n1087 VSS.t316 37.5005
R2235 VSS.n1334 VSS.t41 37.5005
R2236 VSS.t28 VSS.n1308 37.5005
R2237 VSS.t36 VSS.n1254 37.5005
R2238 VSS.n432 VSS.t445 53.1692
R2239 VSS.n1006 VSS.t508 37.5005
R2240 VSS.n1439 VSS.t225 37.5005
R2241 VSS.t233 VSS.n1182 37.5005
R2242 VSS.n1182 VSS.t489 37.5005
R2243 VSS.t442 VSS.n996 37.5005
R2244 VSS.n466 VSS.t59 37.1319
R2245 VSS.n1065 VSS.t304 36.487
R2246 VSS.t404 VSS.n1211 36.487
R2247 VSS.n191 VSS.t1099 36.1361
R2248 VSS.n504 VSS.t598 35.9683
R2249 VSS.t124 VSS.t333 34.3845
R2250 VSS.n1795 VSS.t1259 34.054
R2251 VSS.n1476 VSS.n262 34.0298
R2252 VSS.n1796 VSS.t1151 33.4198
R2253 VSS.t1143 VSS.t461 33.3338
R2254 VSS.n1090 VSS.t262 33.3338
R2255 VSS.t201 VSS.n1253 33.3338
R2256 VSS.n997 VSS.t454 33.3338
R2257 VSS.t96 VSS.n1399 32.8462
R2258 VSS.n1348 VSS.t526 32.8462
R2259 VSS.n292 VSS.n1597 18.6543
R2260 VSS.n1054 VSS.n1011 31.2505
R2261 VSS.n241 VSS.t1140 34.0548
R2262 VSS.n1618 VSS.n1617 30.9283
R2263 VSS.t597 VSS.t1287 30.6368
R2264 VSS.n14 VSS.n1678 18.6123
R2265 VSS.n1760 VSS.n318 30.4988
R2266 VSS.n26 VSS.n1765 12.3024
R2267 VSS.t17 VSS.n257 21389.9
R2268 VSS.n295 VSS.n1626 18.1631
R2269 VSS.n646 VSS.n1900 17.1787
R2270 VSS.n1377 VSS.t358 30.0005
R2271 VSS.t73 VSS.n1370 30.0005
R2272 VSS.t502 VSS.n1364 30.0005
R2273 VSS.n1282 VSS.t65 30.0005
R2274 VSS.n1296 VSS.t362 30.0005
R2275 VSS.n1297 VSS.t381 30.0005
R2276 VSS.n1201 VSS.t302 30.0005
R2277 VSS.n440 VSS.t574 45.7034
R2278 VSS.n1446 VSS.n1444 29.591
R2279 VSS.n1793 VSS.n1792 29.591
R2280 VSS.n1964 VSS.n1963 29.2786
R2281 VSS.n1746 VSS.n1736 29.2101
R2282 VSS.n503 VSS.t1114 29.1846
R2283 VSS.t249 VSS.n1429 29.1846
R2284 VSS.t667 VSS.n507 28.5605
R2285 VSS.n507 VSS.t499 28.5605
R2286 VSS.n1326 VSS.t1103 28.5605
R2287 VSS.t477 VSS.n1302 28.5605
R2288 VSS.n1302 VSS.t406 28.5605
R2289 VSS.t573 VSS.n128 28.5605
R2290 VSS.n128 VSS.t1265 28.5605
R2291 VSS.t570 VSS.n329 28.5605
R2292 VSS.n329 VSS.t418 28.5605
R2293 VSS.t615 VSS.t662 28.4884
R2294 VSS.n2012 VSS.n266 28.3228
R2295 VSS.t591 VSS.n1788 27.5845
R2296 VSS.t658 VSS.n1787 27.5845
R2297 VSS.t270 VSS.n1786 27.5845
R2298 VSS.n1666 VSS.n1665 27.4919
R2299 VSS.t215 VSS.n959 26.9901
R2300 VSS.n959 VSS.t213 26.9901
R2301 VSS.t1098 VSS.n1912 26.9901
R2302 VSS.t1097 VSS.n1912 26.9901
R2303 VSS.n1449 VSS.n1448 26.6333
R2304 VSS.n1968 VSS.n681 26.07
R2305 VSS.t1293 VSS.n1079 25.7148
R2306 VSS.t1142 VSS.n1164 25.7148
R2307 VSS.n1225 VSS.t1172 25.7148
R2308 VSS.n1797 VSS.t1164 25.0481
R2309 VSS.t131 VSS.n1314 25.0005
R2310 VSS.n1765 VSS.n1764 24.9146
R2311 VSS.t1035 VSS.n1443 24.5422
R2312 VSS.n1789 VSS.t1074 24.5422
R2313 VSS.t1294 VSS.t661 24.3248
R2314 VSS.n1399 VSS.t345 24.2748
R2315 VSS.t1212 VSS.n1348 24.2748
R2316 VSS.n1721 VSS.t217 24.1169
R2317 VSS.t582 VSS.n1783 24.0672
R2318 VSS.t1032 VSS.n1443 23.909
R2319 VSS.t1071 VSS.n1789 23.909
R2320 VSS.t1096 VSS.n950 22.7668
R2321 VSS.n768 VSS.n766 21.8775
R2322 VSS.n1444 VSS.t1030 21.6646
R2323 VSS.t1040 VSS.n1450 21.6646
R2324 VSS.t1050 VSS.n262 21.6646
R2325 VSS.t1060 VSS.n266 21.6646
R2326 VSS.t687 VSS.t713 21.4291
R2327 VSS.n1969 VSS.t215 21.396
R2328 VSS.t213 VSS.n951 21.3956
R2329 VSS.n2003 VSS.n177 24.226
R2330 VSS.t1067 VSS.n1793 21.0304
R2331 VSS.n700 VSS.n1462 20.9263
R2332 VSS.n455 VSS.t1143 20.4756
R2333 VSS.n1834 VSS.n369 20.3282
R2334 VSS.n750 VSS.n741 20.2922
R2335 VSS.n1828 VSS.n1812 20.1261
R2336 VSS.n464 VSS.t1201 19.9891
R2337 VSS.t1216 VSS.n466 19.9891
R2338 VSS.n1799 VSS.n1794 19.7864
R2339 VSS.n1927 VSS.n1919 19.7274
R2340 VSS.n1840 VSS.n1839 19.6529
R2341 VSS.n1923 VSS.n1904 19.3895
R2342 VSS.n1469 VSS.n703 19.341
R2343 VSS.n1749 VSS.n1748 19.3346
R2344 VSS.n1971 VSS.n686 19.1541
R2345 VSS.n702 VSS.n1459 19.024
R2346 VSS.n1932 VSS.n1931 18.8341
R2347 VSS.n1655 VSS.n1654 18.8341
R2348 VSS.n1554 VSS.n287 18.8341
R2349 VSS.n1705 VSS.n1704 18.8341
R2350 VSS.n1677 VSS.n1676 18.8341
R2351 VSS.n1942 VSS.n1941 18.8341
R2352 VSS.n1989 VSS.n1988 18.8341
R2353 VSS.n877 VSS.n876 18.8341
R2354 VSS.n2001 VSS.n759 18.7069
R2355 VSS.t420 VSS.n1785 18.7069
R2356 VSS.n1734 VSS.n1733 18.7057
R2357 VSS.n1596 VSS.n1595 18.7057
R2358 VSS.n1625 VSS.n1624 18.7057
R2359 VSS.n1839 VSS.n1838 18.7057
R2360 VSS.n848 VSS.n847 18.7057
R2361 VSS.n906 VSS.n588 18.7057
R2362 VSS.n920 VSS.n919 18.7057
R2363 VSS.n943 VSS.n942 18.7057
R2364 VSS.n1748 VSS.n1747 18.6757
R2365 VSS.n1541 VSS.n1540 18.6757
R2366 VSS.n1657 VSS.n1656 18.6757
R2367 VSS.n1643 VSS.n1642 18.6757
R2368 VSS.n1611 VSS.n1610 18.6757
R2369 VSS.n1719 VSS.n1718 18.6757
R2370 VSS.n1693 VSS.n1692 18.6757
R2371 VSS.n1569 VSS.n977 18.6757
R2372 VSS.n1944 VSS.n1943 18.6757
R2373 VSS.n785 VSS.n776 18.6757
R2374 VSS.n817 VSS.n777 18.6757
R2375 VSS.n862 VSS.n861 18.6757
R2376 VSS.n894 VSS.n893 18.6757
R2377 VSS.n910 VSS.n909 18.6757
R2378 VSS.n945 VSS.n944 18.6757
R2379 VSS.n1722 VSS.t220 18.4647
R2380 VSS.n1721 VSS.n1720 18.4647
R2381 VSS.n1919 VSS.n775 18.4647
R2382 VSS.n1991 VSS.n1990 18.4647
R2383 VSS.n986 VSS.n985 18.462
R2384 VSS.n1091 VSS.t1176 18.2932
R2385 VSS.n1252 VSS.t195 18.2932
R2386 VSS.n1483 VSS.t398 18.2932
R2387 VSS.n1783 VSS.n963 18.2181
R2388 VSS.n690 VSS.t218 18.2148
R2389 VSS.n688 VSS.t216 18.2148
R2390 VSS.t370 VSS.t422 18.1327
R2391 VSS.n1801 VSS.t527 18.1327
R2392 VSS.n1550 VSS.n1549 17.968
R2393 VSS.n1730 VSS.n1729 17.968
R2394 VSS.n1521 VSS.n308 18.6611
R2395 VSS.n1544 VSS.n1543 17.4761
R2396 VSS.n1646 VSS.n1645 17.4761
R2397 VSS.n736 VSS.n1701 18.2338
R2398 VSS.n1620 VSS.n221 18.4002
R2399 VSS.t1027 VSS.n257 25.4692
R2400 VSS.t1037 VSS.n246 28.3469
R2401 VSS.n244 VSS.t1052 28.3469
R2402 VSS.n755 VSS.t1057 17.4387
R2403 VSS.t1062 VSS.n268 17.4387
R2404 VSS.n177 VSS.t1067 28.3469
R2405 VSS.n1790 VSS.t1071 17.4387
R2406 VSS.n309 VSS.n1739 18.1329
R2407 VSS.n1706 VSS.n208 18.3442
R2408 VSS.n1763 VSS.n1762 17.2395
R2409 VSS.t401 VSS.n1249 17.1925
R2410 VSS.t1267 VSS.t313 17.1434
R2411 VSS.t175 VSS.t610 17.1434
R2412 VSS.t120 VSS.n1355 17.1434
R2413 VSS.t119 VSS.n1304 17.1434
R2414 VSS.n2009 VSS.n767 17.1216
R2415 VSS.n1636 VSS.n1635 17.0578
R2416 VSS.n257 VSS.n239 4.48606
R2417 VSS.n515 VSS.n513 0.649832
R2418 VSS.n565 VSS.n357 0.649832
R2419 VSS.n352 VSS.n350 0.649832
R2420 VSS.n176 VSS.n2014 17.0005
R2421 VSS.n176 VSS.n742 17.0005
R2422 VSS.n175 VSS.n2010 17.0005
R2423 VSS.n763 VSS.n175 17.0005
R2424 VSS.n1999 VSS.n175 17.0005
R2425 VSS.n767 VSS.n175 17.0005
R2426 VSS.n2004 VSS.n175 17.0005
R2427 VSS.n175 VSS.n268 17.0005
R2428 VSS.n176 VSS.n243 1.27287
R2429 VSS.n2011 VSS.n176 17.0005
R2430 VSS.n176 VSS.n755 17.0005
R2431 VSS.n176 VSS.n738 17.0005
R2432 VSS.n176 VSS.n739 17.0005
R2433 VSS.n176 VSS.n741 17.0005
R2434 VSS.n176 VSS.n740 17.0005
R2435 VSS.n176 VSS.n244 1.27287
R2436 VSS.n1468 VSS.n174 17.0005
R2437 VSS.n174 VSS.n263 17.0005
R2438 VSS.n174 VSS.n1467 17.0005
R2439 VSS.n174 VSS.n1469 17.0005
R2440 VSS.n1470 VSS.n174 17.0005
R2441 VSS.n174 VSS.n1478 17.0005
R2442 VSS.n174 VSS.n1452 17.0005
R2443 VSS.n174 VSS.n1454 17.0005
R2444 VSS.n174 VSS.n1453 17.0005
R2445 VSS.n174 VSS.n245 1.27287
R2446 VSS.n1451 VSS.n173 17.0005
R2447 VSS.n1448 VSS.n173 17.0005
R2448 VSS.n239 VSS.n1479 17.0005
R2449 VSS.n1445 VSS.n239 17.0005
R2450 VSS.n175 VSS.n756 17.0005
R2451 VSS.n175 VSS.n759 17.0005
R2452 VSS.n1802 VSS.t529 17.0005
R2453 VSS.t529 VSS.n1801 17.0005
R2454 VSS.t529 VSS.n1797 17.0005
R2455 VSS.t529 VSS.n1785 17.0005
R2456 VSS.t529 VSS.n1786 17.0005
R2457 VSS.t529 VSS.n1787 17.0005
R2458 VSS.t529 VSS.n1788 17.0005
R2459 VSS.n241 VSS.t529 1.27287
R2460 VSS.n1790 VSS.t529 17.0005
R2461 VSS.n175 VSS.n242 1.27287
R2462 VSS.n175 VSS.n1791 17.0005
R2463 VSS.n175 VSS.n177 1.27287
R2464 VSS.n175 VSS.n758 17.0005
R2465 VSS.n175 VSS.n757 17.0005
R2466 VSS.n1809 VSS.t529 17.0005
R2467 VSS.n1807 VSS.t529 17.0005
R2468 VSS.n1805 VSS.t529 17.0005
R2469 VSS.n1568 VSS.n237 17.0005
R2470 VSS.n1666 VSS.n38 17.0005
R2471 VSS.n1683 VSS.n13 17.0005
R2472 VSS.n1684 VSS.n13 17.0005
R2473 VSS.n735 VSS.n285 2.58157
R2474 VSS.n292 VSS.n291 0.814001
R2475 VSS.n1601 VSS.n30 17.0005
R2476 VSS.n1602 VSS.n30 17.0005
R2477 VSS.n123 VSS.n1617 17.0005
R2478 VSS.n295 VSS.n71 0.966432
R2479 VSS.n1630 VSS.n47 17.0005
R2480 VSS.n1631 VSS.n47 17.0005
R2481 VSS.n118 VSS.n1736 17.0005
R2482 VSS.n119 VSS.n118 4.17804
R2483 VSS.n181 VSS.n182 1.79862
R2484 VSS.n69 VSS.n318 17.0005
R2485 VSS.n1515 VSS.n23 17.0005
R2486 VSS.n1516 VSS.n23 17.0005
R2487 VSS.n25 VSS.n26 0.00382219
R2488 VSS.n1764 VSS.n25 17.0005
R2489 VSS.n25 VSS.n1509 17.0005
R2490 VSS.n25 VSS.n1510 17.0005
R2491 VSS.n320 VSS.n724 17.0005
R2492 VSS.n320 VSS.n719 17.0005
R2493 VSS.n320 VSS.n723 17.0005
R2494 VSS.n320 VSS.n720 17.0005
R2495 VSS.n320 VSS.n722 17.0005
R2496 VSS.n320 VSS.n975 17.0005
R2497 VSS.n320 VSS.n721 17.0005
R2498 VSS.n1843 VSS.n320 17.0005
R2499 VSS.n18 VSS.n724 17.0005
R2500 VSS.n18 VSS.n719 17.0005
R2501 VSS.n18 VSS.n723 17.0005
R2502 VSS.n18 VSS.n964 17.0005
R2503 VSS.n18 VSS.n966 17.0005
R2504 VSS.n18 VSS.n720 17.0005
R2505 VSS.n18 VSS.n722 17.0005
R2506 VSS.n18 VSS.n971 17.0005
R2507 VSS.n18 VSS.n721 17.0005
R2508 VSS.n18 VSS.n1843 17.0005
R2509 VSS.n979 VSS.n322 17.0005
R2510 VSS.n1820 VSS.n322 17.0005
R2511 VSS.n1824 VSS.n322 17.0005
R2512 VSS.n1825 VSS.n322 17.0005
R2513 VSS.n1818 VSS.n322 17.0005
R2514 VSS.n979 VSS.n142 17.0005
R2515 VSS.n1825 VSS.n142 17.0005
R2516 VSS.n1818 VSS.n142 17.0005
R2517 VSS.n237 VSS.t486 17.0005
R2518 VSS.n237 VSS.n256 17.0005
R2519 VSS.n237 VSS.n251 17.0005
R2520 VSS.n237 VSS.n255 17.0005
R2521 VSS.n237 VSS.n252 17.0005
R2522 VSS.n237 VSS.n254 17.0005
R2523 VSS.n237 VSS.n253 17.0005
R2524 VSS.n1573 VSS.n28 17.0005
R2525 VSS.n28 VSS.n256 17.0005
R2526 VSS.n28 VSS.n251 17.0005
R2527 VSS.n28 VSS.n255 17.0005
R2528 VSS.n28 VSS.n252 17.0005
R2529 VSS.n28 VSS.n254 17.0005
R2530 VSS.n28 VSS.n253 17.0005
R2531 VSS.n222 VSS.n713 17.0005
R2532 VSS.n222 VSS.n708 17.0005
R2533 VSS.n222 VSS.n712 17.0005
R2534 VSS.n222 VSS.t543 17.0005
R2535 VSS.n222 VSS.n711 17.0005
R2536 VSS.n222 VSS.n709 17.0005
R2537 VSS.n367 VSS.n713 17.0005
R2538 VSS.n367 VSS.n708 17.0005
R2539 VSS.n367 VSS.n712 17.0005
R2540 VSS.n367 VSS.t543 17.0005
R2541 VSS.n367 VSS.n711 17.0005
R2542 VSS.n367 VSS.n709 17.0005
R2543 VSS.n367 VSS.n1845 17.0005
R2544 VSS.n746 VSS.n380 17.0005
R2545 VSS.n754 VSS.n380 17.0005
R2546 VSS.n747 VSS.n380 17.0005
R2547 VSS.n380 VSS.n707 17.0005
R2548 VSS.t644 VSS.n380 17.0005
R2549 VSS.n744 VSS.n380 17.0005
R2550 VSS.n749 VSS.n380 17.0005
R2551 VSS.n750 VSS.n380 17.0005
R2552 VSS.n225 VSS.n746 17.0005
R2553 VSS.n225 VSS.n707 17.0005
R2554 VSS.n225 VSS.n749 17.0005
R2555 VSS.n225 VSS.n750 17.0005
R2556 VSS.n225 VSS.n751 17.0005
R2557 VSS.n696 VSS.n699 17.0005
R2558 VSS.n696 VSS.n703 17.0005
R2559 VSS.n696 VSS.n700 17.0005
R2560 VSS.n696 VSS.t546 17.0005
R2561 VSS.n696 VSS.n701 17.0005
R2562 VSS.n696 VSS.n698 17.0005
R2563 VSS.n696 VSS.n702 17.0005
R2564 VSS.n384 VSS.n699 17.0005
R2565 VSS.n384 VSS.n703 17.0005
R2566 VSS.n384 VSS.n700 17.0005
R2567 VSS.n384 VSS.t546 17.0005
R2568 VSS.n384 VSS.n701 17.0005
R2569 VSS.n384 VSS.n698 17.0005
R2570 VSS.n384 VSS.n702 17.0005
R2571 VSS.n760 VSS.n68 17.0005
R2572 VSS.n761 VSS.n68 17.0005
R2573 VSS.n762 VSS.n68 17.0005
R2574 VSS.t1204 VSS.n68 17.0005
R2575 VSS.n764 VSS.n68 17.0005
R2576 VSS.n765 VSS.n68 17.0005
R2577 VSS.n766 VSS.n68 17.0005
R2578 VSS.n364 VSS.n760 17.0005
R2579 VSS.n364 VSS.n761 17.0005
R2580 VSS.n364 VSS.n762 17.0005
R2581 VSS.t1204 VSS.n364 17.0005
R2582 VSS.n364 VSS.n764 17.0005
R2583 VSS.n364 VSS.n765 17.0005
R2584 VSS.n364 VSS.n766 17.0005
R2585 VSS.n145 VSS.n952 17.0005
R2586 VSS.n145 VSS.n956 17.0005
R2587 VSS.n145 VSS.n953 17.0005
R2588 VSS.n145 VSS.n690 17.0005
R2589 VSS.n145 VSS.n689 17.0005
R2590 VSS.n145 VSS.n688 17.0005
R2591 VSS.n145 VSS.n954 17.0005
R2592 VSS.n235 VSS.n232 0.259251
R2593 VSS.n232 VSS.n687 1.45438
R2594 VSS.n234 VSS.n688 6.32111
R2595 VSS.n232 VSS.n233 1.45453
R2596 VSS.n1955 VSS.n404 17.0005
R2597 VSS.n1961 VSS.n409 17.0005
R2598 VSS.n409 VSS.n681 17.0005
R2599 VSS.t1077 VSS.n409 17.0005
R2600 VSS.n1964 VSS.n409 17.0005
R2601 VSS.n474 VSS.n498 5.62715
R2602 VSS.n162 VSS.n1910 17.0005
R2603 VSS.n162 VSS.n1929 17.0005
R2604 VSS.n162 VSS.n1911 17.0005
R2605 VSS.n162 VSS.n1916 17.0005
R2606 VSS.n162 VSS.n1912 17.0005
R2607 VSS.n162 VSS.n1915 17.0005
R2608 VSS.n162 VSS.n1914 17.0005
R2609 VSS.n1970 VSS.n959 17.0005
R2610 VSS.t69 VSS.n999 17.0005
R2611 VSS.t69 VSS.n1000 17.0005
R2612 VSS.t69 VSS.n1481 17.0005
R2613 VSS.n1480 VSS.t69 17.0005
R2614 VSS.t69 VSS.n1001 17.0005
R2615 VSS.t125 VSS.n1499 17.0005
R2616 VSS.t125 VSS.n995 17.0005
R2617 VSS.t125 VSS.n1485 17.0005
R2618 VSS.t125 VSS.n996 17.0005
R2619 VSS.t125 VSS.n1484 17.0005
R2620 VSS.t125 VSS.n1486 17.0005
R2621 VSS.t125 VSS.n1498 17.0005
R2622 VSS.t125 VSS.n1490 17.0005
R2623 VSS.t125 VSS.n1491 17.0005
R2624 VSS.t125 VSS.n1497 17.0005
R2625 VSS.t125 VSS.n1492 17.0005
R2626 VSS.t125 VSS.n1493 17.0005
R2627 VSS.n1500 VSS.t125 17.0005
R2628 VSS.t125 VSS.n1496 17.0005
R2629 VSS.t125 VSS.n1495 17.0005
R2630 VSS.t125 VSS.n1494 17.0005
R2631 VSS.n1012 VSS.t518 17.0005
R2632 VSS.n1014 VSS.t518 17.0005
R2633 VSS.n1016 VSS.t518 17.0005
R2634 VSS.n1019 VSS.t518 17.0005
R2635 VSS.n1020 VSS.t518 17.0005
R2636 VSS.n1021 VSS.t518 17.0005
R2637 VSS.n1024 VSS.t518 17.0005
R2638 VSS.n1027 VSS.t518 17.0005
R2639 VSS.n1030 VSS.t518 17.0005
R2640 VSS.n1033 VSS.t518 17.0005
R2641 VSS.n1036 VSS.t518 17.0005
R2642 VSS.n1039 VSS.t518 17.0005
R2643 VSS.n1042 VSS.t518 17.0005
R2644 VSS.n1044 VSS.t518 17.0005
R2645 VSS.t515 VSS.n509 17.0005
R2646 VSS.t515 VSS.n1136 17.0005
R2647 VSS.t515 VSS.n1112 17.0005
R2648 VSS.t515 VSS.n1135 17.0005
R2649 VSS.t515 VSS.n1113 17.0005
R2650 VSS.t515 VSS.n1134 17.0005
R2651 VSS.t515 VSS.n1114 17.0005
R2652 VSS.t515 VSS.n1115 17.0005
R2653 VSS.t515 VSS.n1133 17.0005
R2654 VSS.t515 VSS.n1116 17.0005
R2655 VSS.t515 VSS.n1132 17.0005
R2656 VSS.t515 VSS.n1117 17.0005
R2657 VSS.t515 VSS.n1131 17.0005
R2658 VSS.t515 VSS.n1118 17.0005
R2659 VSS.t515 VSS.n1130 17.0005
R2660 VSS.t515 VSS.n1119 17.0005
R2661 VSS.t515 VSS.n1129 17.0005
R2662 VSS.t515 VSS.n1123 17.0005
R2663 VSS.t515 VSS.n1126 17.0005
R2664 VSS.t515 VSS.n1124 17.0005
R2665 VSS.t515 VSS.n1125 17.0005
R2666 VSS.n1137 VSS.t515 17.0005
R2667 VSS.n74 VSS.n1138 17.0005
R2668 VSS.n74 VSS.n1108 17.0005
R2669 VSS.n74 VSS.n1110 17.0005
R2670 VSS.n74 VSS.n1109 17.0005
R2671 VSS.n1139 VSS.n74 17.0005
R2672 VSS.n74 VSS.n1140 17.0005
R2673 VSS.n91 VSS.n74 0.649813
R2674 VSS.n74 VSS.n1107 17.0005
R2675 VSS.n74 VSS.n491 0.649813
R2676 VSS.n74 VSS.n1106 17.0005
R2677 VSS.n1141 VSS.n74 17.0005
R2678 VSS.n83 VSS.n1142 17.0005
R2679 VSS.n83 VSS.n1098 17.0005
R2680 VSS.n492 VSS.n83 0.649813
R2681 VSS.n83 VSS.n1099 17.0005
R2682 VSS.n84 VSS.n83 0.649813
R2683 VSS.n83 VSS.n1100 17.0005
R2684 VSS.n493 VSS.n83 0.649813
R2685 VSS.n83 VSS.n1101 17.0005
R2686 VSS.n473 VSS.n83 0.649813
R2687 VSS.n83 VSS.n1102 17.0005
R2688 VSS.n83 VSS.n1105 17.0005
R2689 VSS.n83 VSS.n1103 17.0005
R2690 VSS.n1104 VSS.n515 17.0005
R2691 VSS.n1054 VSS.t78 17.0005
R2692 VSS.n1055 VSS.t78 17.0005
R2693 VSS.n1056 VSS.t78 17.0005
R2694 VSS.n1057 VSS.t78 17.0005
R2695 VSS.n1058 VSS.t78 17.0005
R2696 VSS.n1060 VSS.t78 17.0005
R2697 VSS.n1061 VSS.t78 17.0005
R2698 VSS.n1062 VSS.t78 17.0005
R2699 VSS.n1064 VSS.t78 17.0005
R2700 VSS.n1065 VSS.t78 17.0005
R2701 VSS.n1067 VSS.t78 17.0005
R2702 VSS.n1070 VSS.t78 17.0005
R2703 VSS.n1071 VSS.t78 17.0005
R2704 VSS.n1072 VSS.t78 17.0005
R2705 VSS.n1074 VSS.t78 17.0005
R2706 VSS.n1075 VSS.t78 17.0005
R2707 VSS.n1076 VSS.t78 17.0005
R2708 VSS.n1077 VSS.t78 17.0005
R2709 VSS.n1078 VSS.t78 17.0005
R2710 VSS.n1079 VSS.t78 17.0005
R2711 VSS.n1080 VSS.t78 17.0005
R2712 VSS.n1081 VSS.t78 17.0005
R2713 VSS.n1082 VSS.t78 17.0005
R2714 VSS.n1084 VSS.t78 17.0005
R2715 VSS.n1085 VSS.t78 17.0005
R2716 VSS.n1087 VSS.t78 17.0005
R2717 VSS.n1088 VSS.t78 17.0005
R2718 VSS.t78 VSS.n1050 17.0005
R2719 VSS.t78 VSS.n1051 17.0005
R2720 VSS.n1092 VSS.t78 17.0005
R2721 VSS.n490 VSS.n1093 17.0005
R2722 VSS.n490 VSS.n1047 17.0005
R2723 VSS.n490 VSS.n1049 17.0005
R2724 VSS.n1048 VSS.n490 17.0005
R2725 VSS.n539 VSS.n490 0.00199992
R2726 VSS.n1413 VSS.n1412 17.0005
R2727 VSS.n1413 VSS.n1337 17.0005
R2728 VSS.n1413 VSS.n1410 17.0005
R2729 VSS.n1413 VSS.n1338 17.0005
R2730 VSS.n1413 VSS.n1408 17.0005
R2731 VSS.n1413 VSS.n1340 17.0005
R2732 VSS.n1413 VSS.n1406 17.0005
R2733 VSS.n1413 VSS.n1341 17.0005
R2734 VSS.n1413 VSS.n1405 17.0005
R2735 VSS.n1413 VSS.n1343 17.0005
R2736 VSS.n1413 VSS.n1404 17.0005
R2737 VSS.n1413 VSS.n1344 17.0005
R2738 VSS.n1413 VSS.n1345 17.0005
R2739 VSS.n1413 VSS.n1403 17.0005
R2740 VSS.n1413 VSS.n1346 17.0005
R2741 VSS.n1413 VSS.n1402 17.0005
R2742 VSS.n1413 VSS.n1347 17.0005
R2743 VSS.n1413 VSS.n1401 17.0005
R2744 VSS.n1413 VSS.n1400 17.0005
R2745 VSS.n1413 VSS.n1398 17.0005
R2746 VSS.n1413 VSS.n1352 17.0005
R2747 VSS.n1413 VSS.n1396 17.0005
R2748 VSS.n1413 VSS.n1355 17.0005
R2749 VSS.n1413 VSS.n1395 17.0005
R2750 VSS.n1413 VSS.n1356 17.0005
R2751 VSS.n1413 VSS.n1392 17.0005
R2752 VSS.n1413 VSS.n1357 17.0005
R2753 VSS.n1413 VSS.n1391 17.0005
R2754 VSS.n1413 VSS.n1358 17.0005
R2755 VSS.n1413 VSS.n1359 17.0005
R2756 VSS.n1413 VSS.n1388 17.0005
R2757 VSS.n1413 VSS.n1362 17.0005
R2758 VSS.n1413 VSS.n1387 17.0005
R2759 VSS.n1413 VSS.n1364 17.0005
R2760 VSS.n1413 VSS.n1365 17.0005
R2761 VSS.n1413 VSS.n1366 17.0005
R2762 VSS.n1413 VSS.n1383 17.0005
R2763 VSS.n1413 VSS.n1382 17.0005
R2764 VSS.n1413 VSS.n1369 17.0005
R2765 VSS.n1413 VSS.n1370 17.0005
R2766 VSS.n1413 VSS.n1379 17.0005
R2767 VSS.n1413 VSS.n1371 17.0005
R2768 VSS.n1413 VSS.n1377 17.0005
R2769 VSS.n1413 VSS.n1376 17.0005
R2770 VSS.n1413 VSS.n1373 17.0005
R2771 VSS.n1413 VSS.n1375 17.0005
R2772 VSS.t266 VSS.n1330 17.0005
R2773 VSS.t266 VSS.n1304 17.0005
R2774 VSS.t266 VSS.n1329 17.0005
R2775 VSS.t266 VSS.n1305 17.0005
R2776 VSS.t266 VSS.n1327 17.0005
R2777 VSS.t266 VSS.n1325 17.0005
R2778 VSS.t266 VSS.n1306 17.0005
R2779 VSS.t266 VSS.n1324 17.0005
R2780 VSS.t266 VSS.n1308 17.0005
R2781 VSS.t266 VSS.n1322 17.0005
R2782 VSS.t266 VSS.n1309 17.0005
R2783 VSS.t266 VSS.n1310 17.0005
R2784 VSS.n1319 VSS.t331 17.0005
R2785 VSS.n1316 VSS.t331 17.0005
R2786 VSS.n1315 VSS.t331 17.0005
R2787 VSS.n1314 VSS.t331 17.0005
R2788 VSS.n1312 VSS.t331 17.0005
R2789 VSS.n1311 VSS.t331 17.0005
R2790 VSS.t106 VSS.n1332 17.0005
R2791 VSS.t106 VSS.n472 0.648101
R2792 VSS.n1299 VSS.t106 17.0005
R2793 VSS.n468 VSS.n1334 17.0005
R2794 VSS.n468 VSS.n1298 17.0005
R2795 VSS.n1335 VSS.n468 17.0005
R2796 VSS.n469 VSS.n1145 17.0005
R2797 VSS.n469 VSS.n1297 17.0005
R2798 VSS.n469 VSS.n1146 17.0005
R2799 VSS.n469 VSS.n1296 17.0005
R2800 VSS.n469 VSS.n1147 17.0005
R2801 VSS.n469 VSS.n1295 17.0005
R2802 VSS.n469 VSS.n1148 17.0005
R2803 VSS.n469 VSS.n1294 17.0005
R2804 VSS.n469 VSS.n485 0.649813
R2805 VSS.n469 VSS.n1149 17.0005
R2806 VSS.n469 VSS.n1293 17.0005
R2807 VSS.n1291 VSS.n469 17.0005
R2808 VSS.n1290 VSS.n469 17.0005
R2809 VSS.n1289 VSS.n469 17.0005
R2810 VSS.n1288 VSS.n469 17.0005
R2811 VSS.n1287 VSS.n469 17.0005
R2812 VSS.n1285 VSS.n469 17.0005
R2813 VSS.n1284 VSS.n469 17.0005
R2814 VSS.n1283 VSS.n469 17.0005
R2815 VSS.n470 VSS.n469 0.649813
R2816 VSS.n469 VSS.n1150 17.0005
R2817 VSS.n469 VSS.n1282 17.0005
R2818 VSS.t109 VSS.n1263 17.0005
R2819 VSS.t109 VSS.n1279 17.0005
R2820 VSS.t109 VSS.n1264 17.0005
R2821 VSS.t109 VSS.n1278 17.0005
R2822 VSS.t109 VSS.n1265 17.0005
R2823 VSS.t109 VSS.n1277 17.0005
R2824 VSS.t109 VSS.n1266 17.0005
R2825 VSS.t109 VSS.n1276 17.0005
R2826 VSS.t109 VSS.n1267 17.0005
R2827 VSS.t109 VSS.n1275 17.0005
R2828 VSS.t109 VSS.n1274 17.0005
R2829 VSS.t109 VSS.n1268 17.0005
R2830 VSS.n1273 VSS.t109 17.0005
R2831 VSS.n1272 VSS.t109 17.0005
R2832 VSS.n1271 VSS.t109 17.0005
R2833 VSS.n1270 VSS.t109 17.0005
R2834 VSS.n1269 VSS.t109 17.0005
R2835 VSS.n484 VSS.n482 0.0271432
R2836 VSS.n1262 VSS.n482 17.0005
R2837 VSS.t31 VSS.t852 0.069885
R2838 VSS.n1261 VSS.t94 17.0005
R2839 VSS.n1260 VSS.t94 17.0005
R2840 VSS.n1259 VSS.t94 17.0005
R2841 VSS.n1257 VSS.t94 17.0005
R2842 VSS.n1256 VSS.t94 17.0005
R2843 VSS.n1254 VSS.t94 17.0005
R2844 VSS.n1241 VSS.t94 17.0005
R2845 VSS.n1251 VSS.t94 17.0005
R2846 VSS.n1250 VSS.t94 17.0005
R2847 VSS.n1249 VSS.t94 17.0005
R2848 VSS.n1248 VSS.t94 17.0005
R2849 VSS.n1246 VSS.t94 17.0005
R2850 VSS.n1245 VSS.t94 17.0005
R2851 VSS.n1244 VSS.t94 17.0005
R2852 VSS.n1242 VSS.t94 17.0005
R2853 VSS.n555 VSS.t1122 0.0682317
R2854 VSS.n1226 VSS.t606 17.0005
R2855 VSS.n1228 VSS.t606 17.0005
R2856 VSS.n1229 VSS.t606 17.0005
R2857 VSS.n1230 VSS.t606 17.0005
R2858 VSS.n1231 VSS.t606 17.0005
R2859 VSS.n1234 VSS.t606 17.0005
R2860 VSS.t606 VSS.n1235 17.0005
R2861 VSS.t606 VSS.n1152 17.0005
R2862 VSS.t606 VSS.n1225 17.0005
R2863 VSS.t606 VSS.n1224 17.0005
R2864 VSS.t606 VSS.n1153 17.0005
R2865 VSS.t606 VSS.n1154 17.0005
R2866 VSS.t606 VSS.n1155 17.0005
R2867 VSS.t606 VSS.n1223 17.0005
R2868 VSS.t606 VSS.n1222 17.0005
R2869 VSS.t606 VSS.n1156 17.0005
R2870 VSS.t606 VSS.n1221 17.0005
R2871 VSS.t606 VSS.n1157 17.0005
R2872 VSS.t606 VSS.n1169 17.0005
R2873 VSS.t606 VSS.n1159 17.0005
R2874 VSS.t606 VSS.n1168 17.0005
R2875 VSS.t606 VSS.n1160 17.0005
R2876 VSS.t606 VSS.n1167 17.0005
R2877 VSS.t606 VSS.n1161 17.0005
R2878 VSS.t606 VSS.n1162 17.0005
R2879 VSS.t606 VSS.n1166 17.0005
R2880 VSS.t606 VSS.n1163 17.0005
R2881 VSS.t606 VSS.n1165 17.0005
R2882 VSS.t606 VSS.n1164 17.0005
R2883 VSS.n1216 VSS.t193 17.0005
R2884 VSS.n1215 VSS.t193 17.0005
R2885 VSS.n1213 VSS.t193 17.0005
R2886 VSS.n1211 VSS.t193 17.0005
R2887 VSS.n1210 VSS.t193 17.0005
R2888 VSS.n561 VSS.n92 5.64879
R2889 VSS.t552 VSS.n1208 17.0005
R2890 VSS.t552 VSS.n1209 17.0005
R2891 VSS.n96 VSS.t552 0.666899
R2892 VSS.n432 VSS.t552 0.666899
R2893 VSS.t552 VSS.n1203 17.0005
R2894 VSS.t552 VSS.n1207 17.0005
R2895 VSS.t552 VSS.n1204 17.0005
R2896 VSS.t552 VSS.n1205 17.0005
R2897 VSS.t552 VSS.n1206 17.0005
R2898 VSS.n1217 VSS.t552 17.0005
R2899 VSS.n439 VSS.n1218 17.0005
R2900 VSS.n439 VSS.n440 0.649813
R2901 VSS.n439 VSS.n1194 17.0005
R2902 VSS.n439 VSS.n1202 17.0005
R2903 VSS.n439 VSS.n1195 17.0005
R2904 VSS.n439 VSS.n1201 17.0005
R2905 VSS.n439 VSS.n1196 17.0005
R2906 VSS.n439 VSS.n1200 17.0005
R2907 VSS.n439 VSS.n1197 17.0005
R2908 VSS.n1199 VSS.n355 17.0005
R2909 VSS.n357 VSS.n1198 17.0005
R2910 VSS.t393 VSS.n1007 17.0005
R2911 VSS.t393 VSS.n1003 17.0005
R2912 VSS.t393 VSS.n1006 17.0005
R2913 VSS.t393 VSS.n1004 17.0005
R2914 VSS.t393 VSS.n1005 17.0005
R2915 VSS.n1421 VSS.t393 17.0005
R2916 VSS.n1422 VSS.t393 17.0005
R2917 VSS.n1423 VSS.t393 17.0005
R2918 VSS.n1424 VSS.t393 17.0005
R2919 VSS.n1425 VSS.t393 17.0005
R2920 VSS.n1426 VSS.t393 17.0005
R2921 VSS.n1428 VSS.t393 17.0005
R2922 VSS.n1430 VSS.t393 17.0005
R2923 VSS.n1431 VSS.t393 17.0005
R2924 VSS.n1432 VSS.t393 17.0005
R2925 VSS.n1433 VSS.t393 17.0005
R2926 VSS.n1434 VSS.t393 17.0005
R2927 VSS.n1436 VSS.t393 17.0005
R2928 VSS.n1437 VSS.t393 17.0005
R2929 VSS.n1439 VSS.t393 17.0005
R2930 VSS.n1441 VSS.t393 17.0005
R2931 VSS.n1176 VSS.t151 17.0005
R2932 VSS.n1177 VSS.t151 17.0005
R2933 VSS.n1178 VSS.t151 17.0005
R2934 VSS.n1180 VSS.t151 17.0005
R2935 VSS.n1182 VSS.t151 17.0005
R2936 VSS.n1183 VSS.t151 17.0005
R2937 VSS.n1184 VSS.t151 17.0005
R2938 VSS.n1185 VSS.t151 17.0005
R2939 VSS.t151 VSS.n1172 17.0005
R2940 VSS.t151 VSS.n1175 17.0005
R2941 VSS.t151 VSS.n1173 17.0005
R2942 VSS.t151 VSS.n1174 17.0005
R2943 VSS.n98 VSS.n1187 17.0005
R2944 VSS.n100 VSS.n1171 17.0005
R2945 VSS.n100 VSS.n101 0.00196766
R2946 VSS.n352 VSS.n1170 17.0005
R2947 VSS.n352 VSS.n353 0.00196766
R2948 VSS.n424 VSS.n676 3.5091
R2949 VSS.n586 VSS.n585 1.32271
R2950 VSS.n669 VSS.n598 3.47023
R2951 VSS.n670 VSS.n885 17.0005
R2952 VSS.n670 VSS.n886 17.0005
R2953 VSS.n874 VSS.n869 17.0005
R2954 VSS.n154 VSS.n854 12.8817
R2955 VSS.n112 VSS.n111 4.17804
R2956 VSS.n348 VSS.n856 17.0005
R2957 VSS.n348 VSS.n857 17.0005
R2958 VSS.n801 VSS.n159 13.3072
R2959 VSS.n796 VSS.n158 17.0005
R2960 VSS.n795 VSS.n158 17.0005
R2961 VSS.n789 VSS.n158 17.0005
R2962 VSS.n786 VSS.n158 17.0005
R2963 VSS.n1946 VSS.n640 17.0005
R2964 VSS.n646 VSS.n640 2.60151
R2965 VSS.n640 VSS.n651 17.0005
R2966 VSS.n1906 VSS.n950 17.0005
R2967 VSS.n1952 VSS.n402 17.945
R2968 VSS.n1867 VSS.n1866 16.8958
R2969 VSS.n1859 VSS.n680 16.8958
R2970 VSS.n1856 VSS.n248 17.8309
R2971 VSS.n665 VSS.n154 2.41719
R2972 VSS.t1030 VSS.n240 28.5948
R2973 VSS.n1479 VSS.t1035 16.8046
R2974 VSS.n1451 VSS.t1040 16.8046
R2975 VSS.t1042 VSS.n1456 16.8046
R2976 VSS.n1470 VSS.n1461 16.8046
R2977 VSS.n1468 VSS.t1050 16.8046
R2978 VSS.t1055 VSS.n742 16.8046
R2979 VSS.n2003 VSS.t509 16.8046
R2980 VSS.n1816 VSS.n1814 16.7392
R2981 VSS.t556 VSS.n1311 16.6672
R2982 VSS.n870 VSS.n869 16.6159
R2983 VSS.n2010 VSS.t1204 16.4875
R2984 VSS.n802 VSS.n159 1.11229
R2985 VSS.n1606 VSS.n1605 16.3141
R2986 VSS.n1598 VSS.n1597 16.3141
R2987 VSS.n1668 VSS.n1667 16.2556
R2988 VSS.n1697 VSS.n1696 16.2556
R2989 VSS.n1549 VSS.n1548 16.2556
R2990 VSS.n1616 VSS.n1615 16.2556
R2991 VSS.n1647 VSS.n1646 16.2556
R2992 VSS.n1586 VSS.n1585 16.2556
R2993 VSS.n1729 VSS.n1728 16.2556
R2994 VSS.n1521 VSS.n1518 16.2556
R2995 VSS.n1669 VSS.n1668 16.2556
R2996 VSS.n1671 VSS.n1670 16.2556
R2997 VSS.n1672 VSS.n1671 16.2556
R2998 VSS.n1673 VSS.n1672 16.2556
R2999 VSS.n1696 VSS.n1695 16.2556
R3000 VSS.n1698 VSS.n1697 16.2556
R3001 VSS.n1700 VSS.n1699 16.2556
R3002 VSS.n1701 VSS.n1700 16.2556
R3003 VSS.n1545 VSS.n1544 16.2556
R3004 VSS.n1546 VSS.n1545 16.2556
R3005 VSS.n1548 VSS.n1547 16.2556
R3006 VSS.n1607 VSS.n1606 16.2556
R3007 VSS.n1605 VSS.n1604 16.2556
R3008 VSS.n1604 VSS.n1603 16.2556
R3009 VSS.n1600 VSS.n1599 16.2556
R3010 VSS.n1599 VSS.n1598 16.2556
R3011 VSS.n1615 VSS.n1614 16.2556
R3012 VSS.n1619 VSS.n1613 16.2556
R3013 VSS.n1620 VSS.n1619 16.2556
R3014 VSS.n1648 VSS.n1647 16.2556
R3015 VSS.n1650 VSS.n1649 16.2556
R3016 VSS.n1651 VSS.n1650 16.2556
R3017 VSS.n1585 VSS.n1584 16.2556
R3018 VSS.n1587 VSS.n1586 16.2556
R3019 VSS.n1589 VSS.n1588 16.2556
R3020 VSS.n1590 VSS.n1589 16.2556
R3021 VSS.n1591 VSS.n1590 16.2556
R3022 VSS.n1724 VSS.n728 17.9687
R3023 VSS.n1725 VSS.n1724 16.2556
R3024 VSS.n1726 VSS.n1725 16.2556
R3025 VSS.n1728 VSS.n1727 16.2556
R3026 VSS.n1523 VSS.n1520 16.2556
R3027 VSS.n1523 VSS.n1519 16.2556
R3028 VSS.n1522 VSS.n1518 16.2556
R3029 VSS.n1909 VSS.n1908 16.2556
R3030 VSS.t1164 VSS.n1784 16.235
R3031 VSS.n1577 VSS.n1575 16.1971
R3032 VSS.n1578 VSS.n1576 16.1971
R3033 VSS.n1715 VSS.n1714 16.1971
R3034 VSS.n1712 VSS.n1711 16.1971
R3035 VSS.n1709 VSS.n1708 16.1971
R3036 VSS.n1660 VSS.n731 16.1971
R3037 VSS.n1660 VSS.n1659 16.1971
R3038 VSS.n1659 VSS.n1576 16.1971
R3039 VSS.n1577 VSS.n1574 16.1971
R3040 VSS.n1579 VSS.n1574 16.1971
R3041 VSS.n1842 VSS.t438 16.1543
R3042 VSS.n669 VSS.n881 12.0164
R3043 VSS.n789 VSS.n788 16.1543
R3044 VSS.n1946 VSS.n343 7.51422
R3045 VSS.n1707 VSS.n1706 16.1378
R3046 VSS.n1713 VSS.n1712 16.1378
R3047 VSS.n1714 VSS.n1713 16.1378
R3048 VSS.n1710 VSS.n1709 16.1378
R3049 VSS.n1708 VSS.n1707 16.1378
R3050 VSS.n1759 VSS.n1758 16.0785
R3051 VSS.n1756 VSS.n1755 16.0785
R3052 VSS.n1689 VSS.n1688 16.0785
R3053 VSS.n1688 VSS.n1687 16.0785
R3054 VSS.n1680 VSS.n1679 16.0785
R3055 VSS.n1679 VSS.n1678 16.0785
R3056 VSS.n1756 VSS.n1754 16.0785
R3057 VSS.n1754 VSS.n1517 16.0785
R3058 VSS.n1758 VSS.n1514 16.0785
R3059 VSS.n1759 VSS.n1757 16.0785
R3060 VSS.n1763 VSS.n725 16.0785
R3061 VSS.n725 VSS.n1511 16.0785
R3062 VSS.n1512 VSS.n1511 16.0785
R3063 VSS.n1513 VSS.n1508 16.0785
R3064 VSS.n1508 VSS.n726 16.0785
R3065 VSS.n1690 VSS.n1689 16.0185
R3066 VSS.n1687 VSS.n1686 16.0185
R3067 VSS.n1686 VSS.n1685 16.0185
R3068 VSS.n1682 VSS.n1681 16.0185
R3069 VSS.n1681 VSS.n1680 16.0185
R3070 VSS.n1755 VSS.n70 18.0013
R3071 VSS.n1891 VSS.n1890 15.9584
R3072 VSS.n1892 VSS.n1891 15.9584
R3073 VSS.n1893 VSS.n1892 15.9584
R3074 VSS.n1894 VSS.n1893 15.9584
R3075 VSS.n1896 VSS.n1895 15.9584
R3076 VSS.n1897 VSS.n1896 15.9584
R3077 VSS.n1898 VSS.n1897 15.9584
R3078 VSS.n1899 VSS.n1898 15.9584
R3079 VSS.n1900 VSS.n1899 15.9584
R3080 VSS.n721 VSS.t543 15.9236
R3081 VSS.n722 VSS.n708 15.9236
R3082 VSS.n1602 VSS.t427 15.894
R3083 VSS.n1800 VSS.n1798 15.8785
R3084 VSS.n2006 VSS.n757 15.8534
R3085 VSS.n1635 VSS.n1634 15.8366
R3086 VSS.n1634 VSS.n1633 15.8366
R3087 VSS.n1633 VSS.n1632 15.8366
R3088 VSS.n1629 VSS.n1628 15.8366
R3089 VSS.n1628 VSS.n1627 15.8366
R3090 VSS.n1627 VSS.n1626 15.8366
R3091 VSS.n1537 VSS.n1536 15.7131
R3092 VSS.n1535 VSS.n1534 15.7131
R3093 VSS.n1533 VSS.n1532 15.7131
R3094 VSS.n1742 VSS.n1735 15.7131
R3095 VSS.n1530 VSS.n1529 15.7131
R3096 VSS.n1531 VSS.n1530 15.7131
R3097 VSS.n1532 VSS.n1531 15.7131
R3098 VSS.n1536 VSS.n1535 15.7131
R3099 VSS.n1744 VSS.n1737 15.7131
R3100 VSS.n1743 VSS.n1737 15.7131
R3101 VSS.n1743 VSS.n1738 15.7131
R3102 VSS.n1741 VSS.n1735 15.7131
R3103 VSS.n1741 VSS.n1739 15.7131
R3104 VSS.n716 VSS.n724 15.6928
R3105 VSS.n1950 VSS.n1949 15.6747
R3106 VSS.n1866 VSS.n1865 15.6747
R3107 VSS.n1966 VSS.n1965 15.6747
R3108 VSS.n1862 VSS.n1859 15.6747
R3109 VSS.n1864 VSS.n1861 15.6747
R3110 VSS.n1855 VSS.n1853 15.6747
R3111 VSS.n1954 VSS.n1952 15.6747
R3112 VSS.n1954 VSS.n1953 15.6747
R3113 VSS.n1951 VSS.n1950 15.6747
R3114 VSS.n1949 VSS.n1948 15.6747
R3115 VSS.n1967 VSS.n1966 15.6747
R3116 VSS.n1864 VSS.n679 17.3915
R3117 VSS.n1863 VSS.n1861 15.6747
R3118 VSS.n1862 VSS.n1860 15.6747
R3119 VSS.n678 VSS.n1853 15.6747
R3120 VSS.n1855 VSS.n1852 15.6747
R3121 VSS.n1854 VSS.n1851 15.6747
R3122 VSS.n1856 VSS.n1851 15.6747
R3123 VSS.t192 VSS.n1008 15.6255
R3124 VSS.n1458 VSS.n1454 15.5363
R3125 VSS.n1684 VSS.t1197 15.4644
R3126 VSS.t427 VSS.n1601 15.4644
R3127 VSS.n1516 VSS.t219 15.4644
R3128 VSS.n1510 VSS.t222 15.4644
R3129 VSS.n1843 VSS.n711 15.462
R3130 VSS.n720 VSS.n713 15.462
R3131 VSS.n981 VSS.n719 15.462
R3132 VSS.n2014 VSS.n707 15.2193
R3133 VSS.n707 VSS.n738 15.2193
R3134 VSS.t1197 VSS.n1683 15.0349
R3135 VSS.n1631 VSS.t255 15.0349
R3136 VSS.t219 VSS.n1515 15.0349
R3137 VSS.t222 VSS.n1509 15.0349
R3138 VSS.n1798 VSS.t370 15.0011
R3139 VSS.n1844 VSS.n709 15.0005
R3140 VSS.n1820 VSS.n980 15.0005
R3141 VSS.n1833 VSS.n979 15.0005
R3142 VSS.n1458 VSS.n1453 14.9022
R3143 VSS.n982 VSS.n723 14.7697
R3144 VSS.n1663 VSS.n1573 14.7697
R3145 VSS.t255 VSS.n1630 14.6053
R3146 VSS.n983 VSS.n964 14.539
R3147 VSS.n1068 VSS.t188 14.3531
R3148 VSS.n1799 VSS.t1191 14.2681
R3149 VSS.n1796 VSS.t270 13.7631
R3150 VSS.n1795 VSS.t658 13.7631
R3151 VSS.n1794 VSS.t591 13.7631
R3152 VSS.t220 VSS.n1721 13.6405
R3153 VSS.t1045 VSS.n1452 13.634
R3154 VSS.t1065 VSS.n1999 13.634
R3155 VSS.t1069 VSS.n1791 13.634
R3156 VSS.n235 VSS.n952 13.6501
R3157 VSS.n1572 VSS.n227 13.6068
R3158 VSS.n1825 VSS.n1819 13.3851
R3159 VSS.t422 VSS.n1784 13.3407
R3160 VSS.n2009 VSS.n2004 13.3169
R3161 VSS.n1818 VSS.n1817 13.1543
R3162 VSS.n1826 VSS.n1824 13.1543
R3163 VSS.n1445 VSS.t1027 12.9999
R3164 VSS.n1448 VSS.t1037 12.9999
R3165 VSS.n263 VSS.t1047 12.9999
R3166 VSS.t1052 VSS.n740 12.9999
R3167 VSS.n2004 VSS.t1062 12.9999
R3168 VSS.t1147 VSS.n1808 12.9486
R3169 VSS.n1129 VSS.n1127 12.8945
R3170 VSS.t1101 VSS.t534 12.8945
R3171 VSS.n1947 VSS.n651 12.8871
R3172 VSS.t655 VSS.n1113 12.8576
R3173 VSS.n1135 VSS.t498 12.8576
R3174 VSS.t352 VSS.n1077 12.8576
R3175 VSS.n1406 VSS.t500 12.8576
R3176 VSS.t180 VSS.n1340 12.8576
R3177 VSS.n1408 VSS.t505 12.8576
R3178 VSS.t651 VSS.n1338 12.8576
R3179 VSS.n1275 VSS.t378 12.8576
R3180 VSS.n11 VSS.n917 13.6761
R3181 VSS.n903 VSS.n902 12.8313
R3182 VSS.n2 VSS.n907 4.52904
R3183 VSS.n1088 VSS.t301 12.5005
R3184 VSS.t207 VSS.n1241 12.5005
R3185 VSS.n1484 VSS.t169 12.5005
R3186 VSS.n939 VSS.n938 12.3456
R3187 VSS.n866 VSS.n865 12.3456
R3188 VSS.n842 VSS.n841 12.3456
R3189 VSS.n1984 VSS.n1983 12.3456
R3190 VSS.n247 VSS.n1939 13.2724
R3191 VSS.n1934 VSS.n653 13.0949
R3192 VSS.n807 VSS.n806 12.2896
R3193 VSS.n763 VSS.n418 12.0487
R3194 VSS.n1564 VSS.n256 12.0005
R3195 VSS.n395 VSS.t238 11.9462
R3196 VSS.n360 VSS.t244 11.9452
R3197 VSS.n195 VSS.t240 11.9451
R3198 VSS.t245 VSS.n1881 11.9451
R3199 VSS.n683 VSS.t245 11.9076
R3200 VSS.t240 VSS.n197 11.9093
R3201 VSS.n674 VSS.n928 12.8805
R3202 VSS.n677 VSS.n826 12.5925
R3203 VSS.n921 VSS.n675 11.8468
R3204 VSS.n1450 VSS.n1449 11.8358
R3205 VSS.t244 VSS.n359 11.8339
R3206 VSS.t238 VSS.n394 11.8336
R3207 VSS.n1467 VSS.n699 11.7316
R3208 VSS.n1797 VSS.t420 11.7316
R3209 VSS.n1801 VSS.t582 11.6987
R3210 VSS.n957 VSS.n953 11.6456
R3211 VSS.n956 VSS.n955 11.6456
R3212 VSS.n690 VSS.n233 6.32111
R3213 VSS.n234 VSS.n954 12.6418
R3214 VSS.n955 VSS.n952 11.6456
R3215 VSS.n957 VSS.n956 11.6456
R3216 VSS.n193 VSS.t1099 6.87072
R3217 VSS.n1320 VSS.t1105 11.539
R3218 VSS.n749 VSS.n739 11.4146
R3219 VSS.n2011 VSS.n746 11.4146
R3220 VSS.n769 VSS.t251 11.4146
R3221 VSS.n1562 VSS.n251 11.3082
R3222 VSS.n859 VSS.n849 11.2662
R3223 VSS.n854 VSS.n853 11.2662
R3224 VSS.n1822 VSS.n1821 11.2144
R3225 VSS.n938 VSS.n937 11.2144
R3226 VSS.n934 VSS.n933 11.2144
R3227 VSS.n917 VSS.n916 11.2144
R3228 VSS.n902 VSS.n901 11.2144
R3229 VSS.n898 VSS.n897 11.2144
R3230 VSS.n872 VSS.n866 11.2144
R3231 VSS.n868 VSS.n867 11.2144
R3232 VSS.n855 VSS.n853 11.2144
R3233 VSS.n858 VSS.n851 11.2144
R3234 VSS.n841 VSS.n840 11.2144
R3235 VSS.n837 VSS.n836 11.2144
R3236 VSS.n1983 VSS.n1982 11.2144
R3237 VSS.n1979 VSS.n1978 11.2144
R3238 VSS.n1935 VSS.n1934 11.2144
R3239 VSS.n933 VSS.n63 13.0942
R3240 VSS.n935 VSS.n934 11.2144
R3241 VSS.n937 VSS.n936 11.2144
R3242 VSS.n913 VSS.n912 11.2144
R3243 VSS.n914 VSS.n913 11.2144
R3244 VSS.n916 VSS.n915 11.2144
R3245 VSS.n897 VSS.n896 11.2144
R3246 VSS.n899 VSS.n898 11.2144
R3247 VSS.n901 VSS.n900 11.2144
R3248 VSS.n871 VSS.n867 11.2144
R3249 VSS.n873 VSS.n872 11.2144
R3250 VSS.n859 VSS.n850 11.2144
R3251 VSS.n858 VSS.n849 11.2144
R3252 VSS.n855 VSS.n852 11.2144
R3253 VSS.n836 VSS.n661 13.2654
R3254 VSS.n838 VSS.n837 11.2144
R3255 VSS.n840 VSS.n839 11.2144
R3256 VSS.n1978 VSS.n657 12.8251
R3257 VSS.n1980 VSS.n1979 11.2144
R3258 VSS.n1982 VSS.n1981 11.2144
R3259 VSS.n1936 VSS.n1935 11.2144
R3260 VSS.n1938 VSS.n1937 11.2144
R3261 VSS.n1939 VSS.n1938 11.2144
R3262 VSS.t530 VSS.n1804 11.1874
R3263 VSS.n1926 VSS.n1910 11.186
R3264 VSS.n810 VSS.n809 11.1626
R3265 VSS.n816 VSS.n815 11.1626
R3266 VSS.n1 VSS.t1232 9.73855
R3267 VSS.n813 VSS.n812 11.1626
R3268 VSS.n808 VSS.n807 11.1103
R3269 VSS.n814 VSS.n813 11.1103
R3270 VSS.n815 VSS.n614 11.1103
R3271 VSS.n816 VSS.n814 11.1103
R3272 VSS.n811 VSS.n810 11.1103
R3273 VSS.n809 VSS.n808 11.1103
R3274 VSS.n800 VSS.n799 11.058
R3275 VSS.n791 VSS.n790 11.058
R3276 VSS.n792 VSS.n791 11.058
R3277 VSS.n801 VSS.n800 11.058
R3278 VSS.n976 VSS.n965 11.0052
R3279 VSS.n973 VSS.n965 11.0052
R3280 VSS.n793 VSS.n792 11.0052
R3281 VSS.n794 VSS.n793 11.0052
R3282 VSS.n798 VSS.n797 11.0052
R3283 VSS.n799 VSS.n798 11.0052
R3284 VSS.n1991 VSS.n775 11.0005
R3285 VSS.n1555 VSS.n250 10.9524
R3286 VSS.n1558 VSS.n1557 10.9524
R3287 VSS.n1558 VSS.n1556 10.9524
R3288 VSS.n1565 VSS.n1556 10.9524
R3289 VSS.n1565 VSS.n1555 10.9524
R3290 VSS.n1561 VSS.n255 10.8467
R3291 VSS.n883 VSS.n882 10.8459
R3292 VSS.n890 VSS.n889 10.8459
R3293 VSS.n668 VSS.n890 12.439
R3294 VSS.n889 VSS.n888 10.8459
R3295 VSS.n888 VSS.n887 10.8459
R3296 VSS.n884 VSS.n883 10.8459
R3297 VSS.n882 VSS.n881 10.8459
R3298 VSS.n2005 VSS.n756 10.7805
R3299 VSS.n832 VSS.n826 10.7383
R3300 VSS.n828 VSS.n827 10.7383
R3301 VSS.n830 VSS.n829 10.7383
R3302 VSS.n922 VSS.n921 10.7383
R3303 VSS.n924 VSS.n923 10.7383
R3304 VSS.n928 VSS.n927 10.7383
R3305 VSS.n830 VSS.n828 10.7383
R3306 VSS.n833 VSS.n831 10.7383
R3307 VSS.n833 VSS.n832 10.7383
R3308 VSS.n927 VSS.n926 10.7383
R3309 VSS.n926 VSS.n925 10.7383
R3310 VSS.n923 VSS.n922 10.7383
R3311 VSS.n944 VSS.n774 10.1922
R3312 VSS.n1560 VSS.n252 10.1543
R3313 VSS.n1467 VSS.n1464 10.1463
R3314 VSS.n750 VSS.n739 10.1463
R3315 VSS.n2012 VSS.n2011 10.1463
R3316 VSS.n1928 VSS.n1910 9.93141
R3317 VSS.n770 VSS.n758 9.91764
R3318 VSS.t210 VSS.n254 9.69281
R3319 VSS.n985 VSS.n715 4.50112
R3320 VSS.n1804 VSS.t1209 9.50978
R3321 VSS.n1947 VSS.n1946 9.23127
R3322 VSS.n1559 VSS.n253 9.0005
R3323 VSS.t539 VSS.n369 8.90387
R3324 VSS.n1446 VSS.n1445 8.87812
R3325 VSS.n1478 VSS.n1477 8.87812
R3326 VSS.n764 VSS.n763 8.87812
R3327 VSS.n1792 VSS.n1791 8.87812
R3328 VSS.n1916 VSS.t1098 8.82403
R3329 VSS.n1915 VSS.t1097 8.82403
R3330 VSS.n1921 VSS.n1913 8.72176
R3331 VSS.n1924 VSS.n1913 8.72176
R3332 VSS.t583 VSS.n1805 8.66994
R3333 VSS.t434 VSS.n462 0.826469
R3334 VSS.n1248 VSS.t571 8.59649
R3335 VSS.n1395 VSS.t1251 8.57193
R3336 VSS.n1329 VSS.t328 8.57193
R3337 VSS.n701 VSS.t1170 8.56106
R3338 VSS.t251 VSS.n762 8.56106
R3339 VSS.n1572 VSS.n714 8.53896
R3340 VSS.n857 VSS.t389 8.53896
R3341 VSS.n528 VSS.t186 8.50753
R3342 VSS.t919 VSS.t393 8.50225
R3343 VSS.t1084 VSS.t125 8.50175
R3344 VSS.n1927 VSS.n1921 8.50125
R3345 VSS.n270 VSS.n175 2.3151
R3346 VSS.n269 VSS.t1063 0.130189
R3347 VSS.t1061 VSS.n176 8.501
R3348 VSS.n267 VSS.t1058 0.130189
R3349 VSS.n265 VSS.n176 2.33238
R3350 VSS.t1051 VSS.n176 8.501
R3351 VSS.n264 VSS.t1048 0.130189
R3352 VSS.t1046 VSS.n174 8.501
R3353 VSS.n261 VSS.t1043 0.130189
R3354 VSS.t1041 VSS.n174 8.501
R3355 VSS.n260 VSS.t1038 0.130189
R3356 VSS.t1036 VSS.n173 8.501
R3357 VSS.n259 VSS.t1033 0.130189
R3358 VSS.t1031 VSS.n239 8.501
R3359 VSS.n239 VSS.n258 3.33079
R3360 VSS.t529 VSS.n273 0.609758
R3361 VSS.t1072 VSS.n272 0.130189
R3362 VSS.n175 VSS.t1070 8.501
R3363 VSS.t510 VSS.n271 0.130189
R3364 VSS.n1664 VSS.n40 2.12586
R3365 VSS.n38 VSS.n131 0.00344956
R3366 VSS.n1691 VSS.n168 1.70076
R3367 VSS.n14 VSS.n13 0.536829
R3368 VSS.n281 VSS.n280 0.00189268
R3369 VSS.n50 VSS.n1702 2.42951
R3370 VSS.n1702 VSS.n736 2.53447
R3371 VSS.n1716 VSS.n735 4.63058
R3372 VSS.n203 VSS.n202 0.00244386
R3373 VSS.n1717 VSS.n194 2.83422
R3374 VSS.n5 VSS.n1551 2.12566
R3375 VSS.n1608 VSS.n167 1.70076
R3376 VSS.n292 VSS.n1609 1.50062
R3377 VSS.n1641 VSS.n295 1.70846
R3378 VSS.n1644 VSS.n732 3.40102
R3379 VSS.n1652 VSS.n172 2.42951
R3380 VSS.n1582 VSS.n171 2.42931
R3381 VSS.n1583 VSS.n166 1.70076
R3382 VSS.n302 VSS.n218 0.00444956
R3383 VSS.n218 VSS.n217 0.00254946
R3384 VSS.n305 VSS.n304 0.00210658
R3385 VSS.n730 VSS.n59 1.85816
R3386 VSS.n1723 VSS.n728 3.27123
R3387 VSS.n139 VSS.n1731 2.12566
R3388 VSS.n309 VSS.n1740 1.28536
R3389 VSS.n308 VSS.n307 0.716881
R3390 VSS.n1760 VSS.n24 1.54824
R3391 VSS.n1761 VSS.n25 1.88956
R3392 VSS.n1844 VSS.n49 1.54513
R3393 VSS.n115 VSS.n320 0.00431652
R3394 VSS.n164 VSS.n1834 1.54557
R3395 VSS.n164 VSS.n142 0.00332553
R3396 VSS.n28 VSS.n321 0.00191226
R3397 VSS.n970 VSS.n222 3.40086
R3398 VSS.n715 VSS.n370 0.0498085
R3399 VSS.n231 VSS.n230 0.00185757
R3400 VSS.n1564 VSS.n231 1.547
R3401 VSS.n1846 VSS.n73 1.70083
R3402 VSS.n380 VSS.n376 0.00274942
R3403 VSS.n200 VSS.n201 0.00322575
R3404 VSS.n2012 VSS.n376 2.12578
R3405 VSS.n1476 VSS.n696 1.54616
R3406 VSS.n67 VSS.n65 0.00209045
R3407 VSS.n696 VSS.n704 0.00166635
R3408 VSS.n704 VSS.n705 0.0016189
R3409 VSS.n2009 VSS.n68 2.12591
R3410 VSS.n2006 VSS.n694 2.12602
R3411 VSS.n2003 VSS.n414 1.54729
R3412 VSS.n687 VSS.n686 17.9665
R3413 VSS.n1876 VSS.n212 1.54737
R3414 VSS.n212 VSS.n393 3.30938
R3415 VSS.n1879 VSS.n362 1.54737
R3416 VSS.n683 VSS.n1882 2.01564
R3417 VSS.n193 VSS.n192 0.00428833
R3418 VSS.n1957 VSS.n204 3.40102
R3419 VSS.n1957 VSS.n402 1.69027
R3420 VSS.n403 VSS.n214 0.00344956
R3421 VSS.n215 VSS.n214 0.00254946
R3422 VSS.n1868 VSS.n409 8.501
R3423 VSS.n411 VSS.n409 0.00214255
R3424 VSS.n1868 VSS.n682 2.42951
R3425 VSS.n682 VSS.n224 0.00271416
R3426 VSS.n1869 VSS.n423 2.12562
R3427 VSS.n1869 VSS.n679 3.19512
R3428 VSS.n1870 VSS.n199 1.88946
R3429 VSS.n1872 VSS.n497 2.83428
R3430 VSS.n453 VSS.n474 0.00199986
R3431 VSS.n497 VSS.n184 0.00299992
R3432 VSS.n162 VSS.n642 0.0019165
R3433 VSS.t1026 VSS.n499 0.185022
R3434 VSS.n1483 VSS.t125 8.501
R3435 VSS.n510 VSS.t515 0.826863
R3436 VSS.t485 VSS.n500 0.238281
R3437 VSS.n524 VSS.n74 3.33079
R3438 VSS.n523 VSS.n74 2.31585
R3439 VSS.n522 VSS.n74 2.31585
R3440 VSS.n521 VSS.n83 2.31581
R3441 VSS.n520 VSS.n83 2.31585
R3442 VSS.n519 VSS.n83 2.31585
R3443 VSS.n518 VSS.n83 2.31585
R3444 VSS.n517 VSS.n83 3.33087
R3445 VSS.n83 VSS.t720 8.501
R3446 VSS.n516 VSS.n515 3.33079
R3447 VSS.t78 VSS.n1091 8.501
R3448 VSS.t784 VSS.n541 0.23168
R3449 VSS.t312 VSS.n540 0.129991
R3450 VSS.t780 VSS.n490 8.501
R3451 VSS.n538 VSS.n539 0.00179989
R3452 VSS.n537 VSS.n538 0.00177121
R3453 VSS.n536 VSS.n537 0.00176153
R3454 VSS.n478 VSS.n536 0.00212392
R3455 VSS.n534 VSS.n535 0.00170812
R3456 VSS.n533 VSS.n534 0.00172462
R3457 VSS.n532 VSS.n533 0.00173273
R3458 VSS.n476 VSS.n532 0.00209843
R3459 VSS.n530 VSS.n531 0.00170812
R3460 VSS.n529 VSS.n530 0.00172462
R3461 VSS.n527 VSS.n529 0.00173273
R3462 VSS.n528 VSS.n527 0.00213172
R3463 VSS.n452 VSS.t331 0.00333255
R3464 VSS.t45 VSS.n1301 8.501
R3465 VSS.n544 VSS.n543 0.0017999
R3466 VSS.n471 VSS.t844 0.0432886
R3467 VSS.n471 VSS.t106 4.23011
R3468 VSS.n546 VSS.t840 0.130189
R3469 VSS.t42 VSS.t106 8.501
R3470 VSS.t133 VSS.n468 8.501
R3471 VSS.t60 VSS.n549 0.70302
R3472 VSS.n548 VSS.n469 3.33087
R3473 VSS.n469 VSS.n547 1.09214
R3474 VSS.t50 VSS.n551 0.819453
R3475 VSS.n550 VSS.t857 0.215686
R3476 VSS.t56 VSS.n483 0.0836055
R3477 VSS.n481 VSS.t854 5.6463
R3478 VSS.n481 VSS.n8 0.00421672
R3479 VSS.n133 VSS.n9 3.32884
R3480 VSS.n480 VSS.t852 5.64493
R3481 VSS.t30 VSS.n450 4.25113
R3482 VSS.n1252 VSS.t94 8.501
R3483 VSS.t89 VSS.n122 1.21441
R3484 VSS.n555 VSS.n121 5.64548
R3485 VSS.t89 VSS.n554 1.54621
R3486 VSS.n554 VSS.n444 0.00318146
R3487 VSS.n446 VSS.n445 0.00283248
R3488 VSS.t89 VSS.n446 1.88933
R3489 VSS.t606 VSS.n556 0.321554
R3490 VSS.t425 VSS.n560 0.00258295
R3491 VSS.t371 VSS.n558 1.54634
R3492 VSS.t371 VSS.n562 1.88985
R3493 VSS.t368 VSS.n561 0.0296542
R3494 VSS.t552 VSS.t371 8.501
R3495 VSS.n572 VSS.t552 1.5323
R3496 VSS.t182 VSS.t552 8.501
R3497 VSS.t111 VSS.n571 0.393641
R3498 VSS.n570 VSS.n439 3.33079
R3499 VSS.t277 VSS.n569 0.762889
R3500 VSS.n439 VSS.t899 8.501
R3501 VSS.t896 VSS.n568 0.130189
R3502 VSS.t894 VSS.n355 8.501
R3503 VSS.t891 VSS.n567 0.130189
R3504 VSS.t889 VSS.n357 8.501
R3505 VSS.n566 VSS.n357 3.33079
R3506 VSS.n573 VSS.t393 0.365152
R3507 VSS.n582 VSS.t151 0.161345
R3508 VSS.t984 VSS.n581 0.0712474
R3509 VSS.t981 VSS.n580 0.130189
R3510 VSS.t979 VSS.n98 8.501
R3511 VSS.t976 VSS.n579 0.130189
R3512 VSS.t974 VSS.n98 8.501
R3513 VSS.t971 VSS.n578 0.130189
R3514 VSS.t969 VSS.n100 8.501
R3515 VSS.t966 VSS.n577 0.130189
R3516 VSS.t964 VSS.n100 8.501
R3517 VSS.t961 VSS.n576 0.130189
R3518 VSS.t959 VSS.n352 8.501
R3519 VSS.n575 VSS.n352 3.33079
R3520 VSS.n948 VSS.n676 3.23925
R3521 VSS.n948 VSS.n36 1.88963
R3522 VSS.n148 VSS.n834 2.42931
R3523 VSS.n148 VSS.n147 0.00185699
R3524 VSS.n834 VSS.n677 1.80658
R3525 VSS.n932 VSS.n20 2.42957
R3526 VSS.n940 VSS.n149 1.88956
R3527 VSS.n929 VSS.n33 3.40102
R3528 VSS.n929 VSS.n674 1.25276
R3529 VSS.n35 VSS.n930 1.89154
R3530 VSS.n911 VSS.n586 1.29281
R3531 VSS.n48 VSS.n907 2.12566
R3532 VSS.n895 VSS.n163 1.70097
R3533 VSS.n590 VSS.n152 0.00374982
R3534 VSS.n669 VSS.n892 3.29755
R3535 VSS.n668 VSS.n598 2.49752
R3536 VSS.n596 VSS.n595 0.00255521
R3537 VSS.n892 VSS.n596 1.88993
R3538 VSS.n602 VSS.n601 0.00189268
R3539 VSS.n864 VSS.n666 1.88989
R3540 VSS.n155 VSS.n348 0.00489974
R3541 VSS.n109 VSS.n665 2.12602
R3542 VSS.n608 VSS.n843 8.501
R3543 VSS.n835 VSS.n663 2.83433
R3544 VSS.n661 VSS.n608 1.56272
R3545 VSS.n843 VSS.n664 2.42951
R3546 VSS.n664 VSS.n604 0.00271416
R3547 VSS.n820 VSS.n629 3.40102
R3548 VSS.n820 VSS.n613 3.40102
R3549 VSS.n660 VSS.n659 1.88986
R3550 VSS.n628 VSS.n660 0.00244434
R3551 VSS.n1977 VSS.n622 2.12562
R3552 VSS.n1977 VSS.n657 2.39804
R3553 VSS.n618 VSS.n156 0.00238838
R3554 VSS.n1985 VSS.n156 1.88956
R3555 VSS.n627 VSS.n625 0.00237454
R3556 VSS.n159 VSS.n158 1.15402
R3557 VSS.n636 VSS.n633 0.00233308
R3558 VSS.n1933 VSS.n654 2.42967
R3559 VSS.n653 VSS.n636 1.90933
R3560 VSS.n1940 VSS.n633 2.83422
R3561 VSS.n640 VSS.n638 0.00233308
R3562 VSS.n342 VSS.n343 1.58254
R3563 VSS.n638 VSS.n652 2.83422
R3564 VSS.n646 VSS.n1902 4.60065
R3565 VSS.n1902 VSS.n649 1.88962
R3566 VSS.n649 VSS.n648 0.00166646
R3567 VSS.n648 VSS.n650 0.00159992
R3568 VSS.n1907 VSS.n45 3.40102
R3569 VSS.n1907 VSS.n644 3.4011
R3570 VSS.n232 VSS.n689 8.50158
R3571 VSS.n717 VSS.n982 8.5005
R3572 VSS.n717 VSS.n981 8.5005
R3573 VSS.n717 VSS.n716 8.5005
R3574 VSS.n375 VSS.n1819 8.5005
R3575 VSS.n375 VSS.n1817 8.5005
R3576 VSS.n1833 VSS.n370 8.5005
R3577 VSS.n230 VSS.n1562 8.5005
R3578 VSS.n230 VSS.n1561 8.5005
R3579 VSS.n230 VSS.n1560 8.5005
R3580 VSS.n230 VSS.t210 8.5005
R3581 VSS.n230 VSS.n1559 8.5005
R3582 VSS.n230 VSS.n714 8.5005
R3583 VSS.n210 VSS.n1465 8.5005
R3584 VSS.n210 VSS.n1464 8.5005
R3585 VSS.n210 VSS.n1463 8.5005
R3586 VSS.n210 VSS.n1462 8.5005
R3587 VSS.n210 VSS.n1461 8.5005
R3588 VSS.n1477 VSS.n210 8.5005
R3589 VSS.n210 VSS.n1460 8.5005
R3590 VSS.n210 VSS.n1459 8.5005
R3591 VSS.n210 VSS.n1458 8.5005
R3592 VSS.n210 VSS.n1457 8.5005
R3593 VSS.n413 VSS.n2001 8.5005
R3594 VSS.n413 VSS.n417 8.5005
R3595 VSS.n413 VSS.n2000 8.5005
R3596 VSS.n413 VSS.n1998 8.5005
R3597 VSS.n2005 VSS.n413 8.5005
R3598 VSS.n413 VSS.n769 8.5005
R3599 VSS.n413 VSS.n418 8.5005
R3600 VSS.n413 VSS.n768 8.5005
R3601 VSS.n1923 VSS.n1910 8.5005
R3602 VSS.n1923 VSS.n1916 8.5005
R3603 VSS.n1923 VSS.n1912 8.5005
R3604 VSS.n1923 VSS.n1915 8.5005
R3605 VSS.n1924 VSS.n1923 8.5005
R3606 VSS.n1927 VSS.n1912 8.5005
R3607 VSS.t108 VSS.t109 4.25075
R3608 VSS.n364 VSS.n365 4.1873
R3609 VSS.n210 VSS.n392 2.30524
R3610 VSS.n39 VSS.n38 4.18045
R3611 VSS.n1703 VSS.n50 8.47497
R3612 VSS.n1594 VSS.n302 8.47497
R3613 VSS.n1837 VSS.n322 8.47497
R3614 VSS.n905 VSS.n590 8.47497
R3615 VSS.n846 VSS.n608 8.47497
R3616 VSS.n623 VSS.n618 4.18045
R3617 VSS.n1930 VSS.n1906 8.47497
R3618 VSS.n28 VSS.n27 0.334632
R3619 VSS.n1675 VSS.n39 0.411918
R3620 VSS.n168 VSS.n274 2.29915
R3621 VSS.n64 VSS.n13 4.17786
R3622 VSS.n43 VSS.n42 0.557828
R3623 VSS.n279 VSS.n278 0.981665
R3624 VSS.n282 VSS.n280 3.30804
R3625 VSS.n276 VSS.n275 4.17786
R3626 VSS.n284 VSS.n202 3.30804
R3627 VSS.n285 VSS.n286 0.887801
R3628 VSS.n283 VSS.n194 4.17786
R3629 VSS.n167 VSS.n289 2.29915
R3630 VSS.n293 VSS.n220 0.889778
R3631 VSS.n1621 VSS.n219 8.47145
R3632 VSS.n294 VSS.n71 4.17786
R3633 VSS.n1653 VSS.n299 0.470395
R3634 VSS.n298 VSS.n172 3.30804
R3635 VSS.n1657 VSS.n170 0.33981
R3636 VSS.n1593 VSS.n303 0.992448
R3637 VSS.n303 VSS.n166 2.29915
R3638 VSS.n300 VSS.n217 3.30804
R3639 VSS.n313 VSS.n137 0.670732
R3640 VSS.n314 VSS.n310 4.18045
R3641 VSS.n317 VSS.n306 3.30804
R3642 VSS.n1525 VSS.n315 0.956043
R3643 VSS.n1841 VSS.n320 8.47145
R3644 VSS.n1836 VSS.n978 8.47145
R3645 VSS.n323 VSS.n322 1.20982
R3646 VSS.n165 VSS.n142 0.73565
R3647 VSS.n236 VSS.n1571 8.47145
R3648 VSS.n984 VSS.n371 8.47229
R3649 VSS.n370 VSS.n372 0.470207
R3650 VSS.n387 VSS.n231 4.18022
R3651 VSS.n379 VSS.n73 4.17744
R3652 VSS.n200 VSS.n383 3.3087
R3653 VSS.n381 VSS.n380 0.98958
R3654 VSS.n377 VSS.n378 2.72293
R3655 VSS.n378 VSS.n381 1.04955
R3656 VSS.n2002 VSS.n414 8.47243
R3657 VSS.n415 VSS.n2002 0.518713
R3658 VSS.n1878 VSS.n685 0.664292
R3659 VSS.n685 VSS.n362 4.17926
R3660 VSS.n419 VSS.n398 3.30804
R3661 VSS.n192 VSS.n190 1.4519
R3662 VSS.n405 VSS.n404 0.981131
R3663 VSS.n410 VSS.n409 1.20914
R3664 VSS.n408 VSS.n407 3.30738
R3665 VSS.n420 VSS.n106 5.62715
R3666 VSS.n198 VSS.n416 3.30738
R3667 VSS.n1857 VSS.n183 8.47145
R3668 VSS.n185 VSS.n184 0.73398
R3669 VSS.n37 VSS.n425 1.66718
R3670 VSS.n946 VSS.n424 8.47145
R3671 VSS.n37 VSS.n36 0.476476
R3672 VSS.n22 VSS.n21 3.31014
R3673 VSS.n584 VSS.n583 4.17786
R3674 VSS.n587 VSS.n585 4.17786
R3675 VSS.n0 VSS.n4 0.170782
R3676 VSS.n17 VSS.n16 0.671092
R3677 VSS.n591 VSS.n163 3.30804
R3678 VSS.n594 VSS.n592 3.30804
R3679 VSS.n598 VSS.n600 0.896826
R3680 VSS.n599 VSS.n595 4.17786
R3681 VSS.n878 VSS.n597 8.47145
R3682 VSS.n879 VSS.n671 8.47145
R3683 VSS.n189 VSS.n188 0.889633
R3684 VSS.n603 VSS.n601 3.30804
R3685 VSS.n875 VSS.n667 8.47145
R3686 VSS.n631 VSS.n630 4.17786
R3687 VSS.n108 VSS.n345 8.47145
R3688 VSS.n845 VSS.n662 8.47145
R3689 VSS.n845 VSS.n610 0.356017
R3690 VSS.n610 VSS.n606 4.17786
R3691 VSS.n605 VSS.n604 0.889608
R3692 VSS.n611 VSS.n612 3.30804
R3693 VSS.n617 VSS.n616 0.807038
R3694 VSS.n819 VSS.n628 8.47145
R3695 VSS.n632 VSS.n629 0.666586
R3696 VSS.n1987 VSS.n658 8.47145
R3697 VSS.n1987 VSS.n623 0.35257
R3698 VSS.n626 VSS.n625 2.29904
R3699 VSS.n787 VSS.n656 8.47145
R3700 VSS.n62 VSS.n61 0.468829
R3701 VSS.n187 VSS.n637 1.25279
R3702 VSS.n637 VSS.n636 2.30069
R3703 VSS.n635 VSS.n634 4.17786
R3704 VSS.n187 VSS.n186 0.736006
R3705 VSS.n344 VSS.n342 0.431186
R3706 VSS.n639 VSS.n344 1.27754
R3707 VSS.n341 VSS.n639 4.17786
R3708 VSS.n1903 VSS.n640 8.47145
R3709 VSS.n648 VSS.n647 8.47145
R3710 VSS.n1901 VSS.n650 8.47145
R3711 VSS.n344 VSS.n1901 1.15127
R3712 VSS.n643 VSS.n44 2.29915
R3713 VSS.t779 VSS.n539 8.47111
R3714 VSS.t778 VSS.n538 8.47111
R3715 VSS.t777 VSS.n537 8.47111
R3716 VSS.n525 VSS.n479 4.177
R3717 VSS.t794 VSS.n525 0.119605
R3718 VSS.n479 VSS.t774 8.47111
R3719 VSS.n535 VSS.t773 8.47111
R3720 VSS.n534 VSS.t772 8.47111
R3721 VSS.n533 VSS.t771 8.47111
R3722 VSS.n477 VSS.n526 4.177
R3723 VSS.n526 VSS.t768 0.119605
R3724 VSS.t767 VSS.n477 8.47111
R3725 VSS.t766 VSS.n531 8.47111
R3726 VSS.t787 VSS.n530 8.47111
R3727 VSS.n529 VSS.t765 8.47111
R3728 VSS.n527 VSS.t764 8.47111
R3729 VSS.t331 VSS.n486 0.663195
R3730 VSS.t293 VSS.n542 0.141478
R3731 VSS.n483 VSS.n482 4.20253
R3732 VSS.n451 VSS.n450 4.177
R3733 VSS.t190 VSS.n451 0.119605
R3734 VSS.n124 VSS.t295 0.346116
R3735 VSS.n552 VSS.t361 8.47111
R3736 VSS.n126 VSS.n127 2.74035
R3737 VSS.t432 VSS.n444 8.47111
R3738 VSS.n447 VSS.n445 2.29755
R3739 VSS.n449 VSS.t562 0.119605
R3740 VSS.n449 VSS.n448 4.177
R3741 VSS.n557 VSS.t403 0.549935
R3742 VSS.t283 VSS.n558 8.47111
R3743 VSS.n443 VSS.n125 2.72093
R3744 VSS.t86 VSS.n443 0.235242
R3745 VSS.t1233 VSS.n125 8.47111
R3746 VSS.t417 VSS.n563 8.47111
R3747 VSS.n385 VSS.n384 4.1873
R3748 VSS.n66 VSS.n385 0.463725
R3749 VSS.n66 VSS.n65 4.17723
R3750 VSS.n1471 VSS.n697 8.47103
R3751 VSS.n1473 VSS.n704 8.47103
R3752 VSS.n1472 VSS.n705 8.47103
R3753 VSS.n389 VSS.n388 4.17723
R3754 VSS.n691 VSS.n2008 8.47103
R3755 VSS.n391 VSS.n68 0.981098
R3756 VSS.n2008 VSS.n391 0.856738
R3757 VSS.n695 VSS.n692 8.47103
R3758 VSS.n365 VSS.n692 0.345153
R3759 VSS.n401 VSS.n215 3.30738
R3760 VSS.n406 VSS.n224 0.889286
R3761 VSS.n107 VSS.n106 1.08737
R3762 VSS.n422 VSS.n107 1.47357
R3763 VSS.n474 VSS.n475 1.35205
R3764 VSS.n1143 VSS.t684 8.36235
R3765 VSS.t389 VSS.n856 8.30819
R3766 VSS.t1225 VSS.n795 8.30819
R3767 VSS.n1143 VSS.t733 8.3005
R3768 VSS.t780 VSS.n1415 8.3005
R3769 VSS.n1414 VSS.t137 8.3005
R3770 VSS.n1336 VSS.t33 8.3005
R3771 VSS.t52 VSS.n1144 8.3005
R3772 VSS.t154 VSS.n1220 8.3005
R3773 VSS.n1219 VSS.t84 8.3005
R3774 VSS.n1193 VSS.t931 8.3005
R3775 VSS.n1188 VSS.t984 8.3005
R3776 VSS.t464 VSS.n737 8.3005
R3777 VSS.n2015 VSS.t1056 8.3005
R3778 VSS.n760 VSS.n756 8.244
R3779 VSS.n1674 VSS.n1673 8.15732
R3780 VSS.t541 VSS.n1669 8.15732
R3781 VSS.t0 VSS.n1698 8.15732
R3782 VSS.t540 VSS.n1546 8.15732
R3783 VSS.n1601 VSS.n1600 8.15732
R3784 VSS.n1603 VSS.n1602 8.15732
R3785 VSS.n1614 VSS.t2 8.15732
R3786 VSS.n207 VSS.n1651 18.2331
R3787 VSS.t209 VSS.n1648 8.15732
R3788 VSS.n1592 VSS.n1591 8.15732
R3789 VSS.t542 VSS.n1587 8.15732
R3790 VSS.t608 VSS.n1726 8.15732
R3791 VSS.t607 VSS.n1519 8.15732
R3792 VSS.n1667 VSS.n1666 8.15732
R3793 VSS.n1617 VSS.n1616 8.15732
R3794 VSS.n182 VSS.n1520 17.9679
R3795 VSS.n1909 VSS.n950 8.15732
R3796 VSS.n1670 VSS.t541 8.09881
R3797 VSS.n1711 VSS.t416 8.09881
R3798 VSS.n1547 VSS.t540 8.09881
R3799 VSS.t2 VSS.n1613 8.09881
R3800 VSS.n206 VSS.n1579 18.1765
R3801 VSS.n1727 VSS.t608 8.09881
R3802 VSS.n1522 VSS.t607 8.09881
R3803 VSS.n1695 VSS.n1694 8.09881
R3804 VSS.n1699 VSS.t0 8.09881
R3805 VSS.n735 VSS.n1715 17.3579
R3806 VSS.n1608 VSS.n1607 8.09881
R3807 VSS.n1649 VSS.t209 8.09881
R3808 VSS.n1661 VSS.n731 8.09881
R3809 VSS.n1578 VSS.t282 8.09881
R3810 VSS.t282 VSS.n1575 8.09881
R3811 VSS.n1584 VSS.n1583 8.09881
R3812 VSS.n1588 VSS.t542 8.09881
R3813 VSS.n1908 VSS.n1907 8.09881
R3814 VSS.t121 VSS.n966 8.07742
R3815 VSS.n886 VSS.t397 8.07742
R3816 VSS.n796 VSS.t1225 8.07742
R3817 VSS.n1685 VSS.n1684 8.03952
R3818 VSS.n1517 VSS.n1516 8.03952
R3819 VSS.n1757 VSS.n318 8.03952
R3820 VSS.n1764 VSS.n726 8.03952
R3821 VSS.n1513 VSS.n1509 8.03952
R3822 VSS.n1512 VSS.n1510 8.03952
R3823 VSS.n1683 VSS.n1682 8.03952
R3824 VSS.t416 VSS.n1710 8.03952
R3825 VSS.n1515 VSS.n1514 8.03952
R3826 VSS.n1691 VSS.n1690 7.97944
R3827 VSS.n70 VSS.n1753 2.49137
R3828 VSS.n1895 VSS.t611 7.97944
R3829 VSS.t611 VSS.n1894 7.97944
R3830 VSS.n1890 VSS.n651 7.97944
R3831 VSS.t1151 VSS.n1785 7.92694
R3832 VSS.n1630 VSS.n1629 7.91854
R3833 VSS.n1632 VSS.n1631 7.91854
R3834 VSS.t1100 VSS.n1951 7.86671
R3835 VSS.t435 VSS.n1860 7.86671
R3836 VSS.n1854 VSS.t412 7.86671
R3837 VSS.n1871 VSS.n678 7.86671
R3838 VSS.n1538 VSS.n730 3.19185
R3839 VSS.t1076 VSS.n1738 7.85682
R3840 VSS.n1529 VSS.n1528 7.85682
R3841 VSS.t482 VSS.n1533 7.85682
R3842 VSS.n1534 VSS.t482 7.85682
R3843 VSS.n1744 VSS.n1736 7.85682
R3844 VSS.n1742 VSS.t1076 7.85682
R3845 VSS.t397 VSS.n885 7.84665
R3846 VSS.t528 VSS.n1802 7.83145
R3847 VSS.n1948 VSS.n213 7.80845
R3848 VSS.n1953 VSS.t1100 7.80845
R3849 VSS.t1077 VSS.n1967 7.80845
R3850 VSS.n1863 VSS.t435 7.80845
R3851 VSS.t412 VSS.n1852 7.80845
R3852 VSS.n1965 VSS.n1964 7.80845
R3853 VSS.n1865 VSS.n681 7.80845
R3854 VSS.n770 VSS.n757 7.69771
R3855 VSS.t1193 VSS.n1809 7.64452
R3856 VSS.n714 VSS.n253 7.61588
R3857 VSS.n1457 VSS.n1453 7.60988
R3858 VSS.n706 VSS.n740 7.60988
R3859 VSS.n1807 VSS.t324 7.5513
R3860 VSS.t1140 VSS.n1788 7.29283
R3861 VSS.t1191 VSS.n1787 7.29283
R3862 VSS.t1259 VSS.n1786 7.29283
R3863 VSS.t324 VSS.n1806 7.26218
R3864 VSS.t265 VSS.t74 7.1604
R3865 VSS.t108 VSS.t860 7.1604
R3866 VSS.t398 VSS.t68 7.1604
R3867 VSS.n1559 VSS.n254 7.15435
R3868 VSS.n1808 VSS.t1146 7.07637
R3869 VSS.n970 VSS.t121 6.92358
R3870 VSS.n1662 VSS.n1502 6.87335
R3871 VSS.t1078 VSS.n1813 6.7646
R3872 VSS.n1810 VSS.t529 6.72989
R3873 VSS.n1804 VSS.t529 6.72983
R3874 VSS.n1803 VSS.t529 6.72981
R3875 VSS.n1814 VSS.t1078 6.70851
R3876 VSS.n1920 VSS.n1914 6.61168
R3877 VSS.n753 VSS.n751 6.59782
R3878 VSS.n754 VSS.n748 6.59782
R3879 VSS.n2013 VSS.n744 6.59782
R3880 VSS.n706 VSS.n753 6.59782
R3881 VSS.t644 VSS.n2013 6.59782
R3882 VSS.n748 VSS.n747 6.59782
R3883 VSS.t1209 VSS.n1803 6.5266
R3884 VSS.t210 VSS.n252 6.46204
R3885 VSS.n2014 VSS.t644 6.34165
R3886 VSS.n747 VSS.n738 6.34165
R3887 VSS.n2000 VSS.t1065 6.34165
R3888 VSS.n718 VSS.t438 6.18627
R3889 VSS.n1806 VSS.t583 6.14417
R3890 VSS.n1560 VSS.n255 6.0005
R3891 VSS.n1813 VSS.n1812 5.92111
R3892 VSS.n424 VSS.n826 5.81679
R3893 VSS.n424 VSS.n833 5.81679
R3894 VSS.n424 VSS.n827 5.81679
R3895 VSS.n424 VSS.n830 5.81679
R3896 VSS.n832 VSS.n36 5.81679
R3897 VSS.n831 VSS.n36 5.81679
R3898 VSS.n828 VSS.n36 5.81679
R3899 VSS.n829 VSS.n36 5.81679
R3900 VSS.n921 VSS.n105 5.81679
R3901 VSS.n923 VSS.n105 5.81679
R3902 VSS.n925 VSS.n105 5.81679
R3903 VSS.n927 VSS.n105 5.81679
R3904 VSS.n922 VSS.n33 5.81679
R3905 VSS.n924 VSS.n33 5.81679
R3906 VSS.n926 VSS.n33 5.81679
R3907 VSS.n928 VSS.n33 5.81679
R3908 VSS.n882 VSS.n598 5.78991
R3909 VSS.n884 VSS.n598 5.78991
R3910 VSS.n887 VSS.n598 5.78991
R3911 VSS.n889 VSS.n598 5.78991
R3912 VSS.n670 VSS.n881 5.78991
R3913 VSS.n670 VSS.n883 5.78991
R3914 VSS.n670 VSS.n888 5.78991
R3915 VSS.n670 VSS.n890 5.78991
R3916 VSS.t1146 VSS.t423 5.78013
R3917 VSS.n1280 VSS.t1229 5.77665
R3918 VSS.n1918 VSS.n1916 5.76584
R3919 VSS.n1925 VSS.n1924 5.76584
R3920 VSS.n1925 VSS.n1915 5.76525
R3921 VSS.n1918 VSS.n1911 5.76525
R3922 VSS.n1917 VSS.n1911 5.76494
R3923 VSS.n1922 VSS.n1921 5.76494
R3924 VSS.n1929 VSS.n1917 5.76494
R3925 VSS.n1922 VSS.n1914 5.76494
R3926 VSS.n18 VSS.n965 5.76327
R3927 VSS.n18 VSS.n972 5.76327
R3928 VSS.n237 VSS.n250 5.76327
R3929 VSS.n237 VSS.n1565 5.76327
R3930 VSS.n237 VSS.n1558 5.76327
R3931 VSS.n28 VSS.n1555 5.76327
R3932 VSS.n28 VSS.n1556 5.76327
R3933 VSS.n28 VSS.n1557 5.76327
R3934 VSS.n798 VSS.n158 5.76327
R3935 VSS.n793 VSS.n158 5.76327
R3936 VSS.n320 VSS.n973 5.73688
R3937 VSS.n320 VSS.n976 5.73688
R3938 VSS.n320 VSS.n974 5.73688
R3939 VSS.n616 VSS.n811 5.73688
R3940 VSS.n616 VSS.n614 5.73688
R3941 VSS.n808 VSS.n629 5.73688
R3942 VSS.n814 VSS.n629 5.73688
R3943 VSS.n800 VSS.n158 5.73688
R3944 VSS.n791 VSS.n158 5.73688
R3945 VSS.n801 VSS.n61 5.73688
R3946 VSS.n799 VSS.n61 5.73688
R3947 VSS.n797 VSS.n61 5.73688
R3948 VSS.n794 VSS.n61 5.73688
R3949 VSS.n792 VSS.n61 5.73688
R3950 VSS.n790 VSS.n61 5.73688
R3951 VSS.n1822 VSS.n322 5.71073
R3952 VSS.n222 VSS.n710 5.71073
R3953 VSS.n938 VSS.n21 5.71073
R3954 VSS.n936 VSS.n21 5.71073
R3955 VSS.n934 VSS.n21 5.71073
R3956 VSS.n63 VSS.n21 1.90927
R3957 VSS.n917 VSS.n585 5.71073
R3958 VSS.n915 VSS.n585 5.71073
R3959 VSS.n913 VSS.n585 5.71073
R3960 VSS.n2 VSS.n0 0.0144245
R3961 VSS.n1 VSS.n0 0.00531263
R3962 VSS.n2 VSS.t1232 9.73044
R3963 VSS.n902 VSS.n590 5.71073
R3964 VSS.n900 VSS.n590 5.71073
R3965 VSS.n898 VSS.n590 5.71073
R3966 VSS.n896 VSS.n590 5.71073
R3967 VSS.n874 VSS.n866 5.71073
R3968 VSS.n874 VSS.n873 5.71073
R3969 VSS.n874 VSS.n867 5.71073
R3970 VSS.n111 VSS.n850 5.71073
R3971 VSS.n348 VSS.n855 5.71073
R3972 VSS.n348 VSS.n858 5.71073
R3973 VSS.n841 VSS.n608 5.71073
R3974 VSS.n839 VSS.n608 5.71073
R3975 VSS.n837 VSS.n608 5.71073
R3976 VSS.n616 VSS.n807 5.71073
R3977 VSS.n616 VSS.n809 5.71073
R3978 VSS.n616 VSS.n813 5.71073
R3979 VSS.n616 VSS.n816 5.71073
R3980 VSS.n810 VSS.n629 5.71073
R3981 VSS.n812 VSS.n629 5.71073
R3982 VSS.n815 VSS.n629 5.71073
R3983 VSS.n1983 VSS.n618 5.71073
R3984 VSS.n1981 VSS.n618 5.71073
R3985 VSS.n1979 VSS.n618 5.71073
R3986 VSS.n657 VSS.n618 2.45352
R3987 VSS.n1939 VSS.n636 5.71073
R3988 VSS.n1937 VSS.n636 5.71073
R3989 VSS.n1935 VSS.n636 5.71073
R3990 VSS.n1821 VSS.n142 5.68481
R3991 VSS.n1823 VSS.n142 5.68481
R3992 VSS.n937 VSS.n20 5.68481
R3993 VSS.n935 VSS.n20 5.68481
R3994 VSS.n933 VSS.n20 5.68481
R3995 VSS.n916 VSS.n10 5.68481
R3996 VSS.n914 VSS.n10 5.68481
R3997 VSS.n912 VSS.n10 5.68481
R3998 VSS.n901 VSS.n16 5.68481
R3999 VSS.n899 VSS.n16 5.68481
R4000 VSS.n897 VSS.n16 5.68481
R4001 VSS.n872 VSS.n188 5.68481
R4002 VSS.n871 VSS.n188 5.68481
R4003 VSS.n868 VSS.n188 5.68481
R4004 VSS.n111 VSS.n853 5.68481
R4005 VSS.n111 VSS.n852 5.68481
R4006 VSS.n111 VSS.n851 5.68481
R4007 VSS.n111 VSS.n849 5.68481
R4008 VSS.n348 VSS.n854 5.68481
R4009 VSS.n348 VSS.n859 5.68481
R4010 VSS.n840 VSS.n604 5.68481
R4011 VSS.n838 VSS.n604 5.68481
R4012 VSS.n836 VSS.n604 5.68481
R4013 VSS.n1982 VSS.n620 5.68481
R4014 VSS.n1980 VSS.n620 5.68481
R4015 VSS.n1978 VSS.n620 5.68481
R4016 VSS.n1938 VSS.n186 5.68481
R4017 VSS.n1936 VSS.n186 5.68481
R4018 VSS.n1934 VSS.n186 5.68481
R4019 VSS.n1972 VSS.n144 5.66912
R4020 VSS.n237 VSS.n249 5.66778
R4021 VSS.n1566 VSS.n238 0.0032499
R4022 VSS.n1664 VSS.n38 5.66778
R4023 VSS.n1674 VSS.n131 1.70081
R4024 VSS.n1694 VSS.n281 2.42938
R4025 VSS.n202 VSS.n285 0.00249999
R4026 VSS.n1717 VSS.n208 2.04988
R4027 VSS.n135 VSS.n1618 1.54641
R4028 VSS.n135 VSS.n123 0.00259033
R4029 VSS.n1612 VSS.n179 2.83393
R4030 VSS.n1612 VSS.n221 2.06109
R4031 VSS.n732 VSS.n53 0.00229996
R4032 VSS.n1652 VSS.n207 2.53448
R4033 VSS.n56 VSS.n120 0.00243252
R4034 VSS.n120 VSS.n136 0.00199982
R4035 VSS.n171 VSS.n57 0.00385697
R4036 VSS.n1582 VSS.n206 2.52035
R4037 VSS.n1592 VSS.n218 1.70081
R4038 VSS.n1528 VSS.n305 1.70041
R4039 VSS.n1538 VSS.n29 2.12547
R4040 VSS.n137 VSS.n310 0.00374985
R4041 VSS.n139 VSS.n138 0.00277022
R4042 VSS.n1746 VSS.n141 1.54543
R4043 VSS.n141 VSS.n116 0.0026349
R4044 VSS.n118 VSS.n1740 5.66778
R4045 VSS.n1752 VSS.n181 5.66778
R4046 VSS.n1751 VSS.n182 3.27138
R4047 VSS.n1751 VSS.n316 2.12584
R4048 VSS.n307 VSS.n1524 0.00229996
R4049 VSS.n70 VSS.n69 1.40905
R4050 VSS.n1816 VSS.n1815 5.66778
R4051 VSS.n1572 VSS.n237 5.66778
R4052 VSS.n1572 VSS.n321 2.12572
R4053 VSS.n366 VSS.n967 0.0024166
R4054 VSS.n68 VSS.n2006 5.66778
R4055 VSS.n694 VSS.n693 0.00256238
R4056 VSS.n1456 VSS.n211 1.54745
R4057 VSS.n145 VSS.n958 5.66778
R4058 VSS.n197 VSS.n196 0.00443966
R4059 VSS.n1882 VSS.n398 5.66778
R4060 VSS.n214 VSS.n213 1.70081
R4061 VSS.n1963 VSS.n411 2.42919
R4062 VSS.n454 VSS.n453 0.0026491
R4063 VSS.n1872 VSS.n248 1.99364
R4064 VSS.n162 VSS.n146 0.0024996
R4065 VSS.n146 VSS.n161 2.83389
R4066 VSS.t185 VSS.n478 1.41686
R4067 VSS.t185 VSS.n476 1.13344
R4068 VSS.n1320 VSS.t331 5.66778
R4069 VSS.t44 VSS.n544 3.40098
R4070 VSS.t30 VSS.n8 1.3081
R4071 VSS.n122 VSS.n121 0.00415396
R4072 VSS.n554 VSS.n553 0.00181791
R4073 VSS.n562 VSS.n92 0.00261099
R4074 VSS.n932 VSS.n63 1.8661
R4075 VSS.n824 VSS.n1 86.3694
R4076 VSS.n48 VSS.n3 0.00169054
R4077 VSS.n163 VSS.n590 0.00344965
R4078 VSS.n904 VSS.n152 2.12585
R4079 VSS.n891 VSS.n593 2.12584
R4080 VSS.n874 VSS.n666 0.00261098
R4081 VSS.n602 VSS.n870 2.42938
R4082 VSS.n860 VSS.n155 1.70082
R4083 VSS.n111 VSS.n154 2.43925
R4084 VSS.n111 VSS.n109 0.00256238
R4085 VSS.n664 VSS.n607 0.00228546
R4086 VSS.n615 VSS.n660 0.00255515
R4087 VSS.n788 VSS.n624 5.66778
R4088 VSS.n1940 VSS.n247 1.53903
R4089 VSS.n644 VSS.n1906 0.00249999
R4090 VSS.t185 VSS.n528 1.13341
R4091 VSS.n238 VSS.n249 2.12599
R4092 VSS.n1694 VSS.n278 5.66767
R4093 VSS.n1542 VSS.n46 1.88956
R4094 VSS.n135 VSS.n734 0.00240897
R4095 VSS.n47 VSS.n1637 1.88956
R4096 VSS.n1723 VSS.n137 2.12584
R4097 VSS.n306 VSS.n316 0.00179984
R4098 VSS.n1753 VSS.n23 2.42921
R4099 VSS.n49 VSS.n18 0.00443279
R4100 VSS.n1816 VSS.n143 2.12614
R4101 VSS.n1826 VSS.n324 1.54667
R4102 VSS.n970 VSS.n366 2.83432
R4103 VSS.n706 VSS.n201 1.54574
R4104 VSS.n705 VSS.n388 0.00151425
R4105 VSS.n1475 VSS.n67 1.546
R4106 VSS.n364 VSS.n2009 5.66767
R4107 VSS.n362 VSS.n361 0.00231313
R4108 VSS.n421 VSS.n423 0.00274939
R4109 VSS.n454 VSS.n1871 1.70044
R4110 VSS.t44 VSS.n452 1.88962
R4111 VSS.n911 VSS.n583 3.40114
R4112 VSS.n592 VSS.n593 0.00179984
R4113 VSS.n622 VSS.n620 0.00274939
R4114 VSS.n343 VSS.n652 1.50384
R4115 VSS.n542 VSS.t331 3.3334
R4116 VSS.t151 VSS.n581 3.36544
R4117 VSS.t918 VSS.t193 5.64415
R4118 VSS.n1821 VSS.n1820 5.63337
R4119 VSS.n1823 VSS.t1 5.63337
R4120 VSS.n1824 VSS.n1823 5.63337
R4121 VSS.t1089 VSS.n935 5.63337
R4122 VSS.t1090 VSS.n914 5.63337
R4123 VSS.t1091 VSS.n899 5.63337
R4124 VSS.t1092 VSS.n871 5.63337
R4125 VSS.n856 VSS.n852 5.63337
R4126 VSS.t1093 VSS.n838 5.63337
R4127 VSS.t1094 VSS.n1980 5.63337
R4128 VSS.t1095 VSS.n1936 5.63337
R4129 VSS.n912 VSS.n586 13.3841
R4130 VSS.n869 VSS.n868 5.63337
R4131 VSS.n857 VSS.n851 5.63337
R4132 VSS.n969 VSS.n222 5.62715
R4133 VSS.n413 VSS.n415 2.30524
R4134 VSS.n1553 VSS.n5 5.61857
R4135 VSS.n299 VSS.n297 3.31014
R4136 VSS.n382 VSS.n225 3.31706
R4137 VSS.n1567 VSS.n1566 5.61547
R4138 VSS.n1675 VSS.n134 5.61547
R4139 VSS.n132 VSS.n38 1.35228
R4140 VSS.n51 VSS.n52 0.557395
R4141 VSS.n30 VSS.n32 0.465501
R4142 VSS.n1622 VSS.n734 5.61547
R4143 VSS.n1623 VSS.n123 5.61547
R4144 VSS.n296 VSS.n47 0.674754
R4145 VSS.n71 VSS.n72 0.742234
R4146 VSS.n1639 VSS.n1638 5.61547
R4147 VSS.n1653 VSS.n53 5.61547
R4148 VSS.n55 VSS.n54 0.889486
R4149 VSS.n1580 VSS.n120 5.61547
R4150 VSS.n1581 VSS.n136 5.61547
R4151 VSS.n169 VSS.n170 3.30804
R4152 VSS.n57 VSS.n58 0.733552
R4153 VSS.n1527 VSS.n304 5.61547
R4154 VSS.n1539 VSS.n29 5.61547
R4155 VSS.n59 VSS.n60 0.477059
R4156 VSS.n1732 VSS.n138 5.61547
R4157 VSS.n117 VSS.n1745 5.61547
R4158 VSS.n180 VSS.n1750 5.61547
R4159 VSS.n1525 VSS.n1524 5.61547
R4160 VSS.n19 VSS.n18 0.200746
R4161 VSS.n1835 VSS.n143 5.61547
R4162 VSS.n397 VSS.n396 1.35173
R4163 VSS.n947 VSS.n147 5.61547
R4164 VSS.n941 VSS.n150 5.61547
R4165 VSS.n918 VSS.n673 5.61547
R4166 VSS.n918 VSS.n113 0.998494
R4167 VSS.n908 VSS.n48 5.61547
R4168 VSS.n346 VSS.n110 5.61547
R4169 VSS.n844 VSS.n607 5.61547
R4170 VSS.n818 VSS.n615 5.61547
R4171 VSS.n1986 VSS.n157 5.61547
R4172 VSS.n370 VSS.n386 1.20909
R4173 VSS.n222 VSS.n326 1.35191
R4174 VSS.n968 VSS.n967 5.61509
R4175 VSS.n2007 VSS.n693 5.61509
R4176 VSS.n1956 VSS.n403 5.61509
R4177 VSS.n223 VSS.n1962 5.61509
R4178 VSS.n1858 VSS.n453 5.61509
R4179 VSS.n269 VSS.n175 3.33079
R4180 VSS.n176 VSS.n267 3.33079
R4181 VSS.n264 VSS.n174 3.33079
R4182 VSS.n174 VSS.n261 3.33079
R4183 VSS.n260 VSS.n173 3.33079
R4184 VSS.n239 VSS.n259 3.33079
R4185 VSS.t1029 VSS.n258 0.0863258
R4186 VSS.n272 VSS.t529 3.33079
R4187 VSS.n175 VSS.n271 3.33079
R4188 VSS.t69 VSS.t1024 5.61485
R4189 VSS.n494 VSS.t125 0.604794
R4190 VSS.n524 VSS.t741 0.0863258
R4191 VSS.n517 VSS.t231 0.0861948
R4192 VSS.n516 VSS.t718 0.0863258
R4193 VSS.n490 VSS.n540 3.33087
R4194 VSS.t776 VSS.n536 5.61485
R4195 VSS.n532 VSS.t770 5.61485
R4196 VSS.t845 VSS.n543 5.61485
R4197 VSS.n546 VSS.t106 3.33079
R4198 VSS.n468 VSS.t837 5.61485
R4199 VSS.n548 VSS.t834 0.0861948
R4200 VSS.n133 VSS.t369 0.0895683
R4201 VSS.n121 VSS.t850 5.61485
R4202 VSS.t90 VSS.n553 5.61485
R4203 VSS.t237 VSS.n447 0.231606
R4204 VSS.n570 VSS.t914 0.0863258
R4205 VSS.n355 VSS.n568 3.33079
R4206 VSS.n567 VSS.n357 3.33079
R4207 VSS.t887 VSS.n566 0.0863258
R4208 VSS.n580 VSS.n98 3.33079
R4209 VSS.n579 VSS.n98 3.33079
R4210 VSS.n578 VSS.n100 3.33079
R4211 VSS.n577 VSS.n100 3.33079
R4212 VSS.n576 VSS.n352 3.33079
R4213 VSS.t957 VSS.n575 0.0863258
R4214 VSS.n641 VSS.n162 0.896232
R4215 VSS.n114 VSS.n45 1.97656
R4216 VSS.n1802 VSS.n963 5.59404
R4217 VSS.n1845 VSS.n710 5.58155
R4218 VSS.n1846 VSS.n710 5.58155
R4219 VSS.t1 VSS.n1822 5.58155
R4220 VSS.n936 VSS.t1089 5.58155
R4221 VSS.n915 VSS.t1090 5.58155
R4222 VSS.n860 VSS.n850 5.58155
R4223 VSS.n839 VSS.t1093 5.58155
R4224 VSS.n812 VSS.t614 5.58155
R4225 VSS.n1981 VSS.t1094 5.58155
R4226 VSS.n1937 VSS.t1095 5.58155
R4227 VSS.n896 VSS.n895 5.58155
R4228 VSS.n900 VSS.t1091 5.58155
R4229 VSS.n873 VSS.t1092 5.58155
R4230 VSS.n661 VSS.n835 1.52739
R4231 VSS.n1128 VSS.n1120 5.54579
R4232 VSS.n973 VSS.n964 5.52924
R4233 VSS.n976 VSS.n966 5.52924
R4234 VSS.n974 VSS.n971 5.52924
R4235 VSS.n974 VSS.n712 5.52924
R4236 VSS.t614 VSS.n811 5.52924
R4237 VSS.n795 VSS.n794 5.52924
R4238 VSS.n820 VSS.n614 5.52924
R4239 VSS.n790 VSS.n789 5.52924
R4240 VSS.n797 VSS.n796 5.52924
R4241 VSS.n972 VSS.n712 5.47646
R4242 VSS.n975 VSS.n972 5.47646
R4243 VSS.t486 VSS.n1557 5.47646
R4244 VSS.n1573 VSS.n250 5.47646
R4245 VSS.n1997 VSS.n1996 5.47483
R4246 VSS.n887 VSS.n886 5.42319
R4247 VSS.n891 VSS.n668 2.33938
R4248 VSS.n885 VSS.n884 5.42319
R4249 VSS.n1457 VSS.t1042 5.39048
R4250 VSS.n1998 VSS.n767 5.39048
R4251 VSS.n925 VSS.t356 5.36942
R4252 VSS.n829 VSS.n676 11.846
R4253 VSS.t1075 VSS.n827 5.36942
R4254 VSS.n831 VSS.t1075 5.36942
R4255 VSS.t356 VSS.n924 5.36942
R4256 VSS.n1561 VSS.n251 5.30819
R4257 VSS.n1993 VSS.n773 5.2915
R4258 VSS.n753 VSS.n380 5.20259
R4259 VSS.n225 VSS.n748 5.20259
R4260 VSS.n2013 VSS.n225 5.20259
R4261 VSS.n698 VSS.t1045 5.07342
R4262 VSS.t1047 VSS.n1465 5.07342
R4263 VSS.n1929 VSS.n1928 4.96599
R4264 VSS.n1810 VSS.t1193 4.84829
R4265 VSS.n1562 VSS.n256 4.84665
R4266 VSS.n1803 VSS.t528 4.66209
R4267 VSS.n1543 VSS.n1542 4.65994
R4268 VSS.n1645 VSS.n1644 4.65994
R4269 VSS.t529 VSS.n1783 4.65661
R4270 VSS.t529 VSS.n1798 4.65661
R4271 VSS.n1762 VSS.n1761 4.60056
R4272 VSS.n1948 VSS.n204 4.59728
R4273 VSS.n1950 VSS.n204 4.59728
R4274 VSS.n1953 VSS.n204 4.59728
R4275 VSS.n1952 VSS.n204 4.59728
R4276 VSS.n1865 VSS.n224 4.59728
R4277 VSS.n1967 VSS.n224 4.59728
R4278 VSS.n1965 VSS.n224 4.59728
R4279 VSS.n421 VSS.n1862 4.59728
R4280 VSS.n421 VSS.n1863 4.59728
R4281 VSS.n421 VSS.n1864 4.59728
R4282 VSS.n184 VSS.n1851 4.59728
R4283 VSS.n184 VSS.n1852 4.59728
R4284 VSS.n184 VSS.n1853 4.59728
R4285 VSS.n1537 VSS.n29 4.57309
R4286 VSS.n1535 VSS.n29 4.57309
R4287 VSS.n1533 VSS.n29 4.57309
R4288 VSS.n1531 VSS.n29 4.57309
R4289 VSS.n1529 VSS.n29 4.57309
R4290 VSS.n1537 VSS.n730 17.4301
R4291 VSS.n1536 VSS.n59 4.57309
R4292 VSS.n1534 VSS.n59 4.57309
R4293 VSS.n1532 VSS.n59 4.57309
R4294 VSS.n1530 VSS.n59 4.57309
R4295 VSS.n118 VSS.n1739 4.57309
R4296 VSS.n118 VSS.n1735 4.57309
R4297 VSS.n118 VSS.n1738 4.57309
R4298 VSS.n118 VSS.n1737 4.57309
R4299 VSS.n116 VSS.n1741 4.57309
R4300 VSS.n116 VSS.n1742 4.57309
R4301 VSS.n116 VSS.n1743 4.57309
R4302 VSS.n116 VSS.n1744 4.57309
R4303 VSS.n1637 VSS.n1636 4.57017
R4304 VSS.n404 VSS.n1949 4.56814
R4305 VSS.n404 VSS.n1951 4.56814
R4306 VSS.n404 VSS.n1954 4.56814
R4307 VSS.n1866 VSS.n409 4.56814
R4308 VSS.n1966 VSS.n409 4.56814
R4309 VSS.n106 VSS.n1859 4.56814
R4310 VSS.n106 VSS.n1860 4.56814
R4311 VSS.n106 VSS.n1861 4.56814
R4312 VSS.n106 VSS.n679 1.85571
R4313 VSS.n474 VSS.n1856 4.56814
R4314 VSS.n474 VSS.n1854 4.56814
R4315 VSS.n474 VSS.n1855 4.56814
R4316 VSS.n474 VSS.n678 4.56814
R4317 VSS.n1627 VSS.n71 4.54223
R4318 VSS.n1629 VSS.n71 4.54223
R4319 VSS.n1632 VSS.n71 4.54223
R4320 VSS.n1634 VSS.n71 4.54223
R4321 VSS.n1626 VSS.n47 4.54223
R4322 VSS.n1628 VSS.n47 4.54223
R4323 VSS.n1633 VSS.n47 4.54223
R4324 VSS.n1635 VSS.n47 4.54223
R4325 VSS.n1868 VSS.n1867 4.51508
R4326 VSS.n1870 VSS.n680 4.51508
R4327 VSS.n1681 VSS.n13 4.51178
R4328 VSS.n1686 VSS.n13 4.51178
R4329 VSS.n1690 VSS.n13 4.51178
R4330 VSS.n1899 VSS.n640 4.51178
R4331 VSS.n1897 VSS.n640 4.51178
R4332 VSS.n1895 VSS.n640 4.51178
R4333 VSS.n1893 VSS.n640 4.51178
R4334 VSS.n1891 VSS.n640 4.51178
R4335 VSS.n342 VSS.n1900 4.51178
R4336 VSS.n342 VSS.n1898 4.51178
R4337 VSS.n342 VSS.n1896 4.51178
R4338 VSS.n342 VSS.n1894 4.51178
R4339 VSS.n342 VSS.n1892 4.51178
R4340 VSS.n342 VSS.n1890 4.51178
R4341 VSS.n176 VSS.n266 4.48596
R4342 VSS.n244 VSS.n1468 41.3471
R4343 VSS.n174 VSS.n262 4.48596
R4344 VSS.n245 VSS.n1451 41.3471
R4345 VSS.n1450 VSS.n173 4.48596
R4346 VSS.n246 VSS.n173 1.27287
R4347 VSS.n239 VSS.n240 0.363807
R4348 VSS.n1444 VSS.n239 4.48596
R4349 VSS.n175 VSS.n1793 4.48596
R4350 VSS.n1679 VSS.n13 4.48174
R4351 VSS.n1688 VSS.n13 4.48174
R4352 VSS.n1678 VSS.n42 4.48174
R4353 VSS.n1680 VSS.n42 4.48174
R4354 VSS.n1682 VSS.n42 4.48174
R4355 VSS.n1685 VSS.n42 4.48174
R4356 VSS.n1687 VSS.n42 4.48174
R4357 VSS.n1689 VSS.n42 4.48174
R4358 VSS.n1710 VSS.n285 4.48174
R4359 VSS.n1707 VSS.n51 4.48174
R4360 VSS.n1713 VSS.n51 4.48174
R4361 VSS.n69 VSS.n1759 4.48174
R4362 VSS.n69 VSS.n1514 4.48174
R4363 VSS.n69 VSS.n1517 4.48174
R4364 VSS.n69 VSS.n1756 4.48174
R4365 VSS.n1757 VSS.n23 4.48174
R4366 VSS.n1758 VSS.n23 4.48174
R4367 VSS.n1754 VSS.n23 4.48174
R4368 VSS.n1755 VSS.n23 4.48174
R4369 VSS.n727 VSS.n726 4.48174
R4370 VSS.n727 VSS.n1513 4.48174
R4371 VSS.n727 VSS.n1512 4.48174
R4372 VSS.n727 VSS.n725 4.48174
R4373 VSS.n25 VSS.n1508 4.48174
R4374 VSS.n25 VSS.n1511 4.48174
R4375 VSS.n25 VSS.n1763 4.48174
R4376 VSS.n1672 VSS.n38 4.4521
R4377 VSS.n1670 VSS.n38 4.4521
R4378 VSS.n1668 VSS.n38 4.4521
R4379 VSS.n1701 VSS.n50 4.4521
R4380 VSS.n1699 VSS.n50 4.4521
R4381 VSS.n1697 VSS.n50 4.4521
R4382 VSS.n1695 VSS.n50 4.4521
R4383 VSS.n1706 VSS.n285 4.4521
R4384 VSS.n1708 VSS.n285 4.4521
R4385 VSS.n1712 VSS.n285 4.4521
R4386 VSS.n1714 VSS.n285 4.4521
R4387 VSS.n1709 VSS.n51 4.4521
R4388 VSS.n1711 VSS.n51 4.4521
R4389 VSS.n1715 VSS.n51 4.4521
R4390 VSS.n1549 VSS.n5 4.4521
R4391 VSS.n1547 VSS.n5 4.4521
R4392 VSS.n1545 VSS.n5 4.4521
R4393 VSS.n1607 VSS.n291 4.4521
R4394 VSS.n1599 VSS.n30 4.4521
R4395 VSS.n1604 VSS.n30 4.4521
R4396 VSS.n123 VSS.n1620 4.4521
R4397 VSS.n123 VSS.n1613 4.4521
R4398 VSS.n123 VSS.n1615 4.4521
R4399 VSS.n1651 VSS.n297 4.4521
R4400 VSS.n1649 VSS.n297 4.4521
R4401 VSS.n1647 VSS.n297 4.4521
R4402 VSS.n169 VSS.n1579 4.4521
R4403 VSS.n169 VSS.n1577 4.4521
R4404 VSS.n169 VSS.n1578 4.4521
R4405 VSS.n1659 VSS.n169 4.4521
R4406 VSS.n169 VSS.n731 4.4521
R4407 VSS.n57 VSS.n206 1.38587
R4408 VSS.n57 VSS.n1574 4.4521
R4409 VSS.n57 VSS.n1575 4.4521
R4410 VSS.n57 VSS.n1576 4.4521
R4411 VSS.n57 VSS.n1660 4.4521
R4412 VSS.n1590 VSS.n302 4.4521
R4413 VSS.n1588 VSS.n302 4.4521
R4414 VSS.n1586 VSS.n302 4.4521
R4415 VSS.n1584 VSS.n302 4.4521
R4416 VSS.n1729 VSS.n310 4.4521
R4417 VSS.n1727 VSS.n310 4.4521
R4418 VSS.n1725 VSS.n310 4.4521
R4419 VSS.n728 VSS.n310 1.79863
R4420 VSS.n181 VSS.n1521 4.4521
R4421 VSS.n181 VSS.n1522 4.4521
R4422 VSS.n181 VSS.n1523 4.4521
R4423 VSS.n1908 VSS.n1906 4.4521
R4424 VSS.n1476 VSS.n263 4.43931
R4425 VSS.n1673 VSS.n40 4.42284
R4426 VSS.n1671 VSS.n40 4.42284
R4427 VSS.n1669 VSS.n40 4.42284
R4428 VSS.n1667 VSS.n40 4.42284
R4429 VSS.n1700 VSS.n278 4.42284
R4430 VSS.n1698 VSS.n278 4.42284
R4431 VSS.n1696 VSS.n278 4.42284
R4432 VSS.n1548 VSS.n46 4.42284
R4433 VSS.n1546 VSS.n46 4.42284
R4434 VSS.n1544 VSS.n46 4.42284
R4435 VSS.n1598 VSS.n291 4.42284
R4436 VSS.n1600 VSS.n291 4.42284
R4437 VSS.n1603 VSS.n291 4.42284
R4438 VSS.n1605 VSS.n291 4.42284
R4439 VSS.n1597 VSS.n30 4.42284
R4440 VSS.n1606 VSS.n30 4.42284
R4441 VSS.n1619 VSS.n220 4.42284
R4442 VSS.n1614 VSS.n220 4.42284
R4443 VSS.n1616 VSS.n220 4.42284
R4444 VSS.n207 VSS.n54 1.37456
R4445 VSS.n1650 VSS.n54 4.42284
R4446 VSS.n1648 VSS.n54 4.42284
R4447 VSS.n1646 VSS.n54 4.42284
R4448 VSS.n1591 VSS.n216 4.42284
R4449 VSS.n1589 VSS.n216 4.42284
R4450 VSS.n1587 VSS.n216 4.42284
R4451 VSS.n1585 VSS.n216 4.42284
R4452 VSS.n1728 VSS.n137 4.42284
R4453 VSS.n1726 VSS.n137 4.42284
R4454 VSS.n1724 VSS.n137 4.42284
R4455 VSS.n307 VSS.n1518 4.42284
R4456 VSS.n307 VSS.n1519 4.42284
R4457 VSS.n307 VSS.n1520 4.42284
R4458 VSS.n45 VSS.n1909 4.42284
R4459 VSS.t520 VSS.n1148 4.28621
R4460 VSS.t625 VSS.n1155 4.28621
R4461 VSS.n1609 VSS.n30 4.25119
R4462 VSS.n1842 VSS.n115 1.5456
R4463 VSS.n642 VSS.n645 2.83436
R4464 VSS.t68 VSS.n1482 4.25113
R4465 VSS.t192 VSS.n560 2.83414
R4466 VSS.n203 VSS.n1716 1.88937
R4467 VSS.n1644 VSS.n54 4.251
R4468 VSS.n1661 VSS.n56 1.70033
R4469 VSS.n2012 VSS.n225 4.251
R4470 VSS.n1963 VSS.n224 4.251
R4471 VSS.t89 VSS.n1280 4.251
R4472 VSS.n870 VSS.n188 4.251
R4473 VSS.n788 VSS.n627 2.12556
R4474 VSS.n802 VSS.n61 4.251
R4475 VSS.t266 VSS.t265 4.2505
R4476 VSS.n469 VSS.n1151 4.24487
R4477 VSS.t69 VSS.n499 2.74096
R4478 VSS.n124 VSS.t94 1.97622
R4479 VSS.n1906 VSS.n1905 4.17428
R4480 VSS.n1436 VSS.t4 4.16717
R4481 VSS.t486 VSS.n1564 4.15435
R4482 VSS.n162 VSS.n1913 4.14062
R4483 VSS.n2010 VSS.n417 4.12225
R4484 VSS.t236 VSS.n1489 4.09327
R4485 VSS.n1475 VSS.n1459 3.80519
R4486 VSS.t546 VSS.n1470 3.80519
R4487 VSS.n2006 VSS.n2005 3.80519
R4488 VSS.n677 VSS.n36 1.95701
R4489 VSS.n674 VSS.n105 1.35704
R4490 VSS.n33 VSS.n675 3.50911
R4491 VSS.t141 VSS.t226 3.50108
R4492 VSS.n702 VSS.n1460 3.48813
R4493 VSS.n2001 VSS.n760 3.48813
R4494 VSS.n1817 VSS.n1816 3.46204
R4495 VSS.n1819 VSS.n1818 3.46204
R4496 VSS.n1826 VSS.n1825 3.46204
R4497 VSS.n1665 VSS.n1664 3.43693
R4498 VSS.n375 VSS.n1814 3.43223
R4499 VSS.n806 VSS.n629 3.43223
R4500 VSS.n375 VSS.n1813 3.41353
R4501 VSS.n939 VSS.n20 3.41353
R4502 VSS.n865 VSS.n188 3.41353
R4503 VSS.n842 VSS.n604 3.41353
R4504 VSS.n1984 VSS.n620 3.41353
R4505 VSS.n247 VSS.n186 1.55307
R4506 VSS.n1641 VSS.n1640 3.40094
R4507 VSS.n940 VSS.n939 3.38265
R4508 VSS.n865 VSS.n864 3.38265
R4509 VSS.n843 VSS.n842 3.38265
R4510 VSS.n1985 VSS.n1984 3.38265
R4511 VSS.n806 VSS.n659 3.35461
R4512 VSS.n653 VSS.n1933 1.86617
R4513 VSS.n1884 VSS.n962 3.33717
R4514 VSS.t1054 VSS.n265 0.0850573
R4515 VSS.n550 VSS.t109 2.33238
R4516 VSS.n643 VSS.n114 0.83736
R4517 VSS.n74 VSS.n500 2.31514
R4518 VSS.n1551 VSS.n1550 3.29039
R4519 VSS.n1731 VSS.n1730 3.29039
R4520 VSS.n1752 VSS.n308 1.32112
R4521 VSS.n930 VSS.n675 3.23928
R4522 VSS.n1968 VSS.t1077 3.20906
R4523 VSS.n1475 VSS.n1454 3.17108
R4524 VSS.n1808 VSS.t529 3.15936
R4525 VSS.n1806 VSS.t529 3.15936
R4526 VSS.n1996 VSS.n771 3.0915
R4527 VSS.n1994 VSS.n772 3.0915
R4528 VSS.n1477 VSS.n698 2.85402
R4529 VSS.n769 VSS.n761 2.85402
R4530 VSS.t515 VSS.n1120 2.83383
R4531 VSS.n686 VSS.n145 2.6787
R4532 VSS.n232 VSS.n957 2.6787
R4533 VSS.n955 VSS.n232 2.6787
R4534 VSS.n953 VSS.n233 12.6418
R4535 VSS.n234 VSS.n232 1.45453
R4536 VSS.n1885 VSS.n1884 2.67717
R4537 VSS.n1867 VSS.n224 2.65857
R4538 VSS.n421 VSS.n680 2.65857
R4539 VSS.n184 VSS.n248 1.17422
R4540 VSS.n404 VSS.n402 0.981981
R4541 VSS.n1636 VSS.n71 2.62184
R4542 VSS.n1762 VSS.n727 2.60158
R4543 VSS.n1663 VSS.n249 2.57782
R4544 VSS.n51 VSS.n208 1.12735
R4545 VSS.n1543 VSS.n5 2.56199
R4546 VSS.n1645 VSS.n297 2.56199
R4547 VSS.t199 VSS.t203 2.54935
R4548 VSS.t63 VSS.t152 2.54935
R4549 VSS.n736 VSS.n278 1.37468
R4550 VSS.n221 VSS.n220 1.11801
R4551 VSS.n1478 VSS.t1170 2.53696
R4552 VSS.n701 VSS.n1461 2.53696
R4553 VSS.n744 VSS.n742 2.53696
R4554 VSS.n755 VSS.n754 2.53696
R4555 VSS.n762 VSS.n417 2.53696
R4556 VSS.t239 VSS.n1885 2.5305
R4557 VSS.n11 VSS.n10 0.743506
R4558 VSS.n903 VSS.n16 2.43937
R4559 VSS.n1932 VSS.n1904 2.42417
R4560 VSS.n904 VSS.n903 2.41731
R4561 VSS.n1928 VSS.n1927 2.35796
R4562 VSS.t164 VSS.n1008 2.35714
R4563 VSS.n1943 VSS.n1942 2.349
R4564 VSS.n1839 VSS.n977 2.34717
R4565 VSS.t78 VSS.n541 1.77248
R4566 VSS.n1693 VSS.n1677 2.29583
R4567 VSS.t214 VSS.n775 2.2841
R4568 VSS.t628 VSS.t44 2.28014
R4569 VSS.n1719 VSS.n1705 2.24083
R4570 VSS.n848 VSS.n777 2.239
R4571 VSS.n1469 VSS.n1463 2.2199
R4572 VSS.n749 VSS.t1055 2.2199
R4573 VSS.t252 VSS.n1011 2.19188
R4574 VSS.n877 VSS.n862 2.184
R4575 VSS.n1611 VSS.n1554 2.184
R4576 VSS.n906 VSS.n894 2.14733
R4577 VSS.n1643 VSS.n1625 2.14733
R4578 VSS.t125 VSS.n1489 2.1255
R4579 VSS.n1656 VSS.n1655 2.1125
R4580 VSS.n920 VSS.n910 2.11067
R4581 VSS.n943 VSS.n931 2.074
R4582 VSS.n1596 VSS.n1541 2.074
R4583 VSS.n1748 VSS.n1734 2.074
R4584 VSS.n572 VSS.t368 0.588407
R4585 VSS.t552 VSS.n571 1.53002
R4586 VSS.n50 VSS.n277 1.35228
R4587 VSS.n5 VSS.n6 0.981955
R4588 VSS.n297 VSS.n733 1.9715
R4589 VSS.n302 VSS.n301 1.35228
R4590 VSS.n310 VSS.n311 1.35228
R4591 VSS.n1960 VSS.n410 0.689621
R4592 VSS.n21 VSS.n426 1.20982
R4593 VSS.n590 VSS.n589 1.35228
R4594 VSS.n608 VSS.n609 1.52063
R4595 VSS.n618 VSS.n619 1.20982
R4596 VSS.n636 VSS.n655 1.9715
R4597 VSS.n375 VSS.n1827 1.97073
R4598 VSS.n230 VSS.n1563 1.97073
R4599 VSS.n960 VSS.n397 0.644147
R4600 VSS.n1878 VSS.n361 1.97073
R4601 VSS.t423 VSS.n1807 1.95812
R4602 VSS.n1990 VSS.n776 1.92367
R4603 VSS VSS.n2015 1.90715
R4604 VSS.t546 VSS.n1462 1.90285
R4605 VSS.t1204 VSS.n418 1.90285
R4606 VSS.t30 VSS.t196 1.87082
R4607 VSS.n1809 VSS.t1147 1.8649
R4608 VSS.n116 VSS.n309 0.748673
R4609 VSS.n1845 VSS.n1844 1.84665
R4610 VSS.n983 VSS.n723 1.84665
R4611 VSS.n1834 VSS.n1833 1.84665
R4612 VSS.n413 VSS.n770 1.8299
R4613 VSS.n1550 VSS.n46 1.78455
R4614 VSS.n1730 VSS.n137 1.78455
R4615 VSS.t527 VSS.n1800 1.75523
R4616 VSS.t260 VSS.t266 1.74576
R4617 VSS.n585 VSS.n672 1.7268
R4618 VSS.n364 VSS.n390 1.35172
R4619 VSS.n384 VSS.n1466 1.72207
R4620 VSS.n386 VSS.n1832 0.690442
R4621 VSS.n399 VSS.n684 1.72206
R4622 VSS.n696 VSS.n1474 1.71799
R4623 VSS.t226 VSS.n160 1.71424
R4624 VSS.n980 VSS.n979 1.61588
R4625 VSS.n1053 VSS.t78 1.61234
R4626 VSS.n458 VSS.t14 1.60135
R4627 VSS.t8 VSS.n458 1.60135
R4628 VSS.t371 VSS.t85 1.58612
R4629 VSS.n700 VSS.n1463 1.58579
R4630 VSS.t1057 VSS.n746 1.58579
R4631 VSS.n1999 VSS.n765 1.58579
R4632 VSS.n2000 VSS.n764 1.58579
R4633 VSS.n717 VSS.n983 1.54595
R4634 VSS.n370 VSS.n980 1.54595
R4635 VSS.n210 VSS.n1476 1.54595
R4636 VSS.n2009 VSS.n413 1.54595
R4637 VSS.t151 VSS.t64 1.5425
R4638 VSS.n123 VSS.n178 1.09175
R4639 VSS.n1526 VSS.n181 1.52457
R4640 VSS.n874 VSS.n863 1.52457
R4641 VSS.n405 VSS.n1888 0.778165
R4642 VSS.n557 VSS.t193 1.20429
R4643 VSS.n1831 VSS.n228 1.51483
R4644 VSS.n1920 VSS.n161 1.47055
R4645 VSS.t393 VSS.t199 1.41717
R4646 VSS.t151 VSS.t152 1.41717
R4647 VSS.n720 VSS.n970 1.38512
R4648 VSS.n982 VSS.n719 1.38512
R4649 VSS.t75 VSS.t518 1.36943
R4650 VSS.n1927 VSS.n1918 1.36935
R4651 VSS.n1927 VSS.n1925 1.36935
R4652 VSS.n1923 VSS.n1917 1.36903
R4653 VSS.n1923 VSS.n1922 1.36903
R4654 VSS.n118 VSS.n140 1.36088
R4655 VSS.n425 VSS.n424 1.0986
R4656 VSS.n205 VSS.n204 1.08636
R4657 VSS.n41 VSS.n40 0.670719
R4658 VSS.n1593 VSS.n216 1.34922
R4659 VSS.n367 VSS.n368 0.889483
R4660 VSS.t832 VSS.n547 0.0842465
R4661 VSS.n1238 VSS.t94 1.34777
R4662 VSS.n1455 VSS.n209 1.34103
R4663 VSS.n2002 VSS.n412 1.33184
R4664 VSS.n1068 VSS.t78 1.32495
R4665 VSS.t529 VSS.n1784 1.31699
R4666 VSS.t164 VSS.t425 1.30819
R4667 VSS.t151 VSS.t126 0.532009
R4668 VSS.n1805 VSS.t530 1.30558
R4669 VSS.n1997 VSS.n412 1.27928
R4670 VSS.n209 VSS.n773 1.27396
R4671 VSS.n239 VSS.n1443 1.27287
R4672 VSS.t529 VSS.n1796 1.27287
R4673 VSS.t529 VSS.n1795 1.27287
R4674 VSS.t529 VSS.n1794 1.27287
R4675 VSS.n1789 VSS.t529 1.27287
R4676 VSS.n751 VSS.n741 1.26873
R4677 VSS.n1972 VSS.n1971 1.25321
R4678 VSS.n1926 VSS.n645 1.24378
R4679 VSS.n958 VSS.n235 1.13878
R4680 VSS.n1996 VSS.t645 1.23892
R4681 VSS.t11 VSS.n582 1.05573
R4682 VSS.n29 VSS.n729 1.22049
R4683 VSS.n225 VSS.n745 1.21506
R4684 VSS.t252 VSS.t78 1.21479
R4685 VSS.n169 VSS.n1658 1.20997
R4686 VSS.n276 VSS.n279 0.961249
R4687 VSS.n226 VSS.n20 0.807581
R4688 VSS.n621 VSS.n620 0.889273
R4689 VSS.n422 VSS.n421 0.88887
R4690 VSS.t241 VSS.t239 1.19217
R4691 VSS.n1995 VSS.n1994 1.15733
R4692 VSS.n1843 VSS.n709 1.15435
R4693 VSS.n1238 VSS.t37 1.14146
R4694 VSS.t11 VSS.t12 1.13822
R4695 VSS.t103 VSS.t205 1.12407
R4696 VSS.t205 VSS.t253 1.12224
R4697 VSS.n393 VSS.n1875 1.23501
R4698 VSS.t123 VSS.t178 1.11749
R4699 VSS.t346 VSS.n1354 1.11246
R4700 VSS.t346 VSS.t123 1.10122
R4701 VSS.t217 VSS.t214 1.1005
R4702 VSS.n1413 VSS.n1339 1.0994
R4703 VSS.t5 VSS.n573 0.929188
R4704 VSS.n600 VSS.n893 0.641882
R4705 VSS.t471 VSS.t626 1.08754
R4706 VSS.n631 VSS.n189 1.00294
R4707 VSS.n845 VSS.n605 0.884926
R4708 VSS.n1962 VSS.n406 0.947314
R4709 VSS.n288 VSS.n46 0.808221
R4710 VSS.n1621 VSS.n293 0.889212
R4711 VSS.n1732 VSS.n313 1.06163
R4712 VSS.n307 VSS.n315 0.88895
R4713 VSS.n113 VSS.n10 0.807155
R4714 VSS.n185 VSS.n1857 0.961061
R4715 VSS.n291 VSS.n290 1.08419
R4716 VSS.n111 VSS.n153 1.08419
R4717 VSS.n286 VSS.n1718 0.667574
R4718 VSS.n1488 VSS.t98 1.08314
R4719 VSS.n1189 VSS.t115 1.08131
R4720 VSS.n1052 VSS.t103 1.07851
R4721 VSS.n1095 VSS.t62 1.07731
R4722 VSS.n556 VSS.t471 0.918487
R4723 VSS.n1923 VSS.n645 1.063
R4724 VSS.n1923 VSS.n161 1.063
R4725 VSS.n1094 VSS.t129 1.06218
R4726 VSS.n984 VSS.n372 1.13163
R4727 VSS.n374 VSS.n373 1.02691
R4728 VSS.n1883 VSS.n400 0.970948
R4729 VSS.n363 VSS.n961 1.02358
R4730 VSS.n229 VSS.n228 1.02358
R4731 VSS.t931 VSS.n1189 1.05352
R4732 VSS.t325 VSS.t421 1.05106
R4733 VSS.t1003 VSS.t1008 1.04852
R4734 VSS.t12 VSS.t7 1.04151
R4735 VSS.n1331 VSS.t27 1.04028
R4736 VSS.t9 VSS.n1488 1.03446
R4737 VSS.n1354 VSS.t137 1.03032
R4738 VSS.n462 VSS.t9 1.08204
R4739 VSS.t172 VSS.t429 1.02759
R4740 VSS.n283 VSS.n52 1.19729
R4741 VSS.t148 VSS.t350 1.02562
R4742 VSS.t343 VSS.n494 0.773915
R4743 VSS.t48 VSS.t20 1.02369
R4744 VSS.t801 VSS.t72 1.02168
R4745 VSS.n1190 VSS.t926 1.01278
R4746 VSS.n1096 VSS.t677 1.01278
R4747 VSS.t425 VSS.n559 0.753751
R4748 VSS.n1094 VSS.t711 1.00313
R4749 VSS.n1192 VSS.t920 1.00279
R4750 VSS.n72 VSS.n1642 0.718344
R4751 VSS.t677 VSS.n1097 0.987788
R4752 VSS.t931 VSS.n1190 0.9876
R4753 VSS.t684 VSS.n1096 0.9876
R4754 VSS.t126 VSS.t6 0.986045
R4755 VSS.n510 VSS.t25 1.11239
R4756 VSS.n670 VSS.n880 0.983165
R4757 VSS.n817 VSS.n617 0.706537
R4758 VSS.n784 VSS.n158 0.979554
R4759 VSS.n58 VSS.n1580 1.02464
R4760 VSS.n348 VSS.n347 0.556079
R4761 VSS.n551 VSS.t166 0.738827
R4762 VSS.n486 VSS.t35 0.800123
R4763 VSS.n27 VSS.n1567 1.2908
R4764 VSS.n1460 VSS.n1452 0.951673
R4765 VSS.n703 VSS.n1464 0.951673
R4766 VSS.n768 VSS.n765 0.951673
R4767 VSS.n761 VSS.n759 0.951673
R4768 VSS.n4 VSS.n151 1.42288
R4769 VSS.n1191 VSS.t5 0.950274
R4770 VSS.n998 VSS.t1008 0.932151
R4771 VSS.n1191 VSS.t115 0.931401
R4772 VSS.t926 VSS.n1192 0.931164
R4773 VSS.t626 VSS.t154 0.930397
R4774 VSS.n1095 VSS.t129 0.930396
R4775 VSS.n632 VSS.n819 1.01043
R4776 VSS.n569 VSS.t84 0.993067
R4777 VSS.t592 VSS.n273 0.774677
R4778 VSS.n721 VSS.n711 0.923577
R4779 VSS.n981 VSS.n724 0.923577
R4780 VSS.n1239 VSS.t190 0.922974
R4781 VSS.n319 VSS.n19 2.03153
R4782 VSS.n1571 VSS.n1570 0.916724
R4783 VSS.n1875 VSS.n960 0.911715
R4784 VSS.n370 VSS.n369 0.910317
R4785 VSS.t801 VSS.t805 0.91001
R4786 VSS.n32 VSS.n289 1.41919
R4787 VSS.t18 VSS.t1003 0.905709
R4788 VSS.n1943 VSS.n1932 0.904333
R4789 VSS.n1677 VSS.n977 0.904333
R4790 VSS.n170 VSS.n58 1.14826
R4791 VSS.n312 VSS.n116 0.477301
R4792 VSS.n1638 VSS.n296 1.0423
R4793 VSS.n626 VSS.n784 1.11997
R4794 VSS.n296 VSS.n72 1.72142
R4795 VSS.n13 VSS.n12 0.888918
R4796 VSS.n1945 VSS.n640 0.88679
R4797 VSS.n1239 VSS.t94 0.882811
R4798 VSS.n549 VSS.n469 0.734091
R4799 VSS.n34 VSS.n105 1.3777
R4800 VSS.t271 VSS.t421 0.87441
R4801 VSS.n119 VSS.n312 1.23675
R4802 VSS.n1331 VSS.t20 0.869338
R4803 VSS.n639 VSS.n1945 0.984051
R4804 VSS.n288 VSS.n6 1.54779
R4805 VSS.n17 VSS.n589 1.48643
R4806 VSS.n584 VSS.n113 1.03794
R4807 VSS.n346 VSS.n153 0.863732
R4808 VSS.t672 VSS.n1097 0.863441
R4809 VSS.t118 VSS.t87 0.862321
R4810 VSS.t125 VSS.n458 0.8505
R4811 VSS.n1942 VSS.n776 0.8475
R4812 VSS.n1705 VSS.n1693 0.8475
R4813 VSS.t133 VSS.n549 0.921068
R4814 VSS.t137 VSS.t805 0.844114
R4815 VSS.n1958 VSS.n190 0.843833
R4816 VSS.n1959 VSS.n1958 0.843833
R4817 VSS.n1959 VSS.n1887 0.843833
R4818 VSS.n1887 VSS.n1886 0.843833
R4819 VSS.n1829 VSS.n962 0.843833
R4820 VSS.n1830 VSS.n1829 0.843833
R4821 VSS.n1831 VSS.n1830 0.843833
R4822 VSS.n617 VSS.n612 1.10821
R4823 VSS.t98 VSS.t643 0.836146
R4824 VSS.n880 VSS.n879 0.823699
R4825 VSS.n37 VSS.n947 1.1724
R4826 VSS.n422 VSS.n416 1.06378
R4827 VSS.n621 VSS.n1986 0.944022
R4828 VSS.n226 VSS.n941 0.983595
R4829 VSS.n1653 VSS.n55 0.943934
R4830 VSS.n1158 VSS.t154 0.81514
R4831 VSS.n1658 VSS.n1581 0.810769
R4832 VSS.n55 VSS.n298 1.06899
R4833 VSS.n1570 VSS.n237 0.808739
R4834 VSS.n498 VSS.n185 1.02583
R4835 VSS.n315 VSS.n317 1.05579
R4836 VSS.n187 VSS.n635 1.09106
R4837 VSS.n320 VSS.n319 0.804312
R4838 VSS.n406 VSS.n408 1.07333
R4839 VSS.n274 VSS.n43 1.34752
R4840 VSS.n605 VSS.n844 0.952617
R4841 VSS.t48 VSS.n486 0.0764963
R4842 VSS.n494 VSS.t643 0.111128
R4843 VSS.n284 VSS.n286 1.06397
R4844 VSS.n1989 VSS.n777 0.7925
R4845 VSS.n383 VSS.n381 0.98986
R4846 VSS.n1527 VSS.n729 0.784708
R4847 VSS.n594 VSS.n600 1.05209
R4848 VSS.n60 VSS.n1539 1.18211
R4849 VSS.n1593 VSS.n300 0.879986
R4850 VSS.t184 VSS.n559 1.42829
R4851 VSS.n1413 VSS.t805 0.75077
R4852 VSS.n998 VSS.t464 0.74158
R4853 VSS.n862 VSS.n848 0.741167
R4854 VSS.n1625 VSS.n1611 0.741167
R4855 VSS.n378 VSS.n745 0.964049
R4856 VSS.n284 VSS.n52 1.24531
R4857 VSS.n569 VSS.n439 0.611137
R4858 VSS.n1745 VSS.n140 0.727552
R4859 VSS.n273 VSS.t271 0.0671671
R4860 VSS.n1919 VSS.n1904 0.721
R4861 VSS.n205 VSS.n401 0.973493
R4862 VSS.n1526 VSS.n1525 0.707059
R4863 VSS.n368 VSS.n968 0.952307
R4864 VSS.n1675 VSS.n41 1.06175
R4865 VSS.n1840 VSS.n319 0.703475
R4866 VSS.n894 VSS.n877 0.700833
R4867 VSS.n1655 VSS.n1643 0.700833
R4868 VSS.n4 VSS.n909 1.1381
R4869 VSS.n1570 VSS.n1569 0.693998
R4870 VSS.n722 VSS.n713 0.692808
R4871 VSS.n1842 VSS.n716 0.692808
R4872 VSS.n557 VSS.t184 0.0993167
R4873 VSS.n1339 VSS.t178 0.691183
R4874 VSS.t91 VSS.t61 0.690949
R4875 VSS.n1066 VSS.t78 0.68391
R4876 VSS.n1212 VSS.t193 0.68391
R4877 VSS.n1995 VSS.n752 0.6715
R4878 VSS.n1886 VSS.t413 0.6715
R4879 VSS.n1887 VSS.t436 0.6715
R4880 VSS.n1960 VSS.n1959 0.6715
R4881 VSS.n1958 VSS.n1888 0.6715
R4882 VSS.t544 VSS.n962 0.6715
R4883 VSS.n1829 VSS.t439 0.6715
R4884 VSS.n1830 VSS.n373 0.6715
R4885 VSS.n1832 VSS.n1831 0.6715
R4886 VSS.n945 VSS.n425 0.547417
R4887 VSS.n626 VSS.n62 1.41254
R4888 VSS.t69 VSS.n495 0.666899
R4889 VSS.t69 VSS.n496 0.666899
R4890 VSS.t125 VSS.n460 0.666899
R4891 VSS.t125 VSS.n461 0.666899
R4892 VSS.t125 VSS.n456 0.666899
R4893 VSS.n1015 VSS.t518 0.666899
R4894 VSS.n1017 VSS.t518 0.666899
R4895 VSS.n1018 VSS.t518 0.666899
R4896 VSS.t515 VSS.n505 0.666899
R4897 VSS.n1086 VSS.t78 0.666899
R4898 VSS.n1089 VSS.t78 0.666899
R4899 VSS.t78 VSS.n487 0.666899
R4900 VSS.n490 VSS.n489 0.666899
R4901 VSS.t266 VSS.n1307 0.666899
R4902 VSS.t266 VSS.n1323 0.666899
R4903 VSS.n1313 VSS.t331 0.666899
R4904 VSS.n1333 VSS.t106 0.666899
R4905 VSS.n468 VSS.n545 0.666899
R4906 VSS.n1255 VSS.t94 0.666899
R4907 VSS.n1240 VSS.t94 0.666899
R4908 VSS.n1247 VSS.t94 0.666899
R4909 VSS.n1232 VSS.t606 0.666899
R4910 VSS.n1233 VSS.t606 0.666899
R4911 VSS.t393 VSS.n429 0.666899
R4912 VSS.t393 VSS.n430 0.666899
R4913 VSS.n1438 VSS.t393 0.666899
R4914 VSS.n1440 VSS.t393 0.666899
R4915 VSS.n1181 VSS.t151 0.666899
R4916 VSS.n910 VSS.n906 0.666
R4917 VSS.n1656 VSS.n1596 0.666
R4918 VSS.t832 VSS.t58 0.665198
R4919 VSS.n196 VSS.t241 1.37864
R4920 VSS.n1692 VSS.n12 0.661065
R4921 VSS.n752 VSS.n745 0.658375
R4922 VSS.n1945 VSS.n1944 0.658286
R4923 VSS.t125 VSS.n459 0.655024
R4924 VSS.t125 VSS.n457 0.655024
R4925 VSS.n1083 VSS.t78 0.655024
R4926 VSS.n1258 VSS.t94 0.655024
R4927 VSS.n1435 VSS.t393 0.655024
R4928 VSS.n1886 VSS.t241 0.653167
R4929 VSS.n391 VSS.n2007 0.899189
R4930 VSS.n1043 VSS.t518 0.649813
R4931 VSS.n1045 VSS.t518 0.649813
R4932 VSS.t515 VSS.n501 0.649813
R4933 VSS.t515 VSS.n508 0.649813
R4934 VSS.t515 VSS.n507 0.649813
R4935 VSS.n74 VSS.n85 0.649813
R4936 VSS.n74 VSS.n90 0.649813
R4937 VSS.n74 VSS.n89 0.649813
R4938 VSS.n74 VSS.n87 0.649813
R4939 VSS.n74 VSS.n88 0.649813
R4940 VSS.n83 VSS.n75 0.649813
R4941 VSS.n83 VSS.n76 0.649813
R4942 VSS.n83 VSS.n78 0.649813
R4943 VSS.n83 VSS.n77 0.649813
R4944 VSS.n83 VSS.n79 0.649813
R4945 VSS.n83 VSS.n80 0.649813
R4946 VSS.n83 VSS.n82 0.649813
R4947 VSS.n83 VSS.n81 0.649813
R4948 VSS.n511 VSS.n83 0.0258175
R4949 VSS.n1413 VSS.n1010 0.649813
R4950 VSS.n1413 VSS.n1411 0.649813
R4951 VSS.n1413 VSS.n1409 0.649813
R4952 VSS.n1413 VSS.n1407 0.649813
R4953 VSS.n1413 VSS.n1342 0.649813
R4954 VSS.n1413 VSS.n1348 0.649813
R4955 VSS.n1413 VSS.n1349 0.649813
R4956 VSS.n1413 VSS.n1399 0.649813
R4957 VSS.n1413 VSS.n1397 0.649813
R4958 VSS.n1413 VSS.n1353 0.649813
R4959 VSS.n1413 VSS.n1394 0.649813
R4960 VSS.n1413 VSS.n1393 0.649813
R4961 VSS.n1413 VSS.n1389 0.649813
R4962 VSS.n1413 VSS.n1360 0.649813
R4963 VSS.n1413 VSS.n1361 0.649813
R4964 VSS.n1413 VSS.n1363 0.649813
R4965 VSS.n1413 VSS.n1385 0.649813
R4966 VSS.n1413 VSS.n1367 0.649813
R4967 VSS.n1413 VSS.n1381 0.649813
R4968 VSS.n1413 VSS.n1378 0.649813
R4969 VSS.n1413 VSS.n1374 0.649813
R4970 VSS.t266 VSS.n1009 0.649813
R4971 VSS.t266 VSS.n1302 0.649813
R4972 VSS.t266 VSS.n1303 0.649813
R4973 VSS.t266 VSS.n1328 0.649813
R4974 VSS.t266 VSS.n1326 0.649813
R4975 VSS.n469 VSS.n466 0.649813
R4976 VSS.n469 VSS.n464 0.649813
R4977 VSS.n1292 VSS.n469 0.649813
R4978 VSS.n1286 VSS.n469 0.649813
R4979 VSS.n469 VSS.n463 0.649813
R4980 VSS.t109 VSS.n130 0.649813
R4981 VSS.t109 VSS.n129 0.649813
R4982 VSS.t109 VSS.n128 0.649813
R4983 VSS.t606 VSS.n338 0.649813
R4984 VSS.t606 VSS.n327 0.649813
R4985 VSS.t606 VSS.n336 0.649813
R4986 VSS.t606 VSS.n329 0.649813
R4987 VSS.t606 VSS.n331 0.649813
R4988 VSS.n1236 VSS.t606 0.649813
R4989 VSS.n439 VSS.n437 0.649813
R4990 VSS.n439 VSS.n436 0.649813
R4991 VSS.n439 VSS.n433 0.649813
R4992 VSS.n439 VSS.n434 0.649813
R4993 VSS.n439 VSS.n435 0.649813
R4994 VSS.n564 VSS.n439 0.0258175
R4995 VSS.n442 VSS.n355 0.0258175
R4996 VSS.n358 VSS.n357 0.00196766
R4997 VSS.n1427 VSS.t393 0.649813
R4998 VSS.n1186 VSS.t151 0.649813
R4999 VSS.n104 VSS.n98 0.00196766
R5000 VSS.n427 VSS.n98 0.0258175
R5001 VSS.n428 VSS.n100 0.0258175
R5002 VSS.n918 VSS.n672 0.649698
R5003 VSS.t66 VSS.n547 0.526214
R5004 VSS.n1013 VSS.t518 0.648101
R5005 VSS.t515 VSS.n506 0.648101
R5006 VSS.t78 VSS.n488 0.648101
R5007 VSS.n1318 VSS.t331 0.648101
R5008 VSS.n1227 VSS.t606 0.648101
R5009 VSS.t552 VSS.n93 0.648101
R5010 VSS.t393 VSS.n431 0.648101
R5011 VSS.n875 VSS.n863 0.648051
R5012 VSS.t429 VSS.t88 0.647627
R5013 VSS.n510 VSS.t22 0.541264
R5014 VSS.n1456 VSS.n245 11.5429
R5015 VSS.n699 VSS.n1465 0.634615
R5016 VSS.n1998 VSS.n766 0.634615
R5017 VSS.n944 VSS.n943 0.629333
R5018 VSS.n931 VSS.n920 0.629333
R5019 VSS.t69 VSS.n998 0.622016
R5020 VSS.n785 VSS.n784 0.621208
R5021 VSS.t109 VSS.n551 0.518648
R5022 VSS.t62 VSS.t75 0.607838
R5023 VSS.n1858 VSS.n475 0.776243
R5024 VSS.n1096 VSS.t518 0.605685
R5025 VSS.n1190 VSS.t393 0.605685
R5026 VSS.n389 VSS.n1466 0.72404
R5027 VSS.n589 VSS.n588 0.593455
R5028 VSS.n311 VSS.n1733 0.593455
R5029 VSS.n6 VSS.n287 0.728619
R5030 VSS.n1474 VSS.n1471 0.603955
R5031 VSS.n1474 VSS.n1473 0.601371
R5032 VSS.n1884 VSS.n1883 0.598167
R5033 VSS.t239 VSS.n960 0.598167
R5034 VSS.n1885 VSS.n961 0.598167
R5035 VSS.n1238 VSS.t52 0.592647
R5036 VSS.n861 VSS.n153 0.589466
R5037 VSS.n1610 VSS.n290 0.589466
R5038 VSS.t82 VSS.t25 0.584914
R5039 VSS.n1927 VSS.n1926 0.582501
R5040 VSS.n230 VSS.n229 0.39639
R5041 VSS.n1875 VSS.n396 0.560228
R5042 VSS.n363 VSS.n361 0.39639
R5043 VSS.n400 VSS.n399 0.470947
R5044 VSS.n375 VSS.n374 0.39565
R5045 VSS.n372 VSS.n1832 0.974206
R5046 VSS.n1192 VSS.t393 0.553645
R5047 VSS.t125 VSS.n462 0.470295
R5048 VSS.n1466 VSS.n772 0.54743
R5049 VSS.n1883 VSS.n684 0.546892
R5050 VSS.n771 VSS.n390 0.643447
R5051 VSS.n931 VSS.n34 18.8595
R5052 VSS.n609 VSS.n847 0.545858
R5053 VSS.n107 VSS.t436 0.735165
R5054 VSS.n475 VSS.t413 0.642821
R5055 VSS.n1658 VSS.n1657 0.535239
R5056 VSS.n1191 VSS.t393 0.520336
R5057 VSS.t606 VSS.n1158 0.51902
R5058 VSS.t429 VSS.t606 0.513485
R5059 VSS.t902 VSS.t182 0.513265
R5060 VSS.t439 VSS.n717 0.781392
R5061 VSS.t902 VSS.n571 0.0922555
R5062 VSS.t27 VSS.t260 0.503743
R5063 VSS.n1540 VSS.n729 0.503621
R5064 VSS.n326 VSS.t544 0.644416
R5065 VSS.n1111 VSS.t174 0.49816
R5066 VSS.n1878 VSS.n961 0.498096
R5067 VSS.n1827 VSS.n373 0.498096
R5068 VSS.n1563 VSS.n228 0.498096
R5069 VSS.n230 VSS.n227 0.493752
R5070 VSS.n572 VSS.t905 0.382846
R5071 VSS.t645 VSS.n1995 0.490917
R5072 VSS.n114 VSS.n641 1.23523
R5073 VSS.t118 VSS.t606 0.472722
R5074 VSS.n1720 VSS.n1719 0.471667
R5075 VSS.t529 VSS.t325 0.470139
R5076 VSS.n1097 VSS.t518 0.467653
R5077 VSS.t69 VSS.t1003 0.464129
R5078 VSS.n1331 VSS.t266 0.462359
R5079 VSS.n975 VSS.t543 0.462038
R5080 VSS.n971 VSS.n708 0.462038
R5081 VSS.n1747 VSS.n140 0.460402
R5082 VSS.t253 VSS.n1053 0.454734
R5083 VSS.n1941 VSS.n655 0.447566
R5084 VSS.n1988 VSS.n619 0.639884
R5085 VSS.n942 VSS.n426 0.639884
R5086 VSS.n1838 VSS.n323 0.639884
R5087 VSS.n1595 VSS.n301 0.593455
R5088 VSS.n1654 VSS.n733 0.447566
R5089 VSS.n1704 VSS.n277 0.593455
R5090 VSS.n1676 VSS.n132 0.593455
R5091 VSS.n1624 VSS.n178 0.578676
R5092 VSS.n1749 VSS.n1526 0.440921
R5093 VSS.n876 VSS.n863 0.440921
R5094 VSS.t69 VSS.t17 0.436397
R5095 VSS.n641 VSS.n1905 1.02336
R5096 VSS.n573 VSS.t113 0.0478915
R5097 VSS.n1722 VSS.n1541 0.424
R5098 VSS.t125 VSS.n1488 0.42351
R5099 VSS.n499 VSS.t343 0.510925
R5100 VSS.n582 VSS.t350 0.443043
R5101 VSS.n559 VSS.t101 0.532156
R5102 VSS.n1413 VSS.t72 0.404364
R5103 VSS.t151 VSS.t12 0.396726
R5104 VSS.n919 VSS.n672 0.393331
R5105 VSS.n1052 VSS.t78 0.388126
R5106 VSS.t205 VSS.t78 0.38812
R5107 VSS.n1095 VSS.t518 0.386666
R5108 VSS.t91 VSS.t518 0.378278
R5109 VSS.t172 VSS.n556 1.0648
R5110 VSS.n1990 VSS.n1989 0.372667
R5111 VSS.t606 VSS.t626 0.370777
R5112 VSS.t148 VSS.t64 0.36683
R5113 VSS.n124 VSS.t54 0.227832
R5114 VSS.n326 VSS.n968 0.774435
R5115 VSS.n1189 VSS.t393 0.357708
R5116 VSS.n1750 VSS.n317 0.472995
R5117 VSS.n1623 VSS.n1622 0.356631
R5118 VSS.n1552 VSS.n288 0.991918
R5119 VSS.n908 VSS.n151 0.356631
R5120 VSS.n1745 VSS.n312 1.18271
R5121 VSS.n1732 VSS.n311 0.771313
R5122 VSS.n1581 VSS.n1580 0.356631
R5123 VSS.n1413 VSS.t123 0.352554
R5124 VSS.n1553 VSS.n1552 0.352321
R5125 VSS.n1339 VSS.t273 0.347348
R5126 VSS.n1927 VSS.n1920 0.345198
R5127 VSS.t22 VSS.n500 0.437362
R5128 VSS.t739 VSS.n523 0.433869
R5129 VSS.t736 VSS.n522 0.433869
R5130 VSS.n518 VSS.t724 0.433869
R5131 VSS.n519 VSS.t727 0.433869
R5132 VSS.n520 VSS.t730 0.433869
R5133 VSS.t733 VSS.n521 0.433709
R5134 VSS.t510 VSS.n270 0.434702
R5135 VSS.n1052 VSS.t263 0.341688
R5136 VSS.t1066 VSS.n270 0.238428
R5137 VSS.t730 VSS.n521 0.235876
R5138 VSS.n523 VSS.t736 0.235729
R5139 VSS.t722 VSS.n518 0.235729
R5140 VSS.t724 VSS.n519 0.235729
R5141 VSS.t727 VSS.n520 0.235729
R5142 VSS.t733 VSS.n522 0.235729
R5143 VSS.n1720 VSS.n1554 0.321333
R5144 VSS.t509 VSS.n758 0.317558
R5145 VSS.t515 VSS.n1111 0.307048
R5146 VSS.n550 VSS.t858 0.0850573
R5147 VSS.t1053 VSS.n265 0.215686
R5148 VSS.t263 VSS.n541 1.21142
R5149 VSS.t432 VSS.t90 0.301114
R5150 VSS.t775 VSS.t776 0.301114
R5151 VSS.t562 VSS.t237 0.301114
R5152 VSS.t771 VSS.t770 0.301114
R5153 VSS.t776 VSS.t777 0.300775
R5154 VSS.t90 VSS.t511 0.300775
R5155 VSS.t769 VSS.t770 0.300775
R5156 VSS.n984 VSS.n386 0.766938
R5157 VSS.n2007 VSS.n692 0.299608
R5158 VSS.n1858 VSS.n1857 0.299566
R5159 VSS.n420 VSS.n416 0.458448
R5160 VSS.n408 VSS.n1961 0.30202
R5161 VSS.n401 VSS.n1956 0.476049
R5162 VSS.n1836 VSS.n1835 0.297623
R5163 VSS.n1987 VSS.n621 0.893541
R5164 VSS.n819 VSS.n818 0.297623
R5165 VSS.n345 VSS.n112 0.356403
R5166 VSS.n392 VSS.n1455 0.519477
R5167 VSS.n1571 VSS.n27 1.23521
R5168 VSS.n1621 VSS.n178 0.803796
R5169 VSS.n1930 VSS.n643 0.519513
R5170 VSS.n314 VSS.n313 1.12715
R5171 VSS.n1594 VSS.n303 0.519513
R5172 VSS.n1638 VSS.n294 0.415026
R5173 VSS.n1622 VSS.n293 0.94842
R5174 VSS.n1610 VSS.n32 1.07563
R5175 VSS.n282 VSS.n279 1.02349
R5176 VSS.n1835 VSS.n165 1.02573
R5177 VSS.n603 VSS.n189 1.06834
R5178 VSS.n591 VSS.n17 1.17807
R5179 VSS.n947 VSS.n946 0.297283
R5180 VSS.n1986 VSS.n619 0.822065
R5181 VSS.n632 VSS.n612 1.17489
R5182 VSS.n844 VSS.n609 0.718071
R5183 VSS.n347 VSS.n346 1.14241
R5184 VSS.n594 VSS.n880 0.999433
R5185 VSS.n941 VSS.n426 0.822065
R5186 VSS.n419 VSS.n684 0.780481
R5187 VSS.n393 VSS.n397 0.888227
R5188 VSS.n60 VSS.n1527 1.17863
R5189 VSS.n300 VSS.n301 0.8876
R5190 VSS.n298 VSS.n733 0.720921
R5191 VSS.n290 VSS.n289 1.09266
R5192 VSS.n12 VSS.n274 1.16882
R5193 VSS.n41 VSS.n132 1.48639
R5194 VSS.n383 VSS.n382 0.574343
R5195 VSS.n1941 VSS.n637 0.336476
R5196 VSS.n22 VSS.n226 1.10919
R5197 VSS.n1703 VSS.n282 0.406948
R5198 VSS.n905 VSS.n591 0.406948
R5199 VSS.n1239 VSS.t37 0.285332
R5200 VSS.n969 VSS.n379 0.400409
R5201 VSS.t54 VSS.t52 0.269894
R5202 VSS.t114 VSS.t393 0.266125
R5203 VSS.n1111 VSS.t82 0.261698
R5204 VSS.t918 VSS.t283 0.251828
R5205 VSS.t787 VSS.t766 0.241078
R5206 VSS.n525 VSS.t775 0.119605
R5207 VSS.t777 VSS.t778 0.241078
R5208 VSS.n447 VSS.t432 0.53223
R5209 VSS.t35 VSS.t293 0.241078
R5210 VSS.t511 VSS.n127 0.210995
R5211 VSS.t766 VSS.t767 0.241078
R5212 VSS.t778 VSS.t779 0.241078
R5213 VSS.t361 VSS.t295 0.241078
R5214 VSS.t764 VSS.t765 0.241078
R5215 VSS.t1202 VSS.n449 0.119605
R5216 VSS.t1233 VSS.t417 0.241078
R5217 VSS.t372 VSS.t1233 0.241078
R5218 VSS.n443 VSS.t372 0.235599
R5219 VSS.t283 VSS.t86 0.241078
R5220 VSS.t774 VSS.t794 0.241078
R5221 VSS.t773 VSS.t774 0.241078
R5222 VSS.t772 VSS.t773 0.241078
R5223 VSS.t771 VSS.t772 0.241078
R5224 VSS.t767 VSS.t768 0.241078
R5225 VSS.n526 VSS.t769 0.119605
R5226 VSS.t765 VSS.t787 0.241078
R5227 VSS.n410 VSS.n1962 0.827509
R5228 VSS.n405 VSS.n205 1.43248
R5229 VSS.n379 VSS.n368 1.01117
R5230 VSS.n1827 VSS.n325 0.665128
R5231 VSS.n325 VSS.n374 1.3109
R5232 VSS.n2008 VSS.n390 0.715939
R5233 VSS.n1471 VSS.n66 0.358554
R5234 VSS.n1473 VSS.n1472 0.239982
R5235 VSS.n1472 VSS.n389 0.358554
R5236 VSS.n542 VSS.t848 0.0946685
R5237 VSS.n1642 VSS.n294 0.282257
R5238 VSS.n1718 VSS.n283 0.282257
R5239 VSS.n1692 VSS.n64 0.282257
R5240 VSS.n43 VSS.n64 1.19453
R5241 VSS.n1903 VSS.n647 0.238275
R5242 VSS.n1901 VSS.n647 0.238275
R5243 VSS.n62 VSS.n787 1.13843
R5244 VSS.n893 VSS.n599 0.282257
R5245 VSS.n878 VSS.n599 0.356017
R5246 VSS.n879 VSS.n878 0.238275
R5247 VSS.n587 VSS.n584 0.47376
R5248 VSS.n34 VSS.n33 0.912681
R5249 VSS.n635 VSS.n655 0.663367
R5250 VSS.n347 VSS.n345 1.07793
R5251 VSS.n631 VSS.n875 0.356017
R5252 VSS.n363 VSS.n685 1.30536
R5253 VSS.n1563 VSS.n387 0.664292
R5254 VSS.n387 VSS.n229 1.30536
R5255 VSS.n165 VSS.n323 1.49839
R5256 VSS.n19 VSS.n1841 1.34818
R5257 VSS.n276 VSS.n277 0.830047
R5258 VSS.n1747 VSS.n119 0.281874
R5259 VSS.n1568 VSS.n1567 0.237693
R5260 VSS.n861 VSS.n112 0.281874
R5261 VSS.n1837 VSS.n1836 0.231236
R5262 VSS.n846 VSS.n610 0.348979
R5263 VSS.t42 VSS.t837 0.227075
R5264 VSS.t851 VSS.t850 0.227075
R5265 VSS.t60 VSS.t834 0.227075
R5266 VSS.t784 VSS.t782 0.227075
R5267 VSS.t1026 VSS.t1024 0.227075
R5268 VSS.t592 VSS.t1073 0.226736
R5269 VSS.t1068 VSS.t1070 0.226736
R5270 VSS.t1064 VSS.t1066 0.226736
R5271 VSS.t1061 VSS.t1059 0.226736
R5272 VSS.t720 VSS.t718 0.226736
R5273 VSS.t841 VSS.t843 0.226736
R5274 VSS.t45 VSS.t845 0.226736
R5275 VSS.n133 VSS.t853 0.135098
R5276 VSS.t889 VSS.t887 0.226736
R5277 VSS.t894 VSS.t892 0.226736
R5278 VSS.t899 VSS.t897 0.226736
R5279 VSS.t111 VSS.t914 0.226736
R5280 VSS.t959 VSS.t957 0.226736
R5281 VSS.t964 VSS.t962 0.226736
R5282 VSS.t969 VSS.t967 0.226736
R5283 VSS.t974 VSS.t972 0.226736
R5284 VSS.t979 VSS.t977 0.226736
R5285 VSS.t984 VSS.t982 0.226736
R5286 VSS.t1029 VSS.t1031 0.226736
R5287 VSS.t1036 VSS.t1034 0.226736
R5288 VSS.t1039 VSS.t1041 0.226736
R5289 VSS.t1046 VSS.t1044 0.226736
R5290 VSS.t1049 VSS.t1051 0.226736
R5291 VSS.t485 VSS.t741 0.226736
R5292 VSS.t231 VSS.t722 0.224575
R5293 VSS.n1750 VSS.n1749 0.223862
R5294 VSS.n1624 VSS.n1623 0.223862
R5295 VSS.n876 VSS.n603 0.340225
R5296 VSS.n1540 VSS.n1539 0.223523
R5297 VSS.n818 VSS.n817 0.223523
R5298 VSS.n909 VSS.n908 0.223523
R5299 VSS.n1992 VSS.n774 0.2205
R5300 VSS.n269 VSS.t1064 0.0863258
R5301 VSS.t1073 VSS.n272 0.0863258
R5302 VSS.t1068 VSS.n271 0.0863258
R5303 VSS.t1028 VSS.n258 0.130189
R5304 VSS.n260 VSS.t1039 0.0863258
R5305 VSS.n264 VSS.t1049 0.0863258
R5306 VSS.t1044 VSS.n261 0.0863258
R5307 VSS.t1034 VSS.n259 0.0863258
R5308 VSS.n546 VSS.t841 0.0863258
R5309 VSS.t845 VSS.t844 0.218325
R5310 VSS.t897 VSS.n568 0.0863258
R5311 VSS.n566 VSS.t886 0.130189
R5312 VSS.t892 VSS.n567 0.0863258
R5313 VSS.t84 VSS.n570 0.130189
R5314 VSS.n575 VSS.t956 0.130189
R5315 VSS.t962 VSS.n576 0.0863258
R5316 VSS.t967 VSS.n577 0.0863258
R5317 VSS.t972 VSS.n578 0.0863258
R5318 VSS.t977 VSS.n579 0.0863258
R5319 VSS.t982 VSS.n580 0.0863258
R5320 VSS.n524 VSS.t739 0.130189
R5321 VSS.n516 VSS.t717 0.130189
R5322 VSS.t1059 VSS.n267 0.0863258
R5323 VSS.t160 VSS.t850 0.217986
R5324 VSS.t58 VSS.n548 0.129991
R5325 VSS.t749 VSS.n517 0.129991
R5326 VSS.n540 VSS.t782 0.0861948
R5327 VSS.n1413 VSS.n1354 0.215222
R5328 VSS.n1931 VSS.n1905 0.211517
R5329 VSS.t684 VSS.t711 0.209894
R5330 VSS.t858 VSS.t50 0.209256
R5331 VSS.n1734 VSS.n1722 0.205833
R5332 VSS.t66 VSS.n1151 0.204087
R5333 VSS.t403 VSS.t918 0.197809
R5334 VSS.t616 VSS.n1053 0.190555
R5335 VSS.n1158 VSS.t144 0.189273
R5336 VSS.n413 VSS.n412 0.187792
R5337 VSS.n210 VSS.n209 0.186001
R5338 VSS.n1956 VSS.n1955 0.184975
R5339 VSS.n1994 VSS.n1993 0.183833
R5340 VSS.t1122 VSS.t361 0.180789
R5341 VSS.n451 VSS.t31 0.299894
R5342 VSS.t854 VSS.t40 0.24604
R5343 VSS.t417 VSS.n561 0.238594
R5344 VSS.n787 VSS.n786 0.178685
R5345 VSS.n1094 VSS.t518 0.17168
R5346 VSS.t779 VSS.t780 0.167039
R5347 VSS.t40 VSS.n483 0.083315
R5348 VSS.n127 VSS.t160 0.187065
R5349 VSS.n1841 VSS.n1840 0.164514
R5350 VSS.n1944 VSS.n1903 0.164514
R5351 VSS.n919 VSS.n587 0.282257
R5352 VSS.n946 VSS.n945 0.164514
R5353 VSS.t151 VSS.n160 0.159098
R5354 VSS.t764 VSS.t186 0.158289
R5355 VSS.t33 VSS.t837 0.150486
R5356 VSS.t464 VSS.t1024 0.150486
R5357 VSS.t515 VSS.n504 0.145678
R5358 VSS.t1229 VSS.t1202 0.138289
R5359 VSS.n1828 VSS.n375 0.1373
R5360 VSS.t1056 VSS.t1054 0.135506
R5361 VSS.n415 VSS.n1997 0.352294
R5362 VSS.t544 VSS.n969 0.132082
R5363 VSS.t413 VSS.n498 0.132082
R5364 VSS.n581 VSS.t1000 0.0476546
R5365 VSS.n287 VSS.n1553 0.109767
R5366 VSS.n1654 VSS.n299 0.224521
R5367 VSS.n942 VSS.n22 0.224521
R5368 VSS.n715 VSS.t539 9.69813
R5369 VSS.t369 VSS.t852 0.25327
R5370 VSS.n1569 VSS.n1568 0.104924
R5371 VSS.n786 VSS.n785 0.104924
R5372 VSS.t848 VSS.t45 0.103403
R5373 VSS.n555 VSS.t851 0.0346178
R5374 VSS.t1072 VSS.t1070 0.0855
R5375 VSS.t1063 VSS.t1061 0.0855
R5376 VSS.t1056 VSS.t1058 0.0855
R5377 VSS.t720 VSS.t749 0.0855
R5378 VSS.t780 VSS.t312 0.0855
R5379 VSS.t840 VSS.t42 0.0855
R5380 VSS.t843 VSS.n471 0.0432886
R5381 VSS.t891 VSS.t889 0.0855
R5382 VSS.t896 VSS.t894 0.0855
R5383 VSS.t961 VSS.t959 0.0855
R5384 VSS.t966 VSS.t964 0.0855
R5385 VSS.t971 VSS.t969 0.0855
R5386 VSS.t976 VSS.t974 0.0855
R5387 VSS.t981 VSS.t979 0.0855
R5388 VSS.t1031 VSS.t1033 0.0855
R5389 VSS.t1038 VSS.t1036 0.0855
R5390 VSS.t1041 VSS.t1043 0.0855
R5391 VSS.t1048 VSS.t1046 0.0855
R5392 VSS.t1051 VSS.t1053 0.0855
R5393 VSS.t857 VSS.t56 0.0855
R5394 VSS.t7 VSS.t1000 0.0845024
R5395 VSS.n771 VSS.n365 0.187058
R5396 VSS.n382 VSS.n752 0.240149
R5397 VSS.n385 VSS.n772 0.187058
R5398 VSS.n392 VSS.n773 0.351531
R5399 VSS.n396 VSS.n394 0.0772774
R5400 VSS.n361 VSS.n359 0.0770006
R5401 VSS.t899 VSS.t277 0.07425
R5402 VSS.t905 VSS.t182 0.07425
R5403 VSS.t920 VSS.t919 0.0721489
R5404 VSS.t33 VSS.t133 0.068
R5405 VSS.n2015 VSS.n737 0.0623545
R5406 VSS.n1188 VSS.n737 0.0623545
R5407 VSS.n1193 VSS.n1188 0.0623545
R5408 VSS.n1219 VSS.n1193 0.0623545
R5409 VSS.n1220 VSS.n1219 0.0623545
R5410 VSS.n1220 VSS.n1144 0.0623545
R5411 VSS.n1336 VSS.n1144 0.0623545
R5412 VSS.n1414 VSS.n1336 0.0623545
R5413 VSS.n1415 VSS.n1414 0.0623545
R5414 VSS.n1415 VSS.n1143 0.0623545
R5415 VSS.n1676 VSS.n39 0.167394
R5416 VSS.n1704 VSS.n1703 0.0530519
R5417 VSS.n1595 VSS.n1594 0.0530519
R5418 VSS.n1733 VSS.n314 0.167394
R5419 VSS.n1838 VSS.n1837 0.0530519
R5420 VSS.n588 VSS.n905 0.0530519
R5421 VSS.n847 VSS.n846 0.0530519
R5422 VSS.n1988 VSS.n623 0.167394
R5423 VSS.t854 VSS.t853 0.118377
R5424 VSS.n1931 VSS.n1930 0.0530519
R5425 VSS.n420 VSS.t436 0.132082
R5426 VSS.n1961 VSS.n1960 0.048625
R5427 VSS.n1955 VSS.n1888 0.048625
R5428 VSS.n1151 VSS.t354 0.0381133
R5429 VSS.n718 VSS.n717 0.0110151
R5430 VSS.t125 VSS.n455 0.0271432
R5431 VSS.n1243 VSS.t94 0.0271432
R5432 VSS.n1429 VSS.t393 0.0268175
R5433 VSS.n1317 VSS.t331 0.0266763
R5434 VSS.n1300 VSS.t106 0.0266763
R5435 VSS.t552 VSS.n94 0.0266763
R5436 VSS.n1179 VSS.t151 0.0266763
R5437 VSS.n1023 VSS.t518 0.0258175
R5438 VSS.n1025 VSS.t518 0.0258175
R5439 VSS.n1026 VSS.t518 0.0258175
R5440 VSS.n1028 VSS.t518 0.0258175
R5441 VSS.n1029 VSS.t518 0.0258175
R5442 VSS.n1031 VSS.t518 0.0258175
R5443 VSS.n1032 VSS.t518 0.0258175
R5444 VSS.n1034 VSS.t518 0.0258175
R5445 VSS.n1035 VSS.t518 0.0258175
R5446 VSS.n1037 VSS.t518 0.0258175
R5447 VSS.n1038 VSS.t518 0.0258175
R5448 VSS.n1040 VSS.t518 0.0258175
R5449 VSS.n1041 VSS.t518 0.0258175
R5450 VSS.t515 VSS.n502 0.0258175
R5451 VSS.t515 VSS.n503 0.0258175
R5452 VSS.n74 VSS.n86 0.0258175
R5453 VSS.n515 VSS.n514 0.0258175
R5454 VSS.n1069 VSS.t78 0.0258175
R5455 VSS.n1073 VSS.t78 0.0258175
R5456 VSS.n1413 VSS.n1351 0.0258175
R5457 VSS.n1413 VSS.n1386 0.0258175
R5458 VSS.n1413 VSS.n1384 0.0258175
R5459 VSS.n1413 VSS.n1368 0.0258175
R5460 VSS.n1413 VSS.n1380 0.0258175
R5461 VSS.n1413 VSS.n1372 0.0258175
R5462 VSS.n469 VSS.n467 0.0258175
R5463 VSS.n469 VSS.n465 0.0258175
R5464 VSS.t606 VSS.n339 0.0258175
R5465 VSS.t606 VSS.n337 0.0258175
R5466 VSS.t606 VSS.n328 0.0258175
R5467 VSS.t606 VSS.n330 0.0258175
R5468 VSS.t606 VSS.n334 0.0258175
R5469 VSS.t606 VSS.n333 0.0258175
R5470 VSS.t606 VSS.n332 0.0148803
R5471 VSS.t552 VSS.n95 0.0258175
R5472 VSS.n439 VSS.n438 0.0258175
R5473 VSS.n355 VSS.n441 0.0258175
R5474 VSS.n357 VSS.n356 0.0258175
R5475 VSS.n357 VSS.n354 0.0258175
R5476 VSS.n98 VSS.n102 0.0258175
R5477 VSS.n98 VSS.n103 0.0258175
R5478 VSS.n100 VSS.n97 0.0258175
R5479 VSS.n100 VSS.n99 0.0258175
R5480 VSS.n352 VSS.n351 0.0258175
R5481 VSS.n352 VSS.n349 0.0258175
R5482 VSS.n683 VSS.n399 0.00516532
R5483 VSS.n192 VSS.n191 0.0134392
R5484 VSS.n1970 VSS.n1969 0.0118318
R5485 VSS.n1970 VSS.n951 0.0113687
R5486 VSS.n697 VSS.n696 0.0049982
R5487 VSS.n658 VSS.n618 0.00399997
R5488 VSS.n563 VSS.n125 0.00399966
R5489 VSS.n553 VSS.n126 0.00399966
R5490 VSS.n1881 VSS.n399 0.00399853
R5491 VSS.n361 VSS.n360 0.00391295
R5492 VSS.n558 VSS.t193 0.00389968
R5493 VSS.n396 VSS.n395 0.00382886
R5494 VSS.n667 VSS.n630 0.00374975
R5495 VSS.n734 VSS.n220 0.00249998
R5496 VSS.n1970 VSS.n144 0.00142776
R5497 VSS.n1640 VSS.n1639 0.00229998
R5498 VSS.n280 VSS.n278 0.00224999
R5499 VSS.n544 VSS.t106 0.00319996
R5500 VSS.n642 VSS.n1906 0.00308329
R5501 VSS.n1022 VSS.t518 0.00194928
R5502 VSS.n1413 VSS.n1350 0.00194928
R5503 VSS.n1413 VSS.n1390 0.00194928
R5504 VSS.n1280 VSS.n448 0.00175
R5505 VSS.n663 VSS.n662 0.00183324
R5506 VSS.n1566 VSS.n237 0.00166667
R5507 VSS.n1524 VSS.n181 0.00166667
R5508 VSS.n477 VSS.n476 0.00656105
R5509 VSS.n479 VSS.n478 0.00553879
R5510 VSS.n468 VSS.t106 0.0045
R5511 VSS.n469 VSS.n468 0.004
R5512 VSS.n1482 VSS.t125 0.00387411
R5513 VSS.n482 VSS.n481 0.00166667
R5514 VSS.n563 VSS.n562 0.00138884
R5515 VSS.n667 VSS.n666 0.00138885
R5516 VSS.n624 VSS.n158 0.00166667
R5517 VSS.n616 VSS.n613 0.00169993
R5518 VSS.n109 VSS.n108 0.00143746
R5519 VSS.n874 VSS.n602 0.00335686
R5520 VSS.n598 VSS.n593 0.00349963
R5521 VSS.n145 VSS.n144 0.00146666
R5522 VSS.n1455 VSS.n211 8.47307
R5523 VSS.n695 VSS.n694 0.00143746
R5524 VSS.n236 VSS.n321 0.00368703
R5525 VSS.n1815 VSS.n978 0.00166667
R5526 VSS.n180 VSS.n316 0.00349963
R5527 VSS.n649 VSS.n640 0.00383238
R5528 VSS.n454 VSS.n183 0.00264922
R5529 VSS.n490 VSS.t78 0.0035
R5530 VSS.t266 VSS.t331 0.00349999
R5531 VSS.n342 VSS.n341 0.00349999
R5532 VSS.n634 VSS.n186 0.00349999
R5533 VSS.n585 VSS.n583 0.00349999
R5534 VSS.n583 VSS.n10 0.00349998
R5535 VSS.n497 VSS.n474 0.00349984
R5536 VSS.n613 VSS.n611 0.00329996
R5537 VSS.n658 VSS.n622 0.00324964
R5538 VSS.n663 VSS.n604 0.00316663
R5539 VSS.n627 VSS.n61 0.00312453
R5540 VSS.n74 VSS.t515 0.003
R5541 VSS.n157 VSS.n156 0.00211077
R5542 VSS.n629 VSS.n628 0.00299994
R5543 VSS.n371 VSS.n370 0.00227229
R5544 VSS.n695 VSS.n364 0.00299993
R5545 VSS.n348 VSS.n108 0.00299993
R5546 VSS.n629 VSS.n611 0.00299993
R5547 VSS.n654 VSS.n636 0.00292843
R5548 VSS.n1815 VSS.n322 0.00283329
R5549 VSS.n625 VSS.n624 0.00283329
R5550 VSS.n377 VSS.n376 0.00274975
R5551 VSS.n597 VSS.n671 0.00279984
R5552 VSS.n324 VSS.n375 0.00276359
R5553 VSS.n155 VSS.n110 0.00259933
R5554 VSS.n45 VSS.n44 0.00259995
R5555 VSS.n616 VSS.n615 0.0025
R5556 VSS.n662 VSS.n606 0.0025
R5557 VSS.n608 VSS.n607 0.0025
R5558 VSS.n595 VSS.n598 0.0025
R5559 VSS.n673 VSS.n585 0.0025
R5560 VSS.n597 VSS.n596 0.00144443
R5561 VSS.n634 VSS.n633 0.0016666
R5562 VSS.n341 VSS.n638 0.0016666
R5563 VSS.n608 VSS.n606 0.00249999
R5564 VSS.n644 VSS.n44 0.00249995
R5565 VSS.n601 VSS.n188 0.00224999
R5566 VSS.n671 VSS.n670 0.0022
R5567 VSS.n670 VSS.n592 0.0022
R5568 VSS.n305 VSS.n29 0.00474868
R5569 VSS.n169 VSS.n136 0.00166667
R5570 VSS.n732 VSS.n297 0.00169993
R5571 VSS.n179 VSS.n219 0.00358297
R5572 VSS.n281 VSS.n50 0.00335686
R5573 VSS.n1301 VSS.n543 0.0015
R5574 VSS.n1301 VSS.n452 0.0041663
R5575 VSS.n450 VSS.t94 0.00399999
R5576 VSS.n448 VSS.n446 0.00466596
R5577 VSS.n199 VSS.n198 0.00233283
R5578 VSS.n1482 VSS.t69 0.00287493
R5579 VSS.n9 VSS.n8 0.00211469
R5580 VSS.n106 VSS.n423 0.00324964
R5581 VSS.n535 VSS.n479 0.00316655
R5582 VSS.n531 VSS.n477 0.00316655
R5583 VSS.n355 VSS.n439 0.003
R5584 VSS.t552 VSS.n92 0.003
R5585 VSS.n480 VSS.n450 0.00299999
R5586 VSS.n400 VSS.n419 1.30345
R5587 VSS.n985 VSS.n371 2.12699
R5588 VSS.n560 VSS.t193 0.00501649
R5589 VSS.n357 VSS.n355 0.004
R5590 VSS.n73 VSS.n367 0.00399971
R5591 VSS.n650 VSS.n342 0.00389998
R5592 VSS.n691 VSS.n364 0.00374999
R5593 VSS.t606 VSS.n335 0.00350468
R5594 VSS.n380 VSS.n200 0.00349999
R5595 VSS.n411 VSS.n223 0.0033567
R5596 VSS.n682 VSS.n407 0.00328546
R5597 VSS.n377 VSS.n225 0.00324997
R5598 VSS.n388 VSS.n384 0.0032
R5599 VSS.n367 VSS.n366 0.00308327
R5600 VSS.n413 VSS.n414 0.00249137
R5601 VSS.n445 VSS.n444 0.00299997
R5602 VSS.n150 VSS.n149 0.00211077
R5603 VSS.n409 VSS.n407 0.00299997
R5604 VSS.n404 VSS.n403 0.00299997
R5605 VSS.n65 VSS.n697 0.0029998
R5606 VSS.n399 VSS.n398 0.00295831
R5607 VSS.n324 VSS.n325 4.17885
R5608 VSS.n1971 VSS.n232 0.145164
R5609 VSS.n168 VSS.n15 0.00293029
R5610 VSS.n30 VSS.n31 0.00316462
R5611 VSS.n147 VSS.n36 0.00749934
R5612 VSS.n7 VSS.n46 0.00293452
R5613 VSS.n115 VSS.n18 0.00737988
R5614 VSS.n673 VSS.n10 0.00649949
R5615 VSS.n480 VSS.n9 0.00649906
R5616 VSS.n24 VSS.n23 0.00446649
R5617 VSS.n29 VSS.n59 0.00633192
R5618 VSS.n35 VSS.n33 0.00274592
R5619 VSS.n320 VSS.n49 0.00386046
R5620 VSS.n352 VSS.n100 0.006
R5621 VSS.n552 VSS.t94 0.00599963
R5622 VSS.n558 VSS.n125 0.00599958
R5623 VSS.n152 VSS.n16 0.00594967
R5624 VSS.n57 VSS.n56 0.00589878
R5625 VSS.n21 VSS.n149 0.00588834
R5626 VSS.n727 VSS.n26 0.00398098
R5627 VSS.n203 VSS.n51 0.00555469
R5628 VSS.n131 VSS.n40 0.00554945
R5629 VSS.n141 VSS.n117 0.00535975
R5630 VSS.n291 VSS.n31 0.00220827
R5631 VSS.n404 VSS.n204 0.0049999
R5632 VSS.n201 VSS.n225 0.00552145
R5633 VSS.n515 VSS.n83 0.0055
R5634 VSS.n656 VSS.n61 0.00549993
R5635 VSS.n21 VSS.n20 0.00549971
R5636 VSS.n50 VSS.n275 0.00549962
R5637 VSS.n196 VSS.n195 0.00544295
R5638 VSS.n146 VSS.n45 0.00539957
R5639 VSS.n552 VSS.n122 0.00364122
R5640 VSS.n40 VSS.n134 0.00533288
R5641 VSS.n126 VSS.n121 0.00519993
R5642 VSS.n238 VSS.n28 0.00514982
R5643 VSS.n47 VSS.n71 0.00511036
R5644 VSS.n1640 VSS.n47 0.00508847
R5645 VSS.n654 VSS.n186 0.00507141
R5646 VSS.n3 VSS.n0 0.00348392
R5647 VSS.n322 VSS.n164 0.00427099
R5648 VSS.n176 VSS.n175 0.0045
R5649 VSS.n176 VSS.n174 0.0045
R5650 VSS.n174 VSS.n173 0.0045
R5651 VSS.n167 VSS.n31 0.00279162
R5652 VSS.n172 VSS.n54 0.00449994
R5653 VSS.n166 VSS.n302 0.00449994
R5654 VSS.n198 VSS.n421 0.00449994
R5655 VSS.n212 VSS.n396 0.00237366
R5656 VSS.n118 VSS.n116 0.00449989
R5657 VSS.n222 VSS.n967 0.00449975
R5658 VSS.n98 VSS.t151 0.00449955
R5659 VSS.n42 VSS.n15 0.00206927
R5660 VSS.n166 VSS.n216 0.00449928
R5661 VSS.n138 VSS.n137 0.00441632
R5662 VSS.n143 VSS.n142 0.00439996
R5663 VSS.n307 VSS.n306 0.00439993
R5664 VSS.n630 VSS.n188 0.00424998
R5665 VSS.n184 VSS.n183 0.00419999
R5666 VSS.n211 VSS.n210 0.00148567
R5667 VSS.n239 VSS.n173 0.004
R5668 VSS.n163 VSS.n16 0.00384977
R5669 VSS.n7 VSS.n5 0.00256448
R5670 VSS.n278 VSS.n275 0.0035
R5671 VSS.t529 VSS.n175 0.0035
R5672 VSS.n220 VSS.n219 0.00349999
R5673 VSS.n217 VSS.n216 0.00349999
R5674 VSS.n693 VSS.n68 0.00349999
R5675 VSS.n215 VSS.n204 0.00349999
R5676 VSS.n1639 VSS.n71 0.00349999
R5677 VSS.n194 VSS.n51 0.00349999
R5678 VSS.n224 VSS.n223 0.00349999
R5679 VSS.n148 VSS.n424 0.00314221
R5680 VSS.n157 VSS.n620 0.00349994
R5681 VSS.n150 VSS.n20 0.00349994
R5682 VSS.n143 VSS.n978 0.00349991
R5683 VSS.n656 VSS.n158 0.00349985
R5684 VSS.n171 VSS.n169 0.00314221
R5685 VSS.n285 VSS.n194 0.00349969
R5686 VSS.n297 VSS.n172 0.00349966
R5687 VSS.n237 VSS.n236 0.00333331
R5688 VSS.n181 VSS.n180 0.00333331
R5689 VSS.n310 VSS.n139 0.00506216
R5690 VSS.n24 VSS.n69 0.0020294
R5691 VSS.n304 VSS.n59 0.00480926
R5692 VSS.n15 VSS.n13 0.00306459
R5693 VSS.n68 VSS.n691 0.00474939
R5694 VSS.n134 VSS.n38 0.00466666
R5695 VSS.n199 VSS.n106 0.00466598
R5696 VSS.n100 VSS.n98 0.0045
R5697 VSS.n439 VSS.t552 0.0045
R5698 VSS.n83 VSS.n74 0.0045
R5699 VSS.n35 VSS.n105 0.00211106
R5700 VSS.n118 VSS.n117 0.00449998
R5701 VSS.n111 VSS.n110 0.00449998
R5702 VSS.n54 VSS.n53 0.00449998
R5703 VSS.n424 VSS.n36 0.00449994
R5704 VSS.n482 VSS.t109 0.00449994
R5705 VSS.n384 VSS.n67 0.00390736
R5706 VSS.n73 VSS.n222 0.00449941
R5707 VSS.n123 VSS.n179 0.00441629
R5708 VSS.n7 VSS.n1552 5.61685
R5709 VSS.n151 VSS.n3 5.6172
R5710 oa_sar8_acore18_opt_0.sw_bitcell_opt_term_0.gb.t2 oa_sar8_acore18_opt_0.sw_bitcell_opt_term_0.gb.t1 33.6886
R5711 oa_sar8_acore18_opt_0.sw_bitcell_opt_term_0.gb oa_sar8_acore18_opt_0.sw_bitcell_opt_term_0.gb.t4 24.2374
R5712 oa_sar8_acore18_opt_0.sw_bitcell_opt_term_0.gb oa_sar8_acore18_opt_0.sw_bitcell_opt_term_0.gb.t5 21.7943
R5713 oa_sar8_acore18_opt_0.sw_bitcell_opt_term_0.gb oa_sar8_acore18_opt_0.sw_bitcell_opt_term_0.gb.t6 21.7943
R5714 oa_sar8_acore18_opt_0.sw_bitcell_opt_term_0.gb oa_sar8_acore18_opt_0.sw_bitcell_opt_term_0.gb.t7 21.7943
R5715 oa_sar8_acore18_opt_0.sw_bitcell_opt_term_0.gb oa_sar8_acore18_opt_0.sw_bitcell_opt_term_0.gb.t8 21.7943
R5716 oa_sar8_acore18_opt_0.sw_bitcell_opt_term_0.gb oa_sar8_acore18_opt_0.sw_bitcell_opt_term_0.gb.t9 21.7943
R5717 oa_sar8_acore18_opt_0.sw_bitcell_opt_term_0.gb oa_sar8_acore18_opt_0.sw_bitcell_opt_term_0.gb.t10 21.7943
R5718 oa_sar8_acore18_opt_0.sw_bitcell_opt_term_0.gb oa_sar8_acore18_opt_0.sw_bitcell_opt_term_0.gb.t11 21.7943
R5719 oa_sar8_acore18_opt_0.sw_bitcell_opt_term_0.gb oa_sar8_acore18_opt_0.sw_bitcell_opt_term_0.gb.t12 21.794
R5720 oa_sar8_acore18_opt_0.sw_bitcell_opt_term_0.gb oa_sar8_acore18_opt_0.sw_bitcell_opt_term_0.gb.t0 2.7263
R5721 oa_sar8_acore18_opt_0.sw_bitcell_opt_term_0.gb.t0 oa_sar8_acore18_opt_0.sw_bitcell_opt_term_0.gb.t3 1.8771
R5722 oa_sar8_acore18_opt_0.sw_bitcell_opt_term_0.gb.t3 oa_sar8_acore18_opt_0.sw_bitcell_opt_term_0.gb.t2 1.6637
R5723 oa_sar8_acore18_opt_0.sw_bitcell_opt_term_0.bot oa_sar8_acore18_opt_0.sw_bitcell_opt_term_0.bot.n0 91.1413
R5724 oa_sar8_acore18_opt_0.sw_bitcell_opt_term_0.bot.n0 oa_sar8_acore18_opt_0.sw_bitcell_opt_term_0.bot.t2 30.2721
R5725 oa_sar8_acore18_opt_0.sw_bitcell_opt_term_0.bot.t0 oa_sar8_acore18_opt_0.sw_bitcell_opt_term_0.bot.t1 32.1925
R5726 oa_sar8_acore18_opt_0.sw_bitcell_opt_term_0.bot.n0 oa_sar8_acore18_opt_0.sw_bitcell_opt_term_0.bot 3.46183
R5727 oa_sar8_acore18_opt_0.sw_bitcell_opt_term_0.bot oa_sar8_acore18_opt_0.sw_bitcell_opt_term_0.bot.t0 1.2105
R5728 oa_sar8_acore18_opt_0.sw_bitcell_opt_b0_0.bot oa_sar8_acore18_opt_0.sw_bitcell_opt_b0_0.bot.n0 88.6259
R5729 oa_sar8_acore18_opt_0.sw_bitcell_opt_b0_0.bot.n0 oa_sar8_acore18_opt_0.sw_bitcell_opt_b0_0.bot.t2 42.7308
R5730 oa_sar8_acore18_opt_0.sw_bitcell_opt_b0_0.bot.t0 oa_sar8_acore18_opt_0.sw_bitcell_opt_b0_0.bot.t1 32.1925
R5731 oa_sar8_acore18_opt_0.sw_bitcell_opt_b0_0.bot.n0 oa_sar8_acore18_opt_0.sw_bitcell_opt_b0_0.bot 3.57917
R5732 oa_sar8_acore18_opt_0.sw_bitcell_opt_b0_0.bot oa_sar8_acore18_opt_0.sw_bitcell_opt_b0_0.bot.t0 1.2105
R5733 oa_sar8_acore18_opt_0.sw_bitcell_opt_b1_0.bot oa_sar8_acore18_opt_0.sw_bitcell_opt_b1_0.bot.n1 86.0182
R5734 oa_sar8_acore18_opt_0.sw_bitcell_opt_b1_0.bot.n0 oa_sar8_acore18_opt_0.sw_bitcell_opt_b1_0.bot.t4 37.6963
R5735 oa_sar8_acore18_opt_0.sw_bitcell_opt_b1_0.bot.n0 oa_sar8_acore18_opt_0.sw_bitcell_opt_b1_0.bot.t2 27.8699
R5736 oa_sar8_acore18_opt_0.sw_bitcell_opt_b1_0.bot.t1 oa_sar8_acore18_opt_0.sw_bitcell_opt_b1_0.bot.t0 31.7993
R5737 oa_sar8_acore18_opt_0.sw_bitcell_opt_b1_0.bot.n1 oa_sar8_acore18_opt_0.sw_bitcell_opt_b1_0.bot.n0 4.27324
R5738 oa_sar8_acore18_opt_0.sw_bitcell_opt_b1_0.bot.n1 oa_sar8_acore18_opt_0.sw_bitcell_opt_b1_0.bot 3.6965
R5739 oa_sar8_acore18_opt_0.sw_bitcell_opt_b1_0.bot oa_sar8_acore18_opt_0.sw_bitcell_opt_b1_0.bot.t0 1.2985
R5740 oa_sar8_acore18_opt_0.sw_bitcell_opt_b2_0.bot oa_sar8_acore18_opt_0.sw_bitcell_opt_b2_0.bot.n2 83.3269
R5741 oa_sar8_acore18_opt_0.sw_bitcell_opt_b2_0.bot.t0 oa_sar8_acore18_opt_0.sw_bitcell_opt_b2_0.bot.t1 31.3455
R5742 oa_sar8_acore18_opt_0.sw_bitcell_opt_b2_0.bot.n1 oa_sar8_acore18_opt_0.sw_bitcell_opt_b2_0.bot.t8 28.5267
R5743 oa_sar8_acore18_opt_0.sw_bitcell_opt_b2_0.bot.n0 oa_sar8_acore18_opt_0.sw_bitcell_opt_b2_0.bot.t4 28.1515
R5744 oa_sar8_acore18_opt_0.sw_bitcell_opt_b2_0.bot.n0 oa_sar8_acore18_opt_0.sw_bitcell_opt_b2_0.bot.t2 28.1515
R5745 oa_sar8_acore18_opt_0.sw_bitcell_opt_b2_0.bot.n1 oa_sar8_acore18_opt_0.sw_bitcell_opt_b2_0.bot.t6 27.7749
R5746 oa_sar8_acore18_opt_0.sw_bitcell_opt_b2_0.bot.n0 oa_sar8_acore18_opt_0.sw_bitcell_opt_b2_0.bot.n1 6.62313
R5747 oa_sar8_acore18_opt_0.sw_bitcell_opt_b2_0.bot.n2 oa_sar8_acore18_opt_0.sw_bitcell_opt_b2_0.bot.n0 6.05587
R5748 oa_sar8_acore18_opt_0.sw_bitcell_opt_b2_0.bot.n2 oa_sar8_acore18_opt_0.sw_bitcell_opt_b2_0.bot 3.81383
R5749 oa_sar8_acore18_opt_0.sw_bitcell_opt_b2_0.bot oa_sar8_acore18_opt_0.sw_bitcell_opt_b2_0.bot.t0 1.3865
R5750 oa_sar8_acore18_opt_0.sw_bitcell_opt_b3_0.bot oa_sar8_acore18_opt_0.sw_bitcell_opt_b3_0.bot.n4 80.5475
R5751 oa_sar8_acore18_opt_0.sw_bitcell_opt_b3_0.bot.n0 oa_sar8_acore18_opt_0.sw_bitcell_opt_b3_0.bot.t8 28.4331
R5752 oa_sar8_acore18_opt_0.sw_bitcell_opt_b3_0.bot.n1 oa_sar8_acore18_opt_0.sw_bitcell_opt_b3_0.bot.t6 28.4331
R5753 oa_sar8_acore18_opt_0.sw_bitcell_opt_b3_0.bot.n1 oa_sar8_acore18_opt_0.sw_bitcell_opt_b3_0.bot.t4 28.4331
R5754 oa_sar8_acore18_opt_0.sw_bitcell_opt_b3_0.bot.n3 oa_sar8_acore18_opt_0.sw_bitcell_opt_b3_0.bot.t2 28.4331
R5755 oa_sar8_acore18_opt_0.sw_bitcell_opt_b3_0.bot.n2 oa_sar8_acore18_opt_0.sw_bitcell_opt_b3_0.bot.t16 28.2451
R5756 oa_sar8_acore18_opt_0.sw_bitcell_opt_b3_0.bot.n2 oa_sar8_acore18_opt_0.sw_bitcell_opt_b3_0.bot.t14 27.4933
R5757 oa_sar8_acore18_opt_0.sw_bitcell_opt_b3_0.bot.n2 oa_sar8_acore18_opt_0.sw_bitcell_opt_b3_0.bot.t12 27.4933
R5758 oa_sar8_acore18_opt_0.sw_bitcell_opt_b3_0.bot.n0 oa_sar8_acore18_opt_0.sw_bitcell_opt_b3_0.bot.t10 27.4933
R5759 oa_sar8_acore18_opt_0.sw_bitcell_opt_b3_0.bot.t1 oa_sar8_acore18_opt_0.sw_bitcell_opt_b3_0.bot.t0 31.2836
R5760 oa_sar8_acore18_opt_0.sw_bitcell_opt_b3_0.bot.n4 oa_sar8_acore18_opt_0.sw_bitcell_opt_b3_0.bot.n3 7.08924
R5761 oa_sar8_acore18_opt_0.sw_bitcell_opt_b3_0.bot.n4 oa_sar8_acore18_opt_0.sw_bitcell_opt_b3_0.bot 3.93117
R5762 oa_sar8_acore18_opt_0.sw_bitcell_opt_b3_0.bot.n0 oa_sar8_acore18_opt_0.sw_bitcell_opt_b3_0.bot.n2 1.50404
R5763 oa_sar8_acore18_opt_0.sw_bitcell_opt_b3_0.bot.n3 oa_sar8_acore18_opt_0.sw_bitcell_opt_b3_0.bot.n1 1.50404
R5764 oa_sar8_acore18_opt_0.sw_bitcell_opt_b3_0.bot oa_sar8_acore18_opt_0.sw_bitcell_opt_b3_0.bot.t0 1.4767
R5765 oa_sar8_acore18_opt_0.sw_bitcell_opt_b3_0.bot.n1 oa_sar8_acore18_opt_0.sw_bitcell_opt_b3_0.bot.n0 1.34061
R5766 oa_sar8_acore18_opt_0.sw_bitcell_opt_b4_0.bot oa_sar8_acore18_opt_0.sw_bitcell_opt_b4_0.bot.n7 77.6362
R5767 oa_sar8_acore18_opt_0.sw_bitcell_opt_b4_0.bot.n6 oa_sar8_acore18_opt_0.sw_bitcell_opt_b4_0.bot.t16 29.4665
R5768 oa_sar8_acore18_opt_0.sw_bitcell_opt_b4_0.bot.n6 oa_sar8_acore18_opt_0.sw_bitcell_opt_b4_0.bot.t14 28.7147
R5769 oa_sar8_acore18_opt_0.sw_bitcell_opt_b4_0.bot.n6 oa_sar8_acore18_opt_0.sw_bitcell_opt_b4_0.bot.t12 28.7147
R5770 oa_sar8_acore18_opt_0.sw_bitcell_opt_b4_0.bot.n5 oa_sar8_acore18_opt_0.sw_bitcell_opt_b4_0.bot.t10 28.7147
R5771 oa_sar8_acore18_opt_0.sw_bitcell_opt_b4_0.bot.n5 oa_sar8_acore18_opt_0.sw_bitcell_opt_b4_0.bot.t8 28.7147
R5772 oa_sar8_acore18_opt_0.sw_bitcell_opt_b4_0.bot.n0 oa_sar8_acore18_opt_0.sw_bitcell_opt_b4_0.bot.t6 28.7147
R5773 oa_sar8_acore18_opt_0.sw_bitcell_opt_b4_0.bot.n0 oa_sar8_acore18_opt_0.sw_bitcell_opt_b4_0.bot.t4 28.7147
R5774 oa_sar8_acore18_opt_0.sw_bitcell_opt_b4_0.bot.n1 oa_sar8_acore18_opt_0.sw_bitcell_opt_b4_0.bot.t2 28.7147
R5775 oa_sar8_acore18_opt_0.sw_bitcell_opt_b4_0.bot.n1 oa_sar8_acore18_opt_0.sw_bitcell_opt_b4_0.bot.t32 27.2117
R5776 oa_sar8_acore18_opt_0.sw_bitcell_opt_b4_0.bot.n1 oa_sar8_acore18_opt_0.sw_bitcell_opt_b4_0.bot.t30 27.2117
R5777 oa_sar8_acore18_opt_0.sw_bitcell_opt_b4_0.bot.n4 oa_sar8_acore18_opt_0.sw_bitcell_opt_b4_0.bot.t28 27.2117
R5778 oa_sar8_acore18_opt_0.sw_bitcell_opt_b4_0.bot.n4 oa_sar8_acore18_opt_0.sw_bitcell_opt_b4_0.bot.t26 27.2117
R5779 oa_sar8_acore18_opt_0.sw_bitcell_opt_b4_0.bot.n2 oa_sar8_acore18_opt_0.sw_bitcell_opt_b4_0.bot.t24 27.2117
R5780 oa_sar8_acore18_opt_0.sw_bitcell_opt_b4_0.bot.n2 oa_sar8_acore18_opt_0.sw_bitcell_opt_b4_0.bot.t22 27.2117
R5781 oa_sar8_acore18_opt_0.sw_bitcell_opt_b4_0.bot.n3 oa_sar8_acore18_opt_0.sw_bitcell_opt_b4_0.bot.t20 27.2117
R5782 oa_sar8_acore18_opt_0.sw_bitcell_opt_b4_0.bot.n3 oa_sar8_acore18_opt_0.sw_bitcell_opt_b4_0.bot.t18 27.2117
R5783 oa_sar8_acore18_opt_0.sw_bitcell_opt_b4_0.bot.n7 oa_sar8_acore18_opt_0.sw_bitcell_opt_b4_0.bot.n3 4.18524
R5784 oa_sar8_acore18_opt_0.sw_bitcell_opt_b4_0.bot.n7 oa_sar8_acore18_opt_0.sw_bitcell_opt_b4_0.bot 4.0485
R5785 oa_sar8_acore18_opt_0.sw_bitcell_opt_b4_0.bot.t1 oa_sar8_acore18_opt_0.sw_bitcell_opt_b4_0.bot.t0 30.9415
R5786 oa_sar8_acore18_opt_0.sw_bitcell_opt_b4_0.bot.n4 oa_sar8_acore18_opt_0.sw_bitcell_opt_b4_0.bot.n1 2.41924
R5787 oa_sar8_acore18_opt_0.sw_bitcell_opt_b4_0.bot.n3 oa_sar8_acore18_opt_0.sw_bitcell_opt_b4_0.bot.n2 2.25581
R5788 oa_sar8_acore18_opt_0.sw_bitcell_opt_b4_0.bot oa_sar8_acore18_opt_0.sw_bitcell_opt_b4_0.bot.t0 1.6065
R5789 oa_sar8_acore18_opt_0.sw_bitcell_opt_b4_0.bot.n5 oa_sar8_acore18_opt_0.sw_bitcell_opt_b4_0.bot.n6 1.50404
R5790 oa_sar8_acore18_opt_0.sw_bitcell_opt_b4_0.bot.n0 oa_sar8_acore18_opt_0.sw_bitcell_opt_b4_0.bot.n5 1.50404
R5791 oa_sar8_acore18_opt_0.sw_bitcell_opt_b4_0.bot.n1 oa_sar8_acore18_opt_0.sw_bitcell_opt_b4_0.bot.n0 1.50404
R5792 oa_sar8_acore18_opt_0.sw_bitcell_opt_b4_0.bot.n2 oa_sar8_acore18_opt_0.sw_bitcell_opt_b4_0.bot.n4 1.50404
R5793 oa_sar8_acore18_opt_0.sw_bitcell_opt_b5_0.bot oa_sar8_acore18_opt_0.sw_bitcell_opt_b5_0.bot.n1 78.2287
R5794 oa_sar8_acore18_opt_0.sw_bitcell_opt_b5_0.bot.t1 oa_sar8_acore18_opt_0.sw_bitcell_opt_b5_0.bot.t0 30.8707
R5795 oa_sar8_acore18_opt_0.sw_bitcell_opt_b5_0.bot.n0 oa_sar8_acore18_opt_0.sw_bitcell_opt_b5_0.bot.t2 5.76183
R5796 oa_sar8_acore18_opt_0.sw_bitcell_opt_b5_0.bot.n1 oa_sar8_acore18_opt_0.sw_bitcell_opt_b5_0.bot.t22 5.76183
R5797 oa_sar8_acore18_opt_0.sw_bitcell_opt_b5_0.bot.n0 oa_sar8_acore18_opt_0.sw_bitcell_opt_b5_0.bot 2.76517
R5798 oa_sar8_acore18_opt_0.sw_bitcell_opt_b5_0.bot.n1 oa_sar8_acore18_opt_0.sw_bitcell_opt_b5_0.bot.n0 1.8485
R5799 oa_sar8_acore18_opt_0.sw_bitcell_opt_b5_0.bot oa_sar8_acore18_opt_0.sw_bitcell_opt_b5_0.bot.t0 1.7385
R5800 oa_sar8_acore18_opt_0.sw_bitcell_opt_b5_0.bot.t22 oa_sar8_acore18_opt_0.sw_bitcell_opt_b5_0.bot.t25 1.13277
R5801 oa_sar8_acore18_opt_0.sw_bitcell_opt_b5_0.bot.t25 oa_sar8_acore18_opt_0.sw_bitcell_opt_b5_0.bot.t30 1.13277
R5802 oa_sar8_acore18_opt_0.sw_bitcell_opt_b5_0.bot.t2 oa_sar8_acore18_opt_0.sw_bitcell_opt_b5_0.bot.t5 1.13277
R5803 oa_sar8_acore18_opt_0.sw_bitcell_opt_b5_0.bot.t5 oa_sar8_acore18_opt_0.sw_bitcell_opt_b5_0.bot.t10 1.13277
R5804 oa_sar8_acore18_opt_0.sw_bitcell_opt_b5_0.bot.t10 oa_sar8_acore18_opt_0.sw_bitcell_opt_b5_0.bot.t15 1.13277
R5805 oa_sar8_acore18_opt_0.sw_bitcell_opt_b5_0.bot.t30 oa_sar8_acore18_opt_0.sw_bitcell_opt_b5_0.bot.t35 1.13277
R5806 oa_sar8_acore18_opt_0.sw_bitcell_opt_b6_0.bot oa_sar8_acore18_opt_0.sw_bitcell_opt_b6_0.bot.n0 72.2029
R5807 oa_sar8_acore18_opt_0.sw_bitcell_opt_b6_0.bot.t1 oa_sar8_acore18_opt_0.sw_bitcell_opt_b6_0.bot.t0 30.7555
R5808 oa_sar8_acore18_opt_0.sw_bitcell_opt_b6_0.bot.n1 oa_sar8_acore18_opt_0.sw_bitcell_opt_b6_0.bot.t2 5.92317
R5809 oa_sar8_acore18_opt_0.sw_bitcell_opt_b6_0.bot.n1 oa_sar8_acore18_opt_0.sw_bitcell_opt_b6_0.bot.t22 5.92317
R5810 oa_sar8_acore18_opt_0.sw_bitcell_opt_b6_0.bot.n0 oa_sar8_acore18_opt_0.sw_bitcell_opt_b6_0.bot.t42 5.92317
R5811 oa_sar8_acore18_opt_0.sw_bitcell_opt_b6_0.bot.n0 oa_sar8_acore18_opt_0.sw_bitcell_opt_b6_0.bot.t62 5.92317
R5812 oa_sar8_acore18_opt_0.sw_bitcell_opt_b6_0.bot.n0 oa_sar8_acore18_opt_0.sw_bitcell_opt_b6_0.bot.n1 3.10983
R5813 oa_sar8_acore18_opt_0.sw_bitcell_opt_b6_0.bot.n1 oa_sar8_acore18_opt_0.sw_bitcell_opt_b6_0.bot 2.2665
R5814 oa_sar8_acore18_opt_0.sw_bitcell_opt_b6_0.bot oa_sar8_acore18_opt_0.sw_bitcell_opt_b6_0.bot.t1 1.8705
R5815 oa_sar8_acore18_opt_0.sw_bitcell_opt_b6_0.bot.t62 oa_sar8_acore18_opt_0.sw_bitcell_opt_b6_0.bot.t65 1.13277
R5816 oa_sar8_acore18_opt_0.sw_bitcell_opt_b6_0.bot.t65 oa_sar8_acore18_opt_0.sw_bitcell_opt_b6_0.bot.t70 1.13277
R5817 oa_sar8_acore18_opt_0.sw_bitcell_opt_b6_0.bot.t42 oa_sar8_acore18_opt_0.sw_bitcell_opt_b6_0.bot.t45 1.13277
R5818 oa_sar8_acore18_opt_0.sw_bitcell_opt_b6_0.bot.t45 oa_sar8_acore18_opt_0.sw_bitcell_opt_b6_0.bot.t50 1.13277
R5819 oa_sar8_acore18_opt_0.sw_bitcell_opt_b6_0.bot.t22 oa_sar8_acore18_opt_0.sw_bitcell_opt_b6_0.bot.t25 1.13277
R5820 oa_sar8_acore18_opt_0.sw_bitcell_opt_b6_0.bot.t25 oa_sar8_acore18_opt_0.sw_bitcell_opt_b6_0.bot.t30 1.13277
R5821 oa_sar8_acore18_opt_0.sw_bitcell_opt_b6_0.bot.t2 oa_sar8_acore18_opt_0.sw_bitcell_opt_b6_0.bot.t5 1.13277
R5822 oa_sar8_acore18_opt_0.sw_bitcell_opt_b6_0.bot.t5 oa_sar8_acore18_opt_0.sw_bitcell_opt_b6_0.bot.t10 1.13277
R5823 oa_sar8_acore18_opt_0.sw_bitcell_opt_b6_0.bot.t10 oa_sar8_acore18_opt_0.sw_bitcell_opt_b6_0.bot.t15 1.13277
R5824 oa_sar8_acore18_opt_0.sw_bitcell_opt_b6_0.bot.t30 oa_sar8_acore18_opt_0.sw_bitcell_opt_b6_0.bot.t35 1.13277
R5825 oa_sar8_acore18_opt_0.sw_bitcell_opt_b6_0.bot.t50 oa_sar8_acore18_opt_0.sw_bitcell_opt_b6_0.bot.t55 1.13277
R5826 oa_sar8_acore18_opt_0.sw_bitcell_opt_b6_0.bot.t70 oa_sar8_acore18_opt_0.sw_bitcell_opt_b6_0.bot.t75 1.13277
R5827 oa_sar8_acore18_opt_0.sw_bitcell_opt_b7_0.bot.n8 oa_sar8_acore18_opt_0.sw_bitcell_opt_b7_0.bot.n7 65.072
R5828 oa_sar8_acore18_opt_0.sw_bitcell_opt_b7_0.bot.n0 oa_sar8_acore18_opt_0.sw_bitcell_opt_b7_0.bot.t22 6.0845
R5829 oa_sar8_acore18_opt_0.sw_bitcell_opt_b7_0.bot.n1 oa_sar8_acore18_opt_0.sw_bitcell_opt_b7_0.bot.t2 6.0845
R5830 oa_sar8_acore18_opt_0.sw_bitcell_opt_b7_0.bot.n2 oa_sar8_acore18_opt_0.sw_bitcell_opt_b7_0.bot.t44 6.0845
R5831 oa_sar8_acore18_opt_0.sw_bitcell_opt_b7_0.bot.n3 oa_sar8_acore18_opt_0.sw_bitcell_opt_b7_0.bot.t65 6.0845
R5832 oa_sar8_acore18_opt_0.sw_bitcell_opt_b7_0.bot.n4 oa_sar8_acore18_opt_0.sw_bitcell_opt_b7_0.bot.t86 6.0845
R5833 oa_sar8_acore18_opt_0.sw_bitcell_opt_b7_0.bot.n5 oa_sar8_acore18_opt_0.sw_bitcell_opt_b7_0.bot.t107 6.0845
R5834 oa_sar8_acore18_opt_0.sw_bitcell_opt_b7_0.bot.n6 oa_sar8_acore18_opt_0.sw_bitcell_opt_b7_0.bot.t128 6.0845
R5835 oa_sar8_acore18_opt_0.sw_bitcell_opt_b7_0.bot.n7 oa_sar8_acore18_opt_0.sw_bitcell_opt_b7_0.bot.t149 6.0845
R5836 oa_sar8_acore18_opt_0.sw_bitcell_opt_b7_0.bot.n4 oa_sar8_acore18_opt_0.sw_bitcell_opt_b7_0.bot.n3 4.4885
R5837 oa_sar8_acore18_opt_0.sw_bitcell_opt_b7_0.bot.n8 oa_sar8_acore18_opt_0.sw_bitcell_opt_b7_0.bot.t0 2.0465
R5838 oa_sar8_acore18_opt_0.sw_bitcell_opt_b7_0.bot.t149 oa_sar8_acore18_opt_0.sw_bitcell_opt_b7_0.bot.t152 1.13277
R5839 oa_sar8_acore18_opt_0.sw_bitcell_opt_b7_0.bot.t152 oa_sar8_acore18_opt_0.sw_bitcell_opt_b7_0.bot.t157 1.13277
R5840 oa_sar8_acore18_opt_0.sw_bitcell_opt_b7_0.bot.t157 oa_sar8_acore18_opt_0.sw_bitcell_opt_b7_0.bot.t162 1.13277
R5841 oa_sar8_acore18_opt_0.sw_bitcell_opt_b7_0.bot.t128 oa_sar8_acore18_opt_0.sw_bitcell_opt_b7_0.bot.t131 1.13277
R5842 oa_sar8_acore18_opt_0.sw_bitcell_opt_b7_0.bot.t131 oa_sar8_acore18_opt_0.sw_bitcell_opt_b7_0.bot.t136 1.13277
R5843 oa_sar8_acore18_opt_0.sw_bitcell_opt_b7_0.bot.t136 oa_sar8_acore18_opt_0.sw_bitcell_opt_b7_0.bot.t141 1.13277
R5844 oa_sar8_acore18_opt_0.sw_bitcell_opt_b7_0.bot.t107 oa_sar8_acore18_opt_0.sw_bitcell_opt_b7_0.bot.t110 1.13277
R5845 oa_sar8_acore18_opt_0.sw_bitcell_opt_b7_0.bot.t110 oa_sar8_acore18_opt_0.sw_bitcell_opt_b7_0.bot.t115 1.13277
R5846 oa_sar8_acore18_opt_0.sw_bitcell_opt_b7_0.bot.t115 oa_sar8_acore18_opt_0.sw_bitcell_opt_b7_0.bot.t120 1.13277
R5847 oa_sar8_acore18_opt_0.sw_bitcell_opt_b7_0.bot.t86 oa_sar8_acore18_opt_0.sw_bitcell_opt_b7_0.bot.t89 1.13277
R5848 oa_sar8_acore18_opt_0.sw_bitcell_opt_b7_0.bot.t89 oa_sar8_acore18_opt_0.sw_bitcell_opt_b7_0.bot.t94 1.13277
R5849 oa_sar8_acore18_opt_0.sw_bitcell_opt_b7_0.bot.t94 oa_sar8_acore18_opt_0.sw_bitcell_opt_b7_0.bot.t99 1.13277
R5850 oa_sar8_acore18_opt_0.sw_bitcell_opt_b7_0.bot.t65 oa_sar8_acore18_opt_0.sw_bitcell_opt_b7_0.bot.t68 1.13277
R5851 oa_sar8_acore18_opt_0.sw_bitcell_opt_b7_0.bot.t68 oa_sar8_acore18_opt_0.sw_bitcell_opt_b7_0.bot.t73 1.13277
R5852 oa_sar8_acore18_opt_0.sw_bitcell_opt_b7_0.bot.t73 oa_sar8_acore18_opt_0.sw_bitcell_opt_b7_0.bot.t78 1.13277
R5853 oa_sar8_acore18_opt_0.sw_bitcell_opt_b7_0.bot.t44 oa_sar8_acore18_opt_0.sw_bitcell_opt_b7_0.bot.t47 1.13277
R5854 oa_sar8_acore18_opt_0.sw_bitcell_opt_b7_0.bot.t47 oa_sar8_acore18_opt_0.sw_bitcell_opt_b7_0.bot.t52 1.13277
R5855 oa_sar8_acore18_opt_0.sw_bitcell_opt_b7_0.bot.t52 oa_sar8_acore18_opt_0.sw_bitcell_opt_b7_0.bot.t57 1.13277
R5856 oa_sar8_acore18_opt_0.sw_bitcell_opt_b7_0.bot.t2 oa_sar8_acore18_opt_0.sw_bitcell_opt_b7_0.bot.t5 1.13277
R5857 oa_sar8_acore18_opt_0.sw_bitcell_opt_b7_0.bot.t5 oa_sar8_acore18_opt_0.sw_bitcell_opt_b7_0.bot.t10 1.13277
R5858 oa_sar8_acore18_opt_0.sw_bitcell_opt_b7_0.bot.t10 oa_sar8_acore18_opt_0.sw_bitcell_opt_b7_0.bot.t15 1.13277
R5859 oa_sar8_acore18_opt_0.sw_bitcell_opt_b7_0.bot.t22 oa_sar8_acore18_opt_0.sw_bitcell_opt_b7_0.bot.t25 1.13277
R5860 oa_sar8_acore18_opt_0.sw_bitcell_opt_b7_0.bot.t25 oa_sar8_acore18_opt_0.sw_bitcell_opt_b7_0.bot.t30 1.13277
R5861 oa_sar8_acore18_opt_0.sw_bitcell_opt_b7_0.bot.t30 oa_sar8_acore18_opt_0.sw_bitcell_opt_b7_0.bot.t35 1.13277
R5862 oa_sar8_acore18_opt_0.sw_bitcell_opt_b7_0.bot.t162 oa_sar8_acore18_opt_0.sw_bitcell_opt_b7_0.bot.t167 0.8497
R5863 oa_sar8_acore18_opt_0.sw_bitcell_opt_b7_0.bot.t141 oa_sar8_acore18_opt_0.sw_bitcell_opt_b7_0.bot.t146 0.8497
R5864 oa_sar8_acore18_opt_0.sw_bitcell_opt_b7_0.bot.t120 oa_sar8_acore18_opt_0.sw_bitcell_opt_b7_0.bot.t125 0.8497
R5865 oa_sar8_acore18_opt_0.sw_bitcell_opt_b7_0.bot.t99 oa_sar8_acore18_opt_0.sw_bitcell_opt_b7_0.bot.t104 0.8497
R5866 oa_sar8_acore18_opt_0.sw_bitcell_opt_b7_0.bot.t78 oa_sar8_acore18_opt_0.sw_bitcell_opt_b7_0.bot.t83 0.8497
R5867 oa_sar8_acore18_opt_0.sw_bitcell_opt_b7_0.bot.t57 oa_sar8_acore18_opt_0.sw_bitcell_opt_b7_0.bot.t62 0.8497
R5868 oa_sar8_acore18_opt_0.sw_bitcell_opt_b7_0.bot.t15 oa_sar8_acore18_opt_0.sw_bitcell_opt_b7_0.bot.t20 0.8497
R5869 oa_sar8_acore18_opt_0.sw_bitcell_opt_b7_0.bot.t35 oa_sar8_acore18_opt_0.sw_bitcell_opt_b7_0.bot.t40 0.8497
R5870 oa_sar8_acore18_opt_0.sw_bitcell_opt_b7_0.bot.n7 oa_sar8_acore18_opt_0.sw_bitcell_opt_b7_0.bot.n6 0.381833
R5871 oa_sar8_acore18_opt_0.sw_bitcell_opt_b7_0.bot.n6 oa_sar8_acore18_opt_0.sw_bitcell_opt_b7_0.bot.n5 0.381833
R5872 oa_sar8_acore18_opt_0.sw_bitcell_opt_b7_0.bot.n5 oa_sar8_acore18_opt_0.sw_bitcell_opt_b7_0.bot.n4 0.381833
R5873 oa_sar8_acore18_opt_0.sw_bitcell_opt_b7_0.bot.n3 oa_sar8_acore18_opt_0.sw_bitcell_opt_b7_0.bot.n2 0.381833
R5874 oa_sar8_acore18_opt_0.sw_bitcell_opt_b7_0.bot.n2 oa_sar8_acore18_opt_0.sw_bitcell_opt_b7_0.bot.n1 0.381833
R5875 oa_sar8_acore18_opt_0.sw_bitcell_opt_b7_0.bot.n1 oa_sar8_acore18_opt_0.sw_bitcell_opt_b7_0.bot.n0 0.381833
R5876 oa_sar8_acore18_opt_0.sw_bitcell_opt_b7_0.bot oa_sar8_acore18_opt_0.sw_bitcell_opt_b7_0.bot.n8 0.2634
R5877 oa_sar8_acore18_opt_0.sw_bitcell_opt_b7_0.bot.n0 oa_sar8_acore18_opt_0.sw_bitcell_opt_b7_0.bot 0.125167
R5878 oa_sar8_acore18_opt_0.sw_bitcell_opt_b7_0.bot.t0 oa_sar8_acore18_opt_0.sw_bitcell_opt_b7_0.bot.t1 30.6574
R5879 oa_sar8_acore18_opt_0.sw_bitcell_opt_b7_1.bot.n8 oa_sar8_acore18_opt_0.sw_bitcell_opt_b7_1.bot.n7 47.5985
R5880 oa_sar8_acore18_opt_0.sw_bitcell_opt_b7_1.bot.n0 oa_sar8_acore18_opt_0.sw_bitcell_opt_b7_1.bot.t40 6.0845
R5881 oa_sar8_acore18_opt_0.sw_bitcell_opt_b7_1.bot.n1 oa_sar8_acore18_opt_0.sw_bitcell_opt_b7_1.bot.t19 6.0845
R5882 oa_sar8_acore18_opt_0.sw_bitcell_opt_b7_1.bot.n2 oa_sar8_acore18_opt_0.sw_bitcell_opt_b7_1.bot.t62 6.0845
R5883 oa_sar8_acore18_opt_0.sw_bitcell_opt_b7_1.bot.n3 oa_sar8_acore18_opt_0.sw_bitcell_opt_b7_1.bot.t83 6.0845
R5884 oa_sar8_acore18_opt_0.sw_bitcell_opt_b7_1.bot.n4 oa_sar8_acore18_opt_0.sw_bitcell_opt_b7_1.bot.t104 6.0845
R5885 oa_sar8_acore18_opt_0.sw_bitcell_opt_b7_1.bot.n5 oa_sar8_acore18_opt_0.sw_bitcell_opt_b7_1.bot.t125 6.0845
R5886 oa_sar8_acore18_opt_0.sw_bitcell_opt_b7_1.bot.n6 oa_sar8_acore18_opt_0.sw_bitcell_opt_b7_1.bot.t146 6.0845
R5887 oa_sar8_acore18_opt_0.sw_bitcell_opt_b7_1.bot.n7 oa_sar8_acore18_opt_0.sw_bitcell_opt_b7_1.bot.t167 6.0845
R5888 oa_sar8_acore18_opt_0.sw_bitcell_opt_b7_1.bot.n4 oa_sar8_acore18_opt_0.sw_bitcell_opt_b7_1.bot.n3 4.4885
R5889 oa_sar8_acore18_opt_0.sw_bitcell_opt_b7_1.bot.n8 oa_sar8_acore18_opt_0.sw_bitcell_opt_b7_1.bot.t0 2.0443
R5890 oa_sar8_acore18_opt_0.sw_bitcell_opt_b7_1.bot.t167 oa_sar8_acore18_opt_0.sw_bitcell_opt_b7_1.bot.t162 1.13277
R5891 oa_sar8_acore18_opt_0.sw_bitcell_opt_b7_1.bot.t162 oa_sar8_acore18_opt_0.sw_bitcell_opt_b7_1.bot.t157 1.13277
R5892 oa_sar8_acore18_opt_0.sw_bitcell_opt_b7_1.bot.t157 oa_sar8_acore18_opt_0.sw_bitcell_opt_b7_1.bot.t152 1.13277
R5893 oa_sar8_acore18_opt_0.sw_bitcell_opt_b7_1.bot.t146 oa_sar8_acore18_opt_0.sw_bitcell_opt_b7_1.bot.t141 1.13277
R5894 oa_sar8_acore18_opt_0.sw_bitcell_opt_b7_1.bot.t141 oa_sar8_acore18_opt_0.sw_bitcell_opt_b7_1.bot.t136 1.13277
R5895 oa_sar8_acore18_opt_0.sw_bitcell_opt_b7_1.bot.t136 oa_sar8_acore18_opt_0.sw_bitcell_opt_b7_1.bot.t131 1.13277
R5896 oa_sar8_acore18_opt_0.sw_bitcell_opt_b7_1.bot.t125 oa_sar8_acore18_opt_0.sw_bitcell_opt_b7_1.bot.t120 1.13277
R5897 oa_sar8_acore18_opt_0.sw_bitcell_opt_b7_1.bot.t120 oa_sar8_acore18_opt_0.sw_bitcell_opt_b7_1.bot.t115 1.13277
R5898 oa_sar8_acore18_opt_0.sw_bitcell_opt_b7_1.bot.t115 oa_sar8_acore18_opt_0.sw_bitcell_opt_b7_1.bot.t110 1.13277
R5899 oa_sar8_acore18_opt_0.sw_bitcell_opt_b7_1.bot.t104 oa_sar8_acore18_opt_0.sw_bitcell_opt_b7_1.bot.t99 1.13277
R5900 oa_sar8_acore18_opt_0.sw_bitcell_opt_b7_1.bot.t99 oa_sar8_acore18_opt_0.sw_bitcell_opt_b7_1.bot.t94 1.13277
R5901 oa_sar8_acore18_opt_0.sw_bitcell_opt_b7_1.bot.t94 oa_sar8_acore18_opt_0.sw_bitcell_opt_b7_1.bot.t89 1.13277
R5902 oa_sar8_acore18_opt_0.sw_bitcell_opt_b7_1.bot.t83 oa_sar8_acore18_opt_0.sw_bitcell_opt_b7_1.bot.t78 1.13277
R5903 oa_sar8_acore18_opt_0.sw_bitcell_opt_b7_1.bot.t78 oa_sar8_acore18_opt_0.sw_bitcell_opt_b7_1.bot.t73 1.13277
R5904 oa_sar8_acore18_opt_0.sw_bitcell_opt_b7_1.bot.t73 oa_sar8_acore18_opt_0.sw_bitcell_opt_b7_1.bot.t68 1.13277
R5905 oa_sar8_acore18_opt_0.sw_bitcell_opt_b7_1.bot.t62 oa_sar8_acore18_opt_0.sw_bitcell_opt_b7_1.bot.t57 1.13277
R5906 oa_sar8_acore18_opt_0.sw_bitcell_opt_b7_1.bot.t57 oa_sar8_acore18_opt_0.sw_bitcell_opt_b7_1.bot.t52 1.13277
R5907 oa_sar8_acore18_opt_0.sw_bitcell_opt_b7_1.bot.t52 oa_sar8_acore18_opt_0.sw_bitcell_opt_b7_1.bot.t47 1.13277
R5908 oa_sar8_acore18_opt_0.sw_bitcell_opt_b7_1.bot.t19 oa_sar8_acore18_opt_0.sw_bitcell_opt_b7_1.bot.t14 1.13277
R5909 oa_sar8_acore18_opt_0.sw_bitcell_opt_b7_1.bot.t14 oa_sar8_acore18_opt_0.sw_bitcell_opt_b7_1.bot.t9 1.13277
R5910 oa_sar8_acore18_opt_0.sw_bitcell_opt_b7_1.bot.t9 oa_sar8_acore18_opt_0.sw_bitcell_opt_b7_1.bot.t4 1.13277
R5911 oa_sar8_acore18_opt_0.sw_bitcell_opt_b7_1.bot.t40 oa_sar8_acore18_opt_0.sw_bitcell_opt_b7_1.bot.t35 1.13277
R5912 oa_sar8_acore18_opt_0.sw_bitcell_opt_b7_1.bot.t35 oa_sar8_acore18_opt_0.sw_bitcell_opt_b7_1.bot.t30 1.13277
R5913 oa_sar8_acore18_opt_0.sw_bitcell_opt_b7_1.bot.t30 oa_sar8_acore18_opt_0.sw_bitcell_opt_b7_1.bot.t25 1.13277
R5914 oa_sar8_acore18_opt_0.sw_bitcell_opt_b7_1.bot.t152 oa_sar8_acore18_opt_0.sw_bitcell_opt_b7_1.bot.t148 0.8497
R5915 oa_sar8_acore18_opt_0.sw_bitcell_opt_b7_1.bot.t131 oa_sar8_acore18_opt_0.sw_bitcell_opt_b7_1.bot.t127 0.8497
R5916 oa_sar8_acore18_opt_0.sw_bitcell_opt_b7_1.bot.t110 oa_sar8_acore18_opt_0.sw_bitcell_opt_b7_1.bot.t106 0.8497
R5917 oa_sar8_acore18_opt_0.sw_bitcell_opt_b7_1.bot.t89 oa_sar8_acore18_opt_0.sw_bitcell_opt_b7_1.bot.t85 0.8497
R5918 oa_sar8_acore18_opt_0.sw_bitcell_opt_b7_1.bot.t68 oa_sar8_acore18_opt_0.sw_bitcell_opt_b7_1.bot.t64 0.8497
R5919 oa_sar8_acore18_opt_0.sw_bitcell_opt_b7_1.bot.t47 oa_sar8_acore18_opt_0.sw_bitcell_opt_b7_1.bot.t43 0.8497
R5920 oa_sar8_acore18_opt_0.sw_bitcell_opt_b7_1.bot.t4 oa_sar8_acore18_opt_0.sw_bitcell_opt_b7_1.bot.t1 0.8497
R5921 oa_sar8_acore18_opt_0.sw_bitcell_opt_b7_1.bot.t25 oa_sar8_acore18_opt_0.sw_bitcell_opt_b7_1.bot.t21 0.8497
R5922 oa_sar8_acore18_opt_0.sw_bitcell_opt_b7_1.bot.n7 oa_sar8_acore18_opt_0.sw_bitcell_opt_b7_1.bot.n6 0.381833
R5923 oa_sar8_acore18_opt_0.sw_bitcell_opt_b7_1.bot.n6 oa_sar8_acore18_opt_0.sw_bitcell_opt_b7_1.bot.n5 0.381833
R5924 oa_sar8_acore18_opt_0.sw_bitcell_opt_b7_1.bot.n5 oa_sar8_acore18_opt_0.sw_bitcell_opt_b7_1.bot.n4 0.381833
R5925 oa_sar8_acore18_opt_0.sw_bitcell_opt_b7_1.bot.n3 oa_sar8_acore18_opt_0.sw_bitcell_opt_b7_1.bot.n2 0.381833
R5926 oa_sar8_acore18_opt_0.sw_bitcell_opt_b7_1.bot.n2 oa_sar8_acore18_opt_0.sw_bitcell_opt_b7_1.bot.n1 0.381833
R5927 oa_sar8_acore18_opt_0.sw_bitcell_opt_b7_1.bot.n1 oa_sar8_acore18_opt_0.sw_bitcell_opt_b7_1.bot.n0 0.381833
R5928 oa_sar8_acore18_opt_0.sw_bitcell_opt_b7_1.bot oa_sar8_acore18_opt_0.sw_bitcell_opt_b7_1.bot.n8 0.2656
R5929 oa_sar8_acore18_opt_0.sw_bitcell_opt_b7_1.bot.n0 oa_sar8_acore18_opt_0.sw_bitcell_opt_b7_1.bot 0.125167
R5930 oa_sar8_acore18_opt_0.sw_bitcell_opt_b7_1.bot.t0 oa_sar8_acore18_opt_0.sw_bitcell_opt_b7_1.bot.t169 30.6574
R5931 oa_sar8_acore18_opt_0.sw_bitcell_opt_b6_1.bot oa_sar8_acore18_opt_0.sw_bitcell_opt_b6_1.bot.n0 53.3537
R5932 oa_sar8_acore18_opt_0.sw_bitcell_opt_b6_1.bot.t0 oa_sar8_acore18_opt_0.sw_bitcell_opt_b6_1.bot.t81 30.7555
R5933 oa_sar8_acore18_opt_0.sw_bitcell_opt_b6_1.bot.n1 oa_sar8_acore18_opt_0.sw_bitcell_opt_b6_1.bot.t19 5.92317
R5934 oa_sar8_acore18_opt_0.sw_bitcell_opt_b6_1.bot.n1 oa_sar8_acore18_opt_0.sw_bitcell_opt_b6_1.bot.t39 5.92317
R5935 oa_sar8_acore18_opt_0.sw_bitcell_opt_b6_1.bot.n0 oa_sar8_acore18_opt_0.sw_bitcell_opt_b6_1.bot.t59 5.92317
R5936 oa_sar8_acore18_opt_0.sw_bitcell_opt_b6_1.bot.n0 oa_sar8_acore18_opt_0.sw_bitcell_opt_b6_1.bot.t79 5.92317
R5937 oa_sar8_acore18_opt_0.sw_bitcell_opt_b6_1.bot.n0 oa_sar8_acore18_opt_0.sw_bitcell_opt_b6_1.bot.n1 3.10983
R5938 oa_sar8_acore18_opt_0.sw_bitcell_opt_b6_1.bot.n1 oa_sar8_acore18_opt_0.sw_bitcell_opt_b6_1.bot 2.2665
R5939 oa_sar8_acore18_opt_0.sw_bitcell_opt_b6_1.bot oa_sar8_acore18_opt_0.sw_bitcell_opt_b6_1.bot.t0 1.8683
R5940 oa_sar8_acore18_opt_0.sw_bitcell_opt_b6_1.bot.t79 oa_sar8_acore18_opt_0.sw_bitcell_opt_b6_1.bot.t74 1.13277
R5941 oa_sar8_acore18_opt_0.sw_bitcell_opt_b6_1.bot.t74 oa_sar8_acore18_opt_0.sw_bitcell_opt_b6_1.bot.t69 1.13277
R5942 oa_sar8_acore18_opt_0.sw_bitcell_opt_b6_1.bot.t59 oa_sar8_acore18_opt_0.sw_bitcell_opt_b6_1.bot.t54 1.13277
R5943 oa_sar8_acore18_opt_0.sw_bitcell_opt_b6_1.bot.t54 oa_sar8_acore18_opt_0.sw_bitcell_opt_b6_1.bot.t49 1.13277
R5944 oa_sar8_acore18_opt_0.sw_bitcell_opt_b6_1.bot.t39 oa_sar8_acore18_opt_0.sw_bitcell_opt_b6_1.bot.t34 1.13277
R5945 oa_sar8_acore18_opt_0.sw_bitcell_opt_b6_1.bot.t34 oa_sar8_acore18_opt_0.sw_bitcell_opt_b6_1.bot.t29 1.13277
R5946 oa_sar8_acore18_opt_0.sw_bitcell_opt_b6_1.bot.t19 oa_sar8_acore18_opt_0.sw_bitcell_opt_b6_1.bot.t14 1.13277
R5947 oa_sar8_acore18_opt_0.sw_bitcell_opt_b6_1.bot.t14 oa_sar8_acore18_opt_0.sw_bitcell_opt_b6_1.bot.t9 1.13277
R5948 oa_sar8_acore18_opt_0.sw_bitcell_opt_b6_1.bot.t9 oa_sar8_acore18_opt_0.sw_bitcell_opt_b6_1.bot.t1 1.13277
R5949 oa_sar8_acore18_opt_0.sw_bitcell_opt_b6_1.bot.t29 oa_sar8_acore18_opt_0.sw_bitcell_opt_b6_1.bot.t21 1.13277
R5950 oa_sar8_acore18_opt_0.sw_bitcell_opt_b6_1.bot.t49 oa_sar8_acore18_opt_0.sw_bitcell_opt_b6_1.bot.t41 1.13277
R5951 oa_sar8_acore18_opt_0.sw_bitcell_opt_b6_1.bot.t69 oa_sar8_acore18_opt_0.sw_bitcell_opt_b6_1.bot.t61 1.13277
R5952 oa_sar8_acore18_opt_0.sw_bitcell_opt_b5_1.bot oa_sar8_acore18_opt_0.sw_bitcell_opt_b5_1.bot.n1 58.0925
R5953 oa_sar8_acore18_opt_0.sw_bitcell_opt_b5_1.bot.t41 oa_sar8_acore18_opt_0.sw_bitcell_opt_b5_1.bot.t0 30.8707
R5954 oa_sar8_acore18_opt_0.sw_bitcell_opt_b5_1.bot.n0 oa_sar8_acore18_opt_0.sw_bitcell_opt_b5_1.bot.t19 5.76183
R5955 oa_sar8_acore18_opt_0.sw_bitcell_opt_b5_1.bot.n1 oa_sar8_acore18_opt_0.sw_bitcell_opt_b5_1.bot.t39 5.76183
R5956 oa_sar8_acore18_opt_0.sw_bitcell_opt_b5_1.bot.n0 oa_sar8_acore18_opt_0.sw_bitcell_opt_b5_1.bot 2.76517
R5957 oa_sar8_acore18_opt_0.sw_bitcell_opt_b5_1.bot.n1 oa_sar8_acore18_opt_0.sw_bitcell_opt_b5_1.bot.n0 1.8485
R5958 oa_sar8_acore18_opt_0.sw_bitcell_opt_b5_1.bot oa_sar8_acore18_opt_0.sw_bitcell_opt_b5_1.bot.t0 1.7363
R5959 oa_sar8_acore18_opt_0.sw_bitcell_opt_b5_1.bot.t39 oa_sar8_acore18_opt_0.sw_bitcell_opt_b5_1.bot.t34 1.13277
R5960 oa_sar8_acore18_opt_0.sw_bitcell_opt_b5_1.bot.t34 oa_sar8_acore18_opt_0.sw_bitcell_opt_b5_1.bot.t29 1.13277
R5961 oa_sar8_acore18_opt_0.sw_bitcell_opt_b5_1.bot.t19 oa_sar8_acore18_opt_0.sw_bitcell_opt_b5_1.bot.t14 1.13277
R5962 oa_sar8_acore18_opt_0.sw_bitcell_opt_b5_1.bot.t14 oa_sar8_acore18_opt_0.sw_bitcell_opt_b5_1.bot.t9 1.13277
R5963 oa_sar8_acore18_opt_0.sw_bitcell_opt_b5_1.bot.t9 oa_sar8_acore18_opt_0.sw_bitcell_opt_b5_1.bot.t1 1.13277
R5964 oa_sar8_acore18_opt_0.sw_bitcell_opt_b5_1.bot.t29 oa_sar8_acore18_opt_0.sw_bitcell_opt_b5_1.bot.t21 1.13277
R5965 oa_sar8_acore18_opt_0.sw_bitcell_opt_b4_1.bot oa_sar8_acore18_opt_0.sw_bitcell_opt_b4_1.bot.n7 62.4698
R5966 oa_sar8_acore18_opt_0.sw_bitcell_opt_b4_1.bot.n6 oa_sar8_acore18_opt_0.sw_bitcell_opt_b4_1.bot.t1 29.4665
R5967 oa_sar8_acore18_opt_0.sw_bitcell_opt_b4_1.bot.n6 oa_sar8_acore18_opt_0.sw_bitcell_opt_b4_1.bot.t3 28.7147
R5968 oa_sar8_acore18_opt_0.sw_bitcell_opt_b4_1.bot.n6 oa_sar8_acore18_opt_0.sw_bitcell_opt_b4_1.bot.t5 28.7147
R5969 oa_sar8_acore18_opt_0.sw_bitcell_opt_b4_1.bot.n5 oa_sar8_acore18_opt_0.sw_bitcell_opt_b4_1.bot.t7 28.7147
R5970 oa_sar8_acore18_opt_0.sw_bitcell_opt_b4_1.bot.n5 oa_sar8_acore18_opt_0.sw_bitcell_opt_b4_1.bot.t9 28.7147
R5971 oa_sar8_acore18_opt_0.sw_bitcell_opt_b4_1.bot.n0 oa_sar8_acore18_opt_0.sw_bitcell_opt_b4_1.bot.t11 28.7147
R5972 oa_sar8_acore18_opt_0.sw_bitcell_opt_b4_1.bot.n0 oa_sar8_acore18_opt_0.sw_bitcell_opt_b4_1.bot.t13 28.7147
R5973 oa_sar8_acore18_opt_0.sw_bitcell_opt_b4_1.bot.n1 oa_sar8_acore18_opt_0.sw_bitcell_opt_b4_1.bot.t15 28.7147
R5974 oa_sar8_acore18_opt_0.sw_bitcell_opt_b4_1.bot.n1 oa_sar8_acore18_opt_0.sw_bitcell_opt_b4_1.bot.t17 27.2117
R5975 oa_sar8_acore18_opt_0.sw_bitcell_opt_b4_1.bot.n1 oa_sar8_acore18_opt_0.sw_bitcell_opt_b4_1.bot.t19 27.2117
R5976 oa_sar8_acore18_opt_0.sw_bitcell_opt_b4_1.bot.n4 oa_sar8_acore18_opt_0.sw_bitcell_opt_b4_1.bot.t21 27.2117
R5977 oa_sar8_acore18_opt_0.sw_bitcell_opt_b4_1.bot.n4 oa_sar8_acore18_opt_0.sw_bitcell_opt_b4_1.bot.t23 27.2117
R5978 oa_sar8_acore18_opt_0.sw_bitcell_opt_b4_1.bot.n2 oa_sar8_acore18_opt_0.sw_bitcell_opt_b4_1.bot.t25 27.2117
R5979 oa_sar8_acore18_opt_0.sw_bitcell_opt_b4_1.bot.n2 oa_sar8_acore18_opt_0.sw_bitcell_opt_b4_1.bot.t27 27.2117
R5980 oa_sar8_acore18_opt_0.sw_bitcell_opt_b4_1.bot.n3 oa_sar8_acore18_opt_0.sw_bitcell_opt_b4_1.bot.t29 27.2117
R5981 oa_sar8_acore18_opt_0.sw_bitcell_opt_b4_1.bot.n3 oa_sar8_acore18_opt_0.sw_bitcell_opt_b4_1.bot.t31 27.2117
R5982 oa_sar8_acore18_opt_0.sw_bitcell_opt_b4_1.bot.n7 oa_sar8_acore18_opt_0.sw_bitcell_opt_b4_1.bot.n3 4.18524
R5983 oa_sar8_acore18_opt_0.sw_bitcell_opt_b4_1.bot.n7 oa_sar8_acore18_opt_0.sw_bitcell_opt_b4_1.bot 4.0485
R5984 oa_sar8_acore18_opt_0.sw_bitcell_opt_b4_1.bot.t33 oa_sar8_acore18_opt_0.sw_bitcell_opt_b4_1.bot.t0 30.9415
R5985 oa_sar8_acore18_opt_0.sw_bitcell_opt_b4_1.bot.n4 oa_sar8_acore18_opt_0.sw_bitcell_opt_b4_1.bot.n1 2.41924
R5986 oa_sar8_acore18_opt_0.sw_bitcell_opt_b4_1.bot.n3 oa_sar8_acore18_opt_0.sw_bitcell_opt_b4_1.bot.n2 2.25581
R5987 oa_sar8_acore18_opt_0.sw_bitcell_opt_b4_1.bot oa_sar8_acore18_opt_0.sw_bitcell_opt_b4_1.bot.t0 1.6043
R5988 oa_sar8_acore18_opt_0.sw_bitcell_opt_b4_1.bot.n5 oa_sar8_acore18_opt_0.sw_bitcell_opt_b4_1.bot.n6 1.50404
R5989 oa_sar8_acore18_opt_0.sw_bitcell_opt_b4_1.bot.n0 oa_sar8_acore18_opt_0.sw_bitcell_opt_b4_1.bot.n5 1.50404
R5990 oa_sar8_acore18_opt_0.sw_bitcell_opt_b4_1.bot.n1 oa_sar8_acore18_opt_0.sw_bitcell_opt_b4_1.bot.n0 1.50404
R5991 oa_sar8_acore18_opt_0.sw_bitcell_opt_b4_1.bot.n2 oa_sar8_acore18_opt_0.sw_bitcell_opt_b4_1.bot.n4 1.50404
R5992 oa_sar8_acore18_opt_0.sw_bitcell_opt_b3_1.bot oa_sar8_acore18_opt_0.sw_bitcell_opt_b3_1.bot.n4 66.1797
R5993 oa_sar8_acore18_opt_0.sw_bitcell_opt_b3_1.bot.n0 oa_sar8_acore18_opt_0.sw_bitcell_opt_b3_1.bot.t2 28.4331
R5994 oa_sar8_acore18_opt_0.sw_bitcell_opt_b3_1.bot.n1 oa_sar8_acore18_opt_0.sw_bitcell_opt_b3_1.bot.t4 28.4331
R5995 oa_sar8_acore18_opt_0.sw_bitcell_opt_b3_1.bot.n1 oa_sar8_acore18_opt_0.sw_bitcell_opt_b3_1.bot.t6 28.4331
R5996 oa_sar8_acore18_opt_0.sw_bitcell_opt_b3_1.bot.n3 oa_sar8_acore18_opt_0.sw_bitcell_opt_b3_1.bot.t8 28.4331
R5997 oa_sar8_acore18_opt_0.sw_bitcell_opt_b3_1.bot.n2 oa_sar8_acore18_opt_0.sw_bitcell_opt_b3_1.bot.t10 28.2451
R5998 oa_sar8_acore18_opt_0.sw_bitcell_opt_b3_1.bot.n2 oa_sar8_acore18_opt_0.sw_bitcell_opt_b3_1.bot.t12 27.4933
R5999 oa_sar8_acore18_opt_0.sw_bitcell_opt_b3_1.bot.n2 oa_sar8_acore18_opt_0.sw_bitcell_opt_b3_1.bot.t14 27.4933
R6000 oa_sar8_acore18_opt_0.sw_bitcell_opt_b3_1.bot.n0 oa_sar8_acore18_opt_0.sw_bitcell_opt_b3_1.bot.t16 27.4933
R6001 oa_sar8_acore18_opt_0.sw_bitcell_opt_b3_1.bot.t1 oa_sar8_acore18_opt_0.sw_bitcell_opt_b3_1.bot.t0 31.2836
R6002 oa_sar8_acore18_opt_0.sw_bitcell_opt_b3_1.bot.n4 oa_sar8_acore18_opt_0.sw_bitcell_opt_b3_1.bot.n3 7.08924
R6003 oa_sar8_acore18_opt_0.sw_bitcell_opt_b3_1.bot.n4 oa_sar8_acore18_opt_0.sw_bitcell_opt_b3_1.bot 3.93117
R6004 oa_sar8_acore18_opt_0.sw_bitcell_opt_b3_1.bot.n0 oa_sar8_acore18_opt_0.sw_bitcell_opt_b3_1.bot.n2 1.50404
R6005 oa_sar8_acore18_opt_0.sw_bitcell_opt_b3_1.bot.n3 oa_sar8_acore18_opt_0.sw_bitcell_opt_b3_1.bot.n1 1.50404
R6006 oa_sar8_acore18_opt_0.sw_bitcell_opt_b3_1.bot oa_sar8_acore18_opt_0.sw_bitcell_opt_b3_1.bot.t0 1.4745
R6007 oa_sar8_acore18_opt_0.sw_bitcell_opt_b3_1.bot.n1 oa_sar8_acore18_opt_0.sw_bitcell_opt_b3_1.bot.n0 1.34061
R6008 oa_sar8_acore18_opt_0.sw_bitcell_opt_b2_1.bot oa_sar8_acore18_opt_0.sw_bitcell_opt_b2_1.bot.n2 69.8039
R6009 oa_sar8_acore18_opt_0.sw_bitcell_opt_b2_1.bot.t0 oa_sar8_acore18_opt_0.sw_bitcell_opt_b2_1.bot.t1 31.3455
R6010 oa_sar8_acore18_opt_0.sw_bitcell_opt_b2_1.bot.n1 oa_sar8_acore18_opt_0.sw_bitcell_opt_b2_1.bot.t6 28.5267
R6011 oa_sar8_acore18_opt_0.sw_bitcell_opt_b2_1.bot.n0 oa_sar8_acore18_opt_0.sw_bitcell_opt_b2_1.bot.t2 28.1515
R6012 oa_sar8_acore18_opt_0.sw_bitcell_opt_b2_1.bot.n0 oa_sar8_acore18_opt_0.sw_bitcell_opt_b2_1.bot.t4 28.1515
R6013 oa_sar8_acore18_opt_0.sw_bitcell_opt_b2_1.bot.n1 oa_sar8_acore18_opt_0.sw_bitcell_opt_b2_1.bot.t8 27.7749
R6014 oa_sar8_acore18_opt_0.sw_bitcell_opt_b2_1.bot.n0 oa_sar8_acore18_opt_0.sw_bitcell_opt_b2_1.bot.n1 6.62313
R6015 oa_sar8_acore18_opt_0.sw_bitcell_opt_b2_1.bot.n2 oa_sar8_acore18_opt_0.sw_bitcell_opt_b2_1.bot.n0 6.05587
R6016 oa_sar8_acore18_opt_0.sw_bitcell_opt_b2_1.bot.n2 oa_sar8_acore18_opt_0.sw_bitcell_opt_b2_1.bot 3.81383
R6017 oa_sar8_acore18_opt_0.sw_bitcell_opt_b2_1.bot oa_sar8_acore18_opt_0.sw_bitcell_opt_b2_1.bot.t0 1.3843
R6018 oa_sar8_acore18_opt_0.sw_bitcell_opt_b1_1.bot oa_sar8_acore18_opt_0.sw_bitcell_opt_b1_1.bot.n1 73.3444
R6019 oa_sar8_acore18_opt_0.sw_bitcell_opt_b1_1.bot.n0 oa_sar8_acore18_opt_0.sw_bitcell_opt_b1_1.bot.t3 37.6963
R6020 oa_sar8_acore18_opt_0.sw_bitcell_opt_b1_1.bot.n0 oa_sar8_acore18_opt_0.sw_bitcell_opt_b1_1.bot.t1 27.8699
R6021 oa_sar8_acore18_opt_0.sw_bitcell_opt_b1_1.bot.t5 oa_sar8_acore18_opt_0.sw_bitcell_opt_b1_1.bot.t0 31.7993
R6022 oa_sar8_acore18_opt_0.sw_bitcell_opt_b1_1.bot.n1 oa_sar8_acore18_opt_0.sw_bitcell_opt_b1_1.bot.n0 4.27324
R6023 oa_sar8_acore18_opt_0.sw_bitcell_opt_b1_1.bot.n1 oa_sar8_acore18_opt_0.sw_bitcell_opt_b1_1.bot 3.6965
R6024 oa_sar8_acore18_opt_0.sw_bitcell_opt_b1_1.bot oa_sar8_acore18_opt_0.sw_bitcell_opt_b1_1.bot.t0 1.2963
R6025 oa_sar8_acore18_opt_0.sw_bitcell_opt_b0_1.bot oa_sar8_acore18_opt_0.sw_bitcell_opt_b0_1.bot.n0 76.7925
R6026 oa_sar8_acore18_opt_0.sw_bitcell_opt_b0_1.bot.n0 oa_sar8_acore18_opt_0.sw_bitcell_opt_b0_1.bot.t2 42.7308
R6027 oa_sar8_acore18_opt_0.sw_bitcell_opt_b0_1.bot.t0 oa_sar8_acore18_opt_0.sw_bitcell_opt_b0_1.bot.t1 32.1925
R6028 oa_sar8_acore18_opt_0.sw_bitcell_opt_b0_1.bot.n0 oa_sar8_acore18_opt_0.sw_bitcell_opt_b0_1.bot 3.57917
R6029 oa_sar8_acore18_opt_0.sw_bitcell_opt_b0_1.bot oa_sar8_acore18_opt_0.sw_bitcell_opt_b0_1.bot.t0 1.2083
R6030 oa_sar8_acore18_opt_0.sw_bitcell_opt_term_0.trkb.t4 oa_sar8_acore18_opt_0.sw_bitcell_opt_term_0.trkb.t1 34.0171
R6031 oa_sar8_acore18_opt_0.sw_bitcell_opt_term_0.trkb.n3 oa_sar8_acore18_opt_0.sw_bitcell_opt_term_0.trkb.n2 33.1211
R6032 oa_sar8_acore18_opt_0.sw_bitcell_opt_term_0.trkb.n1 oa_sar8_acore18_opt_0.sw_bitcell_opt_term_0.trkb.t5 30.4509
R6033 oa_sar8_acore18_opt_0.sw_bitcell_opt_term_0.trkb.n6 oa_sar8_acore18_opt_0.sw_bitcell_opt_term_0.trkb.t10 30.4509
R6034 oa_sar8_acore18_opt_0.sw_bitcell_opt_term_0.trkb oa_sar8_acore18_opt_0.sw_bitcell_opt_term_0.trkb.t13 24.7602
R6035 oa_sar8_acore18_opt_0.sw_bitcell_opt_term_0.trkb.n3 oa_sar8_acore18_opt_0.sw_bitcell_opt_term_0.trkb 24.5994
R6036 oa_sar8_acore18_opt_0.sw_bitcell_opt_term_0.trkb.n0 oa_sar8_acore18_opt_0.sw_bitcell_opt_term_0.trkb.t11 22.0333
R6037 oa_sar8_acore18_opt_0.sw_bitcell_opt_term_0.trkb oa_sar8_acore18_opt_0.sw_bitcell_opt_term_0.trkb.t12 22.0333
R6038 oa_sar8_acore18_opt_0.sw_bitcell_opt_term_0.trkb oa_sar8_acore18_opt_0.sw_bitcell_opt_term_0.trkb.t0 22.0333
R6039 oa_sar8_acore18_opt_0.sw_bitcell_opt_term_0.trkb oa_sar8_acore18_opt_0.sw_bitcell_opt_term_0.trkb.t14 22.0333
R6040 oa_sar8_acore18_opt_0.sw_bitcell_opt_term_0.trkb oa_sar8_acore18_opt_0.sw_bitcell_opt_term_0.trkb.t15 22.0333
R6041 oa_sar8_acore18_opt_0.sw_bitcell_opt_term_0.trkb oa_sar8_acore18_opt_0.sw_bitcell_opt_term_0.trkb.t16 22.0333
R6042 oa_sar8_acore18_opt_0.sw_bitcell_opt_term_0.trkb oa_sar8_acore18_opt_0.sw_bitcell_opt_term_0.trkb.t17 22.0333
R6043 oa_sar8_acore18_opt_0.sw_bitcell_opt_term_0.trkb oa_sar8_acore18_opt_0.sw_bitcell_opt_term_0.trkb.t18 22.0333
R6044 oa_sar8_acore18_opt_0.sw_bitcell_opt_term_0.trkb oa_sar8_acore18_opt_0.sw_bitcell_opt_term_0.trkb.t19 22.0333
R6045 oa_sar8_acore18_opt_0.sw_bitcell_opt_term_0.trkb oa_sar8_acore18_opt_0.sw_bitcell_opt_term_0.trkb.t20 22.0333
R6046 oa_sar8_acore18_opt_0.sw_bitcell_opt_term_0.trkb oa_sar8_acore18_opt_0.sw_bitcell_opt_term_0.trkb.t21 22.0333
R6047 oa_sar8_acore18_opt_0.sw_bitcell_opt_term_0.trkb.n2 oa_sar8_acore18_opt_0.sw_bitcell_opt_term_0.trkb.t22 22.0333
R6048 oa_sar8_acore18_opt_0.sw_bitcell_opt_term_0.trkb oa_sar8_acore18_opt_0.sw_bitcell_opt_term_0.trkb.t23 22.0333
R6049 oa_sar8_acore18_opt_0.sw_bitcell_opt_term_0.trkb oa_sar8_acore18_opt_0.sw_bitcell_opt_term_0.trkb.t24 22.0333
R6050 oa_sar8_acore18_opt_0.sw_bitcell_opt_term_0.trkb oa_sar8_acore18_opt_0.sw_bitcell_opt_term_0.trkb.t25 22.0333
R6051 oa_sar8_acore18_opt_0.sw_bitcell_opt_term_0.trkb oa_sar8_acore18_opt_0.sw_bitcell_opt_term_0.trkb.t26 22.0333
R6052 oa_sar8_acore18_opt_0.sw_bitcell_opt_term_0.trkb oa_sar8_acore18_opt_0.sw_bitcell_opt_term_0.trkb.t27 22.0333
R6053 oa_sar8_acore18_opt_0.sw_bitcell_opt_term_0.trkb oa_sar8_acore18_opt_0.sw_bitcell_opt_term_0.trkb.t28 22.0333
R6054 oa_sar8_acore18_opt_0.sw_bitcell_opt_term_0.trkb oa_sar8_acore18_opt_0.sw_bitcell_opt_term_0.trkb.t29 22.0333
R6055 oa_sar8_acore18_opt_0.sw_bitcell_opt_term_0.trkb oa_sar8_acore18_opt_0.sw_bitcell_opt_term_0.trkb.t30 22.0329
R6056 oa_sar8_acore18_opt_0.sw_bitcell_opt_term_0.trkb.n4 oa_sar8_acore18_opt_0.sw_bitcell_opt_term_0.trkb.t8 20.8866
R6057 oa_sar8_acore18_opt_0.sw_bitcell_opt_term_0.trkb.n6 oa_sar8_acore18_opt_0.sw_bitcell_opt_term_0.trkb.t9 20.8866
R6058 oa_sar8_acore18_opt_0.sw_bitcell_opt_term_0.trkb.n1 oa_sar8_acore18_opt_0.sw_bitcell_opt_term_0.trkb.t6 20.8862
R6059 oa_sar8_acore18_opt_0.sw_bitcell_opt_term_0.trkb oa_sar8_acore18_opt_0.sw_bitcell_opt_term_0.trkb.t7 20.8862
R6060 oa_sar8_acore18_opt_0.sw_bitcell_opt_term_0.trkb.n0 oa_sar8_acore18_opt_0.sw_bitcell_opt_term_0.trkb.n3 20.5327
R6061 oa_sar8_acore18_opt_0.sw_bitcell_opt_term_0.trkb oa_sar8_acore18_opt_0.sw_bitcell_opt_term_0.trkb.n5 18.5285
R6062 oa_sar8_acore18_opt_0.sw_bitcell_opt_term_0.trkb.n2 oa_sar8_acore18_opt_0.sw_bitcell_opt_term_0.trkb 3.5634
R6063 oa_sar8_acore18_opt_0.sw_bitcell_opt_term_0.trkb.n0 oa_sar8_acore18_opt_0.sw_bitcell_opt_term_0.trkb 3.0838
R6064 oa_sar8_acore18_opt_0.sw_bitcell_opt_term_0.trkb.n5 oa_sar8_acore18_opt_0.sw_bitcell_opt_term_0.trkb 2.7714
R6065 oa_sar8_acore18_opt_0.sw_bitcell_opt_term_0.trkb oa_sar8_acore18_opt_0.sw_bitcell_opt_term_0.trkb.n0 2.5932
R6066 oa_sar8_acore18_opt_0.sw_bitcell_opt_term_0.trkb oa_sar8_acore18_opt_0.sw_bitcell_opt_term_0.trkb.n1 1.6538
R6067 oa_sar8_acore18_opt_0.sw_bitcell_opt_term_0.trkb oa_sar8_acore18_opt_0.sw_bitcell_opt_term_0.trkb.t3 1.2545
R6068 oa_sar8_acore18_opt_0.sw_bitcell_opt_term_0.trkb.t3 oa_sar8_acore18_opt_0.sw_bitcell_opt_term_0.trkb.t4 1.1335
R6069 oa_sar8_acore18_opt_0.sw_bitcell_opt_term_0.trkb.n5 oa_sar8_acore18_opt_0.sw_bitcell_opt_term_0.trkb.n4 1.1247
R6070 oa_sar8_acore18_opt_0.sw_bitcell_opt_term_0.trkb.n4 oa_sar8_acore18_opt_0.sw_bitcell_opt_term_0.trkb.n6 1.0147
R6071 oa_sar8_acore18_opt_0.sw_bitcell_opt_term_1.bot oa_sar8_acore18_opt_0.sw_bitcell_opt_term_1.bot.n0 80.2363
R6072 oa_sar8_acore18_opt_0.sw_bitcell_opt_term_1.bot.n0 oa_sar8_acore18_opt_0.sw_bitcell_opt_term_1.bot.t1 30.2721
R6073 oa_sar8_acore18_opt_0.sw_bitcell_opt_term_1.bot.t0 oa_sar8_acore18_opt_0.sw_bitcell_opt_term_1.bot.t3 32.1925
R6074 oa_sar8_acore18_opt_0.sw_bitcell_opt_term_1.bot.n0 oa_sar8_acore18_opt_0.sw_bitcell_opt_term_1.bot 3.46183
R6075 oa_sar8_acore18_opt_0.sw_bitcell_opt_term_1.bot oa_sar8_acore18_opt_0.sw_bitcell_opt_term_1.bot.t0 1.2083
R6076 oa_sar8_acore18_opt_0.sw_tg_opt_0.bot oa_sar8_acore18_opt_0.sw_tg_opt_0.bot.t3 122.109
R6077 oa_sar8_acore18_opt_0.sw_tg_opt_0.bot.t1 oa_sar8_acore18_opt_0.sw_tg_opt_0.bot.t0 25.1028
R6078 oa_sar8_acore18_opt_0.sw_tg_opt_0.bot oa_sar8_acore18_opt_0.sw_tg_opt_0.bot.t5 11.6667
R6079 oa_sar8_acore18_opt_0.sw_tg_opt_0.bot oa_sar8_acore18_opt_0.sw_tg_opt_0.bot.t1 11.5613
R6080 oa_sar8_acore18_opt_0.sw_tg_opt_0.bot.t3 oa_sar8_acore18_opt_0.sw_tg_opt_0.bot 10.861
R6081 oa_sar8_acore18_opt_0.sw_tg_opt_0.bot.t3 oa_sar8_acore18_opt_0.sw_tg_opt_0.bot.t4 1.40387
R6082 oa_sar8_acore18_opt_0.sw_tg_opt_0.bot.t3 oa_sar8_acore18_opt_0.sw_tg_opt_0.bot.t2 1.02767
R6083 oa_sar8_acore18_opt_0.sw_tg_opt_1.bot oa_sar8_acore18_opt_0.sw_tg_opt_1.bot.t3 119.483
R6084 oa_sar8_acore18_opt_0.sw_tg_opt_1.bot.t1 oa_sar8_acore18_opt_0.sw_tg_opt_1.bot.t0 25.1028
R6085 oa_sar8_acore18_opt_0.sw_tg_opt_1.bot oa_sar8_acore18_opt_0.sw_tg_opt_1.bot.t5 11.6673
R6086 oa_sar8_acore18_opt_0.sw_tg_opt_1.bot oa_sar8_acore18_opt_0.sw_tg_opt_1.bot.t1 11.5613
R6087 oa_sar8_acore18_opt_0.sw_tg_opt_1.bot.t3 oa_sar8_acore18_opt_0.sw_tg_opt_1.bot 10.8611
R6088 oa_sar8_acore18_opt_0.sw_tg_opt_1.bot.t3 oa_sar8_acore18_opt_0.sw_tg_opt_1.bot.t4 1.40387
R6089 oa_sar8_acore18_opt_0.sw_tg_opt_1.bot.t3 oa_sar8_acore18_opt_0.sw_tg_opt_1.bot.t2 1.02767
R6090 sar_ctrl_async_phys_0.sg13g2_buf_1_2.X.n5 sar_ctrl_async_phys_0.sg13g2_buf_1_2.X 39.6376
R6091 sar_ctrl_async_phys_0.sg13g2_buf_1_2.X.n2 sar_ctrl_async_phys_0.sg13g2_buf_1_2.X 35.2488
R6092 sar_ctrl_async_phys_0.sg13g2_buf_1_2.X.t3 sar_ctrl_async_phys_0.sg13g2_buf_1_2.X.t2 33.4028
R6093 sar_ctrl_async_phys_0.sg13g2_buf_1_2.X.t5 sar_ctrl_async_phys_0.sg13g2_buf_1_2.X.t4 33.4028
R6094 sar_ctrl_async_phys_0.sg13g2_buf_1_2.X.t1 sar_ctrl_async_phys_0.sg13g2_buf_1_2.X.t0 33.4028
R6095 sar_ctrl_async_phys_0.sg13g2_buf_1_2.X.n0 sar_ctrl_async_phys_0.sg13g2_buf_1_2.X 21.6935
R6096 sar_ctrl_async_phys_0.sg13g2_buf_1_2.X.n4 sar_ctrl_async_phys_0.sg13g2_buf_1_2.X 20.5847
R6097 sar_ctrl_async_phys_0.sg13g2_buf_1_2.X.n0 sar_ctrl_async_phys_0.sg13g2_buf_1_2.X 19.4231
R6098 sar_ctrl_async_phys_0.sg13g2_buf_1_2.X.n1 sar_ctrl_async_phys_0.sg13g2_buf_1_2.X 18.7367
R6099 sar_ctrl_async_phys_0.sg13g2_buf_1_2.X sar_ctrl_async_phys_0.sg13g2_buf_1_2.X.t1 15.0489
R6100 sar_ctrl_async_phys_0.sg13g2_buf_1_2.X sar_ctrl_async_phys_0.sg13g2_buf_1_2.X.t5 15.0489
R6101 sar_ctrl_async_phys_0.sg13g2_buf_1_2.X sar_ctrl_async_phys_0.sg13g2_buf_1_2.X.t3 15.0489
R6102 sar_ctrl_async_phys_0.sg13g2_buf_1_2.X.n6 sar_ctrl_async_phys_0.sg13g2_buf_1_2.X.n5 10.9013
R6103 sar_ctrl_async_phys_0.sg13g2_buf_1_2.X.n6 sar_ctrl_async_phys_0.sg13g2_buf_1_2.X 10.3306
R6104 sar_ctrl_async_phys_0.sg13g2_buf_1_2.X.n3 sar_ctrl_async_phys_0.sg13g2_buf_1_2.X.n2 9.69266
R6105 sar_ctrl_async_phys_0.sg13g2_buf_1_2.X sar_ctrl_async_phys_0.sg13g2_buf_1_2.X.n6 9.42528
R6106 sar_ctrl_async_phys_0.sg13g2_buf_1_2.X.n2 sar_ctrl_async_phys_0.sg13g2_buf_1_2.X 9.0005
R6107 sar_ctrl_async_phys_0.sg13g2_buf_1_2.X.n4 sar_ctrl_async_phys_0.sg13g2_buf_1_2.X.n3 4.8581
R6108 sar_ctrl_async_phys_0.sg13g2_buf_1_2.X.n3 sar_ctrl_async_phys_0.sg13g2_buf_1_2.X.n1 2.5349
R6109 sar_ctrl_async_phys_0.sg13g2_buf_1_2.X.n1 sar_ctrl_async_phys_0.sg13g2_buf_1_2.X.n0 2.3941
R6110 sar_ctrl_async_phys_0.sg13g2_buf_1_2.X.n5 sar_ctrl_async_phys_0.sg13g2_buf_1_2.X.n4 1.0565
R6111 sar_ctrl_async_phys_0.sg13g2_buf_1_2.A.t1 sar_ctrl_async_phys_0.sg13g2_buf_1_2.A.t0 33.4028
R6112 sar_ctrl_async_phys_0.sg13g2_buf_1_2.A.t6 sar_ctrl_async_phys_0.sg13g2_buf_1_2.A.t5 33.4028
R6113 sar_ctrl_async_phys_0.sg13g2_buf_1_2.A.t3 sar_ctrl_async_phys_0.sg13g2_buf_1_2.A.t2 33.4028
R6114 sar_ctrl_async_phys_0.sg13g2_buf_1_2.A.n6 sar_ctrl_async_phys_0.sg13g2_buf_1_2.A 22.2479
R6115 sar_ctrl_async_phys_0.sg13g2_buf_1_2.A.n0 sar_ctrl_async_phys_0.sg13g2_buf_1_2.A 22.0279
R6116 sar_ctrl_async_phys_0.sg13g2_buf_1_2.A.n4 sar_ctrl_async_phys_0.sg13g2_buf_1_2.A.n3 19.8983
R6117 sar_ctrl_async_phys_0.sg13g2_buf_1_2.A.n2 sar_ctrl_async_phys_0.sg13g2_buf_1_2.A 18.3671
R6118 sar_ctrl_async_phys_0.sg13g2_buf_1_2.A sar_ctrl_async_phys_0.sg13g2_buf_1_2.A.n6 18.0587
R6119 sar_ctrl_async_phys_0.sg13g2_buf_1_2.A.n0 sar_ctrl_async_phys_0.sg13g2_buf_1_2.A 18.0005
R6120 sar_ctrl_async_phys_0.sg13g2_buf_1_2.A sar_ctrl_async_phys_0.sg13g2_buf_1_2.A.t1 15.0489
R6121 sar_ctrl_async_phys_0.sg13g2_buf_1_2.A sar_ctrl_async_phys_0.sg13g2_buf_1_2.A.t3 15.0489
R6122 sar_ctrl_async_phys_0.sg13g2_buf_1_2.A sar_ctrl_async_phys_0.sg13g2_buf_1_2.A.t6 15.0489
R6123 sar_ctrl_async_phys_0.sg13g2_buf_1_2.A sar_ctrl_async_phys_0.sg13g2_buf_1_2.A.t7 15.0255
R6124 sar_ctrl_async_phys_0.sg13g2_buf_1_2.A sar_ctrl_async_phys_0.sg13g2_buf_1_2.A.t4 15.0152
R6125 sar_ctrl_async_phys_0.sg13g2_buf_1_2.A.n3 sar_ctrl_async_phys_0.sg13g2_buf_1_2.A.n2 14.908
R6126 sar_ctrl_async_phys_0.sg13g2_buf_1_2.A.n2 sar_ctrl_async_phys_0.sg13g2_buf_1_2.A.n1 12.9192
R6127 sar_ctrl_async_phys_0.sg13g2_buf_1_2.A.n6 sar_ctrl_async_phys_0.sg13g2_buf_1_2.A.n5 12.2271
R6128 sar_ctrl_async_phys_0.sg13g2_buf_1_2.A.n1 sar_ctrl_async_phys_0.sg13g2_buf_1_2.A.n0 11.1125
R6129 sar_ctrl_async_phys_0.sg13g2_buf_1_2.A.n1 sar_ctrl_async_phys_0.sg13g2_buf_1_2.A 10.4759
R6130 sar_ctrl_async_phys_0.sg13g2_buf_1_2.A.n5 sar_ctrl_async_phys_0.sg13g2_buf_1_2.A 9.0005
R6131 sar_ctrl_async_phys_0.sg13g2_buf_1_2.A.n4 sar_ctrl_async_phys_0.sg13g2_buf_1_2.A 9.0005
R6132 sar_ctrl_async_phys_0.sg13g2_buf_1_2.A.n3 sar_ctrl_async_phys_0.sg13g2_buf_1_2.A 9.0005
R6133 sar_ctrl_async_phys_0.sg13g2_buf_1_2.A.n5 sar_ctrl_async_phys_0.sg13g2_buf_1_2.A.n4 3.4941
R6134 sar_ctrl_async_phys_0.sg13g2_a22oi_1_0.A1.n6 sar_ctrl_async_phys_0.sg13g2_a22oi_1_0.A1.n5 55.6306
R6135 sar_ctrl_async_phys_0.sg13g2_a22oi_1_0.A1 sar_ctrl_async_phys_0.sg13g2_a22oi_1_0.A1.n6 30.5532
R6136 sar_ctrl_async_phys_0.sg13g2_a22oi_1_0.A1.n0 sar_ctrl_async_phys_0.sg13g2_a22oi_1_0.A1 29.0008
R6137 sar_ctrl_async_phys_0.sg13g2_a22oi_1_0.A1.n1 sar_ctrl_async_phys_0.sg13g2_a22oi_1_0.A1 20.0039
R6138 sar_ctrl_async_phys_0.sg13g2_a22oi_1_0.A1.n1 sar_ctrl_async_phys_0.sg13g2_a22oi_1_0.A1 18.7367
R6139 sar_ctrl_async_phys_0.sg13g2_a22oi_1_0.A1.n4 sar_ctrl_async_phys_0.sg13g2_a22oi_1_0.A1 18.1823
R6140 sar_ctrl_async_phys_0.sg13g2_a22oi_1_0.A1.n3 sar_ctrl_async_phys_0.sg13g2_a22oi_1_0.A1 18.0005
R6141 sar_ctrl_async_phys_0.sg13g2_a22oi_1_0.A1 sar_ctrl_async_phys_0.sg13g2_a22oi_1_0.A1.t11 17.0702
R6142 sar_ctrl_async_phys_0.sg13g2_a22oi_1_0.A1 sar_ctrl_async_phys_0.sg13g2_a22oi_1_0.A1.t13 17.0702
R6143 sar_ctrl_async_phys_0.sg13g2_a22oi_1_0.A1 sar_ctrl_async_phys_0.sg13g2_a22oi_1_0.A1.t14 17.0702
R6144 sar_ctrl_async_phys_0.sg13g2_a22oi_1_0.A1 sar_ctrl_async_phys_0.sg13g2_a22oi_1_0.A1.t12 17.0702
R6145 sar_ctrl_async_phys_0.sg13g2_a22oi_1_0.A1 sar_ctrl_async_phys_0.sg13g2_a22oi_1_0.A1.t10 17.0702
R6146 sar_ctrl_async_phys_0.sg13g2_a22oi_1_0.A1 sar_ctrl_async_phys_0.sg13g2_a22oi_1_0.A1.t2 17.0421
R6147 sar_ctrl_async_phys_0.sg13g2_a22oi_1_0.A1 sar_ctrl_async_phys_0.sg13g2_a22oi_1_0.A1.t1 17.0421
R6148 sar_ctrl_async_phys_0.sg13g2_a22oi_1_0.A1 sar_ctrl_async_phys_0.sg13g2_a22oi_1_0.A1.t4 15.0941
R6149 sar_ctrl_async_phys_0.sg13g2_a22oi_1_0.A1 sar_ctrl_async_phys_0.sg13g2_a22oi_1_0.A1.t3 15.066
R6150 sar_ctrl_async_phys_0.sg13g2_a22oi_1_0.A1 sar_ctrl_async_phys_0.sg13g2_a22oi_1_0.A1.t6 15.066
R6151 sar_ctrl_async_phys_0.sg13g2_a22oi_1_0.A1 sar_ctrl_async_phys_0.sg13g2_a22oi_1_0.A1.t8 15.066
R6152 sar_ctrl_async_phys_0.sg13g2_a22oi_1_0.A1 sar_ctrl_async_phys_0.sg13g2_a22oi_1_0.A1.t9 15.066
R6153 sar_ctrl_async_phys_0.sg13g2_a22oi_1_0.A1 sar_ctrl_async_phys_0.sg13g2_a22oi_1_0.A1.t5 15.066
R6154 sar_ctrl_async_phys_0.sg13g2_a22oi_1_0.A1 sar_ctrl_async_phys_0.sg13g2_a22oi_1_0.A1.t7 15.0005
R6155 sar_ctrl_async_phys_0.sg13g2_a22oi_1_0.A1.n5 sar_ctrl_async_phys_0.sg13g2_a22oi_1_0.A1.n0 11.6608
R6156 sar_ctrl_async_phys_0.sg13g2_a22oi_1_0.A1.n2 sar_ctrl_async_phys_0.sg13g2_a22oi_1_0.A1.n1 11.0008
R6157 sar_ctrl_async_phys_0.sg13g2_a22oi_1_0.A1.n3 sar_ctrl_async_phys_0.sg13g2_a22oi_1_0.A1.n2 10.9013
R6158 sar_ctrl_async_phys_0.sg13g2_a22oi_1_0.A1.n2 sar_ctrl_async_phys_0.sg13g2_a22oi_1_0.A1 9.06603
R6159 sar_ctrl_async_phys_0.sg13g2_a22oi_1_0.A1.n0 sar_ctrl_async_phys_0.sg13g2_a22oi_1_0.A1 9.02858
R6160 sar_ctrl_async_phys_0.sg13g2_a22oi_1_0.A1.n6 sar_ctrl_async_phys_0.sg13g2_a22oi_1_0.A1 9.0005
R6161 sar_ctrl_async_phys_0.sg13g2_a22oi_1_0.A1 sar_ctrl_async_phys_0.sg13g2_a22oi_1_0.A1.t0 6.3941
R6162 sar_ctrl_async_phys_0.sg13g2_a22oi_1_0.A1.n5 sar_ctrl_async_phys_0.sg13g2_a22oi_1_0.A1.n4 2.74306
R6163 sar_ctrl_async_phys_0.sg13g2_a22oi_1_0.A1.n4 sar_ctrl_async_phys_0.sg13g2_a22oi_1_0.A1.n3 1.5757
R6164 sar_ctrl_async_phys_0.dac_code[6].n0 sar_ctrl_async_phys_0.dac_code[6].t2 22.6194
R6165 sar_ctrl_async_phys_0.dac_code[6].n0 sar_ctrl_async_phys_0.dac_code[6].t1 21.1664
R6166 sar_ctrl_async_phys_0.dac_code[6] sar_ctrl_async_phys_0.dac_code[6].t0 5.73774
R6167 sar_ctrl_async_phys_0.dac_code[6] sar_ctrl_async_phys_0.dac_code[6].n0 1.0917
R6168 sar_ctrl_async_phys_0.sg13g2_a21oi_1_0.A1.n0 sar_ctrl_async_phys_0.sg13g2_a21oi_1_0.A1 28.0565
R6169 sar_ctrl_async_phys_0.sg13g2_a21oi_1_0.A1.n6 sar_ctrl_async_phys_0.sg13g2_a21oi_1_0.A1.n5 27.7215
R6170 sar_ctrl_async_phys_0.sg13g2_a21oi_1_0.A1.n2 sar_ctrl_async_phys_0.sg13g2_a21oi_1_0.A1.n1 26.4922
R6171 sar_ctrl_async_phys_0.sg13g2_a21oi_1_0.A1.n4 sar_ctrl_async_phys_0.sg13g2_a21oi_1_0.A1 18.8453
R6172 sar_ctrl_async_phys_0.sg13g2_a21oi_1_0.A1.n3 sar_ctrl_async_phys_0.sg13g2_a21oi_1_0.A1 18.0005
R6173 sar_ctrl_async_phys_0.sg13g2_a21oi_1_0.A1 sar_ctrl_async_phys_0.sg13g2_a21oi_1_0.A1.t4 15.0195
R6174 sar_ctrl_async_phys_0.sg13g2_a21oi_1_0.A1 sar_ctrl_async_phys_0.sg13g2_a21oi_1_0.A1.t6 15.0195
R6175 sar_ctrl_async_phys_0.sg13g2_a21oi_1_0.A1 sar_ctrl_async_phys_0.sg13g2_a21oi_1_0.A1.t5 15.0195
R6176 sar_ctrl_async_phys_0.sg13g2_a21oi_1_0.A1 sar_ctrl_async_phys_0.sg13g2_a21oi_1_0.A1.t3 15.0005
R6177 sar_ctrl_async_phys_0.sg13g2_a21oi_1_0.A1 sar_ctrl_async_phys_0.sg13g2_a21oi_1_0.A1.t1 15.0005
R6178 sar_ctrl_async_phys_0.sg13g2_a21oi_1_0.A1 sar_ctrl_async_phys_0.sg13g2_a21oi_1_0.A1.t2 15.0005
R6179 sar_ctrl_async_phys_0.sg13g2_a21oi_1_0.A1 sar_ctrl_async_phys_0.sg13g2_a21oi_1_0.A1.n6 12.232
R6180 sar_ctrl_async_phys_0.sg13g2_a21oi_1_0.A1.n5 sar_ctrl_async_phys_0.sg13g2_a21oi_1_0.A1.n4 11.9103
R6181 sar_ctrl_async_phys_0.sg13g2_a21oi_1_0.A1.n3 sar_ctrl_async_phys_0.sg13g2_a21oi_1_0.A1.n2 11.1125
R6182 sar_ctrl_async_phys_0.sg13g2_a21oi_1_0.A1.n6 sar_ctrl_async_phys_0.sg13g2_a21oi_1_0.A1 10.8455
R6183 sar_ctrl_async_phys_0.sg13g2_a21oi_1_0.A1.n5 sar_ctrl_async_phys_0.sg13g2_a21oi_1_0.A1 9.3261
R6184 sar_ctrl_async_phys_0.sg13g2_a21oi_1_0.A1.n1 sar_ctrl_async_phys_0.sg13g2_a21oi_1_0.A1 9.32356
R6185 sar_ctrl_async_phys_0.sg13g2_a21oi_1_0.A1.n2 sar_ctrl_async_phys_0.sg13g2_a21oi_1_0.A1 9.0005
R6186 sar_ctrl_async_phys_0.sg13g2_a21oi_1_0.A1.n0 sar_ctrl_async_phys_0.sg13g2_a21oi_1_0.A1 9.0005
R6187 sar_ctrl_async_phys_0.sg13g2_a21oi_1_0.A1.n1 sar_ctrl_async_phys_0.sg13g2_a21oi_1_0.A1.n0 7.33666
R6188 sar_ctrl_async_phys_0.sg13g2_a21oi_1_0.A1 sar_ctrl_async_phys_0.sg13g2_a21oi_1_0.A1.t0 6.43067
R6189 sar_ctrl_async_phys_0.sg13g2_a21oi_1_0.A1.n4 sar_ctrl_async_phys_0.sg13g2_a21oi_1_0.A1.n3 1.6901
R6190 sar_ctrl_async_phys_0.sg13g2_nor2b_1_0.A.n2 sar_ctrl_async_phys_0.sg13g2_nor2b_1_0.A.n1 33.5064
R6191 sar_ctrl_async_phys_0.sg13g2_nor2b_1_0.A.n6 sar_ctrl_async_phys_0.sg13g2_nor2b_1_0.A 27.7895
R6192 sar_ctrl_async_phys_0.sg13g2_nor2b_1_0.A.n1 sar_ctrl_async_phys_0.sg13g2_nor2b_1_0.A 24.4479
R6193 sar_ctrl_async_phys_0.sg13g2_nor2b_1_0.A.n4 sar_ctrl_async_phys_0.sg13g2_nor2b_1_0.A 21.8607
R6194 sar_ctrl_async_phys_0.sg13g2_nor2b_1_0.A.n3 sar_ctrl_async_phys_0.sg13g2_nor2b_1_0.A 21.3239
R6195 sar_ctrl_async_phys_0.sg13g2_nor2b_1_0.A.n0 sar_ctrl_async_phys_0.sg13g2_nor2b_1_0.A 19.7878
R6196 sar_ctrl_async_phys_0.sg13g2_nor2b_1_0.A.n0 sar_ctrl_async_phys_0.sg13g2_nor2b_1_0.A 18.0005
R6197 sar_ctrl_async_phys_0.sg13g2_nor2b_1_0.A.n5 sar_ctrl_async_phys_0.sg13g2_nor2b_1_0.A.n4 16.6007
R6198 sar_ctrl_async_phys_0.sg13g2_nor2b_1_0.A.n3 sar_ctrl_async_phys_0.sg13g2_nor2b_1_0.A.n2 15.0312
R6199 sar_ctrl_async_phys_0.sg13g2_nor2b_1_0.A sar_ctrl_async_phys_0.sg13g2_nor2b_1_0.A.t1 15.0289
R6200 sar_ctrl_async_phys_0.sg13g2_nor2b_1_0.A sar_ctrl_async_phys_0.sg13g2_nor2b_1_0.A.t3 15.0169
R6201 sar_ctrl_async_phys_0.sg13g2_nor2b_1_0.A sar_ctrl_async_phys_0.sg13g2_nor2b_1_0.A.t2 15.0169
R6202 sar_ctrl_async_phys_0.sg13g2_nor2b_1_0.A.n2 sar_ctrl_async_phys_0.sg13g2_nor2b_1_0.A 9.36706
R6203 sar_ctrl_async_phys_0.sg13g2_nor2b_1_0.A sar_ctrl_async_phys_0.sg13g2_nor2b_1_0.A.n6 9.10376
R6204 sar_ctrl_async_phys_0.sg13g2_nor2b_1_0.A.n5 sar_ctrl_async_phys_0.sg13g2_nor2b_1_0.A 9.0005
R6205 sar_ctrl_async_phys_0.sg13g2_nor2b_1_0.A sar_ctrl_async_phys_0.sg13g2_nor2b_1_0.A.t0 5.6237
R6206 sar_ctrl_async_phys_0.sg13g2_nor2b_1_0.A.n6 sar_ctrl_async_phys_0.sg13g2_nor2b_1_0.A.n5 5.1661
R6207 sar_ctrl_async_phys_0.sg13g2_nor2b_1_0.A.n4 sar_ctrl_async_phys_0.sg13g2_nor2b_1_0.A.n3 1.4789
R6208 sar_ctrl_async_phys_0.sg13g2_nor2b_1_0.A.n1 sar_ctrl_async_phys_0.sg13g2_nor2b_1_0.A.n0 1.2677
R6209 sar_ctrl_async_phys_0.sg13g2_buf_1_13.X.n6 sar_ctrl_async_phys_0.sg13g2_buf_1_13.X 50.729
R6210 sar_ctrl_async_phys_0.sg13g2_buf_1_13.X.n0 sar_ctrl_async_phys_0.sg13g2_buf_1_13.X 41.928
R6211 sar_ctrl_async_phys_0.sg13g2_buf_1_13.X.n4 sar_ctrl_async_phys_0.sg13g2_buf_1_13.X.n3 23.8816
R6212 sar_ctrl_async_phys_0.sg13g2_buf_1_13.X.n2 sar_ctrl_async_phys_0.sg13g2_buf_1_13.X.n1 21.5551
R6213 sar_ctrl_async_phys_0.sg13g2_buf_1_13.X.n5 sar_ctrl_async_phys_0.sg13g2_buf_1_13.X.n4 20.9573
R6214 sar_ctrl_async_phys_0.sg13g2_buf_1_13.X.n2 sar_ctrl_async_phys_0.sg13g2_buf_1_13.X 18.9535
R6215 sar_ctrl_async_phys_0.sg13g2_buf_1_13.X.n1 sar_ctrl_async_phys_0.sg13g2_buf_1_13.X 17.073
R6216 sar_ctrl_async_phys_0.sg13g2_buf_1_13.X.n3 sar_ctrl_async_phys_0.sg13g2_buf_1_13.X.n2 15.04
R6217 sar_ctrl_async_phys_0.sg13g2_buf_1_13.X sar_ctrl_async_phys_0.sg13g2_buf_1_13.X.t1 15.0005
R6218 sar_ctrl_async_phys_0.sg13g2_buf_1_13.X sar_ctrl_async_phys_0.sg13g2_buf_1_13.X.t2 15.0005
R6219 sar_ctrl_async_phys_0.sg13g2_buf_1_13.X.n4 sar_ctrl_async_phys_0.sg13g2_buf_1_13.X 10.6607
R6220 sar_ctrl_async_phys_0.sg13g2_buf_1_13.X sar_ctrl_async_phys_0.sg13g2_buf_1_13.X.n6 9.73736
R6221 sar_ctrl_async_phys_0.sg13g2_buf_1_13.X.n3 sar_ctrl_async_phys_0.sg13g2_buf_1_13.X 9.36873
R6222 sar_ctrl_async_phys_0.sg13g2_buf_1_13.X.n0 sar_ctrl_async_phys_0.sg13g2_buf_1_13.X 9.0218
R6223 sar_ctrl_async_phys_0.sg13g2_buf_1_13.X.n1 sar_ctrl_async_phys_0.sg13g2_buf_1_13.X 9.01217
R6224 sar_ctrl_async_phys_0.sg13g2_buf_1_13.X sar_ctrl_async_phys_0.sg13g2_buf_1_13.X.t0 5.6237
R6225 sar_ctrl_async_phys_0.sg13g2_buf_1_13.X.n5 sar_ctrl_async_phys_0.sg13g2_buf_1_13.X.n0 1.29106
R6226 sar_ctrl_async_phys_0.sg13g2_buf_1_13.X.n6 sar_ctrl_async_phys_0.sg13g2_buf_1_13.X.n5 1.06226
R6227 sar_ctrl_async_phys_0.dac_code_n[1].n0 sar_ctrl_async_phys_0.dac_code_n[1].t2 22.2379
R6228 sar_ctrl_async_phys_0.dac_code_n[1].n0 sar_ctrl_async_phys_0.dac_code_n[1].t1 21.1147
R6229 sar_ctrl_async_phys_0.dac_code_n[1] sar_ctrl_async_phys_0.dac_code_n[1].t0 17.0317
R6230 sar_ctrl_async_phys_0.dac_code_n[1].t0 sar_ctrl_async_phys_0.dac_code_n[1] 8.62605
R6231 sar_ctrl_async_phys_0.dac_code_n[1] sar_ctrl_async_phys_0.dac_code_n[1].n0 1.0378
R6232 sar_ctrl_async_phys_0.sg13g2_buf_1_3.A sar_ctrl_async_phys_0.sg13g2_buf_1_3.A.n1 63.3286
R6233 sar_ctrl_async_phys_0.sg13g2_buf_1_3.A.n1 sar_ctrl_async_phys_0.sg13g2_buf_1_3.A.n0 45.8586
R6234 sar_ctrl_async_phys_0.sg13g2_buf_1_3.A.n0 sar_ctrl_async_phys_0.sg13g2_buf_1_3.A 38.3317
R6235 sar_ctrl_async_phys_0.sg13g2_buf_1_3.A.n1 sar_ctrl_async_phys_0.sg13g2_buf_1_3.A 19.9013
R6236 sar_ctrl_async_phys_0.sg13g2_buf_1_3.A sar_ctrl_async_phys_0.sg13g2_buf_1_3.A.t1 15.0122
R6237 sar_ctrl_async_phys_0.sg13g2_buf_1_3.A sar_ctrl_async_phys_0.sg13g2_buf_1_3.A.t2 15.0005
R6238 sar_ctrl_async_phys_0.sg13g2_buf_1_3.A sar_ctrl_async_phys_0.sg13g2_buf_1_3.A.t3 15.0005
R6239 sar_ctrl_async_phys_0.sg13g2_buf_1_3.A.n0 sar_ctrl_async_phys_0.sg13g2_buf_1_3.A 9.01217
R6240 sar_ctrl_async_phys_0.sg13g2_buf_1_3.A sar_ctrl_async_phys_0.sg13g2_buf_1_3.A.t0 5.6237
R6241 sar_ctrl_async_phys_0.sg13g2_dfrbpq_1_0.CLK.n17 sar_ctrl_async_phys_0.sg13g2_dfrbpq_1_0.CLK 34.5479
R6242 sar_ctrl_async_phys_0.sg13g2_dfrbpq_1_0.CLK sar_ctrl_async_phys_0.sg13g2_dfrbpq_1_0.CLK.n26 32.1079
R6243 sar_ctrl_async_phys_0.sg13g2_dfrbpq_1_0.CLK.n11 sar_ctrl_async_phys_0.sg13g2_dfrbpq_1_0.CLK 32.0927
R6244 sar_ctrl_async_phys_0.sg13g2_dfrbpq_1_0.CLK.n9 sar_ctrl_async_phys_0.sg13g2_dfrbpq_1_0.CLK 20.7167
R6245 sar_ctrl_async_phys_0.sg13g2_dfrbpq_1_0.CLK.n22 sar_ctrl_async_phys_0.sg13g2_dfrbpq_1_0.CLK 20.5847
R6246 sar_ctrl_async_phys_0.sg13g2_dfrbpq_1_0.CLK.n7 sar_ctrl_async_phys_0.sg13g2_dfrbpq_1_0.CLK.n5 20.2415
R6247 sar_ctrl_async_phys_0.sg13g2_dfrbpq_1_0.CLK.n14 sar_ctrl_async_phys_0.sg13g2_dfrbpq_1_0.CLK.n13 19.9013
R6248 sar_ctrl_async_phys_0.sg13g2_dfrbpq_1_0.CLK.n9 sar_ctrl_async_phys_0.sg13g2_dfrbpq_1_0.CLK 19.8807
R6249 sar_ctrl_async_phys_0.sg13g2_dfrbpq_1_0.CLK.n19 sar_ctrl_async_phys_0.sg13g2_dfrbpq_1_0.CLK 19.6623
R6250 sar_ctrl_async_phys_0.sg13g2_dfrbpq_1_0.CLK sar_ctrl_async_phys_0.sg13g2_dfrbpq_1_0.CLK.n20 19.4759
R6251 sar_ctrl_async_phys_0.sg13g2_dfrbpq_1_0.CLK.n7 sar_ctrl_async_phys_0.sg13g2_dfrbpq_1_0.CLK.n6 19.2941
R6252 sar_ctrl_async_phys_0.sg13g2_dfrbpq_1_0.CLK.n2 sar_ctrl_async_phys_0.sg13g2_dfrbpq_1_0.CLK 18.1823
R6253 sar_ctrl_async_phys_0.sg13g2_dfrbpq_1_0.CLK.n8 sar_ctrl_async_phys_0.sg13g2_dfrbpq_1_0.CLK 18.1823
R6254 sar_ctrl_async_phys_0.sg13g2_dfrbpq_1_0.CLK sar_ctrl_async_phys_0.sg13g2_dfrbpq_1_0.CLK.t15 15.0222
R6255 sar_ctrl_async_phys_0.sg13g2_dfrbpq_1_0.CLK sar_ctrl_async_phys_0.sg13g2_dfrbpq_1_0.CLK.t21 15.0214
R6256 sar_ctrl_async_phys_0.sg13g2_dfrbpq_1_0.CLK sar_ctrl_async_phys_0.sg13g2_dfrbpq_1_0.CLK.t12 15.0197
R6257 sar_ctrl_async_phys_0.sg13g2_dfrbpq_1_0.CLK sar_ctrl_async_phys_0.sg13g2_dfrbpq_1_0.CLK.t17 15.0022
R6258 sar_ctrl_async_phys_0.sg13g2_dfrbpq_1_0.CLK sar_ctrl_async_phys_0.sg13g2_dfrbpq_1_0.CLK.t22 15.0022
R6259 sar_ctrl_async_phys_0.sg13g2_dfrbpq_1_0.CLK sar_ctrl_async_phys_0.sg13g2_dfrbpq_1_0.CLK.t9 15.0022
R6260 sar_ctrl_async_phys_0.sg13g2_dfrbpq_1_0.CLK sar_ctrl_async_phys_0.sg13g2_dfrbpq_1_0.CLK.t13 15.0022
R6261 sar_ctrl_async_phys_0.sg13g2_dfrbpq_1_0.CLK sar_ctrl_async_phys_0.sg13g2_dfrbpq_1_0.CLK.t10 15.0022
R6262 sar_ctrl_async_phys_0.sg13g2_dfrbpq_1_0.CLK sar_ctrl_async_phys_0.sg13g2_dfrbpq_1_0.CLK.t8 15.0022
R6263 sar_ctrl_async_phys_0.sg13g2_dfrbpq_1_0.CLK sar_ctrl_async_phys_0.sg13g2_dfrbpq_1_0.CLK.t6 15.0022
R6264 sar_ctrl_async_phys_0.sg13g2_dfrbpq_1_0.CLK sar_ctrl_async_phys_0.sg13g2_dfrbpq_1_0.CLK.t1 15.0022
R6265 sar_ctrl_async_phys_0.sg13g2_dfrbpq_1_0.CLK sar_ctrl_async_phys_0.sg13g2_dfrbpq_1_0.CLK.t14 15.0022
R6266 sar_ctrl_async_phys_0.sg13g2_dfrbpq_1_0.CLK sar_ctrl_async_phys_0.sg13g2_dfrbpq_1_0.CLK.t11 15.0022
R6267 sar_ctrl_async_phys_0.sg13g2_dfrbpq_1_0.CLK sar_ctrl_async_phys_0.sg13g2_dfrbpq_1_0.CLK.t18 15.0022
R6268 sar_ctrl_async_phys_0.sg13g2_dfrbpq_1_0.CLK sar_ctrl_async_phys_0.sg13g2_dfrbpq_1_0.CLK.t20 15.0022
R6269 sar_ctrl_async_phys_0.sg13g2_dfrbpq_1_0.CLK sar_ctrl_async_phys_0.sg13g2_dfrbpq_1_0.CLK.t16 15.0022
R6270 sar_ctrl_async_phys_0.sg13g2_dfrbpq_1_0.CLK sar_ctrl_async_phys_0.sg13g2_dfrbpq_1_0.CLK.t7 15.0022
R6271 sar_ctrl_async_phys_0.sg13g2_dfrbpq_1_0.CLK sar_ctrl_async_phys_0.sg13g2_dfrbpq_1_0.CLK.t5 15.0022
R6272 sar_ctrl_async_phys_0.sg13g2_dfrbpq_1_0.CLK sar_ctrl_async_phys_0.sg13g2_dfrbpq_1_0.CLK.t4 15.0022
R6273 sar_ctrl_async_phys_0.sg13g2_dfrbpq_1_0.CLK sar_ctrl_async_phys_0.sg13g2_dfrbpq_1_0.CLK.t3 15.0022
R6274 sar_ctrl_async_phys_0.sg13g2_dfrbpq_1_0.CLK sar_ctrl_async_phys_0.sg13g2_dfrbpq_1_0.CLK.t19 15.0022
R6275 sar_ctrl_async_phys_0.sg13g2_dfrbpq_1_0.CLK sar_ctrl_async_phys_0.sg13g2_dfrbpq_1_0.CLK.t2 15.0005
R6276 sar_ctrl_async_phys_0.sg13g2_dfrbpq_1_0.CLK.n24 sar_ctrl_async_phys_0.sg13g2_dfrbpq_1_0.CLK 14.3391
R6277 sar_ctrl_async_phys_0.sg13g2_dfrbpq_1_0.CLK.n26 sar_ctrl_async_phys_0.sg13g2_dfrbpq_1_0.CLK.n25 13.6439
R6278 sar_ctrl_async_phys_0.sg13g2_dfrbpq_1_0.CLK.n8 sar_ctrl_async_phys_0.sg13g2_dfrbpq_1_0.CLK.n7 13.6439
R6279 sar_ctrl_async_phys_0.sg13g2_dfrbpq_1_0.CLK.n13 sar_ctrl_async_phys_0.sg13g2_dfrbpq_1_0.CLK 12.7823
R6280 sar_ctrl_async_phys_0.sg13g2_dfrbpq_1_0.CLK.n0 sar_ctrl_async_phys_0.sg13g2_dfrbpq_1_0.CLK 12.4501
R6281 sar_ctrl_async_phys_0.sg13g2_dfrbpq_1_0.CLK.n2 sar_ctrl_async_phys_0.sg13g2_dfrbpq_1_0.CLK.n1 12.2653
R6282 sar_ctrl_async_phys_0.sg13g2_dfrbpq_1_0.CLK.n22 sar_ctrl_async_phys_0.sg13g2_dfrbpq_1_0.CLK.n21 12.2271
R6283 sar_ctrl_async_phys_0.sg13g2_dfrbpq_1_0.CLK.n20 sar_ctrl_async_phys_0.sg13g2_dfrbpq_1_0.CLK.n0 11.7255
R6284 sar_ctrl_async_phys_0.sg13g2_dfrbpq_1_0.CLK.n0 sar_ctrl_async_phys_0.sg13g2_dfrbpq_1_0.CLK.n16 11.5349
R6285 sar_ctrl_async_phys_0.sg13g2_dfrbpq_1_0.CLK.n11 sar_ctrl_async_phys_0.sg13g2_dfrbpq_1_0.CLK.n10 11.3352
R6286 sar_ctrl_async_phys_0.sg13g2_dfrbpq_1_0.CLK.n25 sar_ctrl_async_phys_0.sg13g2_dfrbpq_1_0.CLK.n23 11.212
R6287 sar_ctrl_async_phys_0.sg13g2_dfrbpq_1_0.CLK.n23 sar_ctrl_async_phys_0.sg13g2_dfrbpq_1_0.CLK.n22 11.1125
R6288 sar_ctrl_async_phys_0.sg13g2_dfrbpq_1_0.CLK.n6 sar_ctrl_async_phys_0.sg13g2_dfrbpq_1_0.CLK 11.0127
R6289 sar_ctrl_async_phys_0.sg13g2_dfrbpq_1_0.CLK.n16 sar_ctrl_async_phys_0.sg13g2_dfrbpq_1_0.CLK.n15 10.8455
R6290 sar_ctrl_async_phys_0.sg13g2_dfrbpq_1_0.CLK.n1 sar_ctrl_async_phys_0.sg13g2_dfrbpq_1_0.CLK 10.8455
R6291 sar_ctrl_async_phys_0.sg13g2_dfrbpq_1_0.CLK.n3 sar_ctrl_async_phys_0.sg13g2_dfrbpq_1_0.CLK 10.6461
R6292 sar_ctrl_async_phys_0.sg13g2_dfrbpq_1_0.CLK.n1 sar_ctrl_async_phys_0.sg13g2_dfrbpq_1_0.CLK 10.5999
R6293 sar_ctrl_async_phys_0.sg13g2_dfrbpq_1_0.CLK.n21 sar_ctrl_async_phys_0.sg13g2_dfrbpq_1_0.CLK 10.4349
R6294 sar_ctrl_async_phys_0.sg13g2_dfrbpq_1_0.CLK.n19 sar_ctrl_async_phys_0.sg13g2_dfrbpq_1_0.CLK.n18 10.2911
R6295 sar_ctrl_async_phys_0.sg13g2_dfrbpq_1_0.CLK.n23 sar_ctrl_async_phys_0.sg13g2_dfrbpq_1_0.CLK 10.1063
R6296 sar_ctrl_async_phys_0.sg13g2_dfrbpq_1_0.CLK.n12 sar_ctrl_async_phys_0.sg13g2_dfrbpq_1_0.CLK 9.4229
R6297 sar_ctrl_async_phys_0.sg13g2_dfrbpq_1_0.CLK.n0 sar_ctrl_async_phys_0.sg13g2_dfrbpq_1_0.CLK 9.3767
R6298 sar_ctrl_async_phys_0.sg13g2_dfrbpq_1_0.CLK.n4 sar_ctrl_async_phys_0.sg13g2_dfrbpq_1_0.CLK 9.2117
R6299 sar_ctrl_async_phys_0.sg13g2_dfrbpq_1_0.CLK.n3 sar_ctrl_async_phys_0.sg13g2_dfrbpq_1_0.CLK 9.2117
R6300 sar_ctrl_async_phys_0.sg13g2_dfrbpq_1_0.CLK.n21 sar_ctrl_async_phys_0.sg13g2_dfrbpq_1_0.CLK 9.2117
R6301 sar_ctrl_async_phys_0.sg13g2_dfrbpq_1_0.CLK.n17 sar_ctrl_async_phys_0.sg13g2_dfrbpq_1_0.CLK 9.1655
R6302 sar_ctrl_async_phys_0.sg13g2_dfrbpq_1_0.CLK.n6 sar_ctrl_async_phys_0.sg13g2_dfrbpq_1_0.CLK 9.00222
R6303 sar_ctrl_async_phys_0.sg13g2_dfrbpq_1_0.CLK.n25 sar_ctrl_async_phys_0.sg13g2_dfrbpq_1_0.CLK.n24 9.0005
R6304 sar_ctrl_async_phys_0.sg13g2_dfrbpq_1_0.CLK.n18 sar_ctrl_async_phys_0.sg13g2_dfrbpq_1_0.CLK 9.0005
R6305 sar_ctrl_async_phys_0.sg13g2_dfrbpq_1_0.CLK.n15 sar_ctrl_async_phys_0.sg13g2_dfrbpq_1_0.CLK 9.0005
R6306 sar_ctrl_async_phys_0.sg13g2_dfrbpq_1_0.CLK.n14 sar_ctrl_async_phys_0.sg13g2_dfrbpq_1_0.CLK 9.0005
R6307 sar_ctrl_async_phys_0.sg13g2_dfrbpq_1_0.CLK.n5 sar_ctrl_async_phys_0.sg13g2_dfrbpq_1_0.CLK 9.0005
R6308 sar_ctrl_async_phys_0.sg13g2_dfrbpq_1_0.CLK.n26 sar_ctrl_async_phys_0.sg13g2_dfrbpq_1_0.CLK 9.0005
R6309 sar_ctrl_async_phys_0.sg13g2_dfrbpq_1_0.CLK.n24 sar_ctrl_async_phys_0.sg13g2_dfrbpq_1_0.CLK 9.0005
R6310 sar_ctrl_async_phys_0.sg13g2_dfrbpq_1_0.CLK.n15 sar_ctrl_async_phys_0.sg13g2_dfrbpq_1_0.CLK.n14 8.12866
R6311 sar_ctrl_async_phys_0.sg13g2_dfrbpq_1_0.CLK sar_ctrl_async_phys_0.sg13g2_dfrbpq_1_0.CLK.t0 6.35651
R6312 sar_ctrl_async_phys_0.sg13g2_dfrbpq_1_0.CLK.n18 sar_ctrl_async_phys_0.sg13g2_dfrbpq_1_0.CLK.n17 5.29506
R6313 sar_ctrl_async_phys_0.sg13g2_dfrbpq_1_0.CLK.n12 sar_ctrl_async_phys_0.sg13g2_dfrbpq_1_0.CLK.n11 4.57346
R6314 sar_ctrl_async_phys_0.sg13g2_dfrbpq_1_0.CLK.n4 sar_ctrl_async_phys_0.sg13g2_dfrbpq_1_0.CLK.n3 3.4501
R6315 sar_ctrl_async_phys_0.sg13g2_dfrbpq_1_0.CLK.n5 sar_ctrl_async_phys_0.sg13g2_dfrbpq_1_0.CLK.n4 3.40306
R6316 sar_ctrl_async_phys_0.sg13g2_dfrbpq_1_0.CLK.n16 sar_ctrl_async_phys_0.sg13g2_dfrbpq_1_0.CLK.n2 3.2653
R6317 sar_ctrl_async_phys_0.sg13g2_dfrbpq_1_0.CLK.n10 sar_ctrl_async_phys_0.sg13g2_dfrbpq_1_0.CLK.n9 2.1125
R6318 sar_ctrl_async_phys_0.sg13g2_dfrbpq_1_0.CLK.n20 sar_ctrl_async_phys_0.sg13g2_dfrbpq_1_0.CLK.n19 1.9013
R6319 sar_ctrl_async_phys_0.sg13g2_dfrbpq_1_0.CLK.n13 sar_ctrl_async_phys_0.sg13g2_dfrbpq_1_0.CLK.n12 1.80146
R6320 sar_ctrl_async_phys_0.sg13g2_dfrbpq_1_0.CLK.n10 sar_ctrl_async_phys_0.sg13g2_dfrbpq_1_0.CLK.n8 1.0565
C0 sar_ctrl_async_phys_0.sg13g2_nor2_1_2.Y a_34266_38484# 0.01682f
C1 sar_ctrl_async_phys_0.sg13g2_buf_1_9.A a_32696_30664# 0.01483f
C2 sar_ctrl_async_phys_0.sg13g2_inv_1_5.Y a_30100_33663# 0.01899f
C3 a_34896_40546# VDD 0.07636f
C4 sar_ctrl_async_phys_0.sg13g2_nor2_1_0.Y sar_ctrl_async_phys_0.sg13g2_a22oi_1_3.A2 0.13948f
C5 a_28862_36863# a_28977_36864# 0.55452f
C6 sar_ctrl_async_phys_0.sg13g2_nor2_1_7.B a_28651_39740# 0.26243f
C7 sar_ctrl_async_phys_0.dac_code_n[7] oa_sar8_acore18_opt_0.sw_bitcell_opt_b3_1.bot 0.13522f
C8 a_25496_39034# VDD 0.11649f
C9 a_32443_32260# VDD 0.20713f
C10 sar_ctrl_async_phys_0.dac_code_n[0] vinn 0.03781f
C11 a_27134_39887# a_27249_39888# 0.55452f
C12 oa_sar8_acore18_opt_0.sw_bitcell_opt_b6_0.bot oa_sar8_acore18_opt_0.sw_bitcell_opt_term_0.gb 0.65179f
C13 sar_ctrl_async_phys_0.sg13g2_nor2b_1_0.A a_34721_39775# 0.01139f
C14 sar_ctrl_async_phys_0.sg13g2_and2_1_2.X a_27530_39666# 0.01557f
C15 a_30746_31356# a_30772_31392# 0.36952f
C16 sar_ctrl_async_phys_0.sg13g2_a21oi_1_0.A1 sar_ctrl_async_phys_0.sg13g2_buf_1_21.A 0.06127f
C17 sar_ctrl_async_phys_0.cmp_n a_30632_22281# 1.92064f
C18 sar_ctrl_async_phys_0.sg13g2_buf_1_6.A a_34171_41332# 0.01653f
C19 a_34651_30748# VDD 0.20367f
C20 sar_ctrl_async_phys_0.sg13g2_a21oi_1_6.A2 a_33109_45725# 0.01263f
C21 sar_ctrl_async_phys_0.sg13g2_buf_1_2.X result[5] 0.26141f
C22 w_39600_n9960# oa_sar8_acore18_opt_0.sw_bitcell_opt_term_0.vin 0.03635f
C23 sar_ctrl_async_phys_0.sg13g2_nor2b_1_4.Y sar_ctrl_async_phys_0.sg13g2_dfrbpq_1_0.CLK 0.03195f
C24 a_31261_38232# VDD 0.41012f
C25 sar_ctrl_async_phys_0.sg13g2_buf_1_13.X a_32116_40464# 0.04555f
C26 sar_ctrl_async_phys_0.sg13g2_nor2_1_4.Y sar_ctrl_async_phys_0.sg13g2_dlygate4sd3_1_8.A 0.04987f
C27 sar_ctrl_async_phys_0.sg13g2_buf_1_13.A a_32116_40464# 0.01749f
C28 a_29701_36874# VDD 0.2609f
C29 sar_ctrl_async_phys_0.sg13g2_buf_1_13.X sar_ctrl_async_phys_0.sg13g2_nor2_1_7.A 0.23094f
C30 a_35288_33688# result[7] 0.09723f
C31 sar_ctrl_async_phys_0.sg13g2_a21oi_1_6.B1 a_33558_43922# 0.02757f
C32 sar_ctrl_async_phys_0.sg13g2_dfrbpq_1_0.CLK a_32251_35284# 0.0745f
C33 sar_ctrl_async_phys_0.sg13g2_and2_1_5.X sar_ctrl_async_phys_0.sg13g2_buf_1_23.A 0.02801f
C34 sar_ctrl_async_phys_0.sg13g2_buf_1_23.A sar_ctrl_async_phys_0.sg13g2_buf_1_16.A 0.0103f
C35 sar_ctrl_async_phys_0.sg13g2_nor2_1_0.Y a_32602_39996# 0.01759f
C36 sar_ctrl_async_phys_0.sg13g2_nand2b_1_1.Y a_35772_41936# 0.01395f
C37 sar_ctrl_async_phys_0.sg13g2_buf_1_2.A sar_ctrl_async_phys_0.sg13g2_buf_1_5.A 0.0369f
C38 sar_ctrl_async_phys_0.sg13g2_buf_1_2.A a_31828_37440# 0.38064f
C39 sar_ctrl_async_phys_0.sg13g2_a21oi_1_7.A2 a_33270_39698# 0.0111f
C40 sar_ctrl_async_phys_0.sg13g2_dfrbpq_1_0.CLK sar_ctrl_async_phys_0.sg13g2_a21oi_1_7.A2 0.04621f
C41 sar_ctrl_async_phys_0.sg13g2_nand2b_1_0.A_N a_27738_40460# 0.01502f
C42 sar_ctrl_async_phys_0.sg13g2_buf_1_3.A a_33846_34850# 0.01267f
C43 sar_ctrl_async_phys_0.sg13g2_a22oi_1_3.A2 a_33366_41210# 0.01879f
C44 sar_ctrl_async_phys_0.sg13g2_dfrbpq_1_0.CLK sar_ctrl_async_phys_0.sg13g2_a22oi_1_0.B2 0.24376f
C45 sar_ctrl_async_phys_0.sg13g2_a22oi_1_0.A2 a_34555_35935# 0.01406f
C46 sar_ctrl_async_phys_0.sg13g2_a21oi_1_2.B1 a_30043_40471# 0.01044f
C47 sar_ctrl_async_phys_0.sg13g2_nand2_1_3.Y sar_ctrl_async_phys_0.sg13g2_buf_1_6.A 0.61033f
C48 oa_sar8_acore18_opt_0.sw_bitcell_opt_b3_0.bot oa_sar8_acore18_opt_0.sw_bitcell_opt_term_0.VSS 1.74142f
C49 sar_ctrl_async_phys_0.sg13g2_dfrbpq_1_9.RESET_B sar_ctrl_async_phys_0.sg13g2_buf_1_32.A 0.02299f
C50 sar_ctrl_async_phys_0.sg13g2_buf_1_44.A sar_ctrl_async_phys_0.dac_code[0] 0.32842f
C51 sar_ctrl_async_phys_0.sg13g2_buf_1_13.A sar_ctrl_async_phys_0.sg13g2_a22oi_1_2.A2 0.32981f
C52 sar_ctrl_async_phys_0.sg13g2_and2_1_5.X a_34904_38948# 0.26671f
C53 sar_ctrl_async_phys_0.hold_req oa_sar8_acore18_opt_0.sw_bitcell_opt_b3_0.bot 0.10376f
C54 sar_ctrl_async_phys_0.sg13g2_a22oi_1_0.A2 sar_ctrl_async_phys_0.sg13g2_buf_1_2.A 0.46684f
C55 sar_ctrl_async_phys_0.sg13g2_buf_1_2.A a_34132_32904# 0.03302f
C56 sar_ctrl_async_phys_0.sg13g2_a22oi_1_0.A2 a_34651_34423# 0.02089f
C57 sar_ctrl_async_phys_0.dac_code_n[2] sar_ctrl_async_phys_0.dac_code[4] 0.06321f
C58 a_31136_43726# a_30879_43845# 0.34468f
C59 sar_ctrl_async_phys_0.sg13g2_a22oi_1_2.A2 a_35053_40730# 0.07576f
C60 sar_ctrl_async_phys_0.sg13g2_a21oi_1_7.Y a_31828_37440# 0.04232f
C61 sar_ctrl_async_phys_0.sg13g2_a21oi_1_7.Y sar_ctrl_async_phys_0.sg13g2_buf_1_5.A 0.39538f
C62 sar_ctrl_async_phys_0.sg13g2_nor2_1_0.Y a_31732_45000# 0.01829f
C63 sar_ctrl_async_phys_0.sg13g2_a21oi_1_1.B1 sar_ctrl_async_phys_0.sg13g2_a21oi_1_2.B1 0.04384f
C64 sar_ctrl_async_phys_0.sg13g2_nor2_1_7.B VDD 0.66302f
C65 a_35211_37436# VDD 0.23284f
C66 sar_ctrl_async_phys_0.sg13g2_a22oi_1_3.A2 sar_ctrl_async_phys_0.sg13g2_a22oi_1_2.B1 0.02123f
C67 sar_ctrl_async_phys_0.sg13g2_inv_1_2.A result[5] 0.70528f
C68 sar_ctrl_async_phys_0.sg13g2_a22oi_1_0.B2 a_34895_32460# 0.06588f
C69 sar_ctrl_async_phys_0.sg13g2_buf_1_3.A a_33089_32215# 0.0149f
C70 sar_ctrl_async_phys_0.sg13g2_buf_1_44.A VDD 0.51499f
C71 sar_ctrl_async_phys_0.sg13g2_dfrbpq_1_0.CLK sar_ctrl_async_phys_0.sg13g2_dfrbpq_1_2.Q 0.01476f
C72 sar_ctrl_async_phys_0.sg13g2_buf_1_0.A a_34420_34837# 0.01162f
C73 sar_ctrl_async_phys_0.dac_code_n[0] sar_ctrl_async_phys_0.dac_code_n[4] 0.16743f
C74 sar_ctrl_async_phys_0.sg13g2_buf_1_14.A sar_ctrl_async_phys_0.sg13g2_buf_1_6.A 1.05089f
C75 a_36336_36010# VDD 0.06839f
C76 sar_ctrl_async_phys_0.sg13g2_buf_1_25.A VDD 0.78205f
C77 sar_ctrl_async_phys_0.sg13g2_buf_1_33.A sar_ctrl_async_phys_0.dac_code[2] 0.23829f
C78 sar_ctrl_async_phys_0.sg13g2_dfrbpq_1_9.Q VDD 0.55001f
C79 sar_ctrl_async_phys_0.dac_code[2] sar_ctrl_async_phys_0.dac_code[5] 0.25122f
C80 sar_ctrl_async_phys_0.dac_code_n[7] oa_sar8_acore18_opt_0.sw_bitcell_opt_b7_1.bot 1.34338f
C81 sar_ctrl_async_phys_0.sg13g2_nor2_1_3.B a_26630_37814# 0.09468f
C82 a_30331_33772# VDD 0.20623f
C83 sar_ctrl_async_phys_0.sg13g2_nor2_1_1.A a_33754_37436# 0.04354f
C84 a_34459_44356# a_35199_44311# 0.26905f
C85 oa_sar8_acore18_opt_0.sw_tg_opt_1.bot oa_sar8_acore18_opt_0.sw_bitcell_opt_b0_1.bot 0.92588f
C86 oa_sar8_acore18_opt_0.sw_bitcell_opt_b2_0.bot oa_sar8_acore18_opt_0.sw_bitcell_opt_term_0.gb 0.63441f
C87 sar_ctrl_async_phys_0.sg13g2_inv_1_10.Y a_28130_40838# 0.11676f
C88 sar_ctrl_async_phys_0.sg13g2_a21oi_1_5.B1 sar_ctrl_async_phys_0.sg13g2_buf_1_13.A 0.01432f
C89 sar_ctrl_async_phys_0.sg13g2_nor2b_1_0.A sar_ctrl_async_phys_0.sg13g2_buf_1_2.A 0.35722f
C90 sar_ctrl_async_phys_0.sg13g2_dlygate4sd3_1_0.A VDD 0.32219f
C91 a_34615_31475# result[2] 0.0199f
C92 sar_ctrl_async_phys_0.sg13g2_nand2b_1_3.Y sar_ctrl_async_phys_0.dac_code_n[7] 0.19572f
C93 a_33936_31675# result[3] 0.01309f
C94 a_35402_46878# sar_ctrl_async_phys_0.sg13g2_buf_1_34.A 0.01535f
C95 a_30872_30758# VDD 0.1445f
C96 sar_ctrl_async_phys_0.sg13g2_a22oi_1_5.A2 a_31140_42690# 0.09558f
C97 sar_ctrl_async_phys_0.sg13g2_buf_1_2.A sar_ctrl_async_phys_0.sg13g2_dlygate4sd3_1_1.X 0.01506f
C98 a_25990_40484# VDD 0.18606f
C99 sar_ctrl_async_phys_0.sg13g2_nor2b_1_4.Y a_30678_46946# 0.27757f
C100 sar_ctrl_async_phys_0.sg13g2_buf_1_5.A a_36056_32176# 0.26554f
C101 a_28392_41214# a_28662_41214# 0.26306f
C102 sar_ctrl_async_phys_0.sg13g2_dfrbpq_1_0.CLK sar_ctrl_async_phys_0.sg13g2_inv_1_1.A 0.3111f
C103 sar_ctrl_async_phys_0.sg13g2_and2_1_5.X a_34815_39775# 0.04123f
C104 sar_ctrl_async_phys_0.sg13g2_a22oi_1_3.A2 a_33168_32986# 0.03006f
C105 sar_ctrl_async_phys_0.dac_code[1] m3_41836_n2380# 0.05732f
C106 a_35770_43484# a_36152_43570# 0.01012f
C107 sar_ctrl_async_phys_0.sg13g2_nor2b_1_0.A sar_ctrl_async_phys_0.sg13g2_a21oi_1_7.Y 1.59115f
C108 sar_ctrl_async_phys_0.sg13g2_a22oi_1_3.A2 a_33675_43020# 0.15779f
C109 sar_ctrl_async_phys_0.sg13g2_buf_1_13.X sar_ctrl_async_phys_0.sg13g2_dlygate4sd3_1_4.A 0.02318f
C110 a_26280_41214# a_26550_41214# 0.26306f
C111 a_32090_40428# a_32533_40471# 0.02242f
C112 sar_ctrl_async_phys_0.sg13g2_nor2_1_4.Y sar_ctrl_async_phys_0.sg13g2_dfrbpq_1_9.RESET_B 0.01388f
C113 sar_ctrl_async_phys_0.sg13g2_a22oi_1_1.A2 a_32400_41413# 0.02659f
C114 sar_ctrl_async_phys_0.sg13g2_dlygate4sd3_1_4.A sar_ctrl_async_phys_0.sg13g2_and2_1_2.X 0.18251f
C115 sar_ctrl_async_phys_0.sg13g2_o21ai_1_1.B1 sar_ctrl_async_phys_0.sg13g2_nor2_1_10.B 0.10625f
C116 w_39600_n9960# sar_ctrl_async_phys_0.dac_code[2] 0.04487f
C117 sar_ctrl_async_phys_0.sg13g2_buf_1_2.X a_32251_35284# 0.42048f
C118 sar_ctrl_async_phys_0.sg13g2_dfrbpq_1_0.CLK a_31542_37874# 0.04881f
C119 a_36058_34412# sar_ctrl_async_phys_0.sg13g2_buf_1_1.A 0.11729f
C120 sar_ctrl_async_phys_0.sg13g2_nor2_1_6.A a_28950_39386# 0.36017f
C121 oa_sar8_acore18_opt_0.sw_bitcell_opt_term_0.bot oa_sar8_acore18_opt_0.sw_bitcell_opt_term_0.VSS 1.4091f
C122 a_34815_39775# sar_ctrl_async_phys_0.sg13g2_buf_1_23.A 0.01232f
C123 a_28870_35948# a_28758_35924# 0.55452f
C124 a_29749_32117# a_29620_32151# 0.01562f
C125 sar_ctrl_async_phys_0.sg13g2_dfrbpq_1_0.CLK a_32341_32117# 0.26167f
C126 sar_ctrl_async_phys_0.sg13g2_a21oi_1_0.A2 a_35211_37436# 0.0884f
C127 sar_ctrl_async_phys_0.sg13g2_nand2b_1_2.Y a_34618_46044# 0.06278f
C128 sar_ctrl_async_phys_0.sg13g2_inv_1_0.A sar_ctrl_async_phys_0.sg13g2_inv_1_0.Y 0.08064f
C129 sar_ctrl_async_phys_0.dac_code_n[7] oa_sar8_acore18_opt_0.bstrap_opt_w2_c1200_1.out 2.1309f
C130 sar_ctrl_async_phys_0.sg13g2_dlygate4sd3_1_4.A track 0.03055f
C131 sar_ctrl_async_phys_0.sg13g2_nor2_1_10.B a_29755_38959# 0.05882f
C132 sar_ctrl_async_phys_0.hold_req oa_sar8_acore18_opt_0.sw_bitcell_opt_term_0.bot 6.49491f
C133 sar_ctrl_async_phys_0.bit_active[7] sar_ctrl_async_phys_0.dac_code[7] 0.11326f
C134 sar_ctrl_async_phys_0.sg13g2_nand2_1_3.A a_35103_43845# 0.03131f
C135 sar_ctrl_async_phys_0.sg13g2_nor2_1_2.Y sar_ctrl_async_phys_0.sg13g2_a21oi_1_0.A1 0.01695f
C136 sar_ctrl_async_phys_0.sg13g2_dfrbpq_1_9.RESET_B a_33248_45238# 0.0987f
C137 sar_ctrl_async_phys_0.sg13g2_nand2b_1_2.Y a_34357_44213# 0.01064f
C138 a_35672_46508# sar_ctrl_async_phys_0.sg13g2_nand2b_1_1.Y 0.25782f
C139 sar_ctrl_async_phys_0.sg13g2_a21oi_1_1.Y a_34106_34380# 0.0138f
C140 sar_ctrl_async_phys_0.sg13g2_o21ai_1_1.B1 a_33632_40702# 0.15572f
C141 sar_ctrl_async_phys_0.dac_code[3] sar_ctrl_async_phys_0.dac_code_n[7] 0.06328f
C142 sar_ctrl_async_phys_0.dac_code[2] a_35772_41936# 0.02152f
C143 sar_ctrl_async_phys_0.sg13g2_buf_1_2.X sar_ctrl_async_phys_0.sg13g2_a22oi_1_0.B2 0.19901f
C144 sar_ctrl_async_phys_0.sg13g2_dfrbpq_1_0.CLK sar_ctrl_async_phys_0.sg13g2_a21oi_1_1.Y 0.81107f
C145 sar_ctrl_async_phys_0.sg13g2_dfrbpq_1_0.CLK a_34549_30605# 0.27569f
C146 a_36056_33688# busy 0.08833f
C147 sar_ctrl_async_phys_0.sg13g2_nor2_1_4.Y a_26385_39214# 0.05017f
C148 sar_ctrl_async_phys_0.sg13g2_a22oi_1_0.A2 a_34261_36653# 0.01218f
C149 a_29620_43488# a_30139_43495# 0.34102f
C150 a_30037_43495# a_29908_43909# 0.01562f
C151 sar_ctrl_async_phys_0.sg13g2_a22oi_1_1.A2 a_32715_43020# 0.15709f
C152 sar_ctrl_async_phys_0.sg13g2_a22oi_1_2.A2 a_32116_40464# 0.03286f
C153 a_35280_35365# sar_ctrl_async_phys_0.bit_active[0] 0.01212f
C154 sar_ctrl_async_phys_0.sg13g2_buf_1_3.A sar_ctrl_async_phys_0.sg13g2_a22oi_1_0.Y 0.087f
C155 oa_sar8_acore18_opt_0.sw_bitcell_opt_term_0.gb m3_45264_n2380# 1.58415f
C156 a_33951_45823# a_34208_45966# 0.34468f
C157 sar_ctrl_async_phys_0.sg13g2_a21oi_1_6.B1 sar_ctrl_async_phys_0.sg13g2_nand2_1_6.B 0.18021f
C158 sar_ctrl_async_phys_0.sg13g2_nor4_1_0.Y sar_ctrl_async_phys_0.sg13g2_nand2b_1_0.A_N 0.75885f
C159 a_34555_35935# VDD 0.20631f
C160 sar_ctrl_async_phys_0.sg13g2_o21ai_1_1.B1 sar_ctrl_async_phys_0.sg13g2_nor2_1_12.A 0.16958f
C161 sar_ctrl_async_phys_0.sg13g2_nor2_1_3.Y sar_ctrl_async_phys_0.sg13g2_nor2_1_5.Y 0.0929f
C162 sar_ctrl_async_phys_0.sg13g2_nor2_1_11.Y a_30785_43845# 0.01691f
C163 oa_sar8_acore18_opt_0.sw_tg_opt_1.bot oa_sar8_acore18_opt_0.sw_bitcell_opt_b4_1.bot 6.43385f
C164 a_34453_35935# sar_ctrl_async_phys_0.bit_active[2] 0.02481f
C165 sar_ctrl_async_phys_0.sg13g2_buf_1_2.A VDD 7.4144f
C166 sar_ctrl_async_phys_0.sg13g2_buf_1_13.X a_26544_38389# 0.01016f
C167 a_33654_44234# a_33940_44552# 0.41329f
C168 sar_ctrl_async_phys_0.sg13g2_nor2_1_1.Y sar_ctrl_async_phys_0.sg13g2_a21oi_1_2.B1 0.01178f
C169 sar_ctrl_async_phys_0.sg13g2_dlygate4sd3_1_7.X a_26662_41278# 0.03712f
C170 sar_ctrl_async_phys_0.sg13g2_buf_1_3.A sar_ctrl_async_phys_0.sg13g2_nor2_1_2.A 0.23912f
C171 a_34651_34423# VDD 0.20563f
C172 sar_ctrl_async_phys_0.sg13g2_and2_1_2.X a_26544_38389# 0.10857f
C173 sar_ctrl_async_phys_0.hold_req oa_sar8_acore18_opt_0.bstrap_opt_w2_c1200_1.gb 0.01335f
C174 a_33368_44366# a_33552_44366# 0.0524f
C175 a_29332_32456# VDD 0.07664f
C176 sar_ctrl_async_phys_0.sg13g2_a21oi_1_1.B1 sar_ctrl_async_phys_0.sg13g2_buf_1_34.A 0.26726f
C177 sar_ctrl_async_phys_0.sg13g2_buf_1_7.A result[3] 0.35457f
C178 sar_ctrl_async_phys_0.sg13g2_a22oi_1_1.A2 sar_ctrl_async_phys_0.sg13g2_a21oi_1_2.B1 0.01285f
C179 sar_ctrl_async_phys_0.dac_code[0] oa_sar8_acore18_opt_0.sw_bitcell_opt_b3_0.bot 0.10525f
C180 a_34055_31352# result[2] 0.0129f
C181 a_32986_44532# sar_ctrl_async_phys_0.sg13g2_nand2_1_3.B 0.11497f
C182 sar_ctrl_async_phys_0.dac_code_n[6] oa_sar8_acore18_opt_0.sw_bitcell_opt_b5_0.bot 0.59547f
C183 sar_ctrl_async_phys_0.sg13g2_o21ai_1_1.A2 VDD 0.83308f
C184 sar_ctrl_async_phys_0.sg13g2_dfrbpq_1_0.CLK sar_ctrl_async_phys_0.bit_active[2] 0.47511f
C185 sar_ctrl_async_phys_0.dac_code_n[3] oa_sar8_acore18_opt_0.sw_bitcell_opt_b5_0.bot 0.5616f
C186 a_34555_35935# a_35295_36285# 0.26905f
C187 a_34767_31359# VDD 0.24566f
C188 sar_ctrl_async_phys_0.sg13g2_inv_1_3.Y result[3] 0.01217f
C189 sar_ctrl_async_phys_0.sg13g2_nor2_1_3.A VDD 1.38182f
C190 sar_ctrl_async_phys_0.sg13g2_a21oi_1_0.B1 sar_ctrl_async_phys_0.sg13g2_nand2_1_2.A 0.33613f
C191 sar_ctrl_async_phys_0.sg13g2_a21oi_1_4.B1 sar_ctrl_async_phys_0.dac_code_n[7] 0.66472f
C192 oa_sar8_acore18_opt_0.sw_bitcell_opt_term_0.trkb oa_sar8_acore18_opt_0.sw_bitcell_opt_b5_0.bot 1.47626f
C193 sar_ctrl_async_phys_0.sg13g2_buf_1_2.A a_35295_36285# 0.13344f
C194 oa_sar8_acore18_opt_0.sw_bitcell_opt_b3_0.bot VDD 3.00009f
C195 sar_ctrl_async_phys_0.sg13g2_a21oi_1_7.Y VDD 0.90147f
C196 sar_ctrl_async_phys_0.sg13g2_buf_1_16.A a_33846_34850# 0.28844f
C197 a_35360_43726# a_35103_43845# 0.34468f
C198 sar_ctrl_async_phys_0.sg13g2_dlygate4sd3_1_4.A a_27530_39666# 0.41275f
C199 sar_ctrl_async_phys_0.sg13g2_buf_1_23.A a_34010_35892# 0.03723f
C200 a_30752_39190# VDD 0.16828f
C201 sar_ctrl_async_phys_0.dac_code[1] sar_ctrl_async_phys_0.dac_code[6] 0.13606f
C202 sar_ctrl_async_phys_0.sg13g2_buf_1_32.A VDD 0.55669f
C203 sar_ctrl_async_phys_0.sg13g2_a21oi_1_4.B1 sar_ctrl_async_phys_0.sg13g2_nor2_1_2.Y 0.57151f
C204 sar_ctrl_async_phys_0.sg13g2_buf_1_2.A a_35391_34773# 0.1332f
C205 sar_ctrl_async_phys_0.sg13g2_dfrbpq_1_0.CLK sar_ctrl_async_phys_0.sg13g2_nor2_1_5.Y 0.02874f
C206 a_30043_40471# a_31040_40702# 0.03061f
C207 sar_ctrl_async_phys_0.sg13g2_dfrbpq_1_0.CLK a_30229_33629# 0.24778f
C208 a_34651_34423# a_35391_34773# 0.26905f
C209 sar_ctrl_async_phys_0.sg13g2_a21oi_1_6.B1 sar_ctrl_async_phys_0.dac_code_n[6] 0.1434f
C210 a_33556_40016# a_33844_39711# 0.43707f
C211 a_29332_32456# a_29851_32260# 0.34114f
C212 sar_ctrl_async_phys_0.sg13g2_dfrbpq_1_0.CLK a_31258_32436# 0.02009f
C213 sar_ctrl_async_phys_0.sg13g2_nand2b_1_1.Y a_34069_41189# 0.01247f
C214 sar_ctrl_async_phys_0.sg13g2_a21oi_1_2.A2 a_29653_38959# 0.01305f
C215 sar_ctrl_async_phys_0.sg13g2_buf_1_23.A a_34363_36796# 0.01615f
C216 sar_ctrl_async_phys_0.sg13g2_dfrbpq_1_9.RESET_B a_32480_46750# 0.09868f
C217 sar_ctrl_async_phys_0.sg13g2_a21oi_1_6.B1 sar_ctrl_async_phys_0.dac_code_n[3] 0.01284f
C218 a_35770_36972# a_36152_36806# 0.01012f
C219 sar_ctrl_async_phys_0.sg13g2_buf_1_7.A a_33440_32358# 0.04188f
C220 oa_sar8_acore18_opt_0.sw_bitcell_opt_b6_0.bot oa_sar8_acore18_opt_0.sw_bitcell_opt_b3_0.bot 0.52132f
C221 oa_sar8_acore18_opt_0.sw_bitcell_opt_b5_0.bot oa_sar8_acore18_opt_0.sw_bitcell_opt_b4_0.bot 6.20215f
C222 sar_ctrl_async_phys_0.sg13g2_dfrbpq_1_0.CLK sar_ctrl_async_phys_0.sg13g2_dlygate4sd3_1_3.A 0.04923f
C223 sar_ctrl_async_phys_0.dac_code[0] a_36152_45082# 0.01701f
C224 sar_ctrl_async_phys_0.sg13g2_buf_1_2.X a_32341_32117# 0.04224f
C225 sar_ctrl_async_phys_0.dac_code_n[0] oa_sar8_acore18_opt_0.sw_tg_opt_0.bot 0.19921f
C226 sar_ctrl_async_phys_0.sg13g2_nand2_1_1.B sar_ctrl_async_phys_0.sg13g2_nand2_1_1.Y 0.38331f
C227 sar_ctrl_async_phys_0.sg13g2_buf_1_3.A sar_ctrl_async_phys_0.sg13g2_a22oi_1_1.B2 0.51549f
C228 a_29334_43922# a_29620_43488# 0.41329f
C229 sar_ctrl_async_phys_0.sg13g2_a21oi_1_7.Y a_31830_40898# 0.03136f
C230 sar_ctrl_async_phys_0.sg13g2_buf_1_20.A sar_ctrl_async_phys_0.dac_code[6] 0.02203f
C231 a_25608_40501# a_25878_40460# 0.26306f
C232 sar_ctrl_async_phys_0.sg13g2_nor2b_1_0.A sar_ctrl_async_phys_0.sg13g2_dfrbpq_1_1.D 0.11577f
C233 sar_ctrl_async_phys_0.bit_active[6] sar_ctrl_async_phys_0.dac_code[7] 0.01877f
C234 sar_ctrl_async_phys_0.sg13g2_nor4_1_0.C sar_ctrl_async_phys_0.sg13g2_nand2b_1_3.Y 0.01999f
C235 sar_ctrl_async_phys_0.sg13g2_buf_1_13.A sar_ctrl_async_phys_0.sg13g2_a22oi_1_0.A1 0.28498f
C236 sar_ctrl_async_phys_0.sg13g2_dfrbpq_1_9.Q a_33658_44996# 0.11587f
C237 sar_ctrl_async_phys_0.sg13g2_a22oi_1_0.A1 a_30671_33292# 0.01796f
C238 sar_ctrl_async_phys_0.sg13g2_a21oi_1_1.Y sar_ctrl_async_phys_0.sg13g2_buf_1_2.X 0.77524f
C239 a_34615_31475# a_35463_31435# 0.097f
C240 sar_ctrl_async_phys_0.sg13g2_buf_1_2.X a_34549_30605# 0.04042f
C241 a_33109_45725# a_33211_45868# 0.47622f
C242 sar_ctrl_async_phys_0.sg13g2_dfrbpq_1_0.CLK sar_ctrl_async_phys_0.sg13g2_buf_1_22.A 0.29992f
C243 a_36056_32176# VDD 0.21841f
C244 a_35288_47296# sar_ctrl_async_phys_0.dac_code_n[0] 0.0923f
C245 a_36152_45082# VDD 0.12034f
C246 sar_ctrl_async_phys_0.sg13g2_buf_1_2.X a_33846_33338# 0.09932f
C247 sar_ctrl_async_phys_0.sg13g2_a22oi_1_0.B1 result[4] 0.06795f
C248 sar_ctrl_async_phys_0.sg13g2_nor2_1_4.Y a_26954_40424# 0.01057f
C249 sar_ctrl_async_phys_0.sg13g2_a22oi_1_0.A1 a_31738_33948# 0.01067f
C250 sar_ctrl_async_phys_0.sg13g2_nor2_1_10.B a_31007_35460# 0.01192f
C251 a_34171_41332# a_34911_41287# 0.26905f
C252 sar_ctrl_async_phys_0.sg13g2_nor2b_1_0.A a_31195_35935# 0.01052f
C253 sar_ctrl_async_phys_0.sg13g2_a22oi_1_1.Y a_31060_31813# 0.01834f
C254 sar_ctrl_async_phys_0.sg13g2_nor2_1_0.Y a_32576_44454# 0.01109f
C255 sar_ctrl_async_phys_0.sg13g2_inv_1_0.Y a_35463_31435# 0.2871f
C256 sar_ctrl_async_phys_0.sg13g2_buf_1_13.X sar_ctrl_async_phys_0.sg13g2_nand3_1_0.Y 0.19781f
C257 sar_ctrl_async_phys_0.dac_code[0] oa_sar8_acore18_opt_0.sw_bitcell_opt_term_0.bot 0.17387f
C258 oa_sar8_acore18_opt_0.bstrap_opt_w2_c1200_1.gb vinp 1.71889f
C259 sar_ctrl_async_phys_0.sg13g2_buf_1_29.A sar_ctrl_async_phys_0.sg13g2_buf_1_13.X 0.04677f
C260 a_31640_34498# VDD 0.14174f
C261 a_29306_32361# a_29046_32138# 0.75507f
C262 sar_ctrl_async_phys_0.sg13g2_and2_1_2.X sar_ctrl_async_phys_0.sg13g2_nand3_1_0.Y 0.66853f
C263 sar_ctrl_async_phys_0.dac_code_n[6] oa_sar8_acore18_opt_0.sw_bitcell_opt_b1_0.bot 0.40705f
C264 a_30576_46594# VDD 0.09878f
C265 sar_ctrl_async_phys_0.sg13g2_buf_1_5.A sar_ctrl_async_phys_0.sg13g2_inv_1_1.Y 0.16887f
C266 sar_ctrl_async_phys_0.sg13g2_nor4_1_0.C sar_ctrl_async_phys_0.sg13g2_a21oi_1_0.A1 0.03633f
C267 a_34261_36653# VDD 0.2432f
C268 sar_ctrl_async_phys_0.sg13g2_a21oi_1_1.B1 sar_ctrl_async_phys_0.dac_code_n[1] 0.022f
C269 sar_ctrl_async_phys_0.sg13g2_nor2_1_10.B a_30964_36349# 0.01087f
C270 a_31579_44356# a_31348_44247# 0.12701f
C271 a_32319_44311# a_32576_44454# 0.34468f
C272 a_31060_44552# a_32225_44311# 0.43239f
C273 sar_ctrl_async_phys_0.sg13g2_buf_1_4.A busy 0.79992f
C274 sar_ctrl_async_phys_0.dac_code_n[3] oa_sar8_acore18_opt_0.sw_bitcell_opt_b1_0.bot 0.10702f
C275 sar_ctrl_async_phys_0.hold_req oa_sar8_acore18_opt_0.sw_bitcell_opt_b5_1.bot 0.09387f
C276 a_30752_39190# a_31162_38948# 0.10373f
C277 sar_ctrl_async_phys_0.sg13g2_dfrbpq_1_9.RESET_B sar_ctrl_async_phys_0.sg13g2_a21oi_1_4.A2 0.01529f
C278 sar_ctrl_async_phys_0.sg13g2_buf_1_13.X a_31093_35935# 0.01259f
C279 sar_ctrl_async_phys_0.sg13g2_nor2_1_3.A a_27120_37522# 0.01861f
C280 sar_ctrl_async_phys_0.sg13g2_nand3_1_0.Y track 0.47239f
C281 a_34036_35928# a_34555_35935# 0.34102f
C282 a_34453_35935# a_34324_36349# 0.01562f
C283 sar_ctrl_async_phys_0.sg13g2_nor2_1_2.Y sar_ctrl_async_phys_0.sg13g2_buf_1_14.A 0.03867f
C284 a_34636_31749# VDD 0.07297f
C285 sar_ctrl_async_phys_0.sg13g2_nor2_1_6.A a_29144_39830# 0.02592f
C286 oa_sar8_acore18_opt_0.sw_bitcell_opt_term_0.trkb oa_sar8_acore18_opt_0.sw_bitcell_opt_b1_0.bot 1.39779f
C287 oa_sar8_acore18_opt_0.sw_bitcell_opt_term_0.bot VDD 3.70504f
C288 sar_ctrl_async_phys_0.sg13g2_nor2_1_4.Y VDD 2.6238f
C289 sar_ctrl_async_phys_0.sg13g2_dfrbpq_1_9.RESET_B a_35456_44454# 0.10325f
C290 sar_ctrl_async_phys_0.sg13g2_buf_1_2.A a_34036_35928# 0.4064f
C291 a_33844_43488# a_34132_43909# 0.43707f
C292 sar_ctrl_async_phys_0.sg13g2_nand2_1_3.Y a_34911_41287# 0.01372f
C293 a_28950_39386# VDD 0.77671f
C294 sar_ctrl_async_phys_0.sg13g2_dfrbpq_1_0.CLK sar_ctrl_async_phys_0.sg13g2_a21oi_1_0.B1 0.17862f
C295 sar_ctrl_async_phys_0.sg13g2_a21oi_1_1.Y sar_ctrl_async_phys_0.sg13g2_inv_1_2.A 0.30327f
C296 a_33248_45238# VDD 0.1695f
C297 sar_ctrl_async_phys_0.sg13g2_inv_1_2.A a_33846_33338# 0.03234f
C298 sar_ctrl_async_phys_0.sg13g2_a22oi_1_5.Y a_30384_31474# 0.01979f
C299 a_33556_40016# a_34075_39820# 0.34114f
C300 sar_ctrl_async_phys_0.sg13g2_buf_1_3.A a_33951_45823# 0.02608f
C301 oa_sar8_acore18_opt_0.sw_bitcell_opt_b6_0.bot oa_sar8_acore18_opt_0.sw_bitcell_opt_term_0.bot 0.62648f
C302 oa_sar8_acore18_opt_0.sw_bitcell_opt_b3_0.bot oa_sar8_acore18_opt_0.sw_bitcell_opt_b2_0.bot 16.4877f
C303 oa_sar8_acore18_opt_0.sw_bitcell_opt_b4_0.bot oa_sar8_acore18_opt_0.sw_bitcell_opt_b1_0.bot 1.10562f
C304 oa_sar8_acore18_opt_0.sw_bitcell_opt_b5_0.bot oa_sar8_acore18_opt_0.sw_bitcell_opt_b0_0.bot 0.36258f
C305 oa_sar8_acore18_opt_0.sw_bitcell_opt_term_0.trkb m3_51760_n2380# 0.03859f
C306 sar_ctrl_async_phys_0.sg13g2_a22oi_1_0.B1 a_31823_32876# 0.05264f
C307 a_34261_36653# a_35009_36751# 0.01058f
C308 a_35103_36751# a_35770_36972# 0.0894f
C309 a_36058_32900# sar_ctrl_async_phys_0.sg13g2_buf_1_8.A 0.11793f
C310 m3_38288_n2380# VDD 0.0275f
C311 sar_ctrl_async_phys_0.sg13g2_buf_1_3.A a_33654_44234# 0.03606f
C312 sar_ctrl_async_phys_0.sg13g2_a21oi_1_6.B1 sar_ctrl_async_phys_0.sg13g2_nand2b_1_7.A_N 0.05298f
C313 sar_ctrl_async_phys_0.sg13g2_buf_1_2.X a_30229_33629# 0.03562f
C314 sar_ctrl_async_phys_0.sg13g2_a22oi_1_1.A2 a_32020_35175# 0.01862f
C315 sar_ctrl_async_phys_0.sg13g2_nor2_1_12.B sar_ctrl_async_phys_0.sg13g2_nand2b_1_0.Y 0.01727f
C316 sar_ctrl_async_phys_0.sg13g2_nand2_1_2.Y VDD 0.49792f
C317 oa_sar8_acore18_opt_0.bstrap_opt_w2_c1200_1.gb VDD 3.8068f
C318 sar_ctrl_async_phys_0.sg13g2_dfrbpq_1_1.D VDD 0.41364f
C319 sar_ctrl_async_phys_0.sg13g2_o21ai_1_1.B1 a_33270_39698# 0.1017f
C320 sar_ctrl_async_phys_0.sg13g2_dfrbpq_1_0.CLK sar_ctrl_async_phys_0.sg13g2_o21ai_1_1.B1 2.48428f
C321 sar_ctrl_async_phys_0.sg13g2_dfrbpq_1_2.Q a_34328_41972# 0.03629f
C322 sar_ctrl_async_phys_0.sg13g2_nand2_1_1.Y sar_ctrl_async_phys_0.sg13g2_buf_1_23.A 0.19689f
C323 sar_ctrl_async_phys_0.dac_code_n[6] sar_ctrl_async_phys_0.dac_code[7] 0.13099f
C324 sar_ctrl_async_phys_0.sg13g2_a21oi_1_0.B1 a_35725_45266# 0.28901f
C325 sar_ctrl_async_phys_0.sg13g2_nor2_1_0.A a_32580_36642# 0.24702f
C326 sar_ctrl_async_phys_0.dac_code_n[2] sar_ctrl_async_phys_0.sample 0.04458f
C327 sar_ctrl_async_phys_0.sg13g2_buf_1_35.A sar_ctrl_async_phys_0.sg13g2_nand2_1_2.Y 0.05804f
C328 sar_ctrl_async_phys_0.sg13g2_inv_1_9.Y sar_ctrl_async_phys_0.sg13g2_nor4_1_0.Y 0.08898f
C329 a_32991_35239# a_33248_35382# 0.34468f
C330 sar_ctrl_async_phys_0.sg13g2_nand2b_1_7.A_N sar_ctrl_async_phys_0.sg13g2_nand2_1_2.B 0.22274f
C331 a_31446_35162# a_32020_35175# 0.31978f
C332 sar_ctrl_async_phys_0.sg13g2_a21oi_1_0.A1 sar_ctrl_async_phys_0.bit_active[7] 0.03403f
C333 sar_ctrl_async_phys_0.dac_code_n[3] sar_ctrl_async_phys_0.dac_code[7] 0.14066f
C334 sar_ctrl_async_phys_0.sg13g2_dfrbpq_1_9.RESET_B sar_ctrl_async_phys_0.sg13g2_nand2_1_3.B 0.0291f
C335 sar_ctrl_async_phys_0.sg13g2_dfrbpq_1_0.CLK a_29755_38959# 0.01244f
C336 oa_sar8_acore18_opt_0.sw_bitcell_opt_b1_1.bot VDD 2.57264f
C337 sar_ctrl_async_phys_0.dac_code_n[1] oa_sar8_acore18_opt_0.sw_tg_opt_1.bot 0.35671f
C338 a_31195_35935# VDD 0.20835f
C339 oa_sar8_acore18_opt_0.sw_bitcell_opt_b6_0.bot m3_38288_n2380# 1.82939f
C340 sar_ctrl_async_phys_0.sg13g2_nor4_1_0.C sar_ctrl_async_phys_0.sg13g2_a21oi_1_4.B1 0.02002f
C341 sar_ctrl_async_phys_0.sg13g2_inv_1_3.Y a_33846_30626# 0.27658f
C342 sar_ctrl_async_phys_0.sg13g2_buf_1_8.A result[4] 0.05851f
C343 sar_ctrl_async_phys_0.sg13g2_dfrbpq_1_9.RESET_B sar_ctrl_async_phys_0.sg13g2_nand2b_1_2.Y 0.02464f
C344 sar_ctrl_async_phys_0.dac_code[7] oa_sar8_acore18_opt_0.sw_bitcell_opt_term_0.trkb 2.57544f
C345 a_33366_41210# a_33652_41528# 0.41329f
C346 a_33626_41433# a_34069_41189# 0.02242f
C347 sar_ctrl_async_phys_0.sg13g2_a22oi_1_1.B2 sar_ctrl_async_phys_0.sg13g2_buf_1_9.A 0.4607f
C348 oa_sar8_acore18_opt_0.sw_bitcell_opt_term_0.vin oa_sar8_acore18_opt_0.sw_bitcell_opt_term_0.VSS 0.08642f
C349 sar_ctrl_async_phys_0.sg13g2_a22oi_1_5.Y a_29912_31474# 0.01318f
C350 sar_ctrl_async_phys_0.sg13g2_nand2_1_2.A a_34520_42760# 0.01063f
C351 sar_ctrl_async_phys_0.sg13g2_buf_1_23.A sar_ctrl_async_phys_0.sg13g2_nor2_1_2.A 0.09176f
C352 sar_ctrl_async_phys_0.sg13g2_o21ai_1_1.B1 a_29236_38952# 0.39226f
C353 a_31935_39775# VDD 0.1759f
C354 sar_ctrl_async_phys_0.cmp_fire a_25608_40501# 0.02225f
C355 sar_ctrl_async_phys_0.sg13g2_o21ai_1_1.B1 sar_ctrl_async_phys_0.sg13g2_inv_1_10.Y 0.04921f
C356 sar_ctrl_async_phys_0.sg13g2_a22oi_1_2.B1 a_33359_32876# 0.0438f
C357 sar_ctrl_async_phys_0.hold_req oa_sar8_acore18_opt_0.sw_bitcell_opt_term_0.vin 0.05699f
C358 sar_ctrl_async_phys_0.sg13g2_a22oi_1_3.A2 sar_ctrl_async_phys_0.sg13g2_buf_1_2.A 0.03865f
C359 a_33344_37678# a_33087_37797# 0.34468f
C360 a_31477_44213# a_31579_44356# 0.47622f
C361 sar_ctrl_async_phys_0.sg13g2_buf_1_13.X sar_ctrl_async_phys_0.sg13g2_nand3b_1_0.Y 0.21444f
C362 a_25596_43448# VDD 0.2875f
C363 sar_ctrl_async_phys_0.sg13g2_inv_1_2.A a_33752_33688# 0.01745f
C364 sar_ctrl_async_phys_0.dac_code[4] sar_ctrl_async_phys_0.dac_code[6] 0.07339f
C365 sar_ctrl_async_phys_0.sg13g2_buf_1_23.A sar_ctrl_async_phys_0.dac_code[6] 0.14555f
C366 sar_ctrl_async_phys_0.sg13g2_nor2b_1_0.A a_31644_36638# 0.01975f
C367 a_29236_38952# a_29755_38959# 0.34102f
C368 a_29653_38959# a_29524_39373# 0.01562f
C369 sar_ctrl_async_phys_0.sg13g2_dfrbpq_1_9.RESET_B a_30037_43495# 0.04163f
C370 sar_ctrl_async_phys_0.sg13g2_a22oi_1_0.B1 sar_ctrl_async_phys_0.sg13g2_a22oi_1_5.Y 0.17305f
C371 a_33750_36362# a_34453_35935# 0.02432f
C372 a_32288_31630# VDD 0.17163f
C373 sar_ctrl_async_phys_0.dac_code[7] oa_sar8_acore18_opt_0.sw_bitcell_opt_b4_0.bot 0.57661f
C374 sar_ctrl_async_phys_0.sg13g2_a21oi_1_2.A2 a_30027_39996# 0.08029f
C375 a_26550_41214# a_26662_41278# 0.55452f
C376 oa_sar8_acore18_opt_0.sw_tg_opt_1.bot vcm 3.45898f
C377 sar_ctrl_async_phys_0.sg13g2_a22oi_1_2.A2 sar_ctrl_async_phys_0.sg13g2_a22oi_1_0.A1 0.1461f
C378 a_28651_39740# a_29144_39830# 0.01096f
C379 sar_ctrl_async_phys_0.sg13g2_buf_1_2.A a_31935_36285# 0.13379f
C380 sar_ctrl_async_phys_0.sg13g2_nor2b_1_0.A sar_ctrl_async_phys_0.sg13g2_a22oi_1_5.A2 2.04866f
C381 sar_ctrl_async_phys_0.dac_code_n[2] sar_ctrl_async_phys_0.dac_code[6] 0.2392f
C382 sar_ctrl_async_phys_0.dac_code_n[0] sar_ctrl_async_phys_0.dac_code[5] 0.06405f
C383 sar_ctrl_async_phys_0.sg13g2_buf_1_14.A a_33818_43452# 0.01104f
C384 a_33558_43922# a_34363_43495# 0.097f
C385 sar_ctrl_async_phys_0.sg13g2_and2_1_2.X a_28176_39830# 0.01198f
C386 a_32480_46750# VDD 0.17123f
C387 oa_sar8_acore18_opt_0.sw_bitcell_opt_b1_0.bot oa_sar8_acore18_opt_0.sw_bitcell_opt_b0_0.bot 18.5888f
C388 oa_sar8_acore18_opt_0.sw_bitcell_opt_b2_0.bot oa_sar8_acore18_opt_0.sw_bitcell_opt_term_0.bot 0.34942f
C389 a_35288_38224# VDD 0.21936f
C390 a_33530_39921# a_33270_39698# 0.75507f
C391 a_31381_46519# sar_ctrl_async_phys_0.sg13g2_dfrbpq_1_0.CLK 0.26994f
C392 sar_ctrl_async_phys_0.sg13g2_a22oi_1_2.A2 a_35595_40460# 0.15778f
C393 oa_sar8_acore18_opt_0.sw_bitcell_opt_term_0.trkb a_21332_n9711# 0.71191f
C394 sar_ctrl_async_phys_0.sg13g2_dfrbpq_1_0.CLK a_33844_36992# 0.08655f
C395 sar_ctrl_async_phys_0.sg13g2_a21oi_1_6.B1 sar_ctrl_async_phys_0.sg13g2_a21oi_1_6.A2 0.11733f
C396 sar_ctrl_async_phys_0.sg13g2_buf_1_3.A a_33366_41210# 0.02968f
C397 a_31064_38318# VDD 0.16569f
C398 sar_ctrl_async_phys_0.dac_code_n[4] sar_ctrl_async_phys_0.dac_code_n[7] 0.12955f
C399 a_35648_33142# a_35391_33261# 0.34468f
C400 sar_ctrl_async_phys_0.dac_code_n[6] oa_sar8_acore18_opt_0.sw_bitcell_opt_b3_1.bot 0.06598f
C401 sar_ctrl_async_phys_0.sg13g2_nor2_1_0.Y sar_ctrl_async_phys_0.sg13g2_buf_1_20.A 0.04153f
C402 sar_ctrl_async_phys_0.sg13g2_inv_1_1.Y VDD 0.50968f
C403 sar_ctrl_async_phys_0.sg13g2_a21oi_1_7.Y a_31935_36285# 0.04293f
C404 sar_ctrl_async_phys_0.sg13g2_nor4_1_0.C sar_ctrl_async_phys_0.sg13g2_buf_1_14.A 2.30126f
C405 sar_ctrl_async_phys_0.sg13g2_inv_1_9.Y a_26174_42911# 0.01407f
C406 sar_ctrl_async_phys_0.dac_code_n[3] oa_sar8_acore18_opt_0.sw_bitcell_opt_b3_1.bot 1.31061f
C407 sar_ctrl_async_phys_0.sg13g2_buf_1_2.X a_29046_32138# 0.12924f
C408 sar_ctrl_async_phys_0.sg13g2_buf_1_20.A a_35664_37695# 0.02472f
C409 sar_ctrl_async_phys_0.sg13g2_a21oi_1_0.A1 sar_ctrl_async_phys_0.sg13g2_nand2b_1_2.A_N 0.01874f
C410 a_35725_45266# a_35807_45366# 0.01117f
C411 sar_ctrl_async_phys_0.dac_code_n[0] a_20412_n9612# 0.04166f
C412 sar_ctrl_async_phys_0.sg13g2_nand2b_1_1.Y sar_ctrl_async_phys_0.sg13g2_nor2b_1_0.A 0.05633f
C413 sar_ctrl_async_phys_0.sg13g2_buf_1_2.A done 0.02759f
C414 oa_sar8_acore18_opt_0.sw_bitcell_opt_term_0.trkb oa_sar8_acore18_opt_0.sw_bitcell_opt_b3_1.bot 1.42826f
C415 a_31732_35480# a_32991_35239# 0.01529f
C416 oa_sar8_acore18_opt_0.sw_bitcell_opt_b5_1.bot VDD 3.86899f
C417 sar_ctrl_async_phys_0.sg13g2_a21oi_1_6.B1 a_32715_43020# 0.03306f
C418 sar_ctrl_async_phys_0.sg13g2_dfrbpq_1_0.CLK a_32212_32151# 0.01563f
C419 sar_ctrl_async_phys_0.sg13g2_buf_1_20.A a_34261_43495# 0.01431f
C420 sar_ctrl_async_phys_0.sg13g2_buf_1_3.A sar_ctrl_async_phys_0.sg13g2_a22oi_1_2.B1 0.04793f
C421 sar_ctrl_async_phys_0.sg13g2_nor2b_1_4.Y a_30774_44234# 0.02381f
C422 sar_ctrl_async_phys_0.sg13g2_a22oi_1_2.A2 sar_ctrl_async_phys_0.sg13g2_buf_1_7.A 0.11462f
C423 sar_ctrl_async_phys_0.sg13g2_a22oi_1_0.A2 result[5] 0.02332f
C424 sar_ctrl_async_phys_0.sg13g2_nor2b_1_0.A a_31450_40460# 0.04521f
C425 sar_ctrl_async_phys_0.sg13g2_dfrbpq_1_0.CLK a_32251_45007# 0.03097f
C426 sar_ctrl_async_phys_0.sg13g2_o21ai_1_1.A2 a_27206_39326# 0.09468f
C427 a_34132_32904# result[5] 0.04301f
C428 sar_ctrl_async_phys_0.sg13g2_a21oi_1_7.Y a_31706_35385# 0.01293f
C429 sar_ctrl_async_phys_0.sg13g2_dfrbpq_1_9.RESET_B a_33844_43488# 0.4173f
C430 sar_ctrl_async_phys_0.sg13g2_buf_1_23.A sar_ctrl_async_phys_0.bit_active[0] 0.11153f
C431 sar_ctrl_async_phys_0.sg13g2_a21oi_1_4.A2 VDD 0.57429f
C432 sar_ctrl_async_phys_0.sg13g2_a21oi_1_0.A1 sar_ctrl_async_phys_0.bit_active[6] 0.0336f
C433 a_26454_41972# VDD 0.22809f
C434 sar_ctrl_async_phys_0.sg13g2_a22oi_1_2.A2 sar_ctrl_async_phys_0.sg13g2_inv_1_3.Y 0.04079f
C435 a_29144_39830# VDD 0.12785f
C436 sar_ctrl_async_phys_0.sg13g2_nand2_1_3.Y sar_ctrl_async_phys_0.bit_active[7] 0.01256f
C437 a_31644_36638# VDD 0.29593f
C438 a_31828_37440# a_32993_37797# 0.43239f
C439 a_36336_41342# VDD 0.07215f
C440 a_26174_42911# a_26289_42912# 0.55452f
C441 sar_ctrl_async_phys_0.sg13g2_o21ai_1_1.B1 a_32149_45007# 0.03623f
C442 a_35456_44454# VDD 0.17022f
C443 a_28950_39386# a_29210_38916# 0.75507f
C444 a_33109_45725# a_32980_45759# 0.01562f
C445 a_35245_45936# sar_ctrl_async_phys_0.sg13g2_nand2_1_6.B 0.18216f
C446 sar_ctrl_async_phys_0.sg13g2_nor2_1_3.A sar_ctrl_async_phys_0.cmp_n 0.04869f
C447 sar_ctrl_async_phys_0.dac_code[7] oa_sar8_acore18_opt_0.sw_bitcell_opt_b0_0.bot 0.11554f
C448 a_34520_33688# VDD 0.21786f
C449 sar_ctrl_async_phys_0.dac_code[2] oa_sar8_acore18_opt_0.sw_bitcell_opt_term_0.VSS 1.06103f
C450 sar_ctrl_async_phys_0.sg13g2_a22oi_1_5.A2 VDD 1.44715f
C451 sar_ctrl_async_phys_0.sg13g2_nor2_1_0.Y sar_ctrl_async_phys_0.sg13g2_nor2_1_0.A 0.10159f
C452 sar_ctrl_async_phys_0.sg13g2_nor2_1_7.A sar_ctrl_async_phys_0.sg13g2_nand3b_1_0.Y 0.05256f
C453 sar_ctrl_async_phys_0.sg13g2_a21oi_1_1.Y a_34308_37400# 0.06162f
C454 sar_ctrl_async_phys_0.hold_req sar_ctrl_async_phys_0.dac_code[2] 0.11497f
C455 sar_ctrl_async_phys_0.sg13g2_a22oi_1_0.B1 a_29812_33968# 0.02056f
C456 a_28272_37522# VDD 0.09419f
C457 sar_ctrl_async_phys_0.sg13g2_nor2_1_11.A sar_ctrl_async_phys_0.sg13g2_and2_1_5.X 0.04683f
C458 oa_sar8_acore18_opt_0.sw_bitcell_opt_b1_0.bot a_35948_n9612# 0.02266f
C459 sar_ctrl_async_phys_0.sg13g2_a21oi_1_7.Y a_32120_38318# 0.0123f
C460 sar_ctrl_async_phys_0.sg13g2_buf_1_0.A a_33658_35460# 0.13299f
C461 a_33248_45238# a_33658_44996# 0.10373f
C462 a_33558_43922# sar_ctrl_async_phys_0.sg13g2_buf_1_14.A 0.05761f
C463 sar_ctrl_async_phys_0.sg13g2_a21oi_1_1.B1 sar_ctrl_async_phys_0.sg13g2_buf_1_13.A 0.01899f
C464 sar_ctrl_async_phys_0.sg13g2_buf_1_14.A sar_ctrl_async_phys_0.bit_active[7] 0.02743f
C465 sar_ctrl_async_phys_0.sg13g2_buf_1_8.A a_31924_32456# 0.03358f
C466 sar_ctrl_async_phys_0.sg13g2_a21oi_1_0.A1 sar_ctrl_async_phys_0.sg13g2_a21oi_1_2.A2 0.76766f
C467 sar_ctrl_async_phys_0.sg13g2_buf_1_29.A a_26160_45878# 0.01154f
C468 sar_ctrl_async_phys_0.sg13g2_nand2b_1_1.Y sar_ctrl_async_phys_0.dac_code[0] 0.09351f
C469 a_29238_40898# a_29524_40464# 0.41329f
C470 sar_ctrl_async_phys_0.dac_code[0] oa_sar8_acore18_opt_0.sw_bitcell_opt_term_0.vin 1.67827f
C471 sar_ctrl_async_phys_0.sg13g2_nand2b_1_1.Y sar_ctrl_async_phys_0.sg13g2_nor2b_1_3.Y 0.3944f
C472 a_30678_46946# a_31381_46519# 0.02432f
C473 sar_ctrl_async_phys_0.dac_code_n[5] oa_sar8_acore18_opt_0.sw_tg_opt_1.bot 0.0767f
C474 rst_n result[0] 0.38691f
C475 sar_ctrl_async_phys_0.sg13g2_nor2b_1_1.B_N a_33558_36674# 0.01175f
C476 a_33818_36897# a_33844_36992# 0.36952f
C477 a_34132_32904# a_35297_33261# 0.43239f
C478 sar_ctrl_async_phys_0.sg13g2_nor2b_1_4.Y sar_ctrl_async_phys_0.sg13g2_dfrbpq_1_9.RESET_B 1.13569f
C479 sar_ctrl_async_phys_0.sg13g2_a22oi_1_1.A2 a_31732_35480# 0.03012f
C480 sar_ctrl_async_phys_0.bit_active[5] VDD 0.09411f
C481 sar_ctrl_async_phys_0.sg13g2_buf_1_2.A a_35288_33688# 0.01307f
C482 sar_ctrl_async_phys_0.sg13g2_buf_1_2.X a_31832_34412# 0.01662f
C483 sar_ctrl_async_phys_0.sg13g2_nand2_1_3.B VDD 0.58743f
C484 sar_ctrl_async_phys_0.sg13g2_dfrbpq_1_0.CLK a_31291_31399# 0.05733f
C485 sar_ctrl_async_phys_0.sg13g2_nand2b_1_1.Y VDD 0.91054f
C486 sar_ctrl_async_phys_0.sg13g2_o21ai_1_1.B1 a_31093_39677# 0.03996f
C487 oa_sar8_acore18_opt_0.sw_bitcell_opt_term_0.trkb oa_sar8_acore18_opt_0.sw_bitcell_opt_b7_1.bot 1.58763f
C488 sar_ctrl_async_phys_0.sg13g2_buf_1_2.A sar_ctrl_async_phys_0.sg13g2_nor2_1_5.B 0.73642f
C489 oa_sar8_acore18_opt_0.sw_bitcell_opt_term_0.vin VDD 4.17846f
C490 sar_ctrl_async_phys_0.sg13g2_nand2_1_2.A sar_ctrl_async_phys_0.dac_code_n[7] 0.1391f
C491 sar_ctrl_async_phys_0.sg13g2_buf_1_35.A sar_ctrl_async_phys_0.sg13g2_nand2_1_3.B 0.6421f
C492 sar_ctrl_async_phys_0.sg13g2_nand2b_1_2.Y VDD 0.79425f
C493 sar_ctrl_async_phys_0.sg13g2_nand2b_1_1.Y sar_ctrl_async_phys_0.sg13g2_buf_1_35.A 0.23271f
C494 a_31446_35162# a_31732_35480# 0.41329f
C495 sar_ctrl_async_phys_0.sg13g2_a21oi_1_7.Y a_30676_40016# 0.02135f
C496 a_32031_31749# a_31937_31749# 0.28931f
C497 sar_ctrl_async_phys_0.sg13g2_buf_1_2.X a_34268_31826# 0.15363f
C498 sar_ctrl_async_phys_0.sg13g2_nand2b_1_2.Y sar_ctrl_async_phys_0.sg13g2_buf_1_35.A 0.02177f
C499 sar_ctrl_async_phys_0.sg13g2_nor2_1_0.Y sar_ctrl_async_phys_0.sg13g2_and2_1_5.X 0.16144f
C500 a_31450_40460# VDD 0.3828f
C501 oa_sar8_acore18_opt_0.sw_bitcell_opt_b7_1.VSS oa_sar8_acore18_opt_0.bstrap_opt_w2_c1200_1.gb 0.08336f
C502 a_28870_35948# VDD 0.19286f
C503 sar_ctrl_async_phys_0.sg13g2_dfrbpq_1_0.CLK a_31483_46519# 0.03637f
C504 a_31381_46519# a_32129_46869# 0.01058f
C505 a_29238_41972# VDD 0.22729f
C506 sar_ctrl_async_phys_0.sg13g2_dfrbpq_1_0.CLK a_31446_45434# 0.0496f
C507 sar_ctrl_async_phys_0.sg13g2_buf_1_6.A sar_ctrl_async_phys_0.dac_code[5] 0.74567f
C508 a_36056_46508# sar_ctrl_async_phys_0.dac_code_n[6] 0.08882f
C509 sar_ctrl_async_phys_0.sg13g2_nor2_1_0.Y a_32404_40885# 0.01543f
C510 a_30037_43495# VDD 0.26385f
C511 sar_ctrl_async_phys_0.sg13g2_nand2_1_3.Y sar_ctrl_async_phys_0.sg13g2_nand2b_1_2.A_N 0.02875f
C512 sar_ctrl_async_phys_0.sg13g2_a21oi_1_0.A1 a_31716_38912# 0.04407f
C513 sar_ctrl_async_phys_0.dac_code[7] a_35948_n9612# 1.21129f
C514 oa_sar8_acore18_opt_0.sw_bitcell_opt_b1_1.bot oa_sar8_acore18_opt_0.sw_bitcell_opt_b7_1.VSS 1.52045f
C515 oa_sar8_acore18_opt_0.sw_bitcell_opt_term_0.vin oa_sar8_acore18_opt_0.sw_bitcell_opt_b6_0.bot 4.13837f
C516 sar_ctrl_async_phys_0.sg13g2_a22oi_1_5.A2 a_31162_38948# 0.04642f
C517 oa_sar8_acore18_opt_0.sw_bitcell_opt_b7_0.bot oa_sar8_acore18_opt_0.sw_bitcell_opt_b5_0.bot 1.04844f
C518 sar_ctrl_async_phys_0.sg13g2_nor2_1_4.Y a_26280_41214# 0.03149f
C519 result[2] result[3] 0.32989f
C520 sar_ctrl_async_phys_0.sg13g2_nor2_1_1.A a_33558_36674# 0.30767f
C521 a_31542_37874# a_32116_37861# 0.31978f
C522 a_35168_41430# VDD 0.16992f
C523 sar_ctrl_async_phys_0.dac_code_n[6] oa_sar8_acore18_opt_0.bstrap_opt_w2_c1200_1.out 1.86099f
C524 a_31195_35935# a_31935_36285# 0.26905f
C525 a_33183_32215# a_33440_32358# 0.34468f
C526 sar_ctrl_async_phys_0.dac_code[1] oa_sar8_acore18_opt_0.sw_bitcell_opt_term_0.gb 0.19794f
C527 a_34236_46472# a_34520_46508# 0.09867f
C528 sar_ctrl_async_phys_0.dac_code_n[3] oa_sar8_acore18_opt_0.bstrap_opt_w2_c1200_1.out 1.74774f
C529 sar_ctrl_async_phys_0.sg13g2_a21oi_1_5.B1 sar_ctrl_async_phys_0.sg13g2_nand2_1_3.A 0.05276f
C530 sar_ctrl_async_phys_0.sg13g2_nor2_1_7.Y sar_ctrl_async_phys_0.sg13g2_nor2_1_5.Y 0.15635f
C531 a_36058_30924# result[1] 0.01388f
C532 sar_ctrl_async_phys_0.sg13g2_nor2_1_3.Y a_27354_37436# 0.01369f
C533 sar_ctrl_async_phys_0.dac_code_n[6] sar_ctrl_async_phys_0.dac_code[3] 0.06252f
C534 VDD result[5] 0.17824f
C535 sar_ctrl_async_phys_0.sg13g2_nor2_1_11.Y a_30879_43845# 0.01312f
C536 sar_ctrl_async_phys_0.sg13g2_nand2_1_2.Y a_35672_42760# 0.25481f
C537 sar_ctrl_async_phys_0.dac_code_n[3] sar_ctrl_async_phys_0.dac_code[3] 2.5649f
C538 oa_sar8_acore18_opt_0.bstrap_opt_w2_c1200_1.out oa_sar8_acore18_opt_0.sw_bitcell_opt_term_0.trkb 10.7665f
C539 a_32149_45007# a_32251_45007# 0.47795f
C540 sar_ctrl_async_phys_0.sg13g2_buf_1_0.A a_32149_35141# 0.01441f
C541 sar_ctrl_async_phys_0.sg13g2_nor2_1_0.A a_31440_37522# 0.02958f
C542 sar_ctrl_async_phys_0.sg13g2_inv_1_0.A result[3] 0.02154f
C543 sar_ctrl_async_phys_0.sg13g2_a21oi_1_6.B1 sar_ctrl_async_phys_0.sg13g2_buf_1_34.A 0.15201f
C544 sar_ctrl_async_phys_0.sg13g2_a22oi_1_0.A2 sar_ctrl_async_phys_0.sg13g2_a22oi_1_0.B2 0.20123f
C545 sar_ctrl_async_phys_0.dac_code_n[7] oa_sar8_acore18_opt_0.sw_tg_opt_0.bot 0.87453f
C546 sar_ctrl_async_phys_0.dac_code[3] oa_sar8_acore18_opt_0.sw_bitcell_opt_term_0.trkb 1.83157f
C547 oa_sar8_acore18_opt_0.sw_bitcell_opt_b2_1.bot oa_sar8_acore18_opt_0.bstrap_opt_w2_c1200_1.gb 0.64344f
C548 sar_ctrl_async_phys_0.sg13g2_dfrbpq_1_9.RESET_B sar_ctrl_async_phys_0.sg13g2_dfrbpq_1_9.D 0.21353f
C549 a_35648_30846# a_36058_30924# 0.10373f
C550 sar_ctrl_async_phys_0.sg13g2_nor2b_1_4.Y sar_ctrl_async_phys_0.sg13g2_nor2b_1_0.A 0.3137f
C551 a_34424_35200# VDD 0.30458f
C552 a_31935_39775# a_32602_39996# 0.0894f
C553 sar_ctrl_async_phys_0.sg13g2_dfrbpq_1_9.RESET_B a_33857_45823# 0.01752f
C554 sar_ctrl_async_phys_0.sg13g2_a21oi_1_1.Y a_34420_33325# 0.01751f
C555 sar_ctrl_async_phys_0.sg13g2_dfrbpq_1_22.D a_30964_39711# 0.01179f
C556 sar_ctrl_async_phys_0.sg13g2_nand3_1_0.C a_25914_38948# 0.01434f
C557 sar_ctrl_async_phys_0.sg13g2_buf_1_14.A sar_ctrl_async_phys_0.bit_active[6] 0.03389f
C558 a_33846_33338# a_34420_33325# 0.31978f
C559 sar_ctrl_async_phys_0.sg13g2_nor2_1_12.B sar_ctrl_async_phys_0.sg13g2_o21ai_1_1.A2 0.17671f
C560 sar_ctrl_async_phys_0.sg13g2_a22oi_1_1.A2 sar_ctrl_async_phys_0.sg13g2_buf_1_13.A 0.25662f
C561 oa_sar8_acore18_opt_0.sw_bitcell_opt_b0_1.bot oa_sar8_acore18_opt_0.sw_bitcell_opt_b3_1.bot 0.42113f
C562 oa_sar8_acore18_opt_0.sw_bitcell_opt_b1_1.bot oa_sar8_acore18_opt_0.sw_bitcell_opt_b2_1.bot 14.401f
C563 sar_ctrl_async_phys_0.sg13g2_nor4_1_0.Y a_28662_41214# 0.01383f
C564 sar_ctrl_async_phys_0.sg13g2_nand2b_1_7.A_N a_36152_43570# 0.0243f
C565 sar_ctrl_async_phys_0.sg13g2_buf_1_16.A sar_ctrl_async_phys_0.sg13g2_a22oi_1_2.B1 0.58842f
C566 sar_ctrl_async_phys_0.sg13g2_a22oi_1_1.Y a_31247_32876# 0.02339f
C567 sar_ctrl_async_phys_0.sg13g2_dfrbpq_1_2.Q sar_ctrl_async_phys_0.sg13g2_a22oi_1_0.A2 0.03256f
C568 sar_ctrl_async_phys_0.sg13g2_nor2_1_1.Y a_34042_40460# 0.02749f
C569 sar_ctrl_async_phys_0.dac_code[0] sar_ctrl_async_phys_0.dac_code[2] 0.20879f
C570 sar_ctrl_async_phys_0.sg13g2_buf_1_7.A a_33936_31675# 0.12f
C571 sar_ctrl_async_phys_0.dac_code[3] oa_sar8_acore18_opt_0.sw_bitcell_opt_b4_0.bot 0.42903f
C572 a_36058_32900# result[6] 0.01398f
C573 a_33844_43488# VDD 0.0722f
C574 sar_ctrl_async_phys_0.sg13g2_buf_1_13.X a_31446_35162# 0.0214f
C575 sar_ctrl_async_phys_0.sg13g2_a21oi_1_4.B1 sar_ctrl_async_phys_0.dac_code_n[6] 0.05419f
C576 sar_ctrl_async_phys_0.sg13g2_buf_1_2.X a_31291_31399# 0.43668f
C577 a_32288_31630# a_32698_31388# 0.10373f
C578 sar_ctrl_async_phys_0.sg13g2_a21oi_1_5.B1 a_33368_44366# 0.01103f
C579 a_28680_40460# VDD 0.01187f
C580 a_30830_35166# a_31007_35460# 0.01057f
C581 w_16692_n9960# oa_sar8_acore18_opt_0.bstrap_opt_w2_c1200_1.gb 3.49708f
C582 sar_ctrl_async_phys_0.sg13g2_a21oi_1_1.B1 sar_ctrl_async_phys_0.sg13g2_a22oi_1_2.A2 0.02928f
C583 a_30678_46946# a_31483_46519# 0.097f
C584 sar_ctrl_async_phys_0.sg13g2_a21oi_1_4.B1 sar_ctrl_async_phys_0.dac_code_n[3] 0.05461f
C585 sar_ctrl_async_phys_0.sg13g2_inv_1_0.A a_33440_32358# 0.02535f
C586 oa_sar8_acore18_opt_0.sw_bitcell_opt_b7_0.bot oa_sar8_acore18_opt_0.sw_bitcell_opt_b1_0.bot 1.00641f
C587 oa_sar8_acore18_opt_0.sw_bitcell_opt_b5_1.bot oa_sar8_acore18_opt_0.sw_bitcell_opt_b7_1.VSS 2.114f
C588 oa_sar8_acore18_opt_0.sw_bitcell_opt_term_0.vin oa_sar8_acore18_opt_0.sw_bitcell_opt_b2_0.bot 3.9682f
C589 sar_ctrl_async_phys_0.sg13g2_buf_1_6.A a_35672_33688# 0.26375f
C590 sar_ctrl_async_phys_0.dac_code[2] VDD 4.34179f
C591 sar_ctrl_async_phys_0.dac_code_n[1] oa_sar8_acore18_opt_0.sw_bitcell_opt_b5_0.bot 0.30346f
C592 w_16692_n9960# oa_sar8_acore18_opt_0.sw_bitcell_opt_b1_1.bot 0.09222f
C593 sar_ctrl_async_phys_0.sg13g2_buf_1_3.A sar_ctrl_async_phys_0.sg13g2_buf_1_25.A 0.0275f
C594 sar_ctrl_async_phys_0.sg13g2_a22oi_1_0.A1 sar_ctrl_async_phys_0.sg13g2_buf_1_7.A 0.13641f
C595 sar_ctrl_async_phys_0.sg13g2_buf_1_35.A sar_ctrl_async_phys_0.dac_code[2] 0.45367f
C596 sar_ctrl_async_phys_0.sg13g2_buf_1_3.A sar_ctrl_async_phys_0.sg13g2_dfrbpq_1_9.Q 0.03175f
C597 a_31542_37874# a_31828_37440# 0.41329f
C598 a_33626_41433# VDD 0.09402f
C599 sar_ctrl_async_phys_0.sg13g2_a21oi_1_7.A2 a_32635_40471# 0.0544f
C600 result[4] result[6] 0.01939f
C601 sar_ctrl_async_phys_0.sg13g2_nor2b_1_0.A sar_ctrl_async_phys_0.sg13g2_dfrbpq_1_2.Q 2.23271f
C602 sar_ctrl_async_phys_0.sg13g2_nor2_1_2.Y a_33270_39698# 0.01427f
C603 sar_ctrl_async_phys_0.sg13g2_nand2_1_2.B a_35103_43845# 0.03025f
C604 sar_ctrl_async_phys_0.sg13g2_dfrbpq_1_0.CLK sar_ctrl_async_phys_0.sg13g2_nor2_1_2.Y 0.02406f
C605 sar_ctrl_async_phys_0.sg13g2_buf_1_4.A a_35770_36972# 0.03239f
C606 sar_ctrl_async_phys_0.sg13g2_buf_1_5.A a_32341_32117# 0.0112f
C607 a_26666_38912# a_26385_39214# 0.26306f
C608 a_25496_39034# a_25680_39034# 0.0524f
C609 a_36058_34412# busy 0.01097f
C610 sar_ctrl_async_phys_0.sg13g2_a22oi_1_0.A1 sar_ctrl_async_phys_0.sg13g2_inv_1_3.Y 0.15333f
C611 a_32480_46750# a_32890_46508# 0.10373f
C612 a_33846_30626# result[1] 0.05217f
C613 sar_ctrl_async_phys_0.dac_code[2] oa_sar8_acore18_opt_0.sw_bitcell_opt_b6_0.bot 1.17676f
C614 sar_ctrl_async_phys_0.sg13g2_a21oi_1_5.B1 sar_ctrl_async_phys_0.sg13g2_a21oi_1_1.B1 1.43767f
C615 sar_ctrl_async_phys_0.sg13g2_a21oi_1_1.Y sar_ctrl_async_phys_0.sg13g2_buf_1_5.A 0.01007f
C616 sar_ctrl_async_phys_0.sg13g2_a22oi_1_2.A2 a_32991_35239# 0.02868f
C617 sar_ctrl_async_phys_0.sg13g2_o21ai_1_1.B1 a_32986_44532# 0.01759f
C618 a_31446_45434# a_32149_45007# 0.02432f
C619 sar_ctrl_async_phys_0.sg13g2_dfrbpq_1_0.CLK a_30783_40821# 0.02139f
C620 sar_ctrl_async_phys_0.sg13g2_a22oi_1_0.B2 a_33080_30664# 0.01421f
C621 sar_ctrl_async_phys_0.sg13g2_nor2b_1_0.A a_32580_43448# 0.05783f
C622 sar_ctrl_async_phys_0.sg13g2_nand2_1_1.Y sar_ctrl_async_phys_0.dac_code[6] 0.30537f
C623 sar_ctrl_async_phys_0.sg13g2_buf_1_2.X sar_ctrl_async_phys_0.sg13g2_inv_1_2.Y 0.0631f
C624 sar_ctrl_async_phys_0.sg13g2_a21oi_1_6.B1 sar_ctrl_async_phys_0.dac_code_n[1] 0.98559f
C625 sar_ctrl_async_phys_0.sg13g2_nor4_1_0.C sar_ctrl_async_phys_0.sg13g2_nand2_1_2.A 0.33232f
C626 oa_sar8_acore18_opt_0.sw_bitcell_opt_b6_1.bot oa_sar8_acore18_opt_0.bstrap_opt_w2_c1200_1.gb 0.73114f
C627 sar_ctrl_async_phys_0.sg13g2_dfrbpq_1_0.CLK a_29350_41996# 0.16187f
C628 sar_ctrl_async_phys_0.sg13g2_nor2b_1_4.Y VDD 0.89287f
C629 sar_ctrl_async_phys_0.sg13g2_a21oi_1_2.B1 a_30027_39996# 0.0171f
C630 sar_ctrl_async_phys_0.sg13g2_dlygate4sd3_1_4.X a_27032_39034# 0.01182f
C631 sar_ctrl_async_phys_0.sg13g2_a22oi_1_2.A2 a_33344_37678# 0.02092f
C632 sar_ctrl_async_phys_0.sg13g2_buf_1_9.A a_32443_32260# 0.02202f
C633 sar_ctrl_async_phys_0.sg13g2_dfrbpq_1_0.CLK a_29620_43488# 0.09382f
C634 a_34132_30944# a_35391_30703# 0.01529f
C635 sar_ctrl_async_phys_0.sg13g2_a21oi_1_7.A2 sar_ctrl_async_phys_0.sg13g2_nor2b_1_3.Y 0.01658f
C636 sar_ctrl_async_phys_0.sg13g2_buf_1_13.X sar_ctrl_async_phys_0.sg13g2_nor4_1_0.Y 0.07566f
C637 a_32251_35284# VDD 0.20626f
C638 a_30676_40016# a_31935_39775# 0.01529f
C639 sar_ctrl_async_phys_0.sg13g2_a22oi_1_0.A2 sar_ctrl_async_phys_0.sg13g2_a21oi_1_1.Y 0.03328f
C640 sar_ctrl_async_phys_0.sg13g2_a21oi_1_1.Y a_34132_32904# 0.01499f
C641 sar_ctrl_async_phys_0.sg13g2_nor4_1_0.Y sar_ctrl_async_phys_0.sg13g2_and2_1_2.X 0.01197f
C642 sar_ctrl_async_phys_0.sg13g2_dfrbpq_1_22.D a_31195_39820# 0.03574f
C643 oa_sar8_acore18_opt_0.sw_bitcell_opt_b0_1.bot oa_sar8_acore18_opt_0.sw_bitcell_opt_b7_1.bot 1.09239f
C644 oa_sar8_acore18_opt_0.sw_bitcell_opt_b3_1.bot oa_sar8_acore18_opt_0.sw_bitcell_opt_b4_1.bot 14.916f
C645 oa_sar8_acore18_opt_0.sw_bitcell_opt_b2_1.bot oa_sar8_acore18_opt_0.sw_bitcell_opt_b5_1.bot 0.56612f
C646 oa_sar8_acore18_opt_0.sw_bitcell_opt_b1_1.bot oa_sar8_acore18_opt_0.sw_bitcell_opt_b6_1.bot 0.51968f
C647 a_32580_36642# a_32888_36806# 0.01393f
C648 a_33846_33338# a_34132_32904# 0.41329f
C649 sar_ctrl_async_phys_0.sg13g2_a22oi_1_3.A2 a_32897_35239# 0.01759f
C650 a_29701_36874# sar_ctrl_async_phys_0.sg13g2_dlygate4sd3_1_0.X 0.01002f
C651 a_31256_37522# VDD 0.13725f
C652 sar_ctrl_async_phys_0.sg13g2_a21oi_1_7.A2 VDD 0.46852f
C653 sar_ctrl_async_phys_0.dac_code[7] oa_sar8_acore18_opt_0.sw_bitcell_opt_b7_0.bot 3.77656f
C654 sar_ctrl_async_phys_0.dac_code[3] oa_sar8_acore18_opt_0.sw_bitcell_opt_b0_0.bot 0.15675f
C655 sar_ctrl_async_phys_0.sg13g2_buf_1_33.A a_36074_41214# 0.01504f
C656 a_32666_45969# a_32692_46064# 0.36952f
C657 sar_ctrl_async_phys_0.sg13g2_dfrbpq_1_9.Q a_35000_45878# 0.01781f
C658 sar_ctrl_async_phys_0.sg13g2_o21ai_1_1.B1 a_32406_45746# 0.08428f
C659 sar_ctrl_async_phys_0.sg13g2_a22oi_1_0.B2 VDD 0.71001f
C660 sar_ctrl_async_phys_0.sg13g2_nor2b_1_0.A a_31542_37874# 0.01761f
C661 sar_ctrl_async_phys_0.sg13g2_o21ai_1_1.B1 a_34069_41189# 0.03518f
C662 oa_sar8_acore18_opt_0.sw_bitcell_opt_term_0.vin m3_45264_n2380# 0.05057f
C663 sar_ctrl_async_phys_0.sg13g2_nand2b_1_1.Y sar_ctrl_async_phys_0.sg13g2_a22oi_1_3.A2 0.01728f
C664 sar_ctrl_async_phys_0.sg13g2_a22oi_1_1.A2 a_32116_40464# 0.01177f
C665 a_35463_31435# result[3] 0.01133f
C666 a_26364_45710# sar_ctrl_async_phys_0.sg13g2_buf_1_13.X 0.26739f
C667 a_33276_42686# sar_ctrl_async_phys_0.sg13g2_buf_1_13.A 0.2659f
C668 sar_ctrl_async_phys_0.sg13g2_nor2_1_15.Y a_33366_41210# 0.27095f
C669 a_26454_39702# a_26566_39766# 0.55452f
C670 sar_ctrl_async_phys_0.sg13g2_inv_1_3.Y sar_ctrl_async_phys_0.sg13g2_buf_1_7.A 0.06138f
C671 sar_ctrl_async_phys_0.sg13g2_buf_1_2.X a_30486_31826# 0.09457f
C672 a_31189_31399# a_31291_31399# 0.47795f
C673 sar_ctrl_async_phys_0.sg13g2_and2_1_2.X a_26454_39702# 0.04616f
C674 a_29238_40898# VDD 0.77764f
C675 a_36056_33688# sar_ctrl_async_phys_0.bit_active[1] 0.25232f
C676 sar_ctrl_async_phys_0.sg13g2_dfrbpq_1_2.Q sar_ctrl_async_phys_0.sg13g2_nor2b_1_3.Y 0.02125f
C677 a_28130_40838# VDD 0.01957f
C678 a_32687_32876# VDD 0.30349f
C679 sar_ctrl_async_phys_0.sg13g2_nor2b_1_0.A sar_ctrl_async_phys_0.sg13g2_a21oi_1_1.Y 0.02733f
C680 sar_ctrl_async_phys_0.dac_code[4] oa_sar8_acore18_opt_0.sw_bitcell_opt_term_0.gb 0.2044f
C681 sar_ctrl_async_phys_0.sg13g2_buf_1_13.A a_33375_40821# 0.03893f
C682 sar_ctrl_async_phys_0.dac_code_n[1] oa_sar8_acore18_opt_0.sw_bitcell_opt_b1_0.bot 0.06187f
C683 sar_ctrl_async_phys_0.sg13g2_a22oi_1_0.Y sar_ctrl_async_phys_0.sg13g2_a22oi_1_1.B2 0.01877f
C684 sar_ctrl_async_phys_0.sg13g2_inv_1_2.A sar_ctrl_async_phys_0.sg13g2_inv_1_2.Y 0.19347f
C685 sar_ctrl_async_phys_0.sg13g2_a22oi_1_0.A2 sar_ctrl_async_phys_0.bit_active[2] 0.47391f
C686 sar_ctrl_async_phys_0.sg13g2_a22oi_1_5.Y a_30497_32215# 0.02059f
C687 oa_sar8_acore18_opt_0.sw_bitcell_opt_term_1.bot oa_sar8_acore18_opt_0.bstrap_opt_w2_c1200_1.gb 0.64577f
C688 sar_ctrl_async_phys_0.sg13g2_a21oi_1_6.A2 sar_ctrl_async_phys_0.sg13g2_a21oi_1_0.A1 0.19823f
C689 sar_ctrl_async_phys_0.sg13g2_dfrbpq_1_2.Q VDD 0.72109f
C690 sar_ctrl_async_phys_0.dac_code_n[7] sar_ctrl_async_phys_0.dac_code[5] 5.26948f
C691 a_33375_40821# a_34042_40460# 0.0894f
C692 a_31328_33870# a_31738_33948# 0.10373f
C693 sar_ctrl_async_phys_0.sg13g2_nor2_1_1.Y sar_ctrl_async_phys_0.sg13g2_a22oi_1_2.A2 0.02303f
C694 sar_ctrl_async_phys_0.dac_code_n[2] oa_sar8_acore18_opt_0.sw_bitcell_opt_term_0.gb 0.10773f
C695 sar_ctrl_async_phys_0.sg13g2_a22oi_1_0.A2 a_34731_37436# 0.05751f
C696 sar_ctrl_async_phys_0.sg13g2_buf_1_35.A sar_ctrl_async_phys_0.sg13g2_dfrbpq_1_2.Q 0.06239f
C697 sar_ctrl_async_phys_0.sg13g2_buf_1_4.A a_33558_36674# 0.01931f
C698 sar_ctrl_async_phys_0.sg13g2_a22oi_1_1.A2 sar_ctrl_async_phys_0.sg13g2_a22oi_1_2.A2 0.16478f
C699 sar_ctrl_async_phys_0.sg13g2_buf_1_3.A sar_ctrl_async_phys_0.sg13g2_buf_1_2.A 0.9635f
C700 a_31898_32361# a_31638_32138# 0.75507f
C701 oa_sar8_acore18_opt_0.bstrap_opt_w2_c1200_1.out oa_sar8_acore18_opt_0.sw_bitcell_opt_b0_1.bot 3.86223f
C702 oa_sar8_acore18_opt_0.sw_bitcell_opt_term_1.bot oa_sar8_acore18_opt_0.sw_bitcell_opt_b1_1.bot 0.38669f
C703 sar_ctrl_async_phys_0.dac_code[2] oa_sar8_acore18_opt_0.sw_bitcell_opt_b2_0.bot 1.44586f
C704 sar_ctrl_async_phys_0.sg13g2_buf_1_13.X sar_ctrl_async_phys_0.sg13g2_nand2_1_0.B 0.13437f
C705 a_34136_47296# sar_ctrl_async_phys_0.cmp_fault 0.2475f
C706 a_34132_30944# result[0] 0.01961f
C707 sar_ctrl_async_phys_0.sg13g2_buf_1_25.A a_34106_32868# 0.02792f
C708 sar_ctrl_async_phys_0.sg13g2_buf_1_6.A a_35672_35200# 0.02682f
C709 a_29524_40464# a_30689_40821# 0.43239f
C710 sar_ctrl_async_phys_0.sg13g2_nand2b_1_1.Y a_35672_42760# 0.04467f
C711 sar_ctrl_async_phys_0.sg13g2_a21oi_1_0.A1 a_32715_43020# 0.03664f
C712 a_32580_43448# VDD 0.20134f
C713 sar_ctrl_async_phys_0.sg13g2_buf_1_25.A sar_ctrl_async_phys_0.sg13g2_buf_1_9.A 1.28644f
C714 sar_ctrl_async_phys_0.sg13g2_nand2b_1_3.Y sar_ctrl_async_phys_0.sg13g2_a21oi_1_2.B1 0.01967f
C715 sar_ctrl_async_phys_0.sg13g2_dfrbpq_1_9.D VDD 0.35733f
C716 sar_ctrl_async_phys_0.sg13g2_dfrbpq_1_11.D a_32192_39918# 0.01327f
C717 sar_ctrl_async_phys_0.sg13g2_a22oi_1_0.A2 sar_ctrl_async_phys_0.sg13g2_buf_1_1.A 0.12608f
C718 sar_ctrl_async_phys_0.sg13g2_a22oi_1_5.A2 a_30507_35204# 0.03662f
C719 sar_ctrl_async_phys_0.sg13g2_buf_1_13.X a_26174_42911# 0.01912f
C720 sar_ctrl_async_phys_0.sg13g2_nor2b_1_3.Y a_34554_40460# 0.01305f
C721 sar_ctrl_async_phys_0.dac_code_n[7] a_20412_n9612# 0.07137f
C722 sar_ctrl_async_phys_0.sg13g2_a22oi_1_1.Y a_30591_32215# 0.01631f
C723 sar_ctrl_async_phys_0.sg13g2_inv_1_1.A VDD 0.1774f
C724 a_34106_30849# a_33846_30626# 0.75507f
C725 sar_ctrl_async_phys_0.sg13g2_a21oi_1_5.B1 sar_ctrl_async_phys_0.sg13g2_nor2_1_1.Y 0.20656f
C726 oa_sar8_acore18_opt_0.sw_bitcell_opt_b5_1.bot oa_sar8_acore18_opt_0.sw_bitcell_opt_b6_1.bot 10.6639f
C727 oa_sar8_acore18_opt_0.sw_bitcell_opt_b4_1.bot oa_sar8_acore18_opt_0.sw_bitcell_opt_b7_1.bot 1.0619f
C728 sar_ctrl_async_phys_0.dac_code[3] a_35948_n9612# 2.19972f
C729 sar_ctrl_async_phys_0.sg13g2_o21ai_1_1.B1 a_29524_40464# 0.40519f
C730 sar_ctrl_async_phys_0.sg13g2_dlygate4sd3_1_9.X VDD 0.2482f
C731 oa_sar8_acore18_opt_0.sw_bitcell_opt_term_0.trkb vinn 0.14717f
C732 sar_ctrl_async_phys_0.sg13g2_nor4_1_0.C sar_ctrl_async_phys_0.sg13g2_dfrbpq_1_0.CLK 1.78849f
C733 sar_ctrl_async_phys_0.sg13g2_buf_1_3.A sar_ctrl_async_phys_0.sg13g2_buf_1_32.A 0.17769f
C734 sar_ctrl_async_phys_0.sg13g2_buf_1_34.A a_36056_41972# 0.25671f
C735 sar_ctrl_async_phys_0.sg13g2_a21oi_1_0.A1 sar_ctrl_async_phys_0.sg13g2_a21oi_1_2.B1 0.51289f
C736 sar_ctrl_async_phys_0.sg13g2_nand2_1_3.A a_35105_44311# 0.01744f
C737 w_39600_n9960# sar_ctrl_async_phys_0.dac_code_n[7] 0.1684f
C738 sar_ctrl_async_phys_0.sg13g2_nand2_1_2.Y a_35018_42726# 0.01573f
C739 sar_ctrl_async_phys_0.dac_code_n[0] oa_sar8_acore18_opt_0.sw_bitcell_opt_term_0.VSS 0.06509f
C740 sar_ctrl_async_phys_0.dac_code_n[1] sar_ctrl_async_phys_0.dac_code[7] 0.12342f
C741 a_31542_37874# VDD 0.77967f
C742 sar_ctrl_async_phys_0.sg13g2_a21oi_1_0.A1 a_30129_39724# 0.01233f
C743 sar_ctrl_async_phys_0.sg13g2_buf_1_22.A sar_ctrl_async_phys_0.sg13g2_a22oi_1_0.A2 0.1691f
C744 sar_ctrl_async_phys_0.dac_code_n[5] oa_sar8_acore18_opt_0.sw_bitcell_opt_b5_0.bot 0.50895f
C745 sar_ctrl_async_phys_0.hold_req sar_ctrl_async_phys_0.dac_code_n[0] 0.04991f
C746 a_26666_38912# VDD 0.32474f
C747 sar_ctrl_async_phys_0.sg13g2_a22oi_1_5.A2 a_30676_40016# 0.02799f
C748 sar_ctrl_async_phys_0.sg13g2_a21oi_1_0.A1 sar_ctrl_async_phys_0.sg13g2_dfrbpq_1_22.D 0.11722f
C749 a_32341_32117# VDD 0.24463f
C750 sar_ctrl_async_phys_0.sg13g2_dfrbpq_1_0.CLK result[4] 0.02578f
C751 sar_ctrl_async_phys_0.dac_code[1] oa_sar8_acore18_opt_0.sw_bitcell_opt_b3_0.bot 0.13194f
C752 sar_ctrl_async_phys_0.sg13g2_nor2b_1_4.Y a_31034_44457# 0.02669f
C753 sar_ctrl_async_phys_0.sg13g2_a22oi_1_3.A2 a_32993_37797# 0.01673f
C754 sar_ctrl_async_phys_0.sg13g2_dfrbpq_1_9.RESET_B sar_ctrl_async_phys_0.sg13g2_a21oi_1_0.B1 0.02099f
C755 sar_ctrl_async_phys_0.sg13g2_and2_1_2.X a_27249_39888# 0.02018f
C756 a_30486_31826# a_31189_31399# 0.02432f
C757 sar_ctrl_async_phys_0.sg13g2_buf_1_6.A a_34069_41189# 0.01712f
C758 sar_ctrl_async_phys_0.sg13g2_a21oi_1_1.Y VDD 0.53981f
C759 a_34549_30605# VDD 0.23934f
C760 sar_ctrl_async_phys_0.sg13g2_a21oi_1_6.A2 a_32692_46064# 0.0292f
C761 a_33846_33338# VDD 0.77489f
C762 a_27249_39888# track 0.0497f
C763 sar_ctrl_async_phys_0.sg13g2_buf_1_13.X a_32090_40428# 0.01556f
C764 sar_ctrl_async_phys_0.sg13g2_nor2_1_4.Y a_26662_41278# 0.02394f
C765 a_29258_36642# VDD 0.30674f
C766 a_34904_33688# result[7] 0.24637f
C767 sar_ctrl_async_phys_0.sg13g2_a22oi_1_5.A2 sar_ctrl_async_phys_0.sg13g2_nor2_1_5.B 0.01023f
C768 sar_ctrl_async_phys_0.sg13g2_and2_1_5.X a_34721_39775# 0.01256f
C769 sar_ctrl_async_phys_0.sg13g2_dfrbpq_1_0.CLK a_32149_35141# 0.29933f
C770 sar_ctrl_async_phys_0.sg13g2_nor2_1_0.Y a_32192_39918# 0.04083f
C771 sar_ctrl_async_phys_0.sg13g2_a21oi_1_1.B1 sar_ctrl_async_phys_0.sg13g2_a22oi_1_0.A1 0.089f
C772 sar_ctrl_async_phys_0.sg13g2_o21ai_1_1.B1 sar_ctrl_async_phys_0.sg13g2_nor2_1_6.A 0.18743f
C773 sar_ctrl_async_phys_0.sg13g2_dfrbpq_1_9.RESET_B sar_ctrl_async_phys_0.sg13g2_o21ai_1_1.B1 0.06226f
C774 a_32116_40464# a_33375_40821# 0.01529f
C775 sar_ctrl_async_phys_0.sg13g2_buf_1_2.A a_31802_37404# 0.25908f
C776 a_29812_33968# a_31071_33727# 0.01529f
C777 sar_ctrl_async_phys_0.sg13g2_nor2b_1_0.A sar_ctrl_async_phys_0.sg13g2_buf_1_22.A 0.66631f
C778 sar_ctrl_async_phys_0.sg13g2_dlygate4sd3_1_6.X VDD 0.31855f
C779 sar_ctrl_async_phys_0.sg13g2_nand2b_1_2.Y a_35245_42242# 0.29629f
C780 oa_sar8_acore18_opt_0.bstrap_opt_w2_c1200_1.out oa_sar8_acore18_opt_0.sw_bitcell_opt_b4_1.bot 4.12808f
C781 oa_sar8_acore18_opt_0.sw_bitcell_opt_term_1.bot oa_sar8_acore18_opt_0.sw_bitcell_opt_b5_1.bot 0.44938f
C782 sar_ctrl_async_phys_0.sg13g2_buf_1_32.A sar_ctrl_async_phys_0.sg13g2_buf_1_20.A 0.02251f
C783 a_36056_35200# sar_ctrl_async_phys_0.bit_active[1] 0.01271f
C784 sar_ctrl_async_phys_0.sg13g2_dfrbpq_1_0.CLK a_28774_41278# 0.03811f
C785 sar_ctrl_async_phys_0.dac_code_n[4] sar_ctrl_async_phys_0.dac_code_n[6] 0.39064f
C786 sar_ctrl_async_phys_0.dac_code_n[2] sar_ctrl_async_phys_0.sg13g2_buf_1_44.A 0.06392f
C787 sar_ctrl_async_phys_0.sg13g2_a21oi_1_4.B1 a_34093_42912# 0.29668f
C788 sar_ctrl_async_phys_0.sg13g2_a22oi_1_3.A2 a_33626_41433# 0.02261f
C789 sar_ctrl_async_phys_0.sg13g2_a22oi_1_2.A2 sar_ctrl_async_phys_0.sg13g2_inv_1_0.A 0.02959f
C790 sar_ctrl_async_phys_0.sg13g2_a21oi_1_2.B1 a_29812_40885# 0.01838f
C791 sar_ctrl_async_phys_0.dac_code_n[2] sar_ctrl_async_phys_0.sg13g2_dfrbpq_1_9.Q 0.01657f
C792 sar_ctrl_async_phys_0.dac_code_n[4] sar_ctrl_async_phys_0.dac_code_n[3] 7.35771f
C793 sar_ctrl_async_phys_0.sg13g2_a21oi_1_0.B1 sar_ctrl_async_phys_0.sg13g2_a22oi_1_0.A2 0.32489f
C794 sar_ctrl_async_phys_0.bit_active[0] result[7] 0.01072f
C795 sar_ctrl_async_phys_0.sg13g2_buf_1_4.A sar_ctrl_async_phys_0.bit_active[1] 0.11969f
C796 sar_ctrl_async_phys_0.bit_active[2] VDD 0.14072f
C797 sar_ctrl_async_phys_0.sg13g2_nor2_1_0.A sar_ctrl_async_phys_0.sg13g2_buf_1_2.A 0.16162f
C798 sar_ctrl_async_phys_0.dac_code_n[4] oa_sar8_acore18_opt_0.sw_bitcell_opt_term_0.trkb 2.02553f
C799 sar_ctrl_async_phys_0.sg13g2_nand2_1_0.B sar_ctrl_async_phys_0.sg13g2_nor2_1_7.A 0.07105f
C800 sar_ctrl_async_phys_0.sg13g2_nor2_1_7.A a_28862_36863# 0.01384f
C801 sar_ctrl_async_phys_0.sg13g2_buf_1_2.A sar_ctrl_async_phys_0.sg13g2_dlygate4sd3_1_0.X 0.15734f
C802 a_30139_43495# a_30879_43845# 0.26905f
C803 sar_ctrl_async_phys_0.sg13g2_a21oi_1_7.Y a_31802_37404# 0.02285f
C804 a_34731_37436# VDD 0.23586f
C805 sar_ctrl_async_phys_0.sg13g2_a21oi_1_2.B1 a_34171_41332# 0.02941f
C806 a_33752_33688# VDD 0.26722f
C807 a_35672_42760# sar_ctrl_async_phys_0.dac_code[2] 0.24511f
C808 sar_ctrl_async_phys_0.sg13g2_a22oi_1_3.A2 a_32251_35284# 0.03097f
C809 a_29786_33873# a_30229_33629# 0.02242f
C810 sar_ctrl_async_phys_0.sg13g2_inv_1_5.Y a_29812_33968# 0.04594f
C811 sar_ctrl_async_phys_0.dac_code_n[5] oa_sar8_acore18_opt_0.sw_bitcell_opt_b1_0.bot 0.22328f
C812 sar_ctrl_async_phys_0.sg13g2_a21oi_1_0.B1 sar_ctrl_async_phys_0.sg13g2_nor2b_1_0.A 0.87854f
C813 sar_ctrl_async_phys_0.dac_code[1] oa_sar8_acore18_opt_0.sw_bitcell_opt_term_0.bot 0.17583f
C814 a_35295_36285# sar_ctrl_async_phys_0.bit_active[2] 0.01554f
C815 sar_ctrl_async_phys_0.sg13g2_nor2_1_5.Y VDD 0.65321f
C816 a_30229_33629# VDD 0.2427f
C817 sar_ctrl_async_phys_0.sg13g2_nor2_1_1.A a_33087_37797# 0.02078f
C818 sar_ctrl_async_phys_0.dac_code_n[4] oa_sar8_acore18_opt_0.sw_bitcell_opt_b4_0.bot 0.18035f
C819 sar_ctrl_async_phys_0.sg13g2_nand2_1_2.A sar_ctrl_async_phys_0.sg13g2_nand2_1_6.B 0.1833f
C820 a_27249_39888# a_27530_39666# 0.26306f
C821 sar_ctrl_async_phys_0.sg13g2_a21oi_1_7.Y sar_ctrl_async_phys_0.sg13g2_nor2_1_0.A 0.23099f
C822 sar_ctrl_async_phys_0.sg13g2_buf_1_1.A VDD 0.39813f
C823 a_31258_32436# VDD 0.38058f
C824 sar_ctrl_async_phys_0.sg13g2_a21oi_1_5.B1 a_33276_42686# 0.01861f
C825 a_28006_35948# VDD 0.23794f
C826 sar_ctrl_async_phys_0.sg13g2_nor4_1_0.Y sar_ctrl_async_phys_0.sg13g2_dlygate4sd3_1_4.A 0.02471f
C827 sar_ctrl_async_phys_0.sg13g2_nand2b_1_3.Y a_34224_42058# 0.02184f
C828 a_34328_41972# sar_ctrl_async_phys_0.dac_code_n[7] 0.2458f
C829 a_33464_31388# result[3] 0.24645f
C830 sar_ctrl_async_phys_0.sg13g2_dlygate4sd3_1_3.A VDD 0.51771f
C831 sar_ctrl_async_phys_0.sg13g2_nor2_1_3.B sar_ctrl_async_phys_0.sg13g2_buf_1_26.X 0.04232f
C832 sar_ctrl_async_phys_0.sg13g2_nand2_1_3.Y sar_ctrl_async_phys_0.sg13g2_a21oi_1_2.B1 0.01564f
C833 sar_ctrl_async_phys_0.sg13g2_buf_1_2.X result[4] 0.02577f
C834 sar_ctrl_async_phys_0.sg13g2_dfrbpq_1_9.RESET_B a_31381_46519# 0.03872f
C835 a_25608_40501# VDD 0.3106f
C836 sar_ctrl_async_phys_0.dac_code[2] sar_ctrl_async_phys_0.cmp_n 0.07726f
C837 sar_ctrl_async_phys_0.sg13g2_o21ai_1_1.B1 sar_ctrl_async_phys_0.sg13g2_nor2b_1_0.A 0.20004f
C838 sar_ctrl_async_phys_0.sg13g2_buf_1_2.A sar_ctrl_async_phys_0.sg13g2_buf_1_16.A 0.2856f
C839 sar_ctrl_async_phys_0.sg13g2_buf_1_13.A a_33556_40016# 0.04345f
C840 sar_ctrl_async_phys_0.sg13g2_dfrbpq_1_0.CLK sar_ctrl_async_phys_0.sg13g2_a22oi_1_5.Y 0.0814f
C841 sar_ctrl_async_phys_0.sg13g2_buf_1_22.A VDD 0.90566f
C842 a_32090_40428# a_32116_40464# 0.36952f
C843 sar_ctrl_async_phys_0.sg13g2_nand2_1_0.Y a_28874_37806# 0.01574f
C844 sar_ctrl_async_phys_0.sg13g2_nand2_1_2.Y sar_ctrl_async_phys_0.dac_code[1] 0.04256f
C845 sar_ctrl_async_phys_0.sg13g2_a22oi_1_2.B1 sar_ctrl_async_phys_0.sg13g2_a22oi_1_0.Y 0.03211f
C846 sar_ctrl_async_phys_0.sg13g2_buf_1_34.A sar_ctrl_async_phys_0.dac_code[3] 0.02338f
C847 sar_ctrl_async_phys_0.sg13g2_buf_1_23.A sar_ctrl_async_phys_0.sg13g2_buf_1_2.A 0.25143f
C848 sar_ctrl_async_phys_0.sg13g2_a21oi_1_6.A2 a_33085_43832# 0.25761f
C849 sar_ctrl_async_phys_0.sg13g2_buf_1_2.X a_32149_35141# 0.03452f
C850 sar_ctrl_async_phys_0.dac_code_n[0] sar_ctrl_async_phys_0.dac_code[0] 0.07052f
C851 sar_ctrl_async_phys_0.sg13g2_a21oi_1_7.A2 a_32602_39996# 0.11536f
C852 sar_ctrl_async_phys_0.sg13g2_nor2_1_2.Y a_33940_41223# 0.01646f
C853 sar_ctrl_async_phys_0.sg13g2_buf_1_14.A sar_ctrl_async_phys_0.sg13g2_a21oi_1_2.B1 0.07826f
C854 sar_ctrl_async_phys_0.dac_code[3] oa_sar8_acore18_opt_0.sw_bitcell_opt_b7_0.bot 2.35239f
C855 sar_ctrl_async_phys_0.sg13g2_a21oi_1_1.Y a_34036_35928# 0.0113f
C856 a_34815_39775# a_34721_39775# 0.28931f
C857 a_28488_35965# a_28758_35924# 0.26306f
C858 a_26364_45710# a_26160_45878# 0.01048f
C859 a_29332_32456# a_29620_32151# 0.43707f
C860 sar_ctrl_async_phys_0.sg13g2_dfrbpq_1_0.CLK a_31924_32456# 0.09966f
C861 sar_ctrl_async_phys_0.sg13g2_buf_1_23.A a_34132_36687# 0.02558f
C862 sar_ctrl_async_phys_0.sg13g2_a21oi_1_2.A2 a_30401_39309# 0.0102f
C863 sar_ctrl_async_phys_0.sg13g2_buf_1_13.X a_31947_41508# 0.02008f
C864 a_36152_36806# a_36336_36806# 0.0524f
C865 sar_ctrl_async_phys_0.sg13g2_nand2_1_3.A a_35360_43726# 0.03808f
C866 sar_ctrl_async_phys_0.sg13g2_and2_1_5.X sar_ctrl_async_phys_0.sg13g2_a21oi_1_7.Y 0.02878f
C867 sar_ctrl_async_phys_0.sg13g2_dfrbpq_1_9.RESET_B a_32251_45007# 0.42066f
C868 sar_ctrl_async_phys_0.dac_code_n[4] sar_ctrl_async_phys_0.sg13g2_nand2b_1_7.A_N 0.28816f
C869 sar_ctrl_async_phys_0.sg13g2_a22oi_1_1.A2 sar_ctrl_async_phys_0.sg13g2_a22oi_1_0.A1 0.13492f
C870 sar_ctrl_async_phys_0.sg13g2_a21oi_1_7.Y sar_ctrl_async_phys_0.sg13g2_buf_1_16.A 0.01645f
C871 sar_ctrl_async_phys_0.sg13g2_nand2b_1_2.Y a_33940_44552# 0.01127f
C872 sar_ctrl_async_phys_0.sg13g2_nand2_1_2.A sar_ctrl_async_phys_0.dac_code_n[6] 0.0104f
C873 sar_ctrl_async_phys_0.sg13g2_o21ai_1_1.B1 a_32635_40471# 0.43932f
C874 sar_ctrl_async_phys_0.dac_code_n[5] sar_ctrl_async_phys_0.dac_code[7] 0.13099f
C875 sar_ctrl_async_phys_0.sg13g2_dfrbpq_1_0.CLK a_34132_30944# 0.06947f
C876 a_35672_33688# busy 0.24512f
C877 sar_ctrl_async_phys_0.dac_code_n[0] VDD 3.86556f
C878 sar_ctrl_async_phys_0.sg13g2_buf_1_6.A sar_ctrl_async_phys_0.sg13g2_a21oi_1_3.A2 0.28939f
C879 sar_ctrl_async_phys_0.dac_code_n[3] sar_ctrl_async_phys_0.sg13g2_nand2_1_2.A 1.10554f
C880 sar_ctrl_async_phys_0.sg13g2_a22oi_1_0.A2 a_33844_36992# 0.02847f
C881 a_29620_43488# a_29908_43909# 0.43707f
C882 sar_ctrl_async_phys_0.sg13g2_buf_1_14.A sar_ctrl_async_phys_0.bit_active[1] 0.03102f
C883 sar_ctrl_async_phys_0.sg13g2_nor2_1_11.A a_29232_43570# 0.02967f
C884 sar_ctrl_async_phys_0.dac_code[5] sar_ctrl_async_phys_0.bit_active[7] 0.01146f
C885 a_34808_35200# sar_ctrl_async_phys_0.bit_active[0] 0.09521f
C886 sar_ctrl_async_phys_0.dac_code[4] oa_sar8_acore18_opt_0.sw_bitcell_opt_b3_0.bot 0.62439f
C887 sar_ctrl_async_phys_0.sg13g2_inv_1_2.A result[4] 0.0117f
C888 oa_sar8_acore18_opt_0.sw_bitcell_opt_term_0.gb m3_41836_n2380# 1.64364f
C889 sar_ctrl_async_phys_0.sg13g2_nor4_1_0.Y a_28392_41214# 0.04475f
C890 sar_ctrl_async_phys_0.sg13g2_buf_1_2.X a_31823_32876# 0.01311f
C891 sar_ctrl_async_phys_0.sg13g2_a21oi_1_1.B1 sar_ctrl_async_phys_0.sg13g2_nand2_1_3.A 0.69659f
C892 sar_ctrl_async_phys_0.sg13g2_a22oi_1_3.A2 sar_ctrl_async_phys_0.sg13g2_inv_1_1.A 0.10413f
C893 sar_ctrl_async_phys_0.sg13g2_a21oi_1_0.B1 VDD 1.01451f
C894 sar_ctrl_async_phys_0.dac_code_n[4] oa_sar8_acore18_opt_0.sw_bitcell_opt_b0_0.bot 0.0829f
C895 a_35948_n9612# vinn 0.98838f
C896 sar_ctrl_async_phys_0.dac_code_n[2] oa_sar8_acore18_opt_0.sw_bitcell_opt_b3_0.bot 0.0829f
C897 sar_ctrl_async_phys_0.sg13g2_buf_1_6.A sar_ctrl_async_phys_0.sg13g2_a22oi_1_0.A2 0.15199f
C898 a_34036_35928# sar_ctrl_async_phys_0.bit_active[2] 0.01888f
C899 sar_ctrl_async_phys_0.dac_code_n[0] oa_sar8_acore18_opt_0.sw_bitcell_opt_b6_0.bot 0.66916f
C900 sar_ctrl_async_phys_0.sg13g2_a21oi_1_0.B1 sar_ctrl_async_phys_0.sg13g2_buf_1_35.A 0.02097f
C901 sar_ctrl_async_phys_0.sg13g2_a21oi_1_4.B1 sar_ctrl_async_phys_0.sg13g2_buf_1_34.A 2.4798f
C902 sar_ctrl_async_phys_0.sg13g2_dlygate4sd3_1_7.X a_26550_41214# 0.02463f
C903 a_29046_32138# VDD 0.78242f
C904 sar_ctrl_async_phys_0.cmp_valid sar_ctrl_async_phys_0.sg13g2_nand2b_1_2.Y 0.0143f
C905 sar_ctrl_async_phys_0.sg13g2_o21ai_1_1.B1 sar_ctrl_async_phys_0.sg13g2_nor2b_1_3.Y 0.10734f
C906 a_33936_31675# result[2] 0.013f
C907 sar_ctrl_async_phys_0.sg13g2_nor2b_1_3.Y a_32792_41342# 0.02026f
C908 sar_ctrl_async_phys_0.sg13g2_nor2_1_2.Y a_34132_43909# 0.0133f
C909 a_34555_35935# a_35552_36166# 0.03061f
C910 sar_ctrl_async_phys_0.sg13g2_inv_1_0.Y result[6] 0.01018f
C911 sar_ctrl_async_phys_0.sg13g2_o21ai_1_1.B1 VDD 9.4148f
C912 sar_ctrl_async_phys_0.sg13g2_dfrbpq_1_0.CLK sar_ctrl_async_phys_0.sg13g2_a21oi_1_2.A2 0.60782f
C913 sar_ctrl_async_phys_0.sg13g2_a22oi_1_0.A1 sar_ctrl_async_phys_0.sg13g2_a22oi_1_1.Y 0.37014f
C914 a_32792_41342# VDD 0.14401f
C915 sar_ctrl_async_phys_0.sg13g2_buf_1_2.A a_35552_36166# 0.09873f
C916 sar_ctrl_async_phys_0.dac_code_n[6] oa_sar8_acore18_opt_0.sw_tg_opt_0.bot 0.61835f
C917 sar_ctrl_async_phys_0.sg13g2_o21ai_1_1.B1 sar_ctrl_async_phys_0.sg13g2_buf_1_35.A 0.0452f
C918 a_34363_43495# a_35103_43845# 0.26905f
C919 a_29755_38959# VDD 0.20731f
C920 sar_ctrl_async_phys_0.dac_code_n[1] oa_sar8_acore18_opt_0.bstrap_opt_w2_c1200_1.out 1.66192f
C921 sar_ctrl_async_phys_0.dac_code_n[3] oa_sar8_acore18_opt_0.sw_tg_opt_0.bot 0.97237f
C922 sar_ctrl_async_phys_0.sg13g2_nor2b_1_0.A sar_ctrl_async_phys_0.sg13g2_buf_1_6.A 0.09008f
C923 sar_ctrl_async_phys_0.sg13g2_buf_1_2.A a_35648_34654# 0.0989f
C924 sar_ctrl_async_phys_0.sg13g2_dfrbpq_1_0.CLK a_32533_40471# 0.26f
C925 sar_ctrl_async_phys_0.sg13g2_dfrbpq_1_0.CLK a_29812_33968# 0.08217f
C926 a_34549_34423# a_35297_34773# 0.01058f
C927 sar_ctrl_async_phys_0.dac_code_n[1] sar_ctrl_async_phys_0.dac_code[3] 0.05494f
C928 a_34651_34423# a_35648_34654# 0.03061f
C929 sar_ctrl_async_phys_0.sg13g2_buf_1_2.X sar_ctrl_async_phys_0.sg13g2_a22oi_1_5.Y 0.27876f
C930 oa_sar8_acore18_opt_0.sw_tg_opt_0.bot oa_sar8_acore18_opt_0.sw_bitcell_opt_term_0.trkb 1.28268f
C931 a_26630_37814# VDD 0.01149f
C932 sar_ctrl_async_phys_0.dac_code_n[5] oa_sar8_acore18_opt_0.sw_bitcell_opt_b3_1.bot 0.06598f
C933 a_33270_39698# a_33844_39711# 0.31978f
C934 a_29332_32456# a_29749_32117# 0.3749f
C935 sar_ctrl_async_phys_0.sg13g2_nand2b_1_0.A_N sar_ctrl_async_phys_0.sg13g2_nor2_1_12.A 0.22406f
C936 a_29046_32138# a_29851_32260# 0.097f
C937 sar_ctrl_async_phys_0.sg13g2_dfrbpq_1_0.CLK a_30848_32358# 0.01162f
C938 sar_ctrl_async_phys_0.sg13g2_nand2b_1_1.Y a_33652_41528# 0.03939f
C939 sar_ctrl_async_phys_0.sg13g2_a21oi_1_2.A2 a_29236_38952# 0.02039f
C940 sar_ctrl_async_phys_0.dac_code_n[4] oa_sar8_acore18_opt_0.sw_bitcell_opt_b0_1.bot 0.06598f
C941 sar_ctrl_async_phys_0.sg13g2_dfrbpq_1_0.CLK a_27624_35965# 0.41101f
C942 a_28856_32270# sar_ctrl_async_phys_0.sg13g2_inv_1_6.Y 0.03202f
C943 sar_ctrl_async_phys_0.sg13g2_dfrbpq_1_9.RESET_B a_31483_46519# 0.42554f
C944 sar_ctrl_async_phys_0.sg13g2_buf_1_7.A a_33183_32215# 0.03043f
C945 m3_60844_n2380# VDD 0.10028f
C946 sar_ctrl_async_phys_0.sg13g2_dfrbpq_1_9.RESET_B a_31446_45434# 0.10987f
C947 sar_ctrl_async_phys_0.sg13g2_o21ai_1_1.B1 a_31830_40898# 0.10198f
C948 sar_ctrl_async_phys_0.sg13g2_inv_1_3.Y result[1] 0.13632f
C949 sar_ctrl_async_phys_0.sg13g2_buf_1_2.X a_31924_32456# 0.43384f
C950 sar_ctrl_async_phys_0.sg13g2_buf_1_33.A sar_ctrl_async_phys_0.sg13g2_nand2b_1_2.A_N 0.19641f
C951 sar_ctrl_async_phys_0.sg13g2_and2_1_2.X a_27032_39034# 0.03689f
C952 sar_ctrl_async_phys_0.sg13g2_buf_1_3.A a_34520_33688# 0.24859f
C953 sar_ctrl_async_phys_0.sg13g2_a22oi_1_0.A1 sar_ctrl_async_phys_0.sg13g2_inv_1_0.A 0.35139f
C954 sar_ctrl_async_phys_0.sg13g2_o21ai_1_1.B1 a_35072_39918# 0.10165f
C955 sar_ctrl_async_phys_0.dac_code[4] oa_sar8_acore18_opt_0.sw_bitcell_opt_term_0.bot 0.159f
C956 a_29334_43922# a_29594_43452# 0.75507f
C957 sar_ctrl_async_phys_0.sg13g2_inv_1_3.Y a_33183_32215# 0.02518f
C958 sar_ctrl_async_phys_0.dac_code_n[4] a_35948_n9612# 0.04813f
C959 sar_ctrl_async_phys_0.sg13g2_nor2_1_0.A a_32538_36972# 0.01372f
C960 sar_ctrl_async_phys_0.sg13g2_nand2_1_2.A sar_ctrl_async_phys_0.sg13g2_nand2b_1_7.A_N 0.39314f
C961 sar_ctrl_async_phys_0.sg13g2_dfrbpq_1_9.Q a_34765_45266# 0.17454f
C962 oa_sar8_acore18_opt_0.sw_tg_opt_0.bot oa_sar8_acore18_opt_0.sw_bitcell_opt_b4_0.bot 6.47993f
C963 sar_ctrl_async_phys_0.sg13g2_buf_1_2.X a_34132_30944# 0.38197f
C964 sar_ctrl_async_phys_0.cmp_p oa_sar8_acore18_opt_0.sw_tg_opt_0.bot 0.01619f
C965 a_34767_31359# a_35418_31668# 0.01562f
C966 a_26666_38912# a_27206_39326# 0.01209f
C967 a_32692_46064# a_33211_45868# 0.34114f
C968 sar_ctrl_async_phys_0.sg13g2_dfrbpq_1_0.CLK a_31716_38912# 0.01073f
C969 sar_ctrl_async_phys_0.sg13g2_buf_1_13.A sar_ctrl_async_phys_0.sg13g2_nor2_1_1.A 0.05854f
C970 a_33750_36362# VDD 0.78079f
C971 sar_ctrl_async_phys_0.dac_code_n[2] oa_sar8_acore18_opt_0.sw_bitcell_opt_term_0.bot 0.34758f
C972 sar_ctrl_async_phys_0.dac_code[6] oa_sar8_acore18_opt_0.sw_bitcell_opt_term_0.gb 0.29684f
C973 sar_ctrl_async_phys_0.sg13g2_nor2_1_4.Y a_26558_40727# 0.04601f
C974 sar_ctrl_async_phys_0.dac_code_n[0] oa_sar8_acore18_opt_0.sw_bitcell_opt_b2_0.bot 0.12572f
C975 sar_ctrl_async_phys_0.sg13g2_a21oi_1_5.B1 sar_ctrl_async_phys_0.sg13g2_a21oi_1_6.B1 0.56532f
C976 sar_ctrl_async_phys_0.sg13g2_a21oi_1_0.A1 a_33777_42748# 0.01171f
C977 sar_ctrl_async_phys_0.sg13g2_nor2b_1_0.A a_30964_36349# 0.01134f
C978 a_34520_47296# sar_ctrl_async_phys_0.sg13g2_a21oi_1_5.B1 0.01772f
C979 sar_ctrl_async_phys_0.sg13g2_nor2_1_0.Y a_32319_44311# 0.03604f
C980 a_33114_41508# sar_ctrl_async_phys_0.sg13g2_nor2_1_15.Y 0.01346f
C981 sar_ctrl_async_phys_0.sg13g2_buf_1_7.A result[2] 0.04723f
C982 sar_ctrl_async_phys_0.sg13g2_buf_1_29.A a_26364_45710# 0.2475f
C983 a_31832_34412# VDD 0.24461f
C984 a_33530_39921# VDD 0.09636f
C985 sar_ctrl_async_phys_0.sg13g2_a21oi_1_4.B1 sar_ctrl_async_phys_0.dac_code_n[1] 0.03136f
C986 a_31381_46519# VDD 0.26496f
C987 a_33844_36992# VDD 0.07206f
C988 sar_ctrl_async_phys_0.sg13g2_a21oi_1_5.B1 sar_ctrl_async_phys_0.sg13g2_nand2_1_2.B 0.01128f
C989 a_31477_44213# a_31348_44247# 0.01562f
C990 sar_ctrl_async_phys_0.sg13g2_dlygate4sd3_1_4.X sar_ctrl_async_phys_0.sg13g2_nor2_1_3.B 0.01052f
C991 sar_ctrl_async_phys_0.sg13g2_buf_1_6.A sar_ctrl_async_phys_0.sg13g2_nor2b_1_3.Y 0.37152f
C992 a_30752_39190# a_30495_39309# 0.34468f
C993 sar_ctrl_async_phys_0.sg13g2_nor2b_1_0.A a_32304_36806# 0.01867f
C994 sar_ctrl_async_phys_0.sg13g2_buf_1_3.A sar_ctrl_async_phys_0.sg13g2_nand2_1_3.B 0.18448f
C995 sar_ctrl_async_phys_0.sg13g2_a21oi_1_2.B1 sar_ctrl_async_phys_0.sg13g2_nor2_1_10.B 0.29603f
C996 sar_ctrl_async_phys_0.sg13g2_buf_1_13.X a_30676_35928# 0.01359f
C997 sar_ctrl_async_phys_0.sg13g2_buf_1_3.A sar_ctrl_async_phys_0.sg13g2_nand2b_1_1.Y 0.01508f
C998 sar_ctrl_async_phys_0.sg13g2_buf_1_14.A a_36056_37436# 0.01626f
C999 sar_ctrl_async_phys_0.sg13g2_inv_1_3.Y result[2] 0.18446f
C1000 a_34036_35928# a_34324_36349# 0.43707f
C1001 a_34268_31826# VDD 0.16814f
C1002 sar_ctrl_async_phys_0.dac_code_n[2] m3_38288_n2380# 0.04834f
C1003 sar_ctrl_async_phys_0.sg13g2_dfrbpq_1_9.RESET_B a_35199_44311# 0.13324f
C1004 sar_ctrl_async_phys_0.sg13g2_buf_1_2.A a_34010_35892# 0.26477f
C1005 sar_ctrl_async_phys_0.sg13g2_buf_1_7.A sar_ctrl_async_phys_0.sg13g2_inv_1_0.A 0.80831f
C1006 sar_ctrl_async_phys_0.sg13g2_buf_1_6.A VDD 1.62458f
C1007 sar_ctrl_async_phys_0.bit_active[4] sar_ctrl_async_phys_0.bit_active[1] 0.35983f
C1008 sar_ctrl_async_phys_0.dac_code_n[2] oa_sar8_acore18_opt_0.bstrap_opt_w2_c1200_1.gb 0.12464f
C1009 a_28560_39034# VDD 0.07229f
C1010 sar_ctrl_async_phys_0.sg13g2_nand2b_1_1.Y sar_ctrl_async_phys_0.dac_code[1] 0.16856f
C1011 a_35772_41936# sar_ctrl_async_phys_0.sg13g2_nand2b_1_2.A_N 0.05153f
C1012 sar_ctrl_async_phys_0.sg13g2_a22oi_1_3.A2 sar_ctrl_async_phys_0.sg13g2_buf_1_22.A 0.23375f
C1013 sar_ctrl_async_phys_0.sg13g2_buf_1_2.A a_33846_34850# 0.11287f
C1014 a_32251_45007# VDD 0.2058f
C1015 sar_ctrl_async_phys_0.dac_code[1] oa_sar8_acore18_opt_0.sw_bitcell_opt_term_0.vin 1.75101f
C1016 sar_ctrl_async_phys_0.sg13g2_inv_1_3.Y sar_ctrl_async_phys_0.sg13g2_inv_1_0.A 0.01585f
C1017 a_29524_40464# a_30783_40821# 0.01529f
C1018 sar_ctrl_async_phys_0.dac_code_n[4] oa_sar8_acore18_opt_0.sw_bitcell_opt_b4_1.bot 1.31781f
C1019 sar_ctrl_async_phys_0.sg13g2_a22oi_1_1.Y sar_ctrl_async_phys_0.sg13g2_dfrbpq_1_17.D 0.16869f
C1020 a_33846_34850# a_34651_34423# 0.097f
C1021 sar_ctrl_async_phys_0.sg13g2_nand2b_1_2.Y sar_ctrl_async_phys_0.dac_code[1] 0.6938f
C1022 a_34132_34416# a_34549_34423# 0.37583f
C1023 sar_ctrl_async_phys_0.sg13g2_buf_1_2.A a_34363_36796# 0.42137f
C1024 sar_ctrl_async_phys_0.dac_code_n[2] oa_sar8_acore18_opt_0.sw_bitcell_opt_b1_1.bot 0.12058f
C1025 a_33270_39698# a_34075_39820# 0.097f
C1026 a_33556_40016# a_33973_39677# 0.3749f
C1027 sar_ctrl_async_phys_0.sg13g2_dfrbpq_1_0.CLK a_34075_39820# 0.02128f
C1028 oa_sar8_acore18_opt_0.sw_bitcell_opt_term_0.trkb m3_48572_n2380# 0.03859f
C1029 sar_ctrl_async_phys_0.sg13g2_a22oi_1_0.B1 a_31247_32876# 0.05312f
C1030 sar_ctrl_async_phys_0.sg13g2_nor2b_1_0.A a_34904_38224# 0.3426f
C1031 oa_sar8_acore18_opt_0.sw_tg_opt_0.bot m3_57896_n2380# 0.05699f
C1032 a_33844_36992# a_35009_36751# 0.43239f
C1033 a_34363_36796# a_34132_36687# 0.12701f
C1034 a_35103_36751# a_35360_36894# 0.34468f
C1035 sar_ctrl_async_phys_0.sg13g2_dfrbpq_1_9.RESET_B sar_ctrl_async_phys_0.dac_code_n[7] 0.0227f
C1036 m3_34580_n2380# VDD 0.02982f
C1037 sar_ctrl_async_phys_0.sg13g2_buf_1_2.X a_29812_33968# 0.40081f
C1038 sar_ctrl_async_phys_0.sg13g2_buf_1_6.A a_35295_36285# 0.03857f
C1039 sar_ctrl_async_phys_0.sg13g2_a22oi_1_0.Y sar_ctrl_async_phys_0.sg13g2_buf_1_25.A 0.02373f
C1040 sar_ctrl_async_phys_0.sg13g2_buf_1_26.X sar_ctrl_async_phys_0.sg13g2_nor2_1_3.Y 0.03053f
C1041 sar_ctrl_async_phys_0.sg13g2_a22oi_1_5.A2 a_30977_33727# 0.01837f
C1042 sar_ctrl_async_phys_0.sg13g2_buf_1_2.X a_30848_32358# 0.1098f
C1043 sar_ctrl_async_phys_0.sg13g2_dfrbpq_1_0.CLK a_34615_31475# 0.03318f
C1044 sar_ctrl_async_phys_0.dac_code_n[7] oa_sar8_acore18_opt_0.sw_bitcell_opt_term_0.VSS 0.01021f
C1045 a_34520_42760# VDD 0.23054f
C1046 sar_ctrl_async_phys_0.sg13g2_buf_1_20.A sar_ctrl_async_phys_0.bit_active[5] 0.10988f
C1047 sar_ctrl_async_phys_0.sg13g2_a22oi_1_1.B2 a_32443_32260# 0.03569f
C1048 sar_ctrl_async_phys_0.sg13g2_nand2_1_3.B sar_ctrl_async_phys_0.sg13g2_buf_1_20.A 0.02531f
C1049 oa_sar8_acore18_opt_0.sw_tg_opt_0.bot oa_sar8_acore18_opt_0.sw_bitcell_opt_b0_0.bot 0.8829f
C1050 sar_ctrl_async_phys_0.sg13g2_nand2b_1_1.Y sar_ctrl_async_phys_0.sg13g2_buf_1_20.A 0.02795f
C1051 sar_ctrl_async_phys_0.sg13g2_buf_1_3.A result[5] 0.03289f
C1052 sar_ctrl_async_phys_0.sg13g2_nand3_1_0.C VDD 0.27453f
C1053 sar_ctrl_async_phys_0.hold_req sar_ctrl_async_phys_0.dac_code_n[7] 0.04276f
C1054 sar_ctrl_async_phys_0.sg13g2_a21oi_1_0.B1 a_35245_45266# 0.11891f
C1055 sar_ctrl_async_phys_0.sg13g2_buf_1_6.A a_35391_34773# 0.0336f
C1056 sar_ctrl_async_phys_0.sg13g2_buf_1_1.A done 0.04139f
C1057 sar_ctrl_async_phys_0.sg13g2_dfrbpq_1_9.RESET_B sar_ctrl_async_phys_0.sg13g2_nor2_1_2.Y 0.42166f
C1058 sar_ctrl_async_phys_0.sg13g2_nand2b_1_2.Y sar_ctrl_async_phys_0.sg13g2_buf_1_20.A 0.02455f
C1059 a_34636_31749# a_35418_31668# 0.43707f
C1060 sar_ctrl_async_phys_0.dac_code_n[0] oa_sar8_acore18_opt_0.sw_bitcell_opt_b7_1.VSS 0.91217f
C1061 sar_ctrl_async_phys_0.sg13g2_dfrbpq_1_22.D a_31674_38948# 0.01293f
C1062 sar_ctrl_async_phys_0.sg13g2_a22oi_1_2.A2 sar_ctrl_async_phys_0.sg13g2_nor2b_1_1.B_N 1.04145f
C1063 sar_ctrl_async_phys_0.dac_code_n[5] a_36056_46508# 0.01311f
C1064 a_33626_41433# a_33652_41528# 0.36952f
C1065 sar_ctrl_async_phys_0.sg13g2_nand3_1_0.Y a_27249_39888# 0.02103f
C1066 sar_ctrl_async_phys_0.dac_code_n[6] sar_ctrl_async_phys_0.dac_code[5] 0.06345f
C1067 sar_ctrl_async_phys_0.sg13g2_nor2_1_5.B a_29258_36642# 0.01498f
C1068 sar_ctrl_async_phys_0.dac_code_n[3] sar_ctrl_async_phys_0.dac_code[5] 0.13755f
C1069 sar_ctrl_async_phys_0.sg13g2_o21ai_1_1.B1 a_29210_38916# 0.25917f
C1070 sar_ctrl_async_phys_0.sg13g2_a21oi_1_4.A2 a_31933_43832# 0.19635f
C1071 sar_ctrl_async_phys_0.dac_code_n[5] oa_sar8_acore18_opt_0.bstrap_opt_w2_c1200_1.out 1.87319f
C1072 sar_ctrl_async_phys_0.sg13g2_buf_1_6.A sar_ctrl_async_phys_0.sg13g2_a21oi_1_0.A2 0.34484f
C1073 a_32304_36806# VDD 0.09525f
C1074 sar_ctrl_async_phys_0.bit_active[1] result[6] 0.01275f
C1075 a_32347_37447# a_33087_37797# 0.26905f
C1076 a_31060_44552# a_31579_44356# 0.34114f
C1077 a_36248_44366# VDD 0.12775f
C1078 sar_ctrl_async_phys_0.dac_code[5] oa_sar8_acore18_opt_0.sw_bitcell_opt_term_0.trkb 2.01172f
C1079 a_29236_38952# a_29524_39373# 0.43707f
C1080 sar_ctrl_async_phys_0.sg13g2_dfrbpq_1_9.RESET_B a_29620_43488# 0.41437f
C1081 a_36152_45082# a_36336_45082# 0.0524f
C1082 sar_ctrl_async_phys_0.sg13g2_nand2b_1_2.Y sar_ctrl_async_phys_0.sg13g2_nand2_1_1.B 0.08404f
C1083 sar_ctrl_async_phys_0.dac_code_n[5] sar_ctrl_async_phys_0.dac_code[3] 0.06252f
C1084 a_33750_36362# a_34036_35928# 0.41329f
C1085 sar_ctrl_async_phys_0.sg13g2_buf_1_21.A VDD 0.57475f
C1086 sar_ctrl_async_phys_0.sg13g2_dfrbpq_1_0.CLK sar_ctrl_async_phys_0.sg13g2_buf_1_26.X 0.02884f
C1087 a_31291_31399# VDD 0.20406f
C1088 sar_ctrl_async_phys_0.sg13g2_buf_1_35.A a_36248_44366# 0.01793f
C1089 sar_ctrl_async_phys_0.sg13g2_buf_1_3.A a_33844_43488# 0.01442f
C1090 sar_ctrl_async_phys_0.sg13g2_nor2_1_2.Y sar_ctrl_async_phys_0.sg13g2_a22oi_1_0.A2 0.01283f
C1091 a_28651_39740# a_28853_39702# 0.01117f
C1092 sar_ctrl_async_phys_0.sg13g2_buf_1_2.A a_32192_36166# 0.0994f
C1093 sar_ctrl_async_phys_0.sg13g2_nand2b_1_7.A_N a_35725_45266# 0.18848f
C1094 oa_sar8_acore18_opt_0.sw_bitcell_opt_b1_0.bot m3_54868_n2380# 1.55726f
C1095 sar_ctrl_async_phys_0.sg13g2_o21ai_1_1.B1 sar_ctrl_async_phys_0.sg13g2_a22oi_1_3.A2 1.35649f
C1096 a_33558_43922# a_34132_43909# 0.31978f
C1097 sar_ctrl_async_phys_0.sg13g2_dfrbpq_1_0.CLK sar_ctrl_async_phys_0.sg13g2_nand2b_1_0.A_N 0.09234f
C1098 sar_ctrl_async_phys_0.sg13g2_a22oi_1_2.A2 sar_ctrl_async_phys_0.sg13g2_nor2_1_1.A 0.32477f
C1099 sar_ctrl_async_phys_0.dac_code_n[6] a_20412_n9612# 0.15855f
C1100 sar_ctrl_async_phys_0.dac_code_n[4] sar_ctrl_async_phys_0.sg13g2_buf_1_34.A 0.03468f
C1101 a_31483_46519# VDD 0.21112f
C1102 sar_ctrl_async_phys_0.sg13g2_a21oi_1_2.B1 a_35482_39996# 0.01759f
C1103 sar_ctrl_async_phys_0.dac_code_n[4] oa_sar8_acore18_opt_0.sw_bitcell_opt_b7_0.bot 1.49586f
C1104 sar_ctrl_async_phys_0.dac_code_n[3] a_20412_n9612# 1.21221f
C1105 sar_ctrl_async_phys_0.sg13g2_inv_1_9.Y sar_ctrl_async_phys_0.sg13g2_nor2_1_12.A 0.03555f
C1106 a_31446_45434# VDD 0.7775f
C1107 sar_ctrl_async_phys_0.dac_code[5] oa_sar8_acore18_opt_0.sw_bitcell_opt_b4_0.bot 0.54659f
C1108 sar_ctrl_async_phys_0.sg13g2_a21oi_1_0.A1 sar_ctrl_async_phys_0.sg13g2_buf_1_13.A 0.08594f
C1109 sar_ctrl_async_phys_0.sg13g2_nor2b_1_0.A sar_ctrl_async_phys_0.dac_code_n[7] 0.0109f
C1110 sar_ctrl_async_phys_0.sg13g2_buf_1_13.X sar_ctrl_async_phys_0.sg13g2_a21oi_1_0.A1 1.08913f
C1111 w_39600_n9960# sar_ctrl_async_phys_0.dac_code_n[6] 0.18842f
C1112 a_34904_38224# VDD 0.21971f
C1113 sar_ctrl_async_phys_0.sg13g2_a22oi_1_5.A2 sar_ctrl_async_phys_0.sg13g2_and2_1_5.X 0.26478f
C1114 sar_ctrl_async_phys_0.sg13g2_a21oi_1_0.B1 a_35672_42760# 0.02215f
C1115 a_31381_46519# a_31252_46933# 0.01562f
C1116 a_30964_46512# sar_ctrl_async_phys_0.sg13g2_dfrbpq_1_0.CLK 0.08225f
C1117 oa_sar8_acore18_opt_0.sw_bitcell_opt_term_0.trkb a_20412_n9612# 0.80047f
C1118 sar_ctrl_async_phys_0.sg13g2_a22oi_1_5.A2 sar_ctrl_async_phys_0.sg13g2_buf_1_16.A 0.09592f
C1119 w_39600_n9960# sar_ctrl_async_phys_0.dac_code_n[3] 0.02244f
C1120 sar_ctrl_async_phys_0.sg13g2_buf_1_3.A a_33626_41433# 0.03047f
C1121 sar_ctrl_async_phys_0.sg13g2_a22oi_1_1.B2 sar_ctrl_async_phys_0.sg13g2_buf_1_25.A 0.38773f
C1122 sar_ctrl_async_phys_0.sg13g2_dlygate4sd3_1_0.X a_28870_35948# 0.16535f
C1123 a_34261_36653# a_34363_36796# 0.47622f
C1124 a_34651_32911# a_35391_33261# 0.26905f
C1125 m3_51760_n2380# m3_54868_n2380# 0.0157f
C1126 sar_ctrl_async_phys_0.dac_code_n[0] sar_ctrl_async_phys_0.cmp_n 0.06905f
C1127 sar_ctrl_async_phys_0.cmp_fire sar_ctrl_async_phys_0.cmp_p 1.21544f
C1128 sar_ctrl_async_phys_0.sg13g2_buf_1_1.A a_35288_33688# 0.25896f
C1129 a_36058_34412# sar_ctrl_async_phys_0.bit_active[1] 0.01328f
C1130 w_39600_n9960# oa_sar8_acore18_opt_0.sw_bitcell_opt_term_0.trkb 2.16982f
C1131 sar_ctrl_async_phys_0.sg13g2_inv_1_10.Y sar_ctrl_async_phys_0.sg13g2_nand2b_1_0.A_N 0.51466f
C1132 sar_ctrl_async_phys_0.sg13g2_nor2_1_2.Y sar_ctrl_async_phys_0.sg13g2_nor2b_1_0.A 0.01529f
C1133 sar_ctrl_async_phys_0.sg13g2_nor4_1_0.C a_29524_40464# 0.03151f
C1134 sar_ctrl_async_phys_0.dac_code[1] sar_ctrl_async_phys_0.dac_code[2] 4.87145f
C1135 sar_ctrl_async_phys_0.sg13g2_nor2_1_5.Y sar_ctrl_async_phys_0.sg13g2_nor2_1_5.B 0.3228f
C1136 sar_ctrl_async_phys_0.sg13g2_a21oi_1_4.B1 sar_ctrl_async_phys_0.dac_code_n[5] 0.24338f
C1137 sar_ctrl_async_phys_0.sg13g2_buf_1_2.A sar_ctrl_async_phys_0.sg13g2_a22oi_1_0.Y 0.89f
C1138 sar_ctrl_async_phys_0.dac_code_n[7] vinp 0.10141f
C1139 sar_ctrl_async_phys_0.sg13g2_inv_1_2.Y VDD 0.32426f
C1140 sar_ctrl_async_phys_0.sg13g2_buf_1_2.X a_34615_31475# 0.43017f
C1141 oa_sar8_acore18_opt_0.sw_bitcell_opt_b2_0.bot m3_34580_n2380# 0.01914f
C1142 sar_ctrl_async_phys_0.sg13g2_buf_1_20.A a_33844_43488# 0.0225f
C1143 w_16692_n9960# sar_ctrl_async_phys_0.dac_code_n[0] 0.03874f
C1144 sar_ctrl_async_phys_0.sg13g2_dfrbpq_1_0.CLK sar_ctrl_async_phys_0.sg13g2_a21oi_1_6.A2 0.15183f
C1145 sar_ctrl_async_phys_0.sg13g2_dfrbpq_1_2.Q a_33652_41528# 0.0114f
C1146 sar_ctrl_async_phys_0.sg13g2_buf_1_13.A sar_ctrl_async_phys_0.sg13g2_buf_1_4.A 0.01764f
C1147 sar_ctrl_async_phys_0.sg13g2_dfrbpq_1_0.CLK a_32020_45421# 0.01747f
C1148 a_34106_32868# result[5] 0.02048f
C1149 sar_ctrl_async_phys_0.sg13g2_dfrbpq_1_9.RESET_B a_33818_43452# 0.24025f
C1150 sar_ctrl_async_phys_0.sg13g2_nor2_1_2.A sar_ctrl_async_phys_0.sg13g2_buf_1_2.A 1.24512f
C1151 sar_ctrl_async_phys_0.sg13g2_a22oi_1_0.A1 a_34132_34416# 0.01252f
C1152 sar_ctrl_async_phys_0.sg13g2_nand2b_1_1.Y sar_ctrl_async_phys_0.sg13g2_and2_1_5.X 1.05854f
C1153 a_31546_43484# VDD 0.38081f
C1154 sar_ctrl_async_phys_0.sg13g2_buf_1_2.X sar_ctrl_async_phys_0.sg13g2_inv_1_0.Y 0.15682f
C1155 w_39600_n9960# oa_sar8_acore18_opt_0.sw_bitcell_opt_b4_0.bot 0.01745f
C1156 a_26566_41996# VDD 0.18949f
C1157 sar_ctrl_async_phys_0.sg13g2_nand2b_1_2.Y sar_ctrl_async_phys_0.sg13g2_and2_1_5.X 0.0108f
C1158 sar_ctrl_async_phys_0.sg13g2_buf_1_20.A sar_ctrl_async_phys_0.dac_code[2] 0.02433f
C1159 sar_ctrl_async_phys_0.sg13g2_a22oi_1_2.B1 a_33168_32986# 0.01005f
C1160 sar_ctrl_async_phys_0.sg13g2_dlygate4sd3_1_1.X a_28488_35965# 0.01053f
C1161 sar_ctrl_async_phys_0.sg13g2_o21ai_1_1.B1 a_31732_45000# 0.04438f
C1162 a_35199_44311# VDD 0.17431f
C1163 sar_ctrl_async_phys_0.sg13g2_a22oi_1_3.A2 a_33530_39921# 0.02452f
C1164 a_34618_46044# sar_ctrl_async_phys_0.sg13g2_nand2_1_6.B 0.11547f
C1165 a_32692_46064# a_32980_45759# 0.43707f
C1166 sar_ctrl_async_phys_0.sg13g2_nor2_1_3.A a_25496_34412# 0.26471f
C1167 sar_ctrl_async_phys_0.dac_code[0] sar_ctrl_async_phys_0.dac_code_n[7] 3.03982f
C1168 a_30486_31826# VDD 0.7766f
C1169 sar_ctrl_async_phys_0.dac_code[4] oa_sar8_acore18_opt_0.sw_bitcell_opt_term_0.vin 1.88518f
C1170 a_34136_33688# VDD 0.21836f
C1171 a_26570_42690# VDD 0.35f
C1172 sar_ctrl_async_phys_0.sg13g2_nor4_1_0.C sar_ctrl_async_phys_0.sg13g2_dfrbpq_1_9.RESET_B 0.02538f
C1173 sar_ctrl_async_phys_0.sg13g2_a21oi_1_6.A2 a_32897_45357# 0.01742f
C1174 sar_ctrl_async_phys_0.sg13g2_a21oi_1_0.B1 a_35245_42242# 0.03048f
C1175 sar_ctrl_async_phys_0.sg13g2_buf_1_2.A a_30390_36362# 0.08743f
C1176 sar_ctrl_async_phys_0.sg13g2_nor2_1_11.A a_31098_43020# 0.01483f
C1177 sar_ctrl_async_phys_0.sg13g2_a21oi_1_4.B1 sar_ctrl_async_phys_0.sg13g2_buf_1_13.X 0.01868f
C1178 sar_ctrl_async_phys_0.dac_code_n[2] sar_ctrl_async_phys_0.sg13g2_nand2b_1_1.Y 0.55584f
C1179 sar_ctrl_async_phys_0.sg13g2_buf_1_0.A a_33248_35382# 0.01326f
C1180 a_33248_45238# a_32991_45357# 0.34468f
C1181 sar_ctrl_async_phys_0.sg13g2_a21oi_1_4.B1 sar_ctrl_async_phys_0.sg13g2_buf_1_13.A 0.01741f
C1182 sar_ctrl_async_phys_0.dac_code_n[2] oa_sar8_acore18_opt_0.sw_bitcell_opt_term_0.vin 0.11612f
C1183 sar_ctrl_async_phys_0.sg13g2_dlygate4sd3_1_0.A a_27894_35924# 0.01144f
C1184 sar_ctrl_async_phys_0.dac_code[5] oa_sar8_acore18_opt_0.sw_bitcell_opt_b0_0.bot 0.15267f
C1185 sar_ctrl_async_phys_0.dac_code_n[4] sar_ctrl_async_phys_0.dac_code_n[1] 0.13991f
C1186 sar_ctrl_async_phys_0.sg13g2_a22oi_1_3.A2 sar_ctrl_async_phys_0.sg13g2_buf_1_6.A 0.02165f
C1187 sar_ctrl_async_phys_0.dac_code_n[7] VDD 6.08775f
C1188 sar_ctrl_async_phys_0.dac_code[6] oa_sar8_acore18_opt_0.sw_bitcell_opt_b3_0.bot 0.51827f
C1189 sar_ctrl_async_phys_0.sg13g2_dfrbpq_1_0.CLK sar_ctrl_async_phys_0.sg13g2_a21oi_1_2.B1 0.46389f
C1190 sar_ctrl_async_phys_0.sg13g2_nand2_1_2.B a_35105_44311# 0.02166f
C1191 sar_ctrl_async_phys_0.sg13g2_nor2_1_2.Y sar_ctrl_async_phys_0.sg13g2_nor2b_1_3.Y 0.01447f
C1192 a_29238_40898# a_29498_40428# 0.75507f
C1193 sar_ctrl_async_phys_0.sg13g2_nor2b_1_4.Y sar_ctrl_async_phys_0.sg13g2_buf_1_20.A 0.17963f
C1194 sar_ctrl_async_phys_0.sg13g2_buf_1_35.A sar_ctrl_async_phys_0.dac_code_n[7] 0.04466f
C1195 sar_ctrl_async_phys_0.sg13g2_buf_1_3.A sar_ctrl_async_phys_0.sg13g2_dfrbpq_1_2.Q 0.31453f
C1196 sar_ctrl_async_phys_0.sg13g2_nand2_1_2.A sar_ctrl_async_phys_0.sg13g2_buf_1_34.A 0.74834f
C1197 a_30678_46946# a_30964_46512# 0.41329f
C1198 sar_ctrl_async_phys_0.sg13g2_nor2_1_13.Y VDD 0.34491f
C1199 sar_ctrl_async_phys_0.sg13g2_dfrbpq_1_0.CLK sar_ctrl_async_phys_0.sg13g2_dfrbpq_1_22.D 0.27751f
C1200 sar_ctrl_async_phys_0.sg13g2_nor2_1_7.B sar_ctrl_async_phys_0.sg13g2_nand2_1_0.Y 0.14809f
C1201 a_33818_36897# a_33558_36674# 0.75507f
C1202 sar_ctrl_async_phys_0.sg13g2_a22oi_1_1.A2 a_31446_35162# 0.05251f
C1203 m3_38288_n2380# m3_41836_n2380# 0.0157f
C1204 sar_ctrl_async_phys_0.sg13g2_buf_1_2.A a_34904_33688# 0.09742f
C1205 sar_ctrl_async_phys_0.sg13g2_nor2_1_2.Y VDD 0.56715f
C1206 sar_ctrl_async_phys_0.sg13g2_buf_1_5.A result[4] 2.29989f
C1207 sar_ctrl_async_phys_0.sg13g2_dfrbpq_1_0.CLK a_31060_31813# 0.01049f
C1208 sar_ctrl_async_phys_0.sg13g2_o21ai_1_1.B1 a_30676_40016# 0.39105f
C1209 sar_ctrl_async_phys_0.sg13g2_inv_1_6.Y a_29912_31474# 0.02791f
C1210 sar_ctrl_async_phys_0.dac_code_n[7] oa_sar8_acore18_opt_0.sw_bitcell_opt_b6_0.bot 0.87364f
C1211 sar_ctrl_async_phys_0.sg13g2_buf_1_35.A sar_ctrl_async_phys_0.sg13g2_nor2_1_2.Y 0.27751f
C1212 sar_ctrl_async_phys_0.sg13g2_buf_1_2.A result[7] 0.03508f
C1213 a_35770_43484# VDD 0.38021f
C1214 sar_ctrl_async_phys_0.sg13g2_buf_1_16.A a_34424_35200# 0.25921f
C1215 sar_ctrl_async_phys_0.dac_code_n[4] vcm 0.06598f
C1216 sar_ctrl_async_phys_0.sg13g2_buf_1_2.X a_34055_31352# 0.16412f
C1217 a_32580_43448# a_32888_43570# 0.01393f
C1218 a_30783_40821# VDD 0.17863f
C1219 a_28488_35965# VDD 0.31287f
C1220 a_31252_46933# a_31483_46519# 0.12701f
C1221 a_30964_46512# a_32129_46869# 0.43239f
C1222 sar_ctrl_async_phys_0.sg13g2_a22oi_1_0.A2 result[4] 0.01617f
C1223 a_34132_32904# result[4] 0.0225f
C1224 a_29350_41996# VDD 0.18735f
C1225 sar_ctrl_async_phys_0.sg13g2_buf_1_13.A a_32347_37447# 0.02427f
C1226 sar_ctrl_async_phys_0.sg13g2_dfrbpq_1_9.RESET_B a_33558_43922# 0.08507f
C1227 a_35672_46508# sar_ctrl_async_phys_0.dac_code_n[6] 0.24512f
C1228 a_29620_43488# VDD 0.07706f
C1229 sar_ctrl_async_phys_0.sg13g2_a21oi_1_0.A1 sar_ctrl_async_phys_0.sg13g2_a22oi_1_2.A2 0.25818f
C1230 sar_ctrl_async_phys_0.sg13g2_a22oi_1_0.A1 sar_ctrl_async_phys_0.sg13g2_nor2b_1_1.B_N 0.0207f
C1231 sar_ctrl_async_phys_0.sg13g2_a22oi_1_5.A2 a_30495_39309# 0.02018f
C1232 sar_ctrl_async_phys_0.dac_code_n[0] oa_sar8_acore18_opt_0.sw_bitcell_opt_term_1.bot 0.12842f
C1233 a_34911_41287# VDD 0.17561f
C1234 sar_ctrl_async_phys_0.sg13g2_buf_1_6.A done 0.1699f
C1235 sar_ctrl_async_phys_0.sg13g2_a22oi_1_1.A2 sar_ctrl_async_phys_0.sg13g2_a22oi_1_1.Y 0.01805f
C1236 sar_ctrl_async_phys_0.sg13g2_nor4_1_0.C sar_ctrl_async_phys_0.sg13g2_nor2b_1_0.A 0.03574f
C1237 a_31093_35935# a_31841_36285# 0.01058f
C1238 a_31195_35935# a_32192_36166# 0.03061f
C1239 sar_ctrl_async_phys_0.sg13g2_a21oi_1_6.B1 sar_ctrl_async_phys_0.sg13g2_nand2_1_3.A 0.14161f
C1240 VDD rst_n 0.13921f
C1241 sar_ctrl_async_phys_0.sg13g2_buf_1_13.X sar_ctrl_async_phys_0.sg13g2_nand3_1_0.A 0.11432f
C1242 sar_ctrl_async_phys_0.dac_code[5] a_35948_n9612# 1.25638f
C1243 oa_sar8_acore18_opt_0.sw_tg_opt_0.bot oa_sar8_acore18_opt_0.sw_bitcell_opt_b7_0.bot 59.4553f
C1244 sar_ctrl_async_phys_0.sg13g2_a21oi_1_5.B1 a_35245_45936# 0.29575f
C1245 sar_ctrl_async_phys_0.sg13g2_nand3_1_0.A sar_ctrl_async_phys_0.sg13g2_and2_1_2.X 0.13469f
C1246 a_35648_30846# result[1] 0.0139f
C1247 sar_ctrl_async_phys_0.sample oa_sar8_acore18_opt_0.bstrap_opt_w2_c1200_1.gb 18.5935f
C1248 sar_ctrl_async_phys_0.sg13g2_buf_1_6.A a_36056_38224# 0.04925f
C1249 sar_ctrl_async_phys_0.sg13g2_dfrbpq_1_0.CLK sar_ctrl_async_phys_0.sg13g2_inv_1_9.Y 0.01047f
C1250 sar_ctrl_async_phys_0.sg13g2_nor4_1_0.C a_28651_39740# 0.0114f
C1251 sar_ctrl_async_phys_0.sg13g2_a21oi_1_5.B1 a_34459_44356# 0.01571f
C1252 a_31732_45000# a_32251_45007# 0.34102f
C1253 a_32149_45007# a_32020_45421# 0.01562f
C1254 sar_ctrl_async_phys_0.sg13g2_buf_1_0.A a_31732_35480# 0.032f
C1255 sar_ctrl_async_phys_0.sg13g2_buf_1_3.A sar_ctrl_async_phys_0.sg13g2_a21oi_1_1.Y 0.12485f
C1256 sar_ctrl_async_phys_0.dac_code[6] oa_sar8_acore18_opt_0.sw_bitcell_opt_term_0.bot 0.36001f
C1257 sar_ctrl_async_phys_0.sg13g2_nand2_1_3.A sar_ctrl_async_phys_0.sg13g2_nand2_1_2.B 1.17744f
C1258 a_32580_43448# sar_ctrl_async_phys_0.sg13g2_buf_1_20.A 0.27005f
C1259 sar_ctrl_async_phys_0.sg13g2_a21oi_1_0.B1 a_34208_45966# 0.04936f
C1260 sar_ctrl_async_phys_0.sg13g2_a21oi_1_5.B1 sar_ctrl_async_phys_0.sg13g2_a21oi_1_0.A1 0.06785f
C1261 sar_ctrl_async_phys_0.sg13g2_nand2b_1_1.Y sar_ctrl_async_phys_0.sg13g2_nor2_1_15.Y 0.01563f
C1262 oa_sar8_acore18_opt_0.sw_bitcell_opt_b0_1.bot a_20412_n9612# 0.14526f
C1263 sar_ctrl_async_phys_0.sg13g2_a22oi_1_2.A2 sar_ctrl_async_phys_0.sg13g2_buf_1_4.A 0.02359f
C1264 sar_ctrl_async_phys_0.sample oa_sar8_acore18_opt_0.sw_bitcell_opt_b1_1.bot 1.6206f
C1265 sar_ctrl_async_phys_0.dac_code[2] sar_ctrl_async_phys_0.dac_code[4] 4.14156f
C1266 sar_ctrl_async_phys_0.sg13g2_buf_1_9.A sar_ctrl_async_phys_0.sg13g2_a22oi_1_0.B2 0.02459f
C1267 sar_ctrl_async_phys_0.sg13g2_dfrbpq_1_2.Q sar_ctrl_async_phys_0.sg13g2_nand2_1_1.B 0.16827f
C1268 a_34549_30605# a_35297_30703# 0.01058f
C1269 a_35391_30703# a_36058_30924# 0.0894f
C1270 sar_ctrl_async_phys_0.sg13g2_nor2b_1_4.Y a_31933_43832# 0.0149f
C1271 a_31093_39677# a_31841_39775# 0.01058f
C1272 a_31935_39775# a_32192_39918# 0.34468f
C1273 sar_ctrl_async_phys_0.sg13g2_nor2_1_12.A a_28236_40440# 0.01075f
C1274 a_33658_35460# VDD 0.38342f
C1275 result[2] result[1] 0.11092f
C1276 sar_ctrl_async_phys_0.dac_code_n[1] sar_ctrl_async_phys_0.sg13g2_nand2_1_2.A 0.02473f
C1277 sar_ctrl_async_phys_0.sg13g2_o21ai_1_1.B1 a_33948_41936# 0.24978f
C1278 sar_ctrl_async_phys_0.sg13g2_inv_1_9.Y sar_ctrl_async_phys_0.sg13g2_inv_1_10.Y 0.01833f
C1279 sar_ctrl_async_phys_0.sg13g2_a21oi_1_7.Y sar_ctrl_async_phys_0.sg13g2_dfrbpq_1_11.D 1.37495f
C1280 sar_ctrl_async_phys_0.dac_code_n[2] sar_ctrl_async_phys_0.dac_code[2] 0.06321f
C1281 sar_ctrl_async_phys_0.dac_code_n[7] oa_sar8_acore18_opt_0.sw_bitcell_opt_b2_0.bot 0.12297f
C1282 sar_ctrl_async_phys_0.sg13g2_buf_1_9.A a_32687_32876# 0.08947f
C1283 a_33754_37436# VDD 0.38063f
C1284 sar_ctrl_async_phys_0.cmp_valid sar_ctrl_async_phys_0.dac_code_n[0] 0.20157f
C1285 a_25596_43448# sar_ctrl_async_phys_0.sample 0.25174f
C1286 sar_ctrl_async_phys_0.sg13g2_nor2_1_4.Y sar_ctrl_async_phys_0.sg13g2_dlygate4sd3_1_7.X 0.17157f
C1287 sar_ctrl_async_phys_0.sg13g2_o21ai_1_1.B1 sar_ctrl_async_phys_0.sg13g2_nor2_1_12.B 0.04551f
C1288 sar_ctrl_async_phys_0.dac_code[6] m3_38288_n2380# 0.04464f
C1289 sar_ctrl_async_phys_0.sg13g2_o21ai_1_1.B1 a_34208_45966# 0.10165f
C1290 VDD busy 0.1759f
C1291 sar_ctrl_async_phys_0.sg13g2_nor2_1_1.Y a_33375_40821# 0.01047f
C1292 sar_ctrl_async_phys_0.sg13g2_inv_1_5.A a_31247_32876# 0.15819f
C1293 sar_ctrl_async_phys_0.sg13g2_buf_1_7.A a_33464_31388# 0.28142f
C1294 w_39600_n9960# a_35948_n9612# 5.05953f
C1295 sar_ctrl_async_phys_0.sg13g2_nand2_1_0.Y sar_ctrl_async_phys_0.sg13g2_buf_1_2.A 0.3177f
C1296 a_33818_43452# VDD 0.0963f
C1297 a_32288_31630# a_32031_31749# 0.34468f
C1298 a_30507_35204# a_31007_35460# 0.03308f
C1299 a_30830_35166# a_30733_35460# 0.02903f
C1300 a_30200_35294# a_30384_35294# 0.0524f
C1301 a_25596_47222# sar_ctrl_async_phys_0.sg13g2_buf_1_29.A 0.2591f
C1302 sar_ctrl_async_phys_0.sg13g2_nor4_1_0.C sar_ctrl_async_phys_0.sg13g2_nor2b_1_3.Y 1.39394f
C1303 sar_ctrl_async_phys_0.sg13g2_inv_1_3.Y a_33464_31388# 0.01022f
C1304 sar_ctrl_async_phys_0.sg13g2_inv_1_0.A a_33183_32215# 0.01138f
C1305 a_36058_32900# VDD 0.37733f
C1306 sar_ctrl_async_phys_0.sg13g2_buf_1_13.A a_32245_37447# 0.03705f
C1307 sar_ctrl_async_phys_0.sg13g2_and2_1_5.X sar_ctrl_async_phys_0.sg13g2_a21oi_1_7.A2 0.84023f
C1308 sar_ctrl_async_phys_0.sg13g2_buf_1_6.A a_35288_33688# 0.01284f
C1309 sar_ctrl_async_phys_0.sg13g2_buf_1_32.A a_33654_44234# 0.0151f
C1310 sar_ctrl_async_phys_0.sg13g2_buf_1_13.X sar_ctrl_async_phys_0.sg13g2_nor2_1_3.B 0.29161f
C1311 sar_ctrl_async_phys_0.sg13g2_and2_1_2.X sar_ctrl_async_phys_0.sg13g2_nor2_1_3.B 0.29369f
C1312 sar_ctrl_async_phys_0.sg13g2_buf_1_3.A a_33752_33688# 0.02442f
C1313 sar_ctrl_async_phys_0.sg13g2_nor4_1_0.C VDD 0.93456f
C1314 sar_ctrl_async_phys_0.dac_code_n[4] sar_ctrl_async_phys_0.dac_code_n[5] 26.7773f
C1315 a_31542_37874# a_31802_37404# 0.75507f
C1316 sar_ctrl_async_phys_0.sg13g2_buf_1_21.A a_36056_38224# 0.26029f
C1317 sar_ctrl_async_phys_0.sg13g2_buf_1_4.A a_35360_36894# 0.0376f
C1318 sar_ctrl_async_phys_0.sg13g2_buf_1_5.A a_31924_32456# 0.01278f
C1319 sar_ctrl_async_phys_0.sg13g2_nor2_1_3.B track 0.02848f
C1320 sar_ctrl_async_phys_0.sg13g2_nor4_1_0.C sar_ctrl_async_phys_0.sg13g2_buf_1_35.A 0.0195f
C1321 a_26270_39215# a_26385_39214# 0.55452f
C1322 a_35391_34773# busy 0.01881f
C1323 a_30390_36362# a_31195_35935# 0.097f
C1324 a_30676_35928# a_31093_35935# 0.37583f
C1325 sar_ctrl_async_phys_0.dac_code_n[1] oa_sar8_acore18_opt_0.sw_tg_opt_0.bot 0.15719f
C1326 a_32480_46750# a_32223_46869# 0.34468f
C1327 VDD result[4] 0.24258f
C1328 sar_ctrl_async_phys_0.sg13g2_inv_1_1.A sar_ctrl_async_phys_0.sg13g2_buf_1_9.A 0.30856f
C1329 a_34106_30849# result[1] 0.01891f
C1330 sar_ctrl_async_phys_0.sg13g2_a21oi_1_1.B1 sar_ctrl_async_phys_0.sg13g2_a21oi_1_6.B1 0.31301f
C1331 sar_ctrl_async_phys_0.sg13g2_a21oi_1_5.B1 a_34904_47296# 0.26401f
C1332 sar_ctrl_async_phys_0.sg13g2_nor2_1_0.Y sar_ctrl_async_phys_0.sg13g2_a21oi_1_7.Y 0.01085f
C1333 sar_ctrl_async_phys_0.sg13g2_and2_1_5.X sar_ctrl_async_phys_0.sg13g2_dfrbpq_1_2.Q 0.01453f
C1334 a_31446_45434# a_31732_45000# 0.41329f
C1335 sar_ctrl_async_phys_0.sg13g2_dfrbpq_1_0.CLK a_31040_40702# 0.01421f
C1336 sar_ctrl_async_phys_0.sg13g2_o21ai_1_1.B1 a_32576_44454# 0.04119f
C1337 sar_ctrl_async_phys_0.sg13g2_buf_1_13.X sar_ctrl_async_phys_0.sg13g2_buf_1_0.A 0.12884f
C1338 sar_ctrl_async_phys_0.sg13g2_nor2_1_0.A a_31542_37874# 0.32603f
C1339 sar_ctrl_async_phys_0.sample oa_sar8_acore18_opt_0.sw_bitcell_opt_b5_1.bot 1.83229f
C1340 sar_ctrl_async_phys_0.sg13g2_a21oi_1_1.B1 sar_ctrl_async_phys_0.sg13g2_nand2_1_2.B 0.02014f
C1341 sar_ctrl_async_phys_0.sg13g2_a21oi_1_2.B1 a_29808_39830# 0.01816f
C1342 sar_ctrl_async_phys_0.sg13g2_a22oi_1_2.A2 a_32347_37447# 0.01035f
C1343 sar_ctrl_async_phys_0.sg13g2_buf_1_9.A a_32341_32117# 0.03489f
C1344 sar_ctrl_async_phys_0.sg13g2_buf_1_13.X a_25596_41174# 0.01547f
C1345 sar_ctrl_async_phys_0.sg13g2_buf_1_3.A sar_ctrl_async_phys_0.sg13g2_buf_1_22.A 0.28128f
C1346 sar_ctrl_async_phys_0.sg13g2_dfrbpq_1_2.Q sar_ctrl_async_phys_0.sg13g2_buf_1_23.A 0.08819f
C1347 a_32149_35141# VDD 0.25831f
C1348 sar_ctrl_async_phys_0.sg13g2_dfrbpq_1_0.CLK a_33211_45868# 0.01841f
C1349 sar_ctrl_async_phys_0.sg13g2_a21oi_1_1.Y a_34106_32868# 0.01866f
C1350 a_26954_40424# a_26673_40726# 0.26306f
C1351 sar_ctrl_async_phys_0.sg13g2_dfrbpq_1_22.D a_31093_39677# 0.01489f
C1352 sar_ctrl_async_phys_0.dac_code_n[7] oa_sar8_acore18_opt_0.sw_bitcell_opt_b7_1.VSS 1.51874f
C1353 a_33846_33338# a_34106_32868# 0.75507f
C1354 oa_sar8_acore18_opt_0.sw_tg_opt_0.bot vcm 3.53635f
C1355 a_29258_36642# sar_ctrl_async_phys_0.sg13g2_dlygate4sd3_1_0.X 0.4338f
C1356 a_28774_41278# VDD 0.19082f
C1357 sar_ctrl_async_phys_0.bit_active[6] sar_ctrl_async_phys_0.sg13g2_a22oi_1_0.A2 0.16426f
C1358 a_32666_45969# a_32406_45746# 0.75507f
C1359 a_33850_32436# VDD 0.38026f
C1360 a_34904_46508# VDD 0.22009f
C1361 sar_ctrl_async_phys_0.sg13g2_buf_1_13.X sar_ctrl_async_phys_0.sg13g2_nor2_1_10.B 2.40093f
C1362 sar_ctrl_async_phys_0.sg13g2_o21ai_1_1.B1 a_33652_41528# 0.41606f
C1363 oa_sar8_acore18_opt_0.sw_bitcell_opt_term_0.vin m3_41836_n2380# 0.05057f
C1364 a_33558_43922# VDD 0.77403f
C1365 sar_ctrl_async_phys_0.sg13g2_buf_1_34.A sar_ctrl_async_phys_0.sg13g2_buf_1_33.A 0.15484f
C1366 sar_ctrl_async_phys_0.sg13g2_a22oi_1_0.A1 sar_ctrl_async_phys_0.sg13g2_a22oi_1_0.B1 2.10579f
C1367 a_30772_31392# a_31291_31399# 0.34102f
C1368 a_31189_31399# a_31060_31813# 0.01562f
C1369 sar_ctrl_async_phys_0.bit_active[7] VDD 0.19009f
C1370 sar_ctrl_async_phys_0.sg13g2_and2_1_2.X a_26184_39702# 0.02461f
C1371 sar_ctrl_async_phys_0.dac_code[5] oa_sar8_acore18_opt_0.sw_bitcell_opt_b7_0.bot 2.3546f
C1372 a_26673_40726# VDD 0.2264f
C1373 a_31823_32876# VDD 0.30319f
C1374 sar_ctrl_async_phys_0.sg13g2_a21oi_1_5.B1 sar_ctrl_async_phys_0.sg13g2_buf_1_14.A 0.11518f
C1375 sar_ctrl_async_phys_0.sg13g2_buf_1_3.A sar_ctrl_async_phys_0.sg13g2_a21oi_1_0.B1 0.36777f
C1376 a_33632_40702# a_34042_40460# 0.10373f
C1377 a_30229_33629# a_30977_33727# 0.01058f
C1378 a_31071_33727# a_31738_33948# 0.0894f
C1379 sar_ctrl_async_phys_0.sg13g2_nor2b_1_0.A sar_ctrl_async_phys_0.bit_active[6] 0.01207f
C1380 sar_ctrl_async_phys_0.dac_code_n[0] sar_ctrl_async_phys_0.dac_code[1] 0.06405f
C1381 sar_ctrl_async_phys_0.sg13g2_a21oi_1_7.Y sar_ctrl_async_phys_0.sg13g2_a22oi_1_2.B1 0.048f
C1382 sar_ctrl_async_phys_0.sg13g2_a21oi_1_0.A1 sar_ctrl_async_phys_0.sg13g2_a22oi_1_0.A1 0.0386f
C1383 sar_ctrl_async_phys_0.sg13g2_dfrbpq_1_0.CLK a_31579_44356# 0.04588f
C1384 sar_ctrl_async_phys_0.dac_code_n[7] oa_sar8_acore18_opt_0.sw_bitcell_opt_b2_1.bot 0.15756f
C1385 a_34136_47296# a_33944_47390# 0.01226f
C1386 sar_ctrl_async_phys_0.sg13g2_and2_1_2.X a_26352_38318# 0.0171f
C1387 sar_ctrl_async_phys_0.dac_code_n[6] oa_sar8_acore18_opt_0.sw_bitcell_opt_term_0.VSS 0.01787f
C1388 sar_ctrl_async_phys_0.sg13g2_buf_1_6.A a_35280_35365# 0.14235f
C1389 sar_ctrl_async_phys_0.sg13g2_a22oi_1_1.B2 sar_ctrl_async_phys_0.sg13g2_inv_1_1.Y 0.07292f
C1390 sar_ctrl_async_phys_0.sg13g2_a21oi_1_0.B1 sar_ctrl_async_phys_0.dac_code[1] 0.16456f
C1391 sar_ctrl_async_phys_0.sg13g2_dfrbpq_1_11.D a_31935_39775# 0.02895f
C1392 sar_ctrl_async_phys_0.sg13g2_buf_1_23.A sar_ctrl_async_phys_0.sg13g2_a21oi_1_1.Y 0.05023f
C1393 sar_ctrl_async_phys_0.dac_code_n[3] oa_sar8_acore18_opt_0.sw_bitcell_opt_term_0.VSS 0.07008f
C1394 sar_ctrl_async_phys_0.hold_req sar_ctrl_async_phys_0.dac_code_n[6] 0.05239f
C1395 sar_ctrl_async_phys_0.sg13g2_nor2_1_12.A track 0.01114f
C1396 sar_ctrl_async_phys_0.sg13g2_dfrbpq_1_17.D a_30384_31474# 0.03037f
C1397 sar_ctrl_async_phys_0.dac_code_n[7] sar_ctrl_async_phys_0.cmp_n 0.06815f
C1398 sar_ctrl_async_phys_0.sg13g2_buf_1_3.A sar_ctrl_async_phys_0.sg13g2_o21ai_1_1.B1 0.03625f
C1399 sar_ctrl_async_phys_0.sg13g2_a21oi_1_0.A1 a_35595_40460# 0.053f
C1400 sar_ctrl_async_phys_0.hold_req sar_ctrl_async_phys_0.dac_code_n[3] 0.06169f
C1401 sar_ctrl_async_phys_0.sg13g2_a22oi_1_0.B1 sar_ctrl_async_phys_0.sg13g2_buf_1_7.A 0.01936f
C1402 oa_sar8_acore18_opt_0.sw_bitcell_opt_term_0.trkb oa_sar8_acore18_opt_0.sw_bitcell_opt_term_0.VSS 0.57977f
C1403 sar_ctrl_async_phys_0.sg13g2_a21oi_1_6.B1 sar_ctrl_async_phys_0.sg13g2_nor2_1_1.Y 0.02767f
C1404 sar_ctrl_async_phys_0.sg13g2_dlygate4sd3_1_4.A sar_ctrl_async_phys_0.sg13g2_nand3_1_0.A 0.2861f
C1405 sar_ctrl_async_phys_0.sg13g2_nor2b_1_3.Y a_33281_40821# 0.02275f
C1406 sar_ctrl_async_phys_0.sg13g2_nor2b_1_0.A sar_ctrl_async_phys_0.sg13g2_a21oi_1_2.A2 0.03556f
C1407 sar_ctrl_async_phys_0.sg13g2_a21oi_1_6.A2 a_32986_44532# 0.05455f
C1408 sar_ctrl_async_phys_0.hold_req oa_sar8_acore18_opt_0.sw_bitcell_opt_term_0.trkb 0.18928f
C1409 sar_ctrl_async_phys_0.sg13g2_a21oi_1_6.B1 sar_ctrl_async_phys_0.sg13g2_a22oi_1_1.A2 0.34964f
C1410 sar_ctrl_async_phys_0.sg13g2_o21ai_1_1.B1 a_29498_40428# 0.27312f
C1411 a_27134_39887# VDD 0.18836f
C1412 sar_ctrl_async_phys_0.sg13g2_a22oi_1_5.Y VDD 0.28437f
C1413 sar_ctrl_async_phys_0.sg13g2_a22oi_1_5.A2 a_30390_36362# 0.03f
C1414 sar_ctrl_async_phys_0.sg13g2_a22oi_1_0.A1 sar_ctrl_async_phys_0.sg13g2_buf_1_4.A 0.05818f
C1415 a_36056_42760# sar_ctrl_async_phys_0.dac_code[3] 0.24511f
C1416 a_29144_39830# a_29328_39830# 0.0524f
C1417 w_16692_n9960# sar_ctrl_async_phys_0.dac_code_n[7] 0.01571f
C1418 sar_ctrl_async_phys_0.sg13g2_a22oi_1_0.B1 sar_ctrl_async_phys_0.sg13g2_inv_1_3.Y 0.01709f
C1419 sar_ctrl_async_phys_0.sg13g2_dfrbpq_1_0.CLK result[3] 0.05627f
C1420 sar_ctrl_async_phys_0.sg13g2_a21oi_1_0.B1 sar_ctrl_async_phys_0.sg13g2_buf_1_20.A 0.02452f
C1421 a_35456_44454# a_35866_44532# 0.10373f
C1422 a_26270_39215# VDD 0.18567f
C1423 sar_ctrl_async_phys_0.sg13g2_a22oi_1_5.A2 a_30390_39698# 0.05134f
C1424 a_31924_32456# VDD 0.07252f
C1425 sar_ctrl_async_phys_0.sg13g2_nand2b_1_2.A_N VDD 0.63094f
C1426 oa_sar8_acore18_opt_0.sw_bitcell_opt_b4_0.bot oa_sar8_acore18_opt_0.sw_bitcell_opt_term_0.VSS 1.93948f
C1427 a_35463_31435# result[2] 0.03128f
C1428 sar_ctrl_async_phys_0.sg13g2_nor2_1_1.Y a_33556_40016# 0.02189f
C1429 sar_ctrl_async_phys_0.sg13g2_buf_1_23.A sar_ctrl_async_phys_0.bit_active[2] 0.03259f
C1430 sar_ctrl_async_phys_0.sg13g2_buf_1_35.A sar_ctrl_async_phys_0.sg13g2_nand2b_1_2.A_N 0.12027f
C1431 a_30486_31826# a_30772_31392# 0.41329f
C1432 sar_ctrl_async_phys_0.hold_req oa_sar8_acore18_opt_0.sw_bitcell_opt_b4_0.bot 0.10625f
C1433 sar_ctrl_async_phys_0.dac_code[6] oa_sar8_acore18_opt_0.sw_bitcell_opt_term_0.vin 2.07616f
C1434 sar_ctrl_async_phys_0.sg13g2_a22oi_1_2.B1 a_31640_34498# 0.02901f
C1435 sar_ctrl_async_phys_0.hold_req sar_ctrl_async_phys_0.cmp_p 0.26979f
C1436 sar_ctrl_async_phys_0.sg13g2_buf_1_6.A a_33652_41528# 0.01469f
C1437 sar_ctrl_async_phys_0.sg13g2_a22oi_1_2.A2 sar_ctrl_async_phys_0.sg13g2_buf_1_0.A 0.03114f
C1438 sar_ctrl_async_phys_0.sg13g2_a22oi_1_0.A1 sar_ctrl_async_phys_0.sg13g2_buf_1_8.A 0.13948f
C1439 sar_ctrl_async_phys_0.dac_code_n[1] sar_ctrl_async_phys_0.dac_code[5] 0.05494f
C1440 a_34132_30944# VDD 0.07206f
C1441 sar_ctrl_async_phys_0.sg13g2_a21oi_1_6.A2 a_32406_45746# 0.05305f
C1442 sar_ctrl_async_phys_0.sg13g2_nor2_1_5.Y a_28368_36877# 0.02459f
C1443 sar_ctrl_async_phys_0.dac_code_n[5] oa_sar8_acore18_opt_0.sw_tg_opt_0.bot 0.79013f
C1444 sar_ctrl_async_phys_0.sg13g2_nor2_1_4.Y a_26550_41214# 0.06483f
C1445 a_28977_36864# VDD 0.2281f
C1446 sar_ctrl_async_phys_0.sg13g2_o21ai_1_1.B1 sar_ctrl_async_phys_0.sg13g2_buf_1_20.A 0.20488f
C1447 sar_ctrl_async_phys_0.sg13g2_dfrbpq_1_0.CLK a_31732_35480# 0.09095f
C1448 sar_ctrl_async_phys_0.dac_code[2] m3_41836_n2380# 0.04566f
C1449 sar_ctrl_async_phys_0.sg13g2_a21oi_1_0.B1 sar_ctrl_async_phys_0.sg13g2_nand2_1_1.B 0.01123f
C1450 sar_ctrl_async_phys_0.sg13g2_a22oi_1_5.Y a_29851_32260# 0.01599f
C1451 a_36152_43570# a_36336_43570# 0.0524f
C1452 sar_ctrl_async_phys_0.sg13g2_a22oi_1_0.Y result[5] 0.04607f
C1453 sar_ctrl_async_phys_0.sg13g2_nor2_1_0.Y a_31935_39775# 0.01677f
C1454 sar_ctrl_async_phys_0.bit_active[6] VDD 0.261f
C1455 sar_ctrl_async_phys_0.sg13g2_buf_1_3.A a_33750_36362# 0.03313f
C1456 a_32533_40471# a_32635_40471# 0.47795f
C1457 sar_ctrl_async_phys_0.sg13g2_nor2b_1_0.A a_31716_38912# 0.07761f
C1458 sar_ctrl_async_phys_0.sg13g2_nand2b_1_2.Y a_34765_42242# 0.12249f
C1459 sar_ctrl_async_phys_0.sg13g2_buf_1_2.X a_33248_35382# 0.10165f
C1460 sar_ctrl_async_phys_0.dac_code_n[7] oa_sar8_acore18_opt_0.sw_bitcell_opt_b6_1.bot 0.13944f
C1461 sar_ctrl_async_phys_0.sg13g2_a21oi_1_7.A2 a_32984_39830# 0.0243f
C1462 sar_ctrl_async_phys_0.sg13g2_dfrbpq_1_0.CLK a_28662_41214# 0.03593f
C1463 sar_ctrl_async_phys_0.sg13g2_nor4_1_0.C sar_ctrl_async_phys_0.sg13g2_a22oi_1_3.A2 0.01183f
C1464 sar_ctrl_async_phys_0.sg13g2_buf_1_3.A a_33530_39921# 0.01438f
C1465 a_30591_32215# a_30497_32215# 0.28931f
C1466 oa_sar8_acore18_opt_0.sw_bitcell_opt_b3_0.bot oa_sar8_acore18_opt_0.sw_bitcell_opt_term_0.gb 0.62478f
C1467 sar_ctrl_async_phys_0.sg13g2_buf_1_3.A a_33844_36992# 0.04556f
C1468 sar_ctrl_async_phys_0.sg13g2_nand2b_1_1.Y a_35866_44532# 0.04126f
C1469 sar_ctrl_async_phys_0.dac_code_n[1] a_20412_n9612# 1.18204f
C1470 sar_ctrl_async_phys_0.sg13g2_nor2_1_10.Y a_29238_40898# 0.28068f
C1471 sar_ctrl_async_phys_0.sg13g2_nand2_1_6.B VDD 0.44959f
C1472 sar_ctrl_async_phys_0.sg13g2_buf_1_2.A a_29701_36874# 0.16422f
C1473 a_30139_43495# a_31136_43726# 0.03061f
C1474 sar_ctrl_async_phys_0.sg13g2_nand2_1_3.A sar_ctrl_async_phys_0.sg13g2_nand2b_1_3.Y 0.0835f
C1475 sar_ctrl_async_phys_0.sg13g2_a21oi_1_2.A2 VDD 0.47894f
C1476 a_36056_35200# sar_ctrl_async_phys_0.bit_active[3] 0.08833f
C1477 sar_ctrl_async_phys_0.sg13g2_buf_1_7.A sar_ctrl_async_phys_0.sg13g2_buf_1_8.A 0.01403f
C1478 sar_ctrl_async_phys_0.sg13g2_buf_1_5.A sar_ctrl_async_phys_0.sg13g2_inv_1_0.Y 0.04631f
C1479 sar_ctrl_async_phys_0.sg13g2_a21oi_1_2.B1 a_34069_41189# 0.02265f
C1480 sar_ctrl_async_phys_0.sg13g2_buf_1_13.X sar_ctrl_async_phys_0.sg13g2_nor2_1_3.Y 0.0208f
C1481 sar_ctrl_async_phys_0.sg13g2_buf_1_3.A sar_ctrl_async_phys_0.sg13g2_buf_1_6.A 0.01874f
C1482 sar_ctrl_async_phys_0.sg13g2_nor2b_1_3.Y a_32533_40471# 0.01302f
C1483 done busy 0.17133f
C1484 sar_ctrl_async_phys_0.sg13g2_buf_1_23.A sar_ctrl_async_phys_0.sg13g2_buf_1_22.A 0.05774f
C1485 oa_sar8_acore18_opt_0.sw_bitcell_opt_term_0.trkb vinp 0.14725f
C1486 a_35245_45936# sar_ctrl_async_phys_0.sg13g2_nand2_1_3.A 0.25625f
C1487 a_30480_42854# VDD 0.07103f
C1488 sar_ctrl_async_phys_0.sg13g2_buf_1_0.A a_34549_34423# 0.01061f
C1489 sar_ctrl_async_phys_0.sg13g2_buf_1_2.X a_35391_33261# 0.13517f
C1490 sar_ctrl_async_phys_0.sg13g2_buf_1_4.A sar_ctrl_async_phys_0.bit_active[3] 1.32795f
C1491 sar_ctrl_async_phys_0.sg13g2_nand2_1_3.A a_34459_44356# 0.01102f
C1492 sar_ctrl_async_phys_0.sg13g2_a22oi_1_3.A2 a_32149_35141# 0.01742f
C1493 sar_ctrl_async_phys_0.sg13g2_and2_1_0.B sar_ctrl_async_phys_0.bit_active[3] 0.02618f
C1494 a_29786_33873# a_29812_33968# 0.36952f
C1495 sar_ctrl_async_phys_0.sg13g2_inv_1_5.Y a_29526_33650# 0.28964f
C1496 sar_ctrl_async_phys_0.sg13g2_a21oi_1_6.A2 a_33179_43832# 0.01025f
C1497 sar_ctrl_async_phys_0.sg13g2_inv_1_3.Y sar_ctrl_async_phys_0.sg13g2_buf_1_8.A 1.02878f
C1498 a_35552_36166# sar_ctrl_async_phys_0.bit_active[2] 0.01001f
C1499 a_32533_40471# VDD 0.24855f
C1500 a_29812_33968# VDD 0.07436f
C1501 sar_ctrl_async_phys_0.sg13g2_a22oi_1_1.A2 a_31841_36285# 0.01339f
C1502 sar_ctrl_async_phys_0.sg13g2_nor2_1_1.A a_33344_37678# 0.02887f
C1503 a_33940_44552# a_35199_44311# 0.01529f
C1504 sar_ctrl_async_phys_0.sg13g2_nand2_1_3.A sar_ctrl_async_phys_0.sg13g2_a21oi_1_0.A1 0.50868f
C1505 sar_ctrl_async_phys_0.sg13g2_nor2_1_11.A sar_ctrl_async_phys_0.sg13g2_a22oi_1_5.A2 0.21896f
C1506 oa_sar8_acore18_opt_0.sw_bitcell_opt_b0_0.bot oa_sar8_acore18_opt_0.sw_bitcell_opt_term_0.VSS 1.37505f
C1507 a_30848_32358# VDD 0.16874f
C1508 a_27624_35965# VDD 0.34255f
C1509 sar_ctrl_async_phys_0.dac_code_n[7] oa_sar8_acore18_opt_0.sw_bitcell_opt_term_1.bot 0.72747f
C1510 sar_ctrl_async_phys_0.bit_active[6] sar_ctrl_async_phys_0.sg13g2_a21oi_1_0.A2 0.01988f
C1511 sar_ctrl_async_phys_0.hold_req oa_sar8_acore18_opt_0.sw_bitcell_opt_b0_0.bot 0.13521f
C1512 sar_ctrl_async_phys_0.dac_code_n[6] sar_ctrl_async_phys_0.dac_code[0] 0.07967f
C1513 sar_ctrl_async_phys_0.sg13g2_nor2b_1_0.A a_34075_39820# 0.0125f
C1514 sar_ctrl_async_phys_0.sg13g2_buf_1_2.X result[3] 2.15139f
C1515 sar_ctrl_async_phys_0.dac_code_n[0] sar_ctrl_async_phys_0.dac_code[4] 0.06405f
C1516 a_35672_46508# sar_ctrl_async_phys_0.sg13g2_buf_1_34.A 0.02417f
C1517 sar_ctrl_async_phys_0.dac_code_n[3] sar_ctrl_async_phys_0.dac_code[0] 0.21181f
C1518 sar_ctrl_async_phys_0.sg13g2_buf_1_3.A a_34520_42760# 0.01584f
C1519 sar_ctrl_async_phys_0.sg13g2_a22oi_1_0.A1 a_34651_32911# 0.05294f
C1520 sar_ctrl_async_phys_0.sg13g2_a21oi_1_0.B1 sar_ctrl_async_phys_0.sg13g2_and2_1_5.X 1.5328f
C1521 sar_ctrl_async_phys_0.sg13g2_nor2_1_7.B sar_ctrl_async_phys_0.sg13g2_buf_1_2.A 0.05014f
C1522 sar_ctrl_async_phys_0.sg13g2_dfrbpq_1_9.RESET_B a_30964_46512# 0.39153f
C1523 sar_ctrl_async_phys_0.dac_code[0] oa_sar8_acore18_opt_0.sw_bitcell_opt_term_0.trkb 1.76704f
C1524 sar_ctrl_async_phys_0.sg13g2_buf_1_2.A sar_ctrl_async_phys_0.sg13g2_buf_1_25.A 0.2652f
C1525 sar_ctrl_async_phys_0.sg13g2_buf_1_13.A a_33270_39698# 0.03019f
C1526 sar_ctrl_async_phys_0.sg13g2_buf_1_16.A a_34420_34837# 0.01262f
C1527 sar_ctrl_async_phys_0.dac_code_n[6] VDD 5.60576f
C1528 sar_ctrl_async_phys_0.sg13g2_dfrbpq_1_0.CLK sar_ctrl_async_phys_0.sg13g2_buf_1_13.A 1.66016f
C1529 sar_ctrl_async_phys_0.sg13g2_dfrbpq_1_0.CLK sar_ctrl_async_phys_0.sg13g2_buf_1_13.X 0.89065f
C1530 sar_ctrl_async_phys_0.sg13g2_nor2_1_2.Y a_33948_41936# 0.01544f
C1531 sar_ctrl_async_phys_0.dac_code_n[0] sar_ctrl_async_phys_0.dac_code_n[2] 0.16846f
C1532 sar_ctrl_async_phys_0.sg13g2_buf_1_23.A a_34324_36349# 0.01318f
C1533 a_31716_38912# VDD 0.19209f
C1534 sar_ctrl_async_phys_0.sg13g2_o21ai_1_1.A2 sar_ctrl_async_phys_0.sg13g2_nor2_1_7.B 0.05181f
C1535 sar_ctrl_async_phys_0.sg13g2_buf_1_20.A sar_ctrl_async_phys_0.sg13g2_buf_1_6.A 0.16043f
C1536 sar_ctrl_async_phys_0.sg13g2_a21oi_1_0.B1 sar_ctrl_async_phys_0.sg13g2_buf_1_23.A 0.02472f
C1537 sar_ctrl_async_phys_0.dac_code_n[3] VDD 4.67091f
C1538 sar_ctrl_async_phys_0.sg13g2_buf_1_13.X a_25878_40460# 0.0651f
C1539 sar_ctrl_async_phys_0.sg13g2_nand3_1_0.A sar_ctrl_async_phys_0.sg13g2_nand3_1_0.Y 0.24509f
C1540 sar_ctrl_async_phys_0.dac_code[2] sar_ctrl_async_phys_0.dac_code[6] 1.03175f
C1541 a_31830_40898# a_32533_40471# 0.02432f
C1542 sar_ctrl_async_phys_0.sg13g2_nand2_1_0.Y a_28272_37522# 0.01646f
C1543 sar_ctrl_async_phys_0.dac_code_n[6] sar_ctrl_async_phys_0.sg13g2_buf_1_35.A 0.14439f
C1544 a_34520_42760# sar_ctrl_async_phys_0.dac_code[1] 0.24516f
C1545 sar_ctrl_async_phys_0.sg13g2_nand2_1_3.Y a_36056_38948# 0.26162f
C1546 oa_sar8_acore18_opt_0.sw_tg_opt_1.bot oa_sar8_acore18_opt_0.sw_bitcell_opt_b3_1.bot 3.21544f
C1547 a_31706_35385# a_32149_35141# 0.02242f
C1548 sar_ctrl_async_phys_0.sg13g2_buf_1_2.X a_31732_35480# 0.417f
C1549 a_31450_40460# sar_ctrl_async_phys_0.sg13g2_dfrbpq_1_11.D 0.0106f
C1550 oa_sar8_acore18_opt_0.sw_bitcell_opt_term_0.bot oa_sar8_acore18_opt_0.sw_bitcell_opt_term_0.gb 0.60025f
C1551 sar_ctrl_async_phys_0.dac_code_n[3] sar_ctrl_async_phys_0.sg13g2_buf_1_35.A 0.02044f
C1552 oa_sar8_acore18_opt_0.sw_bitcell_opt_term_0.trkb VDD 44.7664f
C1553 sar_ctrl_async_phys_0.sg13g2_o21ai_1_1.B1 sar_ctrl_async_phys_0.sg13g2_and2_1_5.X 0.04034f
C1554 a_29046_32138# a_29620_32151# 0.31978f
C1555 a_29851_32260# a_30848_32358# 0.02979f
C1556 sar_ctrl_async_phys_0.sg13g2_dfrbpq_1_0.CLK a_31638_32138# 0.07258f
C1557 sar_ctrl_async_phys_0.sg13g2_a21oi_1_2.A2 a_31162_38948# 0.13268f
C1558 sar_ctrl_async_phys_0.sg13g2_nand2_1_3.B a_33654_44234# 0.01147f
C1559 sar_ctrl_async_phys_0.sg13g2_inv_1_0.A a_35384_32176# 0.02237f
C1560 sar_ctrl_async_phys_0.sg13g2_a21oi_1_2.B1 a_29524_40464# 0.03014f
C1561 sar_ctrl_async_phys_0.sg13g2_dfrbpq_1_9.RESET_B sar_ctrl_async_phys_0.sg13g2_a21oi_1_6.A2 0.08674f
C1562 sar_ctrl_async_phys_0.dac_code[0] oa_sar8_acore18_opt_0.sw_bitcell_opt_b4_0.bot 0.36692f
C1563 sar_ctrl_async_phys_0.dac_code_n[6] oa_sar8_acore18_opt_0.sw_bitcell_opt_b6_0.bot 1.20728f
C1564 sar_ctrl_async_phys_0.sg13g2_buf_1_13.X a_29236_38952# 0.01275f
C1565 sar_ctrl_async_phys_0.sg13g2_nor2_1_1.Y sar_ctrl_async_phys_0.sg13g2_nor2_1_1.A 0.08647f
C1566 sar_ctrl_async_phys_0.sg13g2_a21oi_1_1.Y a_33846_34850# 0.04077f
C1567 sar_ctrl_async_phys_0.sg13g2_buf_1_2.X a_33440_32358# 0.10406f
C1568 sar_ctrl_async_phys_0.sg13g2_a21oi_1_1.Y a_34363_36796# 0.02801f
C1569 sar_ctrl_async_phys_0.dac_code_n[3] oa_sar8_acore18_opt_0.sw_bitcell_opt_b6_0.bot 1.1155f
C1570 sar_ctrl_async_phys_0.sg13g2_a21oi_1_0.B1 a_34904_38948# 0.0437f
C1571 sar_ctrl_async_phys_0.sg13g2_buf_1_6.A sar_ctrl_async_phys_0.sg13g2_nand2_1_1.B 0.31129f
C1572 sar_ctrl_async_phys_0.sg13g2_nor2_1_11.A a_30037_43495# 0.03885f
C1573 sar_ctrl_async_phys_0.sg13g2_a21oi_1_1.B1 sar_ctrl_async_phys_0.sg13g2_nand2b_1_3.Y 0.02945f
C1574 a_34424_35200# sar_ctrl_async_phys_0.bit_active[0] 0.24751f
C1575 sar_ctrl_async_phys_0.sg13g2_a22oi_1_0.Y sar_ctrl_async_phys_0.sg13g2_a22oi_1_0.B2 0.20188f
C1576 sar_ctrl_async_phys_0.sg13g2_inv_1_9.Y sar_ctrl_async_phys_0.sg13g2_dlygate4sd3_1_8.A 0.08132f
C1577 oa_sar8_acore18_opt_0.sw_bitcell_opt_term_0.trkb oa_sar8_acore18_opt_0.sw_bitcell_opt_b6_0.bot 1.46562f
C1578 oa_sar8_acore18_opt_0.sw_bitcell_opt_term_0.gb m3_38288_n2380# 1.70313f
C1579 sar_ctrl_async_phys_0.sg13g2_nor2_1_3.B a_27304_38928# 0.01074f
C1580 oa_sar8_acore18_opt_0.sw_bitcell_opt_b4_0.bot VDD 3.42666f
C1581 a_32341_32117# a_33089_32215# 0.01058f
C1582 sar_ctrl_async_phys_0.cmp_p VDD 6.89721f
C1583 sar_ctrl_async_phys_0.sg13g2_a21oi_1_4.B1 sar_ctrl_async_phys_0.sg13g2_nand2_1_3.A 0.02287f
C1584 sar_ctrl_async_phys_0.dac_code_n[5] sar_ctrl_async_phys_0.dac_code[5] 0.06261f
C1585 sar_ctrl_async_phys_0.sg13g2_a21oi_1_1.B1 a_35245_45936# 0.04263f
C1586 a_35168_41430# a_35578_41508# 0.10373f
C1587 a_35028_n9612# vinn 0.80795f
C1588 sar_ctrl_async_phys_0.sg13g2_a21oi_1_1.B1 a_34459_44356# 0.01146f
C1589 sar_ctrl_async_phys_0.sg13g2_nand2b_1_1.Y sar_ctrl_async_phys_0.sg13g2_nor2_1_0.Y 0.01856f
C1590 a_34075_39820# VDD 0.20685f
C1591 sar_ctrl_async_phys_0.sg13g2_a21oi_1_1.B1 sar_ctrl_async_phys_0.sg13g2_a21oi_1_0.A1 0.08343f
C1592 sar_ctrl_async_phys_0.sg13g2_buf_1_14.A sar_ctrl_async_phys_0.bit_active[3] 0.12605f
C1593 sar_ctrl_async_phys_0.sg13g2_a22oi_1_3.A2 a_33281_40821# 0.01276f
C1594 a_35770_36972# VDD 0.38054f
C1595 sar_ctrl_async_phys_0.sg13g2_a21oi_1_5.B1 sar_ctrl_async_phys_0.sg13g2_nand2_1_2.A 0.48784f
C1596 sar_ctrl_async_phys_0.sg13g2_nand2b_1_0.A_N a_28651_39740# 0.17348f
C1597 a_33464_31388# result[2] 0.10553f
C1598 a_36056_38224# sar_ctrl_async_phys_0.bit_active[7] 0.09117f
C1599 oa_sar8_acore18_opt_0.sw_bitcell_opt_b6_0.bot oa_sar8_acore18_opt_0.sw_bitcell_opt_b4_0.bot 0.87004f
C1600 sar_ctrl_async_phys_0.sg13g2_buf_1_13.A a_32602_35924# 0.11497f
C1601 sar_ctrl_async_phys_0.sg13g2_a22oi_1_0.A1 a_34549_32911# 0.01365f
C1602 sar_ctrl_async_phys_0.sg13g2_nand3_1_0.Y sar_ctrl_async_phys_0.sg13g2_nor2_1_3.B 0.194f
C1603 a_34615_31475# VDD 0.20396f
C1604 sar_ctrl_async_phys_0.dac_code[0] sar_ctrl_async_phys_0.sg13g2_nand2b_1_7.A_N 0.29155f
C1605 a_32666_45969# VDD 0.09543f
C1606 sar_ctrl_async_phys_0.sg13g2_buf_1_3.A sar_ctrl_async_phys_0.sg13g2_inv_1_2.Y 0.03451f
C1607 sar_ctrl_async_phys_0.dac_code_n[5] a_20412_n9612# 1.21641f
C1608 sar_ctrl_async_phys_0.sg13g2_a22oi_1_0.A1 a_31823_33292# 0.01806f
C1609 sar_ctrl_async_phys_0.sg13g2_nand2_1_3.A sar_ctrl_async_phys_0.sg13g2_nand2_1_3.Y 0.74091f
C1610 sar_ctrl_async_phys_0.sg13g2_buf_1_2.A a_34555_35935# 0.42059f
C1611 sar_ctrl_async_phys_0.sg13g2_nand2b_1_2.Y a_34261_43495# 0.03411f
C1612 sar_ctrl_async_phys_0.sg13g2_a22oi_1_0.A1 sar_ctrl_async_phys_0.sg13g2_inv_1_5.A 0.42579f
C1613 sar_ctrl_async_phys_0.sg13g2_a22oi_1_0.A1 sar_ctrl_async_phys_0.sg13g2_buf_1_0.A 0.0296f
C1614 sar_ctrl_async_phys_0.sg13g2_buf_1_16.A a_31832_34412# 0.01122f
C1615 a_34363_43495# a_35360_43726# 0.03061f
C1616 a_34261_43495# a_35009_43845# 0.01058f
C1617 sar_ctrl_async_phys_0.sg13g2_dfrbpq_1_2.Q sar_ctrl_async_phys_0.sg13g2_nor2_1_2.A 0.11709f
C1618 sar_ctrl_async_phys_0.sg13g2_buf_1_23.A a_33750_36362# 0.04016f
C1619 sar_ctrl_async_phys_0.sg13g2_inv_1_0.Y VDD 0.30108f
C1620 sar_ctrl_async_phys_0.dac_code[0] m3_57896_n2380# 0.04356f
C1621 sar_ctrl_async_phys_0.sg13g2_a22oi_1_5.A2 sar_ctrl_async_phys_0.sg13g2_a22oi_1_2.B1 0.01307f
C1622 oa_sar8_acore18_opt_0.sw_tg_opt_1.bot oa_sar8_acore18_opt_0.sw_bitcell_opt_b7_1.bot 59.3946f
C1623 sar_ctrl_async_phys_0.sg13g2_a21oi_1_0.B1 a_34815_39775# 0.01492f
C1624 w_39600_n9960# sar_ctrl_async_phys_0.dac_code_n[5] 0.11753f
C1625 a_34224_45082# VDD 0.06979f
C1626 sar_ctrl_async_phys_0.sg13g2_buf_1_2.A a_34651_34423# 0.42233f
C1627 sar_ctrl_async_phys_0.sg13g2_nand2b_1_7.A_N VDD 0.60292f
C1628 sar_ctrl_async_phys_0.sg13g2_dfrbpq_1_0.CLK a_32116_40464# 0.08371f
C1629 a_29812_40885# a_30043_40471# 0.12701f
C1630 a_34132_34416# a_35297_34773# 0.43239f
C1631 sar_ctrl_async_phys_0.sg13g2_nor2_1_2.Y a_33652_41528# 0.01081f
C1632 sar_ctrl_async_phys_0.sg13g2_buf_1_2.A a_34132_36687# 0.01767f
C1633 a_26160_37522# VDD 0.08637f
C1634 a_34075_39820# a_35072_39918# 0.02979f
C1635 a_29046_32138# a_29749_32117# 0.02454f
C1636 sar_ctrl_async_phys_0.sg13g2_dfrbpq_1_0.CLK a_30591_32215# 0.02312f
C1637 sar_ctrl_async_phys_0.dac_code[0] oa_sar8_acore18_opt_0.sw_bitcell_opt_b0_0.bot 1.43525f
C1638 sar_ctrl_async_phys_0.sg13g2_buf_1_23.A a_33844_36992# 0.01405f
C1639 sar_ctrl_async_phys_0.dac_code_n[6] oa_sar8_acore18_opt_0.sw_bitcell_opt_b2_0.bot 0.08466f
C1640 m3_57896_n2380# VDD 0.01918f
C1641 sar_ctrl_async_phys_0.sg13g2_and2_1_5.X sar_ctrl_async_phys_0.sg13g2_buf_1_6.A 0.08986f
C1642 sar_ctrl_async_phys_0.sg13g2_buf_1_2.X a_31738_33948# 0.04257f
C1643 sar_ctrl_async_phys_0.dac_code_n[3] oa_sar8_acore18_opt_0.sw_bitcell_opt_b2_0.bot 0.10702f
C1644 sar_ctrl_async_phys_0.hold_req oa_sar8_acore18_opt_0.sw_bitcell_opt_b4_1.bot 0.01501f
C1645 sar_ctrl_async_phys_0.sg13g2_buf_1_2.X a_31638_32138# 0.11696f
C1646 sar_ctrl_async_phys_0.sg13g2_buf_1_13.X sar_ctrl_async_phys_0.cmp_fire 0.06573f
C1647 a_32341_32117# a_32031_31749# 0.01182f
C1648 sar_ctrl_async_phys_0.sg13g2_buf_1_3.A a_34136_33688# 0.01733f
C1649 sar_ctrl_async_phys_0.sg13g2_a22oi_1_0.A1 a_33359_33292# 0.01756f
C1650 sar_ctrl_async_phys_0.sg13g2_buf_1_26.X VDD 1.99482f
C1651 sar_ctrl_async_phys_0.sg13g2_o21ai_1_1.B1 a_34815_39775# 0.13308f
C1652 sar_ctrl_async_phys_0.sg13g2_nand2b_1_0.Y a_29144_39830# 0.02523f
C1653 sar_ctrl_async_phys_0.sg13g2_nor2_1_5.B a_29660_37436# 0.01498f
C1654 oa_sar8_acore18_opt_0.sw_bitcell_opt_term_0.trkb oa_sar8_acore18_opt_0.sw_bitcell_opt_b2_0.bot 1.3964f
C1655 sar_ctrl_async_phys_0.sg13g2_a21oi_1_7.Y sar_ctrl_async_phys_0.sg13g2_buf_1_2.A 0.27536f
C1656 oa_sar8_acore18_opt_0.sw_bitcell_opt_b0_0.bot VDD 2.43191f
C1657 sar_ctrl_async_phys_0.sg13g2_buf_1_6.A sar_ctrl_async_phys_0.sg13g2_buf_1_23.A 0.19569f
C1658 sar_ctrl_async_phys_0.sg13g2_a21oi_1_0.A2 a_35770_36972# 0.12556f
C1659 sar_ctrl_async_phys_0.sg13g2_buf_1_2.X a_33846_30626# 0.11059f
C1660 sar_ctrl_async_phys_0.cmp_p a_26184_21025# 2.27077f
C1661 sar_ctrl_async_phys_0.sg13g2_a22oi_1_2.A2 a_33270_39698# 0.01931f
C1662 a_32692_46064# a_33109_45725# 0.3749f
C1663 a_32406_45746# a_33211_45868# 0.097f
C1664 sar_ctrl_async_phys_0.sg13g2_dfrbpq_1_0.CLK sar_ctrl_async_phys_0.sg13g2_a22oi_1_2.A2 0.32727f
C1665 sar_ctrl_async_phys_0.cmp_fire track 0.06444f
C1666 sar_ctrl_async_phys_0.sg13g2_nor4_1_0.C sar_ctrl_async_phys_0.sg13g2_nor2_1_12.B 0.06431f
C1667 sar_ctrl_async_phys_0.sg13g2_nand2b_1_0.A_N VDD 0.65298f
C1668 sar_ctrl_async_phys_0.sg13g2_a21oi_1_1.B1 sar_ctrl_async_phys_0.sg13g2_a21oi_1_4.B1 0.0254f
C1669 a_34520_47296# sar_ctrl_async_phys_0.cmp_fault 0.09679f
C1670 sar_ctrl_async_phys_0.sg13g2_buf_1_3.A sar_ctrl_async_phys_0.dac_code_n[7] 0.11501f
C1671 sar_ctrl_async_phys_0.sg13g2_a22oi_1_1.B2 a_32687_32876# 0.01177f
C1672 a_34904_47296# sar_ctrl_async_phys_0.sg13g2_a21oi_1_1.B1 0.01758f
C1673 sar_ctrl_async_phys_0.sg13g2_a22oi_1_0.A1 a_31071_33727# 0.01346f
C1674 sar_ctrl_async_phys_0.sg13g2_a21oi_1_1.Y sar_ctrl_async_phys_0.sg13g2_a22oi_1_0.Y 0.05055f
C1675 a_33652_41528# a_34911_41287# 0.01529f
C1676 sar_ctrl_async_phys_0.sg13g2_o21ai_1_1.B1 sar_ctrl_async_phys_0.sg13g2_nor2_1_15.Y 0.06319f
C1677 sar_ctrl_async_phys_0.sg13g2_buf_1_13.X a_30830_35166# 0.01122f
C1678 sar_ctrl_async_phys_0.sg13g2_a22oi_1_1.A2 sar_ctrl_async_phys_0.sg13g2_a22oi_1_0.B1 0.19943f
C1679 oa_sar8_acore18_opt_0.sw_tg_opt_1.bot oa_sar8_acore18_opt_0.bstrap_opt_w2_c1200_1.out 0.19002f
C1680 sar_ctrl_async_phys_0.sg13g2_nor2b_1_0.A sar_ctrl_async_phys_0.sg13g2_a21oi_1_2.B1 0.3169f
C1681 sar_ctrl_async_phys_0.sg13g2_nand3_1_0.Y a_26184_39702# 0.07762f
C1682 sar_ctrl_async_phys_0.sg13g2_o21ai_1_1.B1 a_30495_39309# 0.1367f
C1683 a_30964_46512# VDD 0.07696f
C1684 oa_sar8_acore18_opt_0.sw_bitcell_opt_b6_0.bot oa_sar8_acore18_opt_0.sw_bitcell_opt_b0_0.bot 0.56024f
C1685 oa_sar8_acore18_opt_0.sw_bitcell_opt_b4_0.bot oa_sar8_acore18_opt_0.sw_bitcell_opt_b2_0.bot 1.43333f
C1686 oa_sar8_acore18_opt_0.sw_bitcell_opt_b5_0.bot oa_sar8_acore18_opt_0.sw_bitcell_opt_b1_0.bot 0.42516f
C1687 a_33558_36674# VDD 0.77525f
C1688 a_31060_44552# a_31348_44247# 0.43707f
C1689 sar_ctrl_async_phys_0.sg13g2_buf_1_3.A sar_ctrl_async_phys_0.sg13g2_nor2_1_2.Y 4.02349f
C1690 sar_ctrl_async_phys_0.sg13g2_nor2b_1_0.A sar_ctrl_async_phys_0.sg13g2_dfrbpq_1_22.D 1.19537f
C1691 a_29755_38959# a_30495_39309# 0.26905f
C1692 sar_ctrl_async_phys_0.sg13g2_dfrbpq_1_9.RESET_B a_30879_43845# 0.14123f
C1693 sar_ctrl_async_phys_0.dac_code[1] sar_ctrl_async_phys_0.dac_code_n[7] 0.31677f
C1694 sar_ctrl_async_phys_0.sg13g2_nor2_1_2.A sar_ctrl_async_phys_0.sg13g2_a21oi_1_1.Y 0.14307f
C1695 a_34055_31352# VDD 0.1739f
C1696 sar_ctrl_async_phys_0.sg13g2_a21oi_1_5.B1 sar_ctrl_async_phys_0.sg13g2_dfrbpq_1_0.CLK 1.49683f
C1697 a_31261_38232# a_31064_38318# 0.01798f
C1698 sar_ctrl_async_phys_0.sg13g2_nor2_1_1.Y sar_ctrl_async_phys_0.sg13g2_a21oi_1_0.A1 0.12426f
C1699 a_32400_41413# VDD 0.39526f
C1700 sar_ctrl_async_phys_0.sg13g2_a22oi_1_1.A2 sar_ctrl_async_phys_0.sg13g2_a21oi_1_0.A1 0.11018f
C1701 a_33844_43488# a_34261_43495# 0.37583f
C1702 a_28376_39034# VDD 0.13754f
C1703 sar_ctrl_async_phys_0.dac_code[0] a_35948_n9612# 2.10542f
C1704 oa_sar8_acore18_opt_0.sw_bitcell_opt_b0_1.bot VDD 2.34084f
C1705 sar_ctrl_async_phys_0.sg13g2_nor4_1_0.C sar_ctrl_async_phys_0.cmp_valid 0.04083f
C1706 sar_ctrl_async_phys_0.sg13g2_a21oi_1_6.A2 VDD 0.80687f
C1707 sar_ctrl_async_phys_0.dac_code_n[3] m3_45264_n2380# 0.05682f
C1708 a_35245_42242# sar_ctrl_async_phys_0.sg13g2_nand2b_1_2.A_N 0.1674f
C1709 sar_ctrl_async_phys_0.sg13g2_a22oi_1_0.A1 sar_ctrl_async_phys_0.sg13g2_inv_1_5.Y 0.04821f
C1710 a_29941_40471# a_30043_40471# 0.47795f
C1711 sar_ctrl_async_phys_0.sg13g2_a21oi_1_6.A2 sar_ctrl_async_phys_0.sg13g2_buf_1_35.A 0.54372f
C1712 a_33846_34850# a_34420_34837# 0.31978f
C1713 a_34106_34380# a_34549_34423# 0.02242f
C1714 sar_ctrl_async_phys_0.sg13g2_a22oi_1_5.Y a_30772_31392# 0.01992f
C1715 sar_ctrl_async_phys_0.sg13g2_buf_1_20.A sar_ctrl_async_phys_0.dac_code_n[7] 0.34923f
C1716 sar_ctrl_async_phys_0.dac_code_n[6] oa_sar8_acore18_opt_0.sw_bitcell_opt_b7_1.VSS 1.419f
C1717 sar_ctrl_async_phys_0.sg13g2_buf_1_2.A a_34261_36653# 0.03826f
C1718 sar_ctrl_async_phys_0.sg13g2_a22oi_1_1.B2 sar_ctrl_async_phys_0.sg13g2_inv_1_1.A 0.01772f
C1719 sar_ctrl_async_phys_0.sg13g2_dfrbpq_1_0.CLK a_34549_34423# 0.2976f
C1720 oa_sar8_acore18_opt_0.sw_bitcell_opt_b7_0.bot oa_sar8_acore18_opt_0.sw_bitcell_opt_term_0.VSS 2.55598f
C1721 a_33270_39698# a_33973_39677# 0.02454f
C1722 sar_ctrl_async_phys_0.sg13g2_dfrbpq_1_0.CLK a_33973_39677# 0.25466f
C1723 oa_sar8_acore18_opt_0.sw_bitcell_opt_term_0.trkb m3_45264_n2380# 0.03859f
C1724 sar_ctrl_async_phys_0.sg13g2_a22oi_1_0.B1 a_30671_32876# 0.05825f
C1725 sar_ctrl_async_phys_0.dac_code_n[3] oa_sar8_acore18_opt_0.sw_bitcell_opt_b7_1.VSS 1.11123f
C1726 sar_ctrl_async_phys_0.sg13g2_nor2b_1_0.A a_34520_38224# 0.26402f
C1727 sar_ctrl_async_phys_0.hold_req oa_sar8_acore18_opt_0.sw_bitcell_opt_b7_0.bot 0.09707f
C1728 a_34261_36653# a_34132_36687# 0.01562f
C1729 a_35948_n9612# VDD 1.37558f
C1730 sar_ctrl_async_phys_0.bit_active[3] sar_ctrl_async_phys_0.bit_active[4] 0.09377f
C1731 sar_ctrl_async_phys_0.sg13g2_buf_1_2.X a_29526_33650# 0.08726f
C1732 sar_ctrl_async_phys_0.sg13g2_inv_1_3.Y result[0] 0.01469f
C1733 sar_ctrl_async_phys_0.sg13g2_buf_1_6.A a_35552_36166# 0.0219f
C1734 sar_ctrl_async_phys_0.sg13g2_a21oi_1_1.B1 sar_ctrl_async_phys_0.sg13g2_buf_1_14.A 0.08689f
C1735 a_32715_43020# VDD 0.24138f
C1736 sar_ctrl_async_phys_0.sg13g2_a22oi_1_0.B1 sar_ctrl_async_phys_0.sg13g2_a22oi_1_1.Y 0.98944f
C1737 sar_ctrl_async_phys_0.sg13g2_buf_1_2.X a_30591_32215# 0.13983f
C1738 oa_sar8_acore18_opt_0.sw_bitcell_opt_term_0.trkb oa_sar8_acore18_opt_0.sw_bitcell_opt_b7_1.VSS 0.68655f
C1739 a_34093_42912# VDD 0.23805f
C1740 sar_ctrl_async_phys_0.sg13g2_buf_1_3.A rst_n 0.01296f
C1741 sar_ctrl_async_phys_0.sg13g2_nor2_1_2.Y sar_ctrl_async_phys_0.sg13g2_buf_1_20.A 0.18601f
C1742 sar_ctrl_async_phys_0.sg13g2_a22oi_1_1.B2 a_32341_32117# 0.04895f
C1743 sar_ctrl_async_phys_0.sg13g2_o21ai_1_1.B1 sar_ctrl_async_phys_0.sg13g2_nor2_1_10.Y 0.13608f
C1744 sar_ctrl_async_phys_0.sg13g2_buf_1_35.A a_32715_43020# 0.03251f
C1745 sar_ctrl_async_phys_0.sg13g2_a22oi_1_1.A2 sar_ctrl_async_phys_0.sg13g2_buf_1_4.A 0.12918f
C1746 sar_ctrl_async_phys_0.sg13g2_nor2b_1_4.Y sar_ctrl_async_phys_0.sg13g2_nor2_1_0.Y 0.1751f
C1747 a_36336_40546# VDD 0.07168f
C1748 sar_ctrl_async_phys_0.sg13g2_a21oi_1_2.B1 sar_ctrl_async_phys_0.sg13g2_nor2b_1_3.Y 0.01375f
C1749 sar_ctrl_async_phys_0.sg13g2_buf_1_35.A a_34093_42912# 0.26366f
C1750 sar_ctrl_async_phys_0.dac_code[7] oa_sar8_acore18_opt_0.sw_bitcell_opt_b5_0.bot 0.77683f
C1751 sar_ctrl_async_phys_0.sg13g2_buf_1_6.A a_35648_34654# 0.0303f
C1752 a_34636_31749# a_34767_31359# 0.3749f
C1753 sar_ctrl_async_phys_0.sg13g2_buf_1_20.A a_35770_43484# 0.01013f
C1754 oa_sar8_acore18_opt_0.sw_bitcell_opt_b4_0.bot m3_45264_n2380# 1.70379f
C1755 sar_ctrl_async_phys_0.sg13g2_nor2_1_4.Y sar_ctrl_async_phys_0.sg13g2_nor2_1_3.A 0.2622f
C1756 sar_ctrl_async_phys_0.sg13g2_inv_1_3.Y a_33464_30664# 0.02194f
C1757 sar_ctrl_async_phys_0.sg13g2_a21oi_1_2.B1 VDD 1.0017f
C1758 a_33626_41433# a_33366_41210# 0.75507f
C1759 sar_ctrl_async_phys_0.sg13g2_dfrbpq_1_9.RESET_B a_35103_43845# 0.13433f
C1760 sar_ctrl_async_phys_0.sg13g2_buf_1_25.A sar_ctrl_async_phys_0.sg13g2_inv_1_1.Y 0.10584f
C1761 oa_sar8_acore18_opt_0.sw_bitcell_opt_term_0.vin oa_sar8_acore18_opt_0.sw_bitcell_opt_term_0.gb 9.48667f
C1762 sar_ctrl_async_phys_0.sg13g2_a22oi_1_2.A2 sar_ctrl_async_phys_0.sg13g2_buf_1_2.X 0.02278f
C1763 sar_ctrl_async_phys_0.sg13g2_nor2_1_0.Y sar_ctrl_async_phys_0.sg13g2_a21oi_1_7.A2 0.05678f
C1764 oa_sar8_acore18_opt_0.sw_bitcell_opt_b2_0.bot oa_sar8_acore18_opt_0.sw_bitcell_opt_b0_0.bot 0.32482f
C1765 oa_sar8_acore18_opt_0.sw_bitcell_opt_b3_0.bot oa_sar8_acore18_opt_0.sw_bitcell_opt_term_0.bot 0.47284f
C1766 sar_ctrl_async_phys_0.sg13g2_buf_1_3.A a_33658_35460# 0.0612f
C1767 sar_ctrl_async_phys_0.sg13g2_buf_1_6.A sar_ctrl_async_phys_0.sg13g2_nor2_1_15.Y 0.04177f
C1768 sar_ctrl_async_phys_0.sg13g2_nor2_1_2.Y sar_ctrl_async_phys_0.sg13g2_nand2_1_1.B 0.14759f
C1769 sar_ctrl_async_phys_0.sg13g2_nand2b_1_1.Y a_34896_40546# 0.0118f
C1770 sar_ctrl_async_phys_0.sg13g2_a22oi_1_0.B1 sar_ctrl_async_phys_0.sg13g2_inv_1_0.A 0.0284f
C1771 sar_ctrl_async_phys_0.sg13g2_dfrbpq_1_22.D VDD 0.42061f
C1772 a_31352_36806# VDD 0.16122f
C1773 a_32347_37447# a_33344_37678# 0.03061f
C1774 a_30774_44234# a_31579_44356# 0.097f
C1775 a_31060_44552# a_31477_44213# 0.3749f
C1776 sar_ctrl_async_phys_0.dac_code_n[6] oa_sar8_acore18_opt_0.sw_bitcell_opt_b2_1.bot 0.06598f
C1777 sar_ctrl_async_phys_0.sg13g2_a21oi_1_4.B1 sar_ctrl_async_phys_0.sg13g2_nor2_1_1.Y 0.42981f
C1778 sar_ctrl_async_phys_0.sg13g2_a21oi_1_1.Y sar_ctrl_async_phys_0.bit_active[0] 0.19658f
C1779 sar_ctrl_async_phys_0.sg13g2_buf_1_3.A a_33754_37436# 0.04453f
C1780 sar_ctrl_async_phys_0.sg13g2_dfrbpq_1_9.RESET_B a_29594_43452# 0.2396f
C1781 a_33951_45823# a_33857_45823# 0.28931f
C1782 sar_ctrl_async_phys_0.sg13g2_a21oi_1_4.B1 sar_ctrl_async_phys_0.sg13g2_a22oi_1_1.A2 0.01318f
C1783 sar_ctrl_async_phys_0.dac_code_n[3] oa_sar8_acore18_opt_0.sw_bitcell_opt_b2_1.bot 0.11977f
C1784 a_33750_36362# a_34010_35892# 0.75507f
C1785 sar_ctrl_async_phys_0.sg13g2_buf_1_2.X sar_ctrl_async_phys_0.sg13g2_inv_1_6.Y 0.10657f
C1786 sar_ctrl_async_phys_0.sg13g2_nor2_1_4.Y a_26394_37436# 0.01284f
C1787 sar_ctrl_async_phys_0.dac_code_n[4] sar_ctrl_async_phys_0.sg13g2_nand2_1_3.A 0.02608f
C1788 sar_ctrl_async_phys_0.sg13g2_dfrbpq_1_9.RESET_B a_33211_45868# 0.02732f
C1789 sar_ctrl_async_phys_0.bit_active[1] VDD 0.19372f
C1790 sar_ctrl_async_phys_0.dac_code_n[0] sar_ctrl_async_phys_0.sample 0.05119f
C1791 sar_ctrl_async_phys_0.sg13g2_nor2_1_7.Y a_29276_37436# 0.01451f
C1792 sar_ctrl_async_phys_0.sg13g2_buf_1_3.A a_33818_43452# 0.03171f
C1793 sar_ctrl_async_phys_0.dac_code_n[6] sar_ctrl_async_phys_0.cmp_n 0.0675f
C1794 oa_sar8_acore18_opt_0.sw_bitcell_opt_term_0.trkb oa_sar8_acore18_opt_0.sw_bitcell_opt_b2_1.bot 1.41202f
C1795 sar_ctrl_async_phys_0.sg13g2_buf_1_22.A a_35672_38224# 0.26453f
C1796 sar_ctrl_async_phys_0.sg13g2_buf_1_2.A a_31195_35935# 0.42064f
C1797 oa_sar8_acore18_opt_0.sw_bitcell_opt_b4_1.bot VDD 3.45183f
C1798 sar_ctrl_async_phys_0.dac_code_n[3] sar_ctrl_async_phys_0.cmp_n 0.07717f
C1799 sar_ctrl_async_phys_0.sg13g2_dfrbpq_1_0.CLK a_28392_41214# 0.02294f
C1800 sar_ctrl_async_phys_0.sg13g2_a21oi_1_2.B1 a_31830_40898# 0.03618f
C1801 sar_ctrl_async_phys_0.sg13g2_a21oi_1_2.B1 a_35072_39918# 0.05154f
C1802 a_30872_45082# VDD 0.15535f
C1803 sar_ctrl_async_phys_0.sg13g2_a21oi_1_7.Y sar_ctrl_async_phys_0.sg13g2_dfrbpq_1_1.D 0.19199f
C1804 a_28008_23477# oa_sar8_acore18_opt_0.sw_tg_opt_1.bot 0.84801f
C1805 sar_ctrl_async_phys_0.dac_code_n[1] oa_sar8_acore18_opt_0.sw_bitcell_opt_term_0.VSS 0.04328f
C1806 w_16692_n9960# sar_ctrl_async_phys_0.dac_code_n[6] 0.28176f
C1807 a_34520_38224# VDD 0.22196f
C1808 a_31370_34782# sar_ctrl_async_phys_0.sg13g2_a22oi_1_2.B1 0.01617f
C1809 a_30964_46512# a_31252_46933# 0.43707f
C1810 sar_ctrl_async_phys_0.sg13g2_a22oi_1_5.A2 sar_ctrl_async_phys_0.sg13g2_buf_1_25.A 0.1034f
C1811 sar_ctrl_async_phys_0.hold_req sar_ctrl_async_phys_0.dac_code_n[1] 0.04482f
C1812 w_16692_n9960# sar_ctrl_async_phys_0.dac_code_n[3] 0.02423f
C1813 sar_ctrl_async_phys_0.sg13g2_nor4_1_0.C sar_ctrl_async_phys_0.sg13g2_buf_1_3.A 0.03928f
C1814 sar_ctrl_async_phys_0.sg13g2_a22oi_1_1.B2 a_33752_33688# 0.26686f
C1815 sar_ctrl_async_phys_0.sg13g2_a22oi_1_2.A2 sar_ctrl_async_phys_0.sg13g2_inv_1_2.A 0.05542f
C1816 a_33844_36992# a_34363_36796# 0.34114f
C1817 a_34651_32911# a_35648_33142# 0.03061f
C1818 sar_ctrl_async_phys_0.bit_active[0] sar_ctrl_async_phys_0.bit_active[2] 0.01506f
C1819 sar_ctrl_async_phys_0.sg13g2_nor2_1_0.Y a_32580_43448# 0.01032f
C1820 sar_ctrl_async_phys_0.sg13g2_a21oi_1_7.Y a_31195_35935# 0.05766f
C1821 sar_ctrl_async_phys_0.sg13g2_dlygate4sd3_1_4.X VDD 0.25849f
C1822 sar_ctrl_async_phys_0.sg13g2_a22oi_1_5.A2 a_30331_33772# 0.02606f
C1823 w_16692_n9960# oa_sar8_acore18_opt_0.sw_bitcell_opt_term_0.trkb 2.16982f
C1824 sar_ctrl_async_phys_0.sg13g2_inv_1_10.Y a_28392_41214# 0.06515f
C1825 sar_ctrl_async_phys_0.sg13g2_o21ai_1_1.B1 a_32192_39918# 0.10554f
C1826 sar_ctrl_async_phys_0.dac_code[7] oa_sar8_acore18_opt_0.sw_bitcell_opt_b1_0.bot 0.13826f
C1827 sar_ctrl_async_phys_0.sg13g2_buf_1_3.A result[4] 0.0103f
C1828 sar_ctrl_async_phys_0.sg13g2_dlygate4sd3_1_5.A a_25608_40501# 0.41651f
C1829 sar_ctrl_async_phys_0.sg13g2_buf_1_1.A result[7] 1.1502f
C1830 sar_ctrl_async_phys_0.sg13g2_a22oi_1_1.A2 a_32347_37447# 0.04653f
C1831 sar_ctrl_async_phys_0.sg13g2_inv_1_9.Y VDD 1.03121f
C1832 sar_ctrl_async_phys_0.sg13g2_a22oi_1_0.A1 a_34895_32120# 0.01875f
C1833 sar_ctrl_async_phys_0.cmp_n sar_ctrl_async_phys_0.cmp_p 5.78145f
C1834 sar_ctrl_async_phys_0.sg13g2_a21oi_1_7.Y a_31935_39775# 0.03918f
C1835 sar_ctrl_async_phys_0.dac_code_n[0] sar_ctrl_async_phys_0.dac_code[6] 1.39363f
C1836 a_35962_35924# sar_ctrl_async_phys_0.bit_active[3] 0.02751f
C1837 oa_sar8_acore18_opt_0.sw_bitcell_opt_b2_0.bot a_35948_n9612# 0.02825f
C1838 sar_ctrl_async_phys_0.sg13g2_dfrbpq_1_9.RESET_B a_31579_44356# 0.48589f
C1839 sar_ctrl_async_phys_0.sg13g2_nor2_1_1.Y sar_ctrl_async_phys_0.sg13g2_buf_1_14.A 0.11716f
C1840 sar_ctrl_async_phys_0.sg13g2_buf_1_20.A a_33818_43452# 0.01058f
C1841 sar_ctrl_async_phys_0.sg13g2_dfrbpq_1_22.D a_31162_38948# 0.01071f
C1842 sar_ctrl_async_phys_0.dac_code_n[7] sar_ctrl_async_phys_0.dac_code[4] 0.06317f
C1843 sar_ctrl_async_phys_0.sg13g2_nor2_1_2.Y sar_ctrl_async_phys_0.sg13g2_and2_1_5.X 0.01442f
C1844 sar_ctrl_async_phys_0.sg13g2_buf_1_9.A rst_n 0.0125f
C1845 sar_ctrl_async_phys_0.sg13g2_nand2b_1_1.Y sar_ctrl_async_phys_0.sg13g2_buf_1_44.A 0.17852f
C1846 sar_ctrl_async_phys_0.sg13g2_buf_1_34.A sar_ctrl_async_phys_0.dac_code[0] 0.04478f
C1847 sar_ctrl_async_phys_0.sg13g2_a22oi_1_0.A1 a_34106_34380# 0.03499f
C1848 sar_ctrl_async_phys_0.sg13g2_nor2b_1_4.Y a_32538_43484# 0.01296f
C1849 a_30879_43845# VDD 0.17446f
C1850 sar_ctrl_async_phys_0.sg13g2_dfrbpq_1_0.CLK sar_ctrl_async_phys_0.sg13g2_a22oi_1_0.A1 2.01997f
C1851 a_26184_42013# VDD 0.3541f
C1852 sar_ctrl_async_phys_0.dac_code[0] oa_sar8_acore18_opt_0.sw_bitcell_opt_b7_0.bot 2.34456f
C1853 sar_ctrl_async_phys_0.dac_code[7] m3_51760_n2380# 0.05799f
C1854 sar_ctrl_async_phys_0.dac_code_n[6] oa_sar8_acore18_opt_0.sw_bitcell_opt_b6_1.bot 1.4314f
C1855 sar_ctrl_async_phys_0.dac_code_n[2] sar_ctrl_async_phys_0.dac_code_n[7] 0.12929f
C1856 a_31828_37440# a_33087_37797# 0.01529f
C1857 a_31256_37522# a_31440_37522# 0.0524f
C1858 sar_ctrl_async_phys_0.sg13g2_nand2b_1_2.Y sar_ctrl_async_phys_0.sg13g2_dfrbpq_1_9.Q 0.13935f
C1859 sar_ctrl_async_phys_0.sg13g2_inv_1_0.A sar_ctrl_async_phys_0.sg13g2_buf_1_8.A 0.014f
C1860 sar_ctrl_async_phys_0.sg13g2_nor2_1_2.Y sar_ctrl_async_phys_0.sg13g2_buf_1_23.A 0.0117f
C1861 sar_ctrl_async_phys_0.sg13g2_a21oi_1_1.Y a_34808_35200# 0.01622f
C1862 a_32406_45746# a_32980_45759# 0.31978f
C1863 sar_ctrl_async_phys_0.sg13g2_nor4_1_0.C sar_ctrl_async_phys_0.sg13g2_buf_1_20.A 0.02754f
C1864 sar_ctrl_async_phys_0.sg13g2_buf_1_34.A VDD 0.53855f
C1865 sar_ctrl_async_phys_0.dac_code[2] oa_sar8_acore18_opt_0.sw_bitcell_opt_term_0.gb 0.19971f
C1866 oa_sar8_acore18_opt_0.sw_bitcell_opt_term_0.trkb oa_sar8_acore18_opt_0.sw_bitcell_opt_b6_1.bot 1.52713f
C1867 a_26289_42912# VDD 0.22208f
C1868 oa_sar8_acore18_opt_0.sw_bitcell_opt_b7_0.bot VDD 5.14569f
C1869 sar_ctrl_async_phys_0.sg13g2_buf_1_3.A a_33558_43922# 0.04484f
C1870 oa_sar8_acore18_opt_0.sw_bitcell_opt_term_0.bot m3_38288_n2380# 0.02173f
C1871 sar_ctrl_async_phys_0.sg13g2_buf_1_34.A sar_ctrl_async_phys_0.sg13g2_buf_1_35.A 0.07693f
C1872 sar_ctrl_async_phys_0.sg13g2_a22oi_1_0.A1 a_34895_32460# 0.01467f
C1873 a_32251_45007# a_32991_45357# 0.26905f
C1874 sar_ctrl_async_phys_0.sg13g2_buf_1_0.A a_32991_35239# 0.02096f
C1875 sar_ctrl_async_phys_0.sg13g2_nand2_1_2.A sar_ctrl_async_phys_0.sg13g2_nand2_1_3.A 0.08647f
C1876 sar_ctrl_async_phys_0.sg13g2_dfrbpq_1_0.CLK a_31093_35935# 0.27865f
C1877 a_28006_35948# a_27894_35924# 0.55452f
C1878 a_34224_42058# VDD 0.06978f
C1879 sar_ctrl_async_phys_0.sg13g2_dlygate4sd3_1_3.A a_28760_42058# 0.03706f
C1880 a_30678_46946# a_30938_46476# 0.75507f
C1881 oa_sar8_acore18_opt_0.sw_bitcell_opt_b7_0.bot oa_sar8_acore18_opt_0.sw_bitcell_opt_b6_0.bot 11.9275f
C1882 oa_sar8_acore18_opt_0.sw_bitcell_opt_b0_1.bot oa_sar8_acore18_opt_0.sw_bitcell_opt_b7_1.VSS 1.43554f
C1883 a_34132_32904# a_35391_33261# 0.01529f
C1884 sar_ctrl_async_phys_0.sg13g2_dfrbpq_1_0.CLK sar_ctrl_async_phys_0.sg13g2_buf_1_7.A 0.02597f
C1885 sar_ctrl_async_phys_0.sg13g2_buf_1_25.A result[5] 0.13491f
C1886 a_34808_35200# sar_ctrl_async_phys_0.bit_active[2] 0.24512f
C1887 a_36056_37436# VDD 0.25958f
C1888 sar_ctrl_async_phys_0.sg13g2_buf_1_2.A a_34520_33688# 0.25921f
C1889 a_33552_44366# VDD 0.0689f
C1890 sar_ctrl_async_phys_0.sg13g2_a22oi_1_2.B1 sar_ctrl_async_phys_0.sg13g2_inv_1_1.A 0.49173f
C1891 sar_ctrl_async_phys_0.sg13g2_buf_1_26.X sar_ctrl_async_phys_0.cmp_n 0.02125f
C1892 sar_ctrl_async_phys_0.sg13g2_a22oi_1_5.A2 sar_ctrl_async_phys_0.sg13g2_buf_1_2.A 0.02516f
C1893 sar_ctrl_async_phys_0.dac_code_n[6] oa_sar8_acore18_opt_0.sw_bitcell_opt_term_1.bot 0.06773f
C1894 sar_ctrl_async_phys_0.sg13g2_o21ai_1_1.B1 a_30390_39698# 0.11935f
C1895 sar_ctrl_async_phys_0.sg13g2_dlygate4sd3_1_8.A track 0.05323f
C1896 sar_ctrl_async_phys_0.dac_code_n[3] oa_sar8_acore18_opt_0.sw_bitcell_opt_term_1.bot 0.06773f
C1897 sar_ctrl_async_phys_0.sg13g2_dfrbpq_1_0.CLK sar_ctrl_async_phys_0.sg13g2_inv_1_3.Y 0.02038f
C1898 sar_ctrl_async_phys_0.sg13g2_nand2_1_0.Y sar_ctrl_async_phys_0.sg13g2_nor2_1_5.Y 0.54266f
C1899 sar_ctrl_async_phys_0.sg13g2_dfrbpq_1_2.Q a_33675_43020# 0.07616f
C1900 sar_ctrl_async_phys_0.sg13g2_a22oi_1_1.A2 a_32245_37447# 0.05462f
C1901 a_35103_43845# VDD 0.17295f
C1902 sar_ctrl_async_phys_0.sg13g2_buf_1_2.X a_33936_31675# 0.02188f
C1903 a_32696_30664# rst_n 0.27018f
C1904 oa_sar8_acore18_opt_0.sw_bitcell_opt_term_1.bot oa_sar8_acore18_opt_0.sw_bitcell_opt_term_0.trkb 1.39215f
C1905 sar_ctrl_async_phys_0.sg13g2_nor2_1_2.A a_33750_36362# 0.28036f
C1906 sar_ctrl_async_phys_0.sg13g2_buf_1_20.A a_33558_43922# 0.01423f
C1907 a_31040_40702# VDD 0.17149f
C1908 sar_ctrl_async_phys_0.sg13g2_buf_1_20.A sar_ctrl_async_phys_0.bit_active[7] 0.02275f
C1909 a_28968_42013# VDD 0.33591f
C1910 sar_ctrl_async_phys_0.sg13g2_and2_1_0.B a_35201_36285# 0.02086f
C1911 sar_ctrl_async_phys_0.sg13g2_buf_1_9.A result[4] 0.14838f
C1912 a_29594_43452# VDD 0.09683f
C1913 sar_ctrl_async_phys_0.sg13g2_a22oi_1_5.A2 sar_ctrl_async_phys_0.sg13g2_a21oi_1_7.Y 0.07995f
C1914 oa_sar8_acore18_opt_0.sw_bitcell_opt_b1_1.bot oa_sar8_acore18_opt_0.bstrap_opt_w2_c1200_1.gb 0.63917f
C1915 sar_ctrl_async_phys_0.dac_code_n[1] sar_ctrl_async_phys_0.dac_code[0] 0.08213f
C1916 sar_ctrl_async_phys_0.sg13g2_a22oi_1_3.A2 sar_ctrl_async_phys_0.sg13g2_a21oi_1_2.B1 0.01184f
C1917 sar_ctrl_async_phys_0.sg13g2_buf_1_6.A sar_ctrl_async_phys_0.sg13g2_nand2_1_1.Y 0.57898f
C1918 sar_ctrl_async_phys_0.dac_code_n[4] oa_sar8_acore18_opt_0.sw_tg_opt_1.bot 0.07641f
C1919 sar_ctrl_async_phys_0.sg13g2_a22oi_1_5.A2 a_30752_39190# 0.02843f
C1920 a_33211_45868# VDD 0.20597f
C1921 sar_ctrl_async_phys_0.sg13g2_nor2_1_2.A a_33844_36992# 0.03785f
C1922 sar_ctrl_async_phys_0.sg13g2_nor2_1_1.A sar_ctrl_async_phys_0.sg13g2_nor2b_1_1.B_N 0.19058f
C1923 sar_ctrl_async_phys_0.sg13g2_a22oi_1_0.A1 sar_ctrl_async_phys_0.sg13g2_buf_1_2.X 2.19565f
C1924 oa_sar8_acore18_opt_0.sw_bitcell_opt_b0_1.bot oa_sar8_acore18_opt_0.sw_bitcell_opt_b2_1.bot 0.33518f
C1925 sar_ctrl_async_phys_0.sg13g2_buf_1_14.A a_34596_40424# 0.27129f
C1926 sar_ctrl_async_phys_0.sg13g2_a22oi_1_1.A2 sar_ctrl_async_phys_0.sg13g2_buf_1_0.A 0.0305f
C1927 sar_ctrl_async_phys_0.dac_code_n[5] oa_sar8_acore18_opt_0.sw_bitcell_opt_term_0.VSS 0.01411f
C1928 a_30676_35928# a_31841_36285# 0.43239f
C1929 sar_ctrl_async_phys_0.sg13g2_nand3_1_0.A a_26454_39702# 0.02299f
C1930 sar_ctrl_async_phys_0.dac_code_n[1] VDD 4.03381f
C1931 a_32890_46508# sar_ctrl_async_phys_0.sg13g2_a21oi_1_6.A2 0.11728f
C1932 a_35391_30703# result[1] 0.01708f
C1933 sar_ctrl_async_phys_0.sg13g2_nor2_1_7.Y sar_ctrl_async_phys_0.sg13g2_nor2_1_7.A 0.15267f
C1934 sar_ctrl_async_phys_0.hold_req sar_ctrl_async_phys_0.dac_code_n[5] 0.05239f
C1935 sar_ctrl_async_phys_0.sg13g2_buf_1_33.A a_36056_42760# 0.27682f
C1936 sar_ctrl_async_phys_0.sg13g2_buf_1_6.A a_35672_38224# 0.0976f
C1937 sar_ctrl_async_phys_0.dac_code[3] oa_sar8_acore18_opt_0.sw_bitcell_opt_b5_0.bot 0.58748f
C1938 sar_ctrl_async_phys_0.sg13g2_a21oi_1_6.A2 a_31732_45000# 0.0218f
C1939 sar_ctrl_async_phys_0.sg13g2_nor2_1_11.Y a_30139_43495# 0.02465f
C1940 sar_ctrl_async_phys_0.sg13g2_a21oi_1_5.B1 a_34357_44213# 0.01436f
C1941 a_31732_45000# a_32020_45421# 0.43707f
C1942 sar_ctrl_async_phys_0.sg13g2_buf_1_0.A a_31446_35162# 0.01817f
C1943 sar_ctrl_async_phys_0.sg13g2_buf_1_5.A a_31247_32876# 0.08806f
C1944 sar_ctrl_async_phys_0.sg13g2_a22oi_1_0.B2 a_34651_30748# 0.01825f
C1945 sar_ctrl_async_phys_0.sg13g2_nor2_1_0.Y sar_ctrl_async_phys_0.sg13g2_buf_1_22.A 0.03274f
C1946 sar_ctrl_async_phys_0.sg13g2_nor4_1_0.C sar_ctrl_async_phys_0.sg13g2_and2_1_5.X 0.014f
C1947 sar_ctrl_async_phys_0.sg13g2_a21oi_1_6.B1 sar_ctrl_async_phys_0.sg13g2_a21oi_1_0.A1 0.18409f
C1948 sar_ctrl_async_phys_0.sg13g2_a21oi_1_0.B1 a_33951_45823# 0.01863f
C1949 sar_ctrl_async_phys_0.sg13g2_a21oi_1_1.B1 sar_ctrl_async_phys_0.sg13g2_nand2_1_2.A 0.17008f
C1950 sar_ctrl_async_phys_0.sg13g2_buf_1_6.A sar_ctrl_async_phys_0.dac_code[6] 0.14241f
C1951 sar_ctrl_async_phys_0.sg13g2_nand2b_1_1.Y sar_ctrl_async_phys_0.sg13g2_a21oi_1_7.Y 0.19769f
C1952 sar_ctrl_async_phys_0.sg13g2_a21oi_1_0.B1 a_35578_41508# 0.02749f
C1953 sar_ctrl_async_phys_0.sg13g2_buf_1_9.A a_33850_32436# 0.11945f
C1954 oa_sar8_acore18_opt_0.sw_bitcell_opt_b7_0.bot oa_sar8_acore18_opt_0.sw_bitcell_opt_b2_0.bot 0.96738f
C1955 oa_sar8_acore18_opt_0.sw_bitcell_opt_term_0.vin oa_sar8_acore18_opt_0.sw_bitcell_opt_b3_0.bot 3.98018f
C1956 oa_sar8_acore18_opt_0.sw_bitcell_opt_b4_1.bot oa_sar8_acore18_opt_0.sw_bitcell_opt_b7_1.VSS 1.92639f
C1957 a_34651_30748# a_34420_30639# 0.12701f
C1958 a_34132_30944# a_35297_30703# 0.43239f
C1959 a_35391_30703# a_35648_30846# 0.34468f
C1960 a_31195_39820# a_30964_39711# 0.12701f
C1961 a_33248_35382# VDD 0.17492f
C1962 a_30676_40016# a_31841_39775# 0.43239f
C1963 sar_ctrl_async_phys_0.sg13g2_buf_1_32.A sar_ctrl_async_phys_0.sg13g2_nand2_1_3.B 0.02649f
C1964 sar_ctrl_async_phys_0.sg13g2_o21ai_1_1.B1 sar_ctrl_async_phys_0.sg13g2_dfrbpq_1_11.D 0.41737f
C1965 sar_ctrl_async_phys_0.dac_code_n[1] oa_sar8_acore18_opt_0.sw_bitcell_opt_b6_0.bot 0.59859f
C1966 w_16692_n9960# oa_sar8_acore18_opt_0.sw_bitcell_opt_b0_1.bot 0.13149f
C1967 a_33252_36642# a_33558_36674# 0.01036f
C1968 sar_ctrl_async_phys_0.sg13g2_nand2b_1_2.Y sar_ctrl_async_phys_0.sg13g2_buf_1_32.A 1.70691f
C1969 VDD vcm 0.5117f
C1970 a_33087_37797# VDD 0.17863f
C1971 sar_ctrl_async_phys_0.sg13g2_buf_1_13.X sar_ctrl_async_phys_0.sg13g2_nor2_1_6.A 0.57015f
C1972 a_31579_44356# VDD 0.20594f
C1973 sar_ctrl_async_phys_0.sg13g2_nor2_1_4.Y a_26454_41972# 0.05178f
C1974 sar_ctrl_async_phys_0.sg13g2_buf_1_2.A result[5] 0.1275f
C1975 sar_ctrl_async_phys_0.sg13g2_o21ai_1_1.B1 a_33951_45823# 0.13292f
C1976 sar_ctrl_async_phys_0.sg13g2_nor2_1_1.Y a_33632_40702# 0.02388f
C1977 sar_ctrl_async_phys_0.sg13g2_buf_1_2.X sar_ctrl_async_phys_0.sg13g2_buf_1_7.A 0.11641f
C1978 sar_ctrl_async_phys_0.sg13g2_a22oi_1_0.A1 sar_ctrl_async_phys_0.sg13g2_inv_1_2.A 0.34968f
C1979 a_36056_38948# sar_ctrl_async_phys_0.dac_code[5] 0.24516f
C1980 sar_ctrl_async_phys_0.sg13g2_inv_1_5.A sar_ctrl_async_phys_0.sg13g2_a22oi_1_1.Y 0.01425f
C1981 a_31291_31399# a_32031_31749# 0.26905f
C1982 sar_ctrl_async_phys_0.sg13g2_a21oi_1_5.B1 a_33914_44457# 0.01417f
C1983 a_28236_40440# VDD 0.02621f
C1984 a_30507_35204# a_30733_35460# 0.02726f
C1985 sar_ctrl_async_phys_0.sg13g2_nand2_1_3.A a_35725_45266# 0.26305f
C1986 sar_ctrl_async_phys_0.sg13g2_nand2_1_1.Y sar_ctrl_async_phys_0.sg13g2_buf_1_21.A 0.01782f
C1987 sar_ctrl_async_phys_0.sg13g2_buf_1_2.X sar_ctrl_async_phys_0.sg13g2_inv_1_3.Y 0.16124f
C1988 sar_ctrl_async_phys_0.sg13g2_inv_1_3.Y a_33080_31388# 0.04483f
C1989 a_35391_33261# VDD 0.17444f
C1990 sar_ctrl_async_phys_0.sg13g2_a21oi_1_0.A1 a_31947_41508# 0.07631f
C1991 oa_sar8_acore18_opt_0.sw_bitcell_opt_b5_1.bot oa_sar8_acore18_opt_0.bstrap_opt_w2_c1200_1.gb 0.71955f
C1992 sar_ctrl_async_phys_0.sg13g2_buf_1_2.A a_34424_35200# 0.01011f
C1993 sar_ctrl_async_phys_0.sg13g2_buf_1_13.A a_31828_37440# 0.06518f
C1994 sar_ctrl_async_phys_0.sg13g2_a21oi_1_6.B1 a_34363_43495# 0.01549f
C1995 result[0] result[1] 0.33555f
C1996 sar_ctrl_async_phys_0.bit_active[1] done 0.02834f
C1997 sar_ctrl_async_phys_0.sg13g2_a21oi_1_0.A1 a_29653_38959# 0.06416f
C1998 sar_ctrl_async_phys_0.hold_req track 0.05885f
C1999 sar_ctrl_async_phys_0.sg13g2_and2_1_2.X a_26385_39214# 0.03641f
C2000 sar_ctrl_async_phys_0.sg13g2_a22oi_1_0.A1 a_32687_33292# 0.01738f
C2001 sar_ctrl_async_phys_0.sg13g2_buf_1_6.A result[7] 0.02391f
C2002 a_34136_47296# VDD 0.24562f
C2003 a_31738_33948# sar_ctrl_async_phys_0.sg13g2_buf_1_5.A 0.11728f
C2004 oa_sar8_acore18_opt_0.sw_bitcell_opt_b0_1.bot oa_sar8_acore18_opt_0.sw_bitcell_opt_b6_1.bot 0.5306f
C2005 sar_ctrl_async_phys_0.sg13g2_buf_1_20.A sar_ctrl_async_phys_0.bit_active[6] 0.0264f
C2006 oa_sar8_acore18_opt_0.sw_bitcell_opt_b2_1.bot oa_sar8_acore18_opt_0.sw_bitcell_opt_b4_1.bot 1.44803f
C2007 oa_sar8_acore18_opt_0.sw_bitcell_opt_b1_1.bot oa_sar8_acore18_opt_0.sw_bitcell_opt_b5_1.bot 0.43173f
C2008 sar_ctrl_async_phys_0.sg13g2_nand2_1_2.B a_34363_43495# 0.0292f
C2009 sar_ctrl_async_phys_0.sg13g2_buf_1_21.A a_35672_38224# 0.01492f
C2010 sar_ctrl_async_phys_0.sg13g2_buf_1_4.A a_35103_36751# 0.02406f
C2011 sar_ctrl_async_phys_0.sg13g2_buf_1_5.A a_31638_32138# 0.02152f
C2012 sar_ctrl_async_phys_0.sg13g2_and2_1_0.B a_35103_36751# 0.03947f
C2013 VDD result[3] 0.11784f
C2014 sar_ctrl_async_phys_0.sg13g2_buf_1_13.A sar_ctrl_async_phys_0.sg13g2_a22oi_1_0.A2 1.52012f
C2015 a_35648_34654# busy 0.04908f
C2016 a_30650_35892# a_31093_35935# 0.02242f
C2017 a_30390_36362# a_30964_36349# 0.31978f
C2018 a_32341_32117# a_32443_32260# 0.47622f
C2019 sar_ctrl_async_phys_0.sg13g2_buf_1_3.A a_33844_39711# 0.01101f
C2020 sar_ctrl_async_phys_0.dac_code[3] oa_sar8_acore18_opt_0.sw_bitcell_opt_b1_0.bot 0.15675f
C2021 a_25596_41174# sar_ctrl_async_phys_0.sg13g2_nor4_1_0.Y 0.25757f
C2022 sar_ctrl_async_phys_0.sg13g2_o21ai_1_1.B1 sar_ctrl_async_phys_0.sg13g2_nor2_1_0.Y 0.19979f
C2023 sar_ctrl_async_phys_0.sg13g2_a21oi_1_6.B1 sar_ctrl_async_phys_0.sg13g2_a21oi_1_4.B1 0.52255f
C2024 a_31483_46519# a_32223_46869# 0.26905f
C2025 a_33464_30664# result[1] 0.25342f
C2026 sar_ctrl_async_phys_0.sg13g2_a21oi_1_1.B1 a_35288_47296# 0.26428f
C2027 sar_ctrl_async_phys_0.sg13g2_buf_1_6.A sar_ctrl_async_phys_0.bit_active[0] 0.03112f
C2028 sar_ctrl_async_phys_0.sg13g2_dlygate4sd3_1_5.A sar_ctrl_async_phys_0.sg13g2_nand3_1_0.C 0.56051f
C2029 sar_ctrl_async_phys_0.sg13g2_buf_1_21.A sar_ctrl_async_phys_0.dac_code[6] 0.09233f
C2030 sar_ctrl_async_phys_0.sg13g2_buf_1_14.A a_36152_36806# 0.01263f
C2031 sar_ctrl_async_phys_0.sg13g2_nand2b_1_0.A_N sar_ctrl_async_phys_0.sg13g2_nor2_1_12.B 0.85121f
C2032 sar_ctrl_async_phys_0.sg13g2_o21ai_1_1.B1 a_32319_44311# 0.0206f
C2033 sar_ctrl_async_phys_0.sg13g2_buf_1_2.A a_35297_33261# 0.01926f
C2034 a_31446_45434# a_31706_44964# 0.75507f
C2035 sar_ctrl_async_phys_0.sg13g2_buf_1_2.X sar_ctrl_async_phys_0.sg13g2_dfrbpq_1_17.D 0.08937f
C2036 sar_ctrl_async_phys_0.sg13g2_dfrbpq_1_0.CLK a_30043_40471# 0.08009f
C2037 sar_ctrl_async_phys_0.sg13g2_a21oi_1_4.B1 sar_ctrl_async_phys_0.sg13g2_nand2_1_2.B 0.02542f
C2038 oa_sar8_acore18_opt_0.sw_bitcell_opt_term_0.vin oa_sar8_acore18_opt_0.sw_bitcell_opt_term_0.bot 3.81939f
C2039 sar_ctrl_async_phys_0.sg13g2_buf_1_9.A a_31924_32456# 0.02973f
C2040 sar_ctrl_async_phys_0.dac_code_n[1] oa_sar8_acore18_opt_0.sw_bitcell_opt_b2_0.bot 0.0615f
C2041 sar_ctrl_async_phys_0.sg13g2_nand2_1_6.B a_35000_45878# 0.02515f
C2042 result[2] result[0] 0.01285f
C2043 a_34549_30605# a_34651_30748# 0.47622f
C2044 sar_ctrl_async_phys_0.sg13g2_a22oi_1_0.Y sar_ctrl_async_phys_0.sg13g2_inv_1_2.Y 0.49954f
C2045 a_31732_35480# VDD 0.0757f
C2046 sar_ctrl_async_phys_0.sg13g2_dfrbpq_1_0.CLK a_33109_45725# 0.25963f
C2047 a_26558_40727# a_26673_40726# 0.55452f
C2048 a_30650_39921# a_31093_39677# 0.02242f
C2049 sar_ctrl_async_phys_0.sg13g2_dfrbpq_1_22.D a_30676_40016# 0.04455f
C2050 sar_ctrl_async_phys_0.sg13g2_a21oi_1_1.B1 sar_ctrl_async_phys_0.sg13g2_dfrbpq_1_0.CLK 0.33482f
C2051 sar_ctrl_async_phys_0.sg13g2_buf_1_13.X sar_ctrl_async_phys_0.sg13g2_nor2b_1_0.A 1.72641f
C2052 sar_ctrl_async_phys_0.sg13g2_nor2b_1_0.A sar_ctrl_async_phys_0.sg13g2_buf_1_13.A 0.68373f
C2053 sar_ctrl_async_phys_0.sg13g2_nand2_1_3.A sar_ctrl_async_phys_0.sg13g2_buf_1_33.A 0.24674f
C2054 a_28977_36864# sar_ctrl_async_phys_0.sg13g2_dlygate4sd3_1_0.X 0.05019f
C2055 a_35866_44532# a_36248_44366# 0.01012f
C2056 a_28662_41214# VDD 0.22994f
C2057 sar_ctrl_async_phys_0.dac_code_n[5] sar_ctrl_async_phys_0.dac_code[0] 0.2763f
C2058 oa_sar8_acore18_opt_0.sw_bitcell_opt_term_1.bot oa_sar8_acore18_opt_0.sw_bitcell_opt_b0_1.bot 15.0838f
C2059 a_33440_32358# VDD 0.16989f
C2060 a_34520_46508# VDD 0.21859f
C2061 sar_ctrl_async_phys_0.dac_code[2] oa_sar8_acore18_opt_0.sw_bitcell_opt_b3_0.bot 0.55513f
C2062 sar_ctrl_async_phys_0.sg13g2_nor2b_1_0.A a_34042_40460# 0.01072f
C2063 sar_ctrl_async_phys_0.dac_code_n[6] sar_ctrl_async_phys_0.dac_code[1] 0.06252f
C2064 sar_ctrl_async_phys_0.sg13g2_o21ai_1_1.B1 a_33366_41210# 0.10842f
C2065 oa_sar8_acore18_opt_0.sw_bitcell_opt_term_0.vin m3_38288_n2380# 0.05057f
C2066 sar_ctrl_async_phys_0.sg13g2_nand2_1_3.B sar_ctrl_async_phys_0.sg13g2_nand2_1_2.Y 0.38554f
C2067 sar_ctrl_async_phys_0.sg13g2_nand2b_1_1.Y sar_ctrl_async_phys_0.sg13g2_nand2_1_2.Y 0.12498f
C2068 sar_ctrl_async_phys_0.dac_code_n[3] sar_ctrl_async_phys_0.dac_code[1] 0.07695f
C2069 a_26184_39702# a_26454_39702# 0.26306f
C2070 a_30772_31392# a_31060_31813# 0.43707f
C2071 oa_sar8_acore18_opt_0.sw_tg_opt_1.bot oa_sar8_acore18_opt_0.sw_tg_opt_0.bot 0.07925f
C2072 a_36058_30924# VDD 0.37825f
C2073 sar_ctrl_async_phys_0.sg13g2_nand2b_1_2.Y sar_ctrl_async_phys_0.sg13g2_nand2_1_2.Y 0.01556f
C2074 sar_ctrl_async_phys_0.sg13g2_nor4_1_0.Y sar_ctrl_async_phys_0.sg13g2_nor2_1_12.A 0.01387f
C2075 sar_ctrl_async_phys_0.dac_code[3] sar_ctrl_async_phys_0.dac_code[7] 0.07489f
C2076 a_31247_32876# VDD 0.30319f
C2077 sar_ctrl_async_phys_0.dac_code_n[5] VDD 5.2442f
C2078 sar_ctrl_async_phys_0.dac_code[1] oa_sar8_acore18_opt_0.sw_bitcell_opt_term_0.trkb 1.81503f
C2079 sar_ctrl_async_phys_0.sg13g2_buf_1_13.A a_32635_40471# 0.02227f
C2080 sar_ctrl_async_phys_0.sg13g2_a21oi_1_6.B1 sar_ctrl_async_phys_0.sg13g2_buf_1_14.A 0.14382f
C2081 sar_ctrl_async_phys_0.sample sar_ctrl_async_phys_0.dac_code_n[7] 0.04555f
C2082 sar_ctrl_async_phys_0.dac_code_n[5] sar_ctrl_async_phys_0.sg13g2_buf_1_35.A 1.29473f
C2083 oa_sar8_acore18_opt_0.sw_bitcell_opt_b4_1.bot oa_sar8_acore18_opt_0.sw_bitcell_opt_b6_1.bot 0.53583f
C2084 oa_sar8_acore18_opt_0.sw_bitcell_opt_b3_1.bot oa_sar8_acore18_opt_0.sw_bitcell_opt_b7_1.bot 1.18796f
C2085 sar_ctrl_async_phys_0.dac_code_n[6] sar_ctrl_async_phys_0.sg13g2_buf_1_20.A 0.02014f
C2086 a_33632_40702# a_33375_40821# 0.34468f
C2087 a_29812_33968# a_30977_33727# 0.43239f
C2088 a_30331_33772# a_30100_33663# 0.12701f
C2089 sar_ctrl_async_phys_0.sample sar_ctrl_async_phys_0.sg13g2_nor2_1_13.Y 0.05522f
C2090 a_31071_33727# a_31328_33870# 0.34468f
C2091 sar_ctrl_async_phys_0.sg13g2_buf_1_4.A sar_ctrl_async_phys_0.sg13g2_nor2b_1_1.B_N 0.02172f
C2092 sar_ctrl_async_phys_0.sg13g2_dfrbpq_1_0.CLK a_31477_44213# 0.28544f
C2093 sar_ctrl_async_phys_0.sg13g2_and2_1_0.B sar_ctrl_async_phys_0.sg13g2_nor2b_1_1.B_N 0.06038f
C2094 sar_ctrl_async_phys_0.sg13g2_nand2b_1_2.A_N sar_ctrl_async_phys_0.dac_code[4] 0.03478f
C2095 sar_ctrl_async_phys_0.sg13g2_buf_1_13.X a_26168_38318# 0.01557f
C2096 sar_ctrl_async_phys_0.dac_code_n[5] oa_sar8_acore18_opt_0.sw_bitcell_opt_b6_0.bot 0.95229f
C2097 sar_ctrl_async_phys_0.dac_code[1] oa_sar8_acore18_opt_0.sw_bitcell_opt_b4_0.bot 0.36873f
C2098 sar_ctrl_async_phys_0.sg13g2_buf_1_25.A a_33846_33338# 0.01301f
C2099 sar_ctrl_async_phys_0.sg13g2_a22oi_1_5.A2 a_31064_38318# 0.01645f
C2100 sar_ctrl_async_phys_0.sg13g2_and2_1_2.X a_26168_38318# 0.01111f
C2101 sar_ctrl_async_phys_0.sg13g2_nor2_1_0.Y sar_ctrl_async_phys_0.sg13g2_buf_1_6.A 0.14045f
C2102 sar_ctrl_async_phys_0.sg13g2_and2_1_5.X sar_ctrl_async_phys_0.bit_active[6] 0.01032f
C2103 sar_ctrl_async_phys_0.sg13g2_buf_1_13.A sar_ctrl_async_phys_0.sg13g2_nor2b_1_3.Y 0.44519f
C2104 sar_ctrl_async_phys_0.sg13g2_a22oi_1_0.B2 a_34767_31359# 0.05571f
C2105 a_26954_40424# track 0.01114f
C2106 sar_ctrl_async_phys_0.sg13g2_buf_1_6.A a_35664_37695# 0.12982f
C2107 sar_ctrl_async_phys_0.dac_code_n[1] oa_sar8_acore18_opt_0.sw_bitcell_opt_b7_1.VSS 0.9753f
C2108 sar_ctrl_async_phys_0.sg13g2_nand2_1_3.A a_35772_41936# 0.24986f
C2109 oa_sar8_acore18_opt_0.bstrap_opt_w2_c1200_1.out a_21332_n9711# 0.0466f
C2110 sar_ctrl_async_phys_0.sg13g2_a21oi_1_7.A2 sar_ctrl_async_phys_0.sg13g2_a21oi_1_7.Y 0.05536f
C2111 sar_ctrl_async_phys_0.sg13g2_nor2_1_0.Y a_32251_45007# 0.05769f
C2112 sar_ctrl_async_phys_0.sg13g2_inv_1_2.Y sar_ctrl_async_phys_0.sg13g2_a22oi_1_1.B2 0.45727f
C2113 a_26566_41996# sar_ctrl_async_phys_0.sg13g2_dlygate4sd3_1_7.X 0.15635f
C2114 sar_ctrl_async_phys_0.sg13g2_a22oi_1_2.A2 a_31828_37440# 0.01039f
C2115 sar_ctrl_async_phys_0.sg13g2_dfrbpq_1_2.Q sar_ctrl_async_phys_0.sg13g2_buf_1_2.A 0.04752f
C2116 sar_ctrl_async_phys_0.sg13g2_o21ai_1_1.A2 a_28130_40838# 0.07506f
C2117 sar_ctrl_async_phys_0.sg13g2_buf_1_13.X VDD 3.81286f
C2118 sar_ctrl_async_phys_0.sg13g2_buf_1_13.A VDD 1.16683f
C2119 a_26566_39766# VDD 0.18743f
C2120 sar_ctrl_async_phys_0.dac_code_n[7] sar_ctrl_async_phys_0.dac_code[6] 0.16858f
C2121 sar_ctrl_async_phys_0.sg13g2_o21ai_1_1.B1 sar_ctrl_async_phys_0.sg13g2_nand2b_1_0.Y 0.14248f
C2122 sar_ctrl_async_phys_0.sg13g2_and2_1_2.X VDD 0.81066f
C2123 sar_ctrl_async_phys_0.dac_code_n[0] oa_sar8_acore18_opt_0.sw_bitcell_opt_term_0.gb 0.12845f
C2124 sar_ctrl_async_phys_0.sg13g2_a21oi_1_5.B1 sar_ctrl_async_phys_0.sg13g2_dfrbpq_1_9.RESET_B 0.19534f
C2125 sar_ctrl_async_phys_0.sg13g2_buf_1_3.A sar_ctrl_async_phys_0.sg13g2_nand2b_1_7.A_N 0.12833f
C2126 sar_ctrl_async_phys_0.sg13g2_a22oi_1_0.A1 a_34308_37400# 0.08736f
C2127 sar_ctrl_async_phys_0.sg13g2_buf_1_35.A sar_ctrl_async_phys_0.sg13g2_buf_1_13.A 0.06838f
C2128 sar_ctrl_async_phys_0.sg13g2_nor2_1_2.Y sar_ctrl_async_phys_0.sg13g2_nor2_1_2.A 0.12173f
C2129 a_35053_40730# VDD 0.23934f
C2130 sar_ctrl_async_phys_0.sg13g2_nor2_1_1.A sar_ctrl_async_phys_0.sg13g2_buf_1_4.A 0.50372f
C2131 oa_sar8_acore18_opt_0.bstrap_opt_w2_c1200_1.out oa_sar8_acore18_opt_0.sw_bitcell_opt_b3_1.bot 3.99252f
C2132 oa_sar8_acore18_opt_0.sw_bitcell_opt_term_1.bot oa_sar8_acore18_opt_0.sw_bitcell_opt_b4_1.bot 0.7839f
C2133 sar_ctrl_async_phys_0.dac_code[2] oa_sar8_acore18_opt_0.sw_bitcell_opt_term_0.bot 0.16617f
C2134 sar_ctrl_async_phys_0.sg13g2_a21oi_1_4.A2 sar_ctrl_async_phys_0.sg13g2_a22oi_1_5.A2 0.02469f
C2135 a_34042_40460# VDD 0.37835f
C2136 a_31738_33948# VDD 0.38139f
C2137 a_35199_44311# a_35866_44532# 0.0894f
C2138 a_34357_44213# a_35105_44311# 0.01058f
C2139 sar_ctrl_async_phys_0.sg13g2_a21oi_1_0.A1 a_31195_39820# 0.01786f
C2140 VDD track 0.82961f
C2141 a_36336_39830# VDD 0.06741f
C2142 sar_ctrl_async_phys_0.sg13g2_a21oi_1_0.A1 a_30027_39996# 0.03309f
C2143 a_31638_32138# VDD 0.77446f
C2144 sar_ctrl_async_phys_0.sg13g2_buf_1_22.A a_31261_38232# 0.10493f
C2145 sar_ctrl_async_phys_0.sg13g2_a22oi_1_3.A2 a_33087_37797# 0.01326f
C2146 a_35557_31435# result[2] 0.01443f
C2147 sar_ctrl_async_phys_0.sg13g2_nor2_1_1.Y a_33270_39698# 0.03758f
C2148 sar_ctrl_async_phys_0.sg13g2_dfrbpq_1_0.CLK sar_ctrl_async_phys_0.sg13g2_nor2_1_1.Y 0.01743f
C2149 a_34904_38948# sar_ctrl_async_phys_0.bit_active[6] 0.24534f
C2150 a_30486_31826# a_30746_31356# 0.75507f
C2151 sar_ctrl_async_phys_0.sg13g2_a21oi_1_0.A1 a_35672_38948# 0.02777f
C2152 sar_ctrl_async_phys_0.sg13g2_dfrbpq_1_0.CLK sar_ctrl_async_phys_0.sg13g2_a22oi_1_1.A2 1.75947f
C2153 sar_ctrl_async_phys_0.sg13g2_a22oi_1_2.B1 a_31832_34412# 0.27406f
C2154 sar_ctrl_async_phys_0.sg13g2_buf_1_6.A a_33366_41210# 0.01304f
C2155 a_36152_36806# sar_ctrl_async_phys_0.bit_active[4] 0.01103f
C2156 a_33846_30626# VDD 0.77472f
C2157 sar_ctrl_async_phys_0.sg13g2_nor2_1_7.B sar_ctrl_async_phys_0.sg13g2_nor2_1_5.Y 0.06192f
C2158 sar_ctrl_async_phys_0.sg13g2_nor2_1_7.A sar_ctrl_async_phys_0.sg13g2_dlygate4sd3_1_1.X 0.01423f
C2159 a_33752_33688# sar_ctrl_async_phys_0.sg13g2_buf_1_25.A 0.01337f
C2160 sar_ctrl_async_phys_0.sg13g2_nand2_1_3.Y sar_ctrl_async_phys_0.dac_code[7] 0.03573f
C2161 sar_ctrl_async_phys_0.sg13g2_nor2b_1_4.Y a_30576_46594# 0.03037f
C2162 sar_ctrl_async_phys_0.sg13g2_buf_1_13.X a_31830_40898# 0.01976f
C2163 a_28026_36972# VDD 0.01405f
C2164 sar_ctrl_async_phys_0.sg13g2_dfrbpq_1_0.CLK a_31446_35162# 0.01007f
C2165 sar_ctrl_async_phys_0.dac_code_n[2] sar_ctrl_async_phys_0.sg13g2_nand2_1_6.B 0.02173f
C2166 sar_ctrl_async_phys_0.sg13g2_a22oi_1_5.Y a_29749_32117# 0.01375f
C2167 a_34800_39034# VDD 0.09185f
C2168 sar_ctrl_async_phys_0.sg13g2_buf_1_25.A a_31258_32436# 0.12564f
C2169 a_36056_47296# sar_ctrl_async_phys_0.dac_code_n[5] 0.2458f
C2170 a_32116_40464# a_32635_40471# 0.34102f
C2171 a_32533_40471# a_32404_40885# 0.01562f
C2172 sar_ctrl_async_phys_0.sg13g2_buf_1_2.A a_31542_37874# 0.102f
C2173 sar_ctrl_async_phys_0.sg13g2_nor2b_1_0.A sar_ctrl_async_phys_0.sg13g2_a22oi_1_2.A2 0.02385f
C2174 a_30229_33629# a_30331_33772# 0.47622f
C2175 sar_ctrl_async_phys_0.sg13g2_dfrbpq_1_0.CLK result[1] 0.03285f
C2176 a_25496_42854# VDD 0.12976f
C2177 sar_ctrl_async_phys_0.sg13g2_buf_1_2.X a_32991_35239# 0.13292f
C2178 sar_ctrl_async_phys_0.dac_code_n[5] oa_sar8_acore18_opt_0.sw_bitcell_opt_b2_0.bot 0.08014f
C2179 sar_ctrl_async_phys_0.dac_code[1] oa_sar8_acore18_opt_0.sw_bitcell_opt_b0_0.bot 0.16588f
C2180 sar_ctrl_async_phys_0.sg13g2_a21oi_1_1.Y a_34555_35935# 0.05016f
C2181 sar_ctrl_async_phys_0.dac_code_n[1] sar_ctrl_async_phys_0.cmp_n 0.05993f
C2182 sar_ctrl_async_phys_0.dac_code_n[4] oa_sar8_acore18_opt_0.sw_bitcell_opt_b5_0.bot 0.44073f
C2183 sar_ctrl_async_phys_0.sg13g2_nand2b_1_7.A_N sar_ctrl_async_phys_0.sg13g2_buf_1_20.A 0.01538f
C2184 sar_ctrl_async_phys_0.sg13g2_dfrbpq_1_0.CLK a_33183_32215# 0.01574f
C2185 sar_ctrl_async_phys_0.sg13g2_buf_1_14.A sar_ctrl_async_phys_0.dac_code[7] 0.03151f
C2186 sar_ctrl_async_phys_0.sg13g2_buf_1_3.A a_33558_36674# 0.01873f
C2187 sar_ctrl_async_phys_0.sg13g2_nand2b_1_1.Y a_35456_44454# 0.02301f
C2188 sar_ctrl_async_phys_0.sg13g2_dfrbpq_1_9.RESET_B a_34040_45082# 0.01945f
C2189 a_28006_35948# sar_ctrl_async_phys_0.sg13g2_dlygate4sd3_1_0.A 0.18762f
C2190 sar_ctrl_async_phys_0.sg13g2_buf_1_4.A a_36056_33688# 0.26497f
C2191 sar_ctrl_async_phys_0.sg13g2_a21oi_1_1.Y sar_ctrl_async_phys_0.sg13g2_buf_1_2.A 0.21282f
C2192 sar_ctrl_async_phys_0.sg13g2_a21oi_1_1.Y a_34651_34423# 0.01151f
C2193 sar_ctrl_async_phys_0.sg13g2_a22oi_1_0.B2 a_34636_31749# 0.02827f
C2194 sar_ctrl_async_phys_0.sg13g2_a22oi_1_0.A2 a_34549_34423# 0.03723f
C2195 sar_ctrl_async_phys_0.sg13g2_buf_1_2.A a_29258_36642# 0.02017f
C2196 w_16692_n9960# sar_ctrl_async_phys_0.dac_code_n[1] 0.02265f
C2197 sar_ctrl_async_phys_0.sg13g2_a21oi_1_7.Y a_31542_37874# 0.03153f
C2198 sar_ctrl_async_phys_0.sg13g2_a22oi_1_2.A2 a_32635_40471# 0.02543f
C2199 a_35672_35200# sar_ctrl_async_phys_0.bit_active[3] 0.24512f
C2200 a_27530_39666# VDD 0.34608f
C2201 sar_ctrl_async_phys_0.sg13g2_buf_1_13.X a_27120_37522# 0.01277f
C2202 sar_ctrl_async_phys_0.sg13g2_a21oi_1_2.B1 a_33652_41528# 0.04449f
C2203 sar_ctrl_async_phys_0.dac_code_n[6] sar_ctrl_async_phys_0.dac_code[4] 0.06252f
C2204 sar_ctrl_async_phys_0.sg13g2_nor2b_1_3.Y a_32116_40464# 0.03915f
C2205 sar_ctrl_async_phys_0.sg13g2_dfrbpq_1_0.CLK sar_ctrl_async_phys_0.sg13g2_a22oi_1_1.Y 0.14881f
C2206 oa_sar8_acore18_opt_0.sw_bitcell_opt_term_0.gb m3_60844_n2380# 1.40567f
C2207 sar_ctrl_async_phys_0.sg13g2_buf_1_0.A a_34132_34416# 0.01714f
C2208 a_30296_42854# VDD 0.13825f
C2209 sar_ctrl_async_phys_0.sg13g2_nor2_1_12.B a_28410_39996# 0.01682f
C2210 sar_ctrl_async_phys_0.dac_code_n[3] sar_ctrl_async_phys_0.dac_code[4] 0.72379f
C2211 sar_ctrl_async_phys_0.sg13g2_buf_1_2.X a_35648_33142# 0.0994f
C2212 sar_ctrl_async_phys_0.sg13g2_a21oi_1_6.B1 sar_ctrl_async_phys_0.dac_code_n[4] 0.25922f
C2213 sar_ctrl_async_phys_0.sg13g2_a21oi_1_0.A1 sar_ctrl_async_phys_0.sg13g2_nand2b_1_3.Y 0.06191f
C2214 oa_sar8_acore18_opt_0.bstrap_opt_w2_c1200_1.out oa_sar8_acore18_opt_0.sw_bitcell_opt_b7_1.bot 4.61763f
C2215 sar_ctrl_async_phys_0.sg13g2_a22oi_1_3.A2 a_31732_35480# 0.03252f
C2216 a_29786_33873# a_29526_33650# 0.75507f
C2217 sar_ctrl_async_phys_0.sg13g2_dfrbpq_1_0.CLK result[2] 0.05421f
C2218 sar_ctrl_async_phys_0.sg13g2_a21oi_1_6.A2 a_32888_43570# 0.02012f
C2219 sar_ctrl_async_phys_0.dac_code_n[2] sar_ctrl_async_phys_0.dac_code_n[6] 0.14649f
C2220 a_34555_35935# sar_ctrl_async_phys_0.bit_active[2] 0.02023f
C2221 sar_ctrl_async_phys_0.dac_code[4] oa_sar8_acore18_opt_0.sw_bitcell_opt_term_0.trkb 1.96931f
C2222 a_32116_40464# VDD 0.07285f
C2223 sar_ctrl_async_phys_0.sg13g2_nor2_1_7.A VDD 0.64727f
C2224 a_29526_33650# VDD 0.78273f
C2225 sar_ctrl_async_phys_0.cmp_fire oa_sar8_acore18_opt_0.sw_tg_opt_1.bot 0.17568f
C2226 sar_ctrl_async_phys_0.sg13g2_dfrbpq_1_0.CLK sar_ctrl_async_phys_0.sg13g2_nor4_1_0.Y 0.32203f
C2227 a_30591_32215# VDD 0.17242f
C2228 sar_ctrl_async_phys_0.dac_code_n[2] sar_ctrl_async_phys_0.dac_code_n[3] 8.03508f
C2229 sar_ctrl_async_phys_0.dac_code_n[0] sar_ctrl_async_phys_0.sg13g2_dfrbpq_1_9.Q 0.05171f
C2230 sar_ctrl_async_phys_0.dac_code_n[4] sar_ctrl_async_phys_0.sg13g2_nand2_1_2.B 0.01282f
C2231 a_36336_36806# VDD 0.05605f
C2232 sar_ctrl_async_phys_0.sg13g2_buf_1_2.A sar_ctrl_async_phys_0.bit_active[2] 0.01495f
C2233 sar_ctrl_async_phys_0.sg13g2_nor2b_1_0.A a_33973_39677# 0.05993f
C2234 sar_ctrl_async_phys_0.dac_code_n[2] oa_sar8_acore18_opt_0.sw_bitcell_opt_term_0.trkb 1.90235f
C2235 sar_ctrl_async_phys_0.sg13g2_buf_1_3.A a_34093_42912# 0.04288f
C2236 sar_ctrl_async_phys_0.sg13g2_nor2b_1_3.Y sar_ctrl_async_phys_0.sg13g2_a22oi_1_2.A2 1.44583f
C2237 sar_ctrl_async_phys_0.sg13g2_a22oi_1_0.A1 a_34420_33325# 0.01158f
C2238 sar_ctrl_async_phys_0.sg13g2_nand2b_1_2.Y sar_ctrl_async_phys_0.sg13g2_nand2_1_3.B 0.10448f
C2239 sar_ctrl_async_phys_0.sg13g2_nand2b_1_2.Y sar_ctrl_async_phys_0.sg13g2_nand2b_1_1.Y 0.2353f
C2240 sar_ctrl_async_phys_0.sg13g2_dfrbpq_1_9.RESET_B a_30938_46476# 0.26754f
C2241 oa_sar8_acore18_opt_0.sw_tg_opt_1.bot a_20412_n9612# 2.5703f
C2242 sar_ctrl_async_phys_0.sg13g2_dfrbpq_1_0.CLK sar_ctrl_async_phys_0.sg13g2_inv_1_0.A 1.69772f
C2243 a_34520_33688# result[5] 0.0884f
C2244 sar_ctrl_async_phys_0.sg13g2_a21oi_1_0.B1 sar_ctrl_async_phys_0.sg13g2_dfrbpq_1_9.Q 0.08607f
C2245 sar_ctrl_async_phys_0.dac_code[4] oa_sar8_acore18_opt_0.sw_bitcell_opt_b4_0.bot 1.73129f
C2246 sar_ctrl_async_phys_0.sg13g2_a22oi_1_1.A2 sar_ctrl_async_phys_0.sg13g2_buf_1_2.X 0.09473f
C2247 sar_ctrl_async_phys_0.sg13g2_a22oi_1_0.Y result[4] 0.02522f
C2248 sar_ctrl_async_phys_0.sg13g2_and2_1_5.X a_34075_39820# 0.01585f
C2249 sar_ctrl_async_phys_0.dac_code[1] a_35948_n9612# 2.40439f
C2250 sar_ctrl_async_phys_0.sg13g2_a22oi_1_2.A2 VDD 1.27419f
C2251 sar_ctrl_async_phys_0.sg13g2_nor4_1_0.Y sar_ctrl_async_phys_0.sg13g2_inv_1_10.Y 0.06258f
C2252 sar_ctrl_async_phys_0.sg13g2_a21oi_1_0.B1 a_34721_39775# 0.0124f
C2253 a_31830_40898# a_32116_40464# 0.41329f
C2254 sar_ctrl_async_phys_0.sg13g2_buf_1_2.A sar_ctrl_async_phys_0.sg13g2_nor2_1_5.Y 0.02532f
C2255 sar_ctrl_async_phys_0.dac_code_n[5] oa_sar8_acore18_opt_0.sw_bitcell_opt_b7_1.VSS 1.3094f
C2256 sar_ctrl_async_phys_0.sg13g2_dfrbpq_1_0.CLK a_34596_40424# 0.05037f
C2257 sar_ctrl_async_phys_0.dac_code_n[4] oa_sar8_acore18_opt_0.sw_bitcell_opt_b1_0.bot 0.09661f
C2258 sar_ctrl_async_phys_0.sg13g2_buf_1_2.A sar_ctrl_async_phys_0.sg13g2_buf_1_1.A 0.03417f
C2259 sar_ctrl_async_phys_0.sg13g2_a21oi_1_6.A2 sar_ctrl_async_phys_0.sg13g2_buf_1_20.A 0.04565f
C2260 a_31706_35385# a_31732_35480# 0.36952f
C2261 sar_ctrl_async_phys_0.sg13g2_buf_1_2.X a_31446_35162# 0.08508f
C2262 sar_ctrl_async_phys_0.sg13g2_dfrbpq_1_0.CLK a_33375_40821# 0.01353f
C2263 sar_ctrl_async_phys_0.dac_code_n[2] oa_sar8_acore18_opt_0.sw_bitcell_opt_b4_0.bot 0.22577f
C2264 sar_ctrl_async_phys_0.sg13g2_nor2_1_2.Y a_33654_44234# 0.27509f
C2265 a_29851_32260# a_30591_32215# 0.26905f
C2266 sar_ctrl_async_phys_0.sg13g2_dfrbpq_1_0.CLK a_31898_32361# 0.02935f
C2267 sar_ctrl_async_phys_0.sg13g2_nor2_1_4.Y sar_ctrl_async_phys_0.sg13g2_dlygate4sd3_1_9.X 0.11f
C2268 sar_ctrl_async_phys_0.sg13g2_a21oi_1_2.A2 a_30495_39309# 0.01609f
C2269 sar_ctrl_async_phys_0.sg13g2_a22oi_1_0.B1 sar_ctrl_async_phys_0.sg13g2_buf_1_8.A 0.42835f
C2270 sar_ctrl_async_phys_0.sg13g2_inv_1_6.Y VDD 0.43593f
C2271 sar_ctrl_async_phys_0.sg13g2_a21oi_1_2.B1 a_29498_40428# 0.03707f
C2272 sar_ctrl_async_phys_0.sg13g2_a22oi_1_1.A2 a_32149_45007# 0.03327f
C2273 sar_ctrl_async_phys_0.sg13g2_nor2_1_10.B a_29653_38959# 0.02984f
C2274 sar_ctrl_async_phys_0.sg13g2_nor2_1_1.Y a_33882_38484# 0.01284f
C2275 sar_ctrl_async_phys_0.sg13g2_buf_1_2.X result[1] 0.03401f
C2276 sar_ctrl_async_phys_0.sg13g2_a21oi_1_0.A1 sar_ctrl_async_phys_0.sg13g2_buf_1_4.A 0.03614f
C2277 sar_ctrl_async_phys_0.sg13g2_nand2b_1_2.Y a_35168_41430# 0.04989f
C2278 sar_ctrl_async_phys_0.sg13g2_a21oi_1_0.A1 sar_ctrl_async_phys_0.sg13g2_and2_1_0.B 0.29571f
C2279 sar_ctrl_async_phys_0.sg13g2_buf_1_13.X a_29210_38916# 0.02004f
C2280 sar_ctrl_async_phys_0.sg13g2_buf_1_2.X a_33183_32215# 0.13462f
C2281 sar_ctrl_async_phys_0.sg13g2_a21oi_1_1.Y a_34261_36653# 0.04888f
C2282 sar_ctrl_async_phys_0.sg13g2_nor2_1_4.Y a_26666_38912# 0.03011f
C2283 a_29334_43922# a_30139_43495# 0.097f
C2284 sar_ctrl_async_phys_0.sg13g2_dfrbpq_1_0.CLK sar_ctrl_async_phys_0.sg13g2_nand2_1_0.B 0.21542f
C2285 sar_ctrl_async_phys_0.sg13g2_a21oi_1_5.B1 VDD 0.81128f
C2286 sar_ctrl_async_phys_0.sg13g2_nor2_1_11.A a_29620_43488# 0.0304f
C2287 a_26954_40424# sar_ctrl_async_phys_0.sg13g2_dlygate4sd3_1_4.A 0.01565f
C2288 result[7] busy 0.01194f
C2289 sar_ctrl_async_phys_0.sg13g2_buf_1_2.X a_35648_30846# 0.10525f
C2290 a_35557_31435# a_35463_31435# 0.75507f
C2291 oa_sar8_acore18_opt_0.sw_bitcell_opt_term_0.gb m3_34580_n2380# 1.78701f
C2292 a_33211_45868# a_34208_45966# 0.02979f
C2293 a_31924_32456# a_33089_32215# 0.43239f
C2294 a_32443_32260# a_32212_32151# 0.12701f
C2295 a_25496_31388# VDD 0.22258f
C2296 a_33648_36010# VDD 0.08462f
C2297 sar_ctrl_async_phys_0.dac_code_n[1] oa_sar8_acore18_opt_0.sw_bitcell_opt_term_1.bot 0.06659f
C2298 sar_ctrl_async_phys_0.sg13g2_nor2b_1_1.B_N sar_ctrl_async_phys_0.sg13g2_buf_1_0.A 0.20636f
C2299 sar_ctrl_async_phys_0.sg13g2_buf_1_4.A a_36056_35200# 0.02428f
C2300 sar_ctrl_async_phys_0.sg13g2_a22oi_1_0.A1 sar_ctrl_async_phys_0.sg13g2_buf_1_5.A 0.59283f
C2301 sar_ctrl_async_phys_0.sg13g2_buf_1_13.A sar_ctrl_async_phys_0.sg13g2_a22oi_1_3.A2 5.27045f
C2302 a_34069_41189# a_34817_41287# 0.01058f
C2303 a_34911_41287# a_35578_41508# 0.0894f
C2304 sar_ctrl_async_phys_0.sg13g2_buf_1_2.X sar_ctrl_async_phys_0.sg13g2_a22oi_1_1.Y 0.22008f
C2305 a_34261_43495# sar_ctrl_async_phys_0.dac_code_n[7] 0.01126f
C2306 sar_ctrl_async_phys_0.sg13g2_nor2_1_0.Y a_32225_44311# 0.0177f
C2307 sar_ctrl_async_phys_0.bit_active[0] busy 0.12548f
C2308 sar_ctrl_async_phys_0.sg13g2_a21oi_1_4.B1 sar_ctrl_async_phys_0.sg13g2_a21oi_1_0.A1 2.42573f
C2309 sar_ctrl_async_phys_0.dac_code_n[5] oa_sar8_acore18_opt_0.sw_bitcell_opt_b2_1.bot 0.06598f
C2310 a_34549_34423# VDD 0.24778f
C2311 a_33973_39677# VDD 0.26555f
C2312 sar_ctrl_async_phys_0.sg13g2_and2_1_0.B sar_ctrl_async_phys_0.sg13g2_buf_1_4.A 0.40627f
C2313 sar_ctrl_async_phys_0.sg13g2_a21oi_1_6.B1 sar_ctrl_async_phys_0.sg13g2_nand2_1_2.A 0.26036f
C2314 sar_ctrl_async_phys_0.sg13g2_buf_1_29.A sar_ctrl_async_phys_0.hold_req 0.03319f
C2315 a_32986_44532# a_33368_44366# 0.01012f
C2316 a_35360_36894# VDD 0.16911f
C2317 sar_ctrl_async_phys_0.sg13g2_buf_1_2.X result[2] 0.0944f
C2318 a_35672_38224# sar_ctrl_async_phys_0.bit_active[7] 0.24559f
C2319 a_33080_31388# result[2] 0.24606f
C2320 a_32319_44311# a_32225_44311# 0.28931f
C2321 sar_ctrl_async_phys_0.sg13g2_a21oi_1_7.Y sar_ctrl_async_phys_0.sg13g2_buf_1_22.A 0.04864f
C2322 sar_ctrl_async_phys_0.sg13g2_nor2_1_4.Y sar_ctrl_async_phys_0.sg13g2_dlygate4sd3_1_6.X 0.06246f
C2323 sar_ctrl_async_phys_0.sg13g2_dlygate4sd3_1_4.A VDD 0.52233f
C2324 sar_ctrl_async_phys_0.sg13g2_a21oi_1_3.A2 a_35595_40460# 0.09982f
C2325 sar_ctrl_async_phys_0.dac_code_n[4] sar_ctrl_async_phys_0.dac_code[7] 0.13169f
C2326 sar_ctrl_async_phys_0.sg13g2_a22oi_1_0.A2 sar_ctrl_async_phys_0.sg13g2_a22oi_1_0.A1 0.23524f
C2327 sar_ctrl_async_phys_0.sg13g2_nand2_1_1.B a_36336_40546# 0.01794f
C2328 sar_ctrl_async_phys_0.sg13g2_nor2b_1_4.Y sar_ctrl_async_phys_0.sg13g2_a21oi_1_4.A2 0.03254f
C2329 sar_ctrl_async_phys_0.sg13g2_a22oi_1_0.A1 a_34132_32904# 0.02192f
C2330 a_34453_35935# a_35201_36285# 0.01058f
C2331 a_34324_36349# a_34555_35935# 0.12701f
C2332 sar_ctrl_async_phys_0.dac_code_n[5] sar_ctrl_async_phys_0.cmp_n 0.0675f
C2333 sar_ctrl_async_phys_0.sg13g2_nand2_1_2.A sar_ctrl_async_phys_0.sg13g2_nand2_1_2.B 0.4244f
C2334 a_26160_45878# VDD 0.084f
C2335 sar_ctrl_async_phys_0.dac_code[4] oa_sar8_acore18_opt_0.sw_bitcell_opt_b0_0.bot 0.1489f
C2336 sar_ctrl_async_phys_0.sg13g2_a22oi_1_1.B2 result[4] 0.12656f
C2337 sar_ctrl_async_phys_0.dac_code[6] sar_ctrl_async_phys_0.bit_active[7] 0.01559f
C2338 sar_ctrl_async_phys_0.sg13g2_nand2b_1_2.Y a_33844_43488# 0.01197f
C2339 oa_sar8_acore18_opt_0.sw_tg_opt_0.bot oa_sar8_acore18_opt_0.sw_bitcell_opt_b5_0.bot 15.1026f
C2340 a_33844_43488# a_35009_43845# 0.43239f
C2341 sar_ctrl_async_phys_0.sg13g2_a21oi_1_2.B1 sar_ctrl_async_phys_0.sg13g2_nand2_1_1.B 0.03814f
C2342 sar_ctrl_async_phys_0.sg13g2_buf_1_2.X sar_ctrl_async_phys_0.sg13g2_inv_1_0.A 0.1447f
C2343 sar_ctrl_async_phys_0.dac_code_n[2] oa_sar8_acore18_opt_0.sw_bitcell_opt_b0_0.bot 0.0836f
C2344 w_16692_n9960# sar_ctrl_async_phys_0.dac_code_n[5] 0.02244f
C2345 a_34040_45082# VDD 0.12705f
C2346 sar_ctrl_async_phys_0.sg13g2_nand2b_1_1.Y sar_ctrl_async_phys_0.dac_code[2] 0.11362f
C2347 sar_ctrl_async_phys_0.dac_code_n[0] oa_sar8_acore18_opt_0.sw_bitcell_opt_b3_0.bot 0.06958f
C2348 sar_ctrl_async_phys_0.sg13g2_a21oi_1_0.A1 sar_ctrl_async_phys_0.sg13g2_nand2_1_3.Y 0.05131f
C2349 sar_ctrl_async_phys_0.dac_code[2] oa_sar8_acore18_opt_0.sw_bitcell_opt_term_0.vin 1.77777f
C2350 a_34420_34837# a_34651_34423# 0.12701f
C2351 sar_ctrl_async_phys_0.sg13g2_nor2_1_2.Y a_33366_41210# 0.04032f
C2352 sar_ctrl_async_phys_0.sg13g2_buf_1_14.A sar_ctrl_async_phys_0.sg13g2_nand2b_1_3.Y 0.02094f
C2353 a_34075_39820# a_34815_39775# 0.26905f
C2354 a_29046_32138# a_29332_32456# 0.41329f
C2355 sar_ctrl_async_phys_0.sg13g2_buf_1_5.A sar_ctrl_async_phys_0.sg13g2_buf_1_7.A 0.01702f
C2356 sar_ctrl_async_phys_0.sg13g2_buf_1_6.A a_35211_37436# 0.02028f
C2357 sar_ctrl_async_phys_0.sg13g2_buf_1_23.A a_33558_36674# 0.03016f
C2358 m3_54868_n2380# VDD 0.01997f
C2359 sar_ctrl_async_phys_0.sg13g2_and2_1_5.X a_32400_41413# 0.1046f
C2360 sar_ctrl_async_phys_0.sg13g2_buf_1_2.X a_31328_33870# 0.11651f
C2361 sar_ctrl_async_phys_0.sg13g2_buf_1_2.X a_31898_32361# 0.26845f
C2362 sar_ctrl_async_phys_0.sg13g2_and2_1_2.X a_27206_39326# 0.09153f
C2363 sar_ctrl_async_phys_0.sg13g2_buf_1_5.A sar_ctrl_async_phys_0.sg13g2_inv_1_3.Y 0.01606f
C2364 a_26544_38389# VDD 0.4124f
C2365 sar_ctrl_async_phys_0.sg13g2_nand2_1_3.Y sar_ctrl_async_phys_0.dac_code[3] 0.03679f
C2366 sar_ctrl_async_phys_0.sg13g2_buf_1_14.A sar_ctrl_async_phys_0.sg13g2_a21oi_1_0.A1 0.05127f
C2367 a_27206_39326# track 0.02234f
C2368 sar_ctrl_async_phys_0.sg13g2_o21ai_1_1.B1 sar_ctrl_async_phys_0.sg13g2_o21ai_1_1.A2 0.37547f
C2369 sar_ctrl_async_phys_0.sg13g2_buf_1_2.X a_34106_30849# 0.26531f
C2370 a_34615_31475# a_35418_31668# 0.12701f
C2371 a_32406_45746# a_33109_45725# 0.02454f
C2372 a_28392_41214# VDD 0.31306f
C2373 sar_ctrl_async_phys_0.sg13g2_inv_1_1.A sar_ctrl_async_phys_0.sg13g2_inv_1_1.Y 0.0846f
C2374 a_35288_47296# sar_ctrl_async_phys_0.sg13g2_a21oi_1_6.B1 0.0127f
C2375 sar_ctrl_async_phys_0.sg13g2_buf_1_3.A a_34224_42058# 0.0219f
C2376 sar_ctrl_async_phys_0.sg13g2_a22oi_1_1.B2 a_31823_32876# 0.07329f
C2377 sar_ctrl_async_phys_0.sg13g2_buf_1_34.A sar_ctrl_async_phys_0.dac_code[1] 0.09879f
C2378 sar_ctrl_async_phys_0.sg13g2_a22oi_1_1.Y a_31189_31399# 0.01088f
C2379 sar_ctrl_async_phys_0.dac_code[1] oa_sar8_acore18_opt_0.sw_bitcell_opt_b7_0.bot 2.35385f
C2380 sar_ctrl_async_phys_0.sg13g2_o21ai_1_1.B1 sar_ctrl_async_phys_0.sg13g2_a21oi_1_7.Y 0.05026f
C2381 sar_ctrl_async_phys_0.dac_code_n[4] oa_sar8_acore18_opt_0.sw_bitcell_opt_b3_1.bot 0.10478f
C2382 sar_ctrl_async_phys_0.sg13g2_o21ai_1_1.B1 a_30752_39190# 0.103f
C2383 sar_ctrl_async_phys_0.dac_code_n[2] oa_sar8_acore18_opt_0.sw_bitcell_opt_b0_1.bot 0.06598f
C2384 a_30938_46476# VDD 0.09895f
C2385 sar_ctrl_async_phys_0.sg13g2_buf_1_14.A a_36056_35200# 0.26353f
C2386 sar_ctrl_async_phys_0.dac_code[4] a_35948_n9612# 2.00726f
C2387 sar_ctrl_async_phys_0.sg13g2_nor2_1_10.B a_30676_35928# 0.03365f
C2388 a_30774_44234# a_31348_44247# 0.31978f
C2389 a_31579_44356# a_32576_44454# 0.02979f
C2390 sar_ctrl_async_phys_0.sg13g2_nand2b_1_1.Y sar_ctrl_async_phys_0.sg13g2_a21oi_1_7.A2 0.802f
C2391 a_29755_38959# a_30752_39190# 0.03061f
C2392 a_29653_38959# a_30401_39309# 0.01058f
C2393 sar_ctrl_async_phys_0.sg13g2_dfrbpq_1_9.RESET_B a_31136_43726# 0.1063f
C2394 sar_ctrl_async_phys_0.sg13g2_nor2_1_1.Y a_33940_41223# 0.01086f
C2395 sar_ctrl_async_phys_0.sg13g2_nor2_1_3.A a_26630_37814# 0.10236f
C2396 a_30584_44366# sar_ctrl_async_phys_0.sg13g2_nor2_1_11.Y 0.03136f
C2397 sar_ctrl_async_phys_0.sg13g2_buf_1_14.A sar_ctrl_async_phys_0.sg13g2_buf_1_4.A 1.23816f
C2398 a_33750_36362# a_34555_35935# 0.097f
C2399 a_33936_31675# VDD 0.38175f
C2400 sar_ctrl_async_phys_0.sg13g2_dfrbpq_1_9.RESET_B sar_ctrl_async_phys_0.sg13g2_nand2_1_3.A 0.04313f
C2401 sar_ctrl_async_phys_0.sg13g2_buf_1_14.A sar_ctrl_async_phys_0.sg13g2_and2_1_0.B 0.16791f
C2402 sar_ctrl_async_phys_0.sg13g2_a21oi_1_6.B1 sar_ctrl_async_phys_0.sg13g2_dfrbpq_1_0.CLK 0.09238f
C2403 sar_ctrl_async_phys_0.sg13g2_and2_1_5.X sar_ctrl_async_phys_0.sg13g2_a21oi_1_2.B1 4.18393f
C2404 sar_ctrl_async_phys_0.dac_code_n[2] a_35948_n9612# 0.05817f
C2405 oa_sar8_acore18_opt_0.sw_tg_opt_0.bot oa_sar8_acore18_opt_0.sw_bitcell_opt_b1_0.bot 1.08378f
C2406 a_34442_45366# sar_ctrl_async_phys_0.sg13g2_buf_1_32.A 0.01579f
C2407 sar_ctrl_async_phys_0.sg13g2_buf_1_34.A sar_ctrl_async_phys_0.sg13g2_buf_1_20.A 1.37672f
C2408 sar_ctrl_async_phys_0.bit_active[6] a_35672_38224# 0.01077f
C2409 sar_ctrl_async_phys_0.sg13g2_nor2_1_10.B a_30027_39996# 0.16255f
C2410 sar_ctrl_async_phys_0.sg13g2_buf_1_2.A a_33750_36362# 0.11189f
C2411 a_33818_43452# a_34261_43495# 0.02242f
C2412 sar_ctrl_async_phys_0.sg13g2_dfrbpq_1_0.CLK sar_ctrl_async_phys_0.sg13g2_nor2_1_11.Y 0.29136f
C2413 a_27304_38928# VDD 0.01839f
C2414 sar_ctrl_async_phys_0.dac_code_n[0] oa_sar8_acore18_opt_0.sw_bitcell_opt_term_0.bot 4.37442f
C2415 sar_ctrl_async_phys_0.sg13g2_nor4_1_0.C sar_ctrl_async_phys_0.sg13g2_nor2_1_0.Y 0.01761f
C2416 sar_ctrl_async_phys_0.sg13g2_a21oi_1_2.B1 sar_ctrl_async_phys_0.sg13g2_buf_1_23.A 0.04014f
C2417 sar_ctrl_async_phys_0.dac_code[0] a_36056_42760# 0.01822f
C2418 sar_ctrl_async_phys_0.sg13g2_a22oi_1_3.A2 sar_ctrl_async_phys_0.sg13g2_a22oi_1_2.A2 0.64569f
C2419 a_35245_42242# a_35327_42342# 0.01117f
C2420 a_29524_40464# a_30043_40471# 0.34102f
C2421 a_29941_40471# a_29812_40885# 0.01562f
C2422 sar_ctrl_async_phys_0.sg13g2_nand2b_1_1.Y sar_ctrl_async_phys_0.sg13g2_dfrbpq_1_2.Q 0.01735f
C2423 a_34106_34380# a_34132_34416# 0.36952f
C2424 sar_ctrl_async_phys_0.sg13g2_buf_1_2.A a_33844_36992# 0.41127f
C2425 sar_ctrl_async_phys_0.sg13g2_a22oi_1_0.A1 VDD 1.61915f
C2426 sar_ctrl_async_phys_0.sg13g2_dfrbpq_1_0.CLK a_34132_34416# 0.07738f
C2427 a_33270_39698# a_33556_40016# 0.41329f
C2428 sar_ctrl_async_phys_0.sg13g2_dfrbpq_1_0.CLK a_33556_40016# 0.06918f
C2429 oa_sar8_acore18_opt_0.sw_bitcell_opt_term_0.trkb m3_41836_n2380# 0.03859f
C2430 sar_ctrl_async_phys_0.sg13g2_dlygate4sd3_1_5.A a_26270_39215# 0.16093f
C2431 sar_ctrl_async_phys_0.dac_code_n[5] oa_sar8_acore18_opt_0.sw_bitcell_opt_term_1.bot 0.06773f
C2432 a_33844_36992# a_34132_36687# 0.43707f
C2433 sar_ctrl_async_phys_0.sg13g2_buf_1_13.X sar_ctrl_async_phys_0.sg13g2_nor2_1_5.B 0.1237f
C2434 a_35028_n9612# VDD 0.8295f
C2435 sar_ctrl_async_phys_0.sg13g2_a21oi_1_4.B1 sar_ctrl_async_phys_0.sg13g2_buf_1_14.A 0.16535f
C2436 sar_ctrl_async_phys_0.sg13g2_buf_1_26.X a_26728_37416# 0.0162f
C2437 sar_ctrl_async_phys_0.dac_code_n[7] oa_sar8_acore18_opt_0.sw_bitcell_opt_term_0.gb 0.11198f
C2438 a_36056_42760# VDD 0.21757f
C2439 a_35952_39901# sar_ctrl_async_phys_0.dac_code[5] 0.01311f
C2440 sar_ctrl_async_phys_0.sg13g2_a22oi_1_0.B1 sar_ctrl_async_phys_0.sg13g2_inv_1_5.A 1.04129f
C2441 sar_ctrl_async_phys_0.sg13g2_buf_1_20.A a_36056_37436# 0.26901f
C2442 a_30384_35294# VDD 0.06815f
C2443 sar_ctrl_async_phys_0.sg13g2_a22oi_1_1.B2 a_31924_32456# 0.01952f
C2444 sar_ctrl_async_phys_0.sg13g2_nand3_1_0.Y VDD 0.62923f
C2445 sar_ctrl_async_phys_0.sg13g2_a21oi_1_2.B1 a_34904_38948# 0.01448f
C2446 sar_ctrl_async_phys_0.dac_code_n[0] m3_38288_n2380# 0.04726f
C2447 sar_ctrl_async_phys_0.sg13g2_buf_1_29.A VDD 0.58698f
C2448 sar_ctrl_async_phys_0.sg13g2_buf_1_35.A a_36056_42760# 0.02091f
C2449 sar_ctrl_async_phys_0.sg13g2_buf_1_6.A sar_ctrl_async_phys_0.sg13g2_buf_1_2.A 0.0637f
C2450 a_35725_45266# sar_ctrl_async_phys_0.sg13g2_nand2_1_2.B 0.0108f
C2451 a_35595_40460# VDD 0.29276f
C2452 sar_ctrl_async_phys_0.sg13g2_nor2_1_2.A a_34266_37436# 0.01495f
C2453 sar_ctrl_async_phys_0.sg13g2_buf_1_6.A a_34651_34423# 0.01068f
C2454 sar_ctrl_async_phys_0.sg13g2_buf_1_2.X a_35463_31435# 0.09317f
C2455 sar_ctrl_async_phys_0.dac_code_n[0] oa_sar8_acore18_opt_0.bstrap_opt_w2_c1200_1.gb 0.13844f
C2456 sar_ctrl_async_phys_0.sg13g2_dfrbpq_1_9.RESET_B a_31348_44247# 0.01184f
C2457 sar_ctrl_async_phys_0.sg13g2_a21oi_1_1.Y a_34520_33688# 0.04428f
C2458 sar_ctrl_async_phys_0.sg13g2_dfrbpq_1_0.CLK a_29653_38959# 0.25119f
C2459 sar_ctrl_async_phys_0.sg13g2_a21oi_1_5.B1 sar_ctrl_async_phys_0.sg13g2_a22oi_1_3.A2 0.20188f
C2460 sar_ctrl_async_phys_0.sg13g2_buf_1_20.A a_35103_43845# 0.01545f
C2461 a_31093_35935# VDD 0.25066f
C2462 sar_ctrl_async_phys_0.dac_code_n[6] sar_ctrl_async_phys_0.sample 0.04464f
C2463 sar_ctrl_async_phys_0.dac_code_n[3] sar_ctrl_async_phys_0.sample 0.04462f
C2464 sar_ctrl_async_phys_0.sg13g2_dfrbpq_1_9.RESET_B a_35360_43726# 0.09889f
C2465 sar_ctrl_async_phys_0.dac_code[7] oa_sar8_acore18_opt_0.sw_tg_opt_0.bot 0.93466f
C2466 sar_ctrl_async_phys_0.dac_code[5] oa_sar8_acore18_opt_0.sw_bitcell_opt_b5_0.bot 1.97955f
C2467 sar_ctrl_async_phys_0.dac_code_n[1] sar_ctrl_async_phys_0.dac_code[1] 0.05494f
C2468 sar_ctrl_async_phys_0.sg13g2_o21ai_1_1.B1 a_28950_39386# 0.09085f
C2469 sar_ctrl_async_phys_0.sg13g2_buf_1_14.A sar_ctrl_async_phys_0.sg13g2_nand2_1_3.Y 0.03718f
C2470 sar_ctrl_async_phys_0.sg13g2_a21oi_1_0.B1 sar_ctrl_async_phys_0.sg13g2_nand2_1_2.Y 0.14478f
C2471 sar_ctrl_async_phys_0.sample oa_sar8_acore18_opt_0.sw_bitcell_opt_term_0.trkb 12.3826f
C2472 a_30650_39921# VDD 0.09561f
C2473 sar_ctrl_async_phys_0.sg13g2_nor2_1_10.B sar_ctrl_async_phys_0.sg13g2_a22oi_1_0.B1 0.06145f
C2474 a_30774_44234# a_31477_44213# 0.02454f
C2475 sar_ctrl_async_phys_0.sg13g2_inv_1_1.Y a_31258_32436# 0.0146f
C2476 sar_ctrl_async_phys_0.sg13g2_buf_1_7.A VDD 0.52966f
C2477 a_29236_38952# a_29653_38959# 0.37583f
C2478 a_28950_39386# a_29755_38959# 0.097f
C2479 sar_ctrl_async_phys_0.sg13g2_nor2_1_4.Y a_26630_37814# 0.01472f
C2480 a_36056_38948# VDD 0.21706f
C2481 sar_ctrl_async_phys_0.sg13g2_dfrbpq_1_9.RESET_B a_33109_45725# 0.01222f
C2482 sar_ctrl_async_phys_0.cmp_valid sar_ctrl_async_phys_0.dac_code_n[5] 0.01127f
C2483 sar_ctrl_async_phys_0.sg13g2_a21oi_1_1.B1 sar_ctrl_async_phys_0.sg13g2_dfrbpq_1_9.RESET_B 0.01015f
C2484 sar_ctrl_async_phys_0.sg13g2_inv_1_3.Y VDD 0.71849f
C2485 oa_sar8_acore18_opt_0.sw_bitcell_opt_term_0.bot m3_60844_n2380# 1.5154f
C2486 sar_ctrl_async_phys_0.sg13g2_buf_1_22.A a_35288_38224# 0.01674f
C2487 a_33658_44996# a_34040_45082# 0.01012f
C2488 a_33558_43922# a_34261_43495# 0.02432f
C2489 oa_sar8_acore18_opt_0.sw_bitcell_opt_b3_0.bot m3_34580_n2380# 0.01914f
C2490 sar_ctrl_async_phys_0.dac_code_n[4] a_36056_46508# 0.02428f
C2491 sar_ctrl_async_phys_0.sample sar_ctrl_async_phys_0.cmp_p 0.47693f
C2492 sar_ctrl_async_phys_0.sg13g2_a21oi_1_2.B1 a_34815_39775# 0.02557f
C2493 sar_ctrl_async_phys_0.sg13g2_a21oi_1_0.A1 sar_ctrl_async_phys_0.sg13g2_nor2_1_10.B 1.81353f
C2494 sar_ctrl_async_phys_0.dac_code_n[6] sar_ctrl_async_phys_0.dac_code[6] 0.17593f
C2495 a_31832_34412# a_31640_34498# 0.01226f
C2496 sar_ctrl_async_phys_0.sg13g2_a21oi_1_0.A1 a_31563_43020# 0.03524f
C2497 sar_ctrl_async_phys_0.bit_active[3] VDD 0.23103f
C2498 sar_ctrl_async_phys_0.sg13g2_nand2b_1_0.Y a_28578_40460# 0.02356f
C2499 sar_ctrl_async_phys_0.dac_code_n[3] sar_ctrl_async_phys_0.dac_code[6] 0.13816f
C2500 w_39600_n9960# oa_sar8_acore18_opt_0.sw_bitcell_opt_b5_0.bot 0.01116f
C2501 sar_ctrl_async_phys_0.sg13g2_buf_1_32.A a_34520_42760# 0.26043f
C2502 sar_ctrl_async_phys_0.sg13g2_buf_1_25.A a_34136_33688# 0.25901f
C2503 sar_ctrl_async_phys_0.dac_code_n[4] oa_sar8_acore18_opt_0.bstrap_opt_w2_c1200_1.out 1.81036f
C2504 sar_ctrl_async_phys_0.sg13g2_dfrbpq_1_0.CLK sar_ctrl_async_phys_0.sg13g2_nor2b_1_1.B_N 0.20749f
C2505 a_33844_36992# a_34261_36653# 0.3749f
C2506 a_33558_36674# a_34363_36796# 0.097f
C2507 sar_ctrl_async_phys_0.sg13g2_nand2b_1_2.A_N a_35578_41508# 0.1278f
C2508 sar_ctrl_async_phys_0.dac_code[6] oa_sar8_acore18_opt_0.sw_bitcell_opt_term_0.trkb 2.10643f
C2509 a_36056_35200# sar_ctrl_async_phys_0.bit_active[4] 0.24512f
C2510 m3_48572_n2380# m3_51760_n2380# 0.0157f
C2511 sar_ctrl_async_phys_0.dac_code_n[4] sar_ctrl_async_phys_0.dac_code[3] 0.06321f
C2512 sar_ctrl_async_phys_0.sg13g2_a22oi_1_5.A2 a_30229_33629# 0.02156f
C2513 sar_ctrl_async_phys_0.sg13g2_buf_1_34.A sar_ctrl_async_phys_0.dac_code[4] 0.01313f
C2514 sar_ctrl_async_phys_0.sg13g2_o21ai_1_1.B1 a_31935_39775# 0.14613f
C2515 sar_ctrl_async_phys_0.sg13g2_dfrbpq_1_17.D VDD 0.59341f
C2516 sar_ctrl_async_phys_0.dac_code[4] oa_sar8_acore18_opt_0.sw_bitcell_opt_b7_0.bot 2.35443f
C2517 sar_ctrl_async_phys_0.sg13g2_nor2_1_7.A sar_ctrl_async_phys_0.sg13g2_nor2_1_5.B 1.67743f
C2518 sar_ctrl_async_phys_0.sg13g2_a21oi_1_1.B1 sar_ctrl_async_phys_0.sg13g2_a22oi_1_0.A2 0.02267f
C2519 sar_ctrl_async_phys_0.sg13g2_nor4_1_0.C sar_ctrl_async_phys_0.sg13g2_nand2b_1_0.Y 0.34663f
C2520 sar_ctrl_async_phys_0.sg13g2_and2_1_0.B sar_ctrl_async_phys_0.bit_active[4] 0.15852f
C2521 a_36336_43570# VDD 0.05617f
C2522 sar_ctrl_async_phys_0.sg13g2_a22oi_1_0.B1 sar_ctrl_async_phys_0.sg13g2_inv_1_5.Y 0.02755f
C2523 sar_ctrl_async_phys_0.sg13g2_a22oi_1_0.A1 a_34036_35928# 0.01081f
C2524 a_35295_36285# sar_ctrl_async_phys_0.bit_active[3] 0.01275f
C2525 sar_ctrl_async_phys_0.sg13g2_nand3b_1_0.Y VDD 0.73953f
C2526 sar_ctrl_async_phys_0.sg13g2_dfrbpq_1_9.RESET_B a_31477_44213# 0.08404f
C2527 sar_ctrl_async_phys_0.dac_code_n[2] sar_ctrl_async_phys_0.sg13g2_buf_1_34.A 0.13298f
C2528 a_33085_43832# sar_ctrl_async_phys_0.sg13g2_buf_1_14.A 0.10548f
C2529 sar_ctrl_async_phys_0.sg13g2_a22oi_1_2.A2 a_33252_36642# 0.05757f
C2530 sar_ctrl_async_phys_0.sg13g2_a21oi_1_1.Y result[5] 0.02084f
C2531 sar_ctrl_async_phys_0.dac_code_n[2] oa_sar8_acore18_opt_0.sw_bitcell_opt_b7_0.bot 1.68148f
C2532 sar_ctrl_async_phys_0.dac_code[5] oa_sar8_acore18_opt_0.sw_bitcell_opt_b1_0.bot 0.15267f
C2533 sar_ctrl_async_phys_0.dac_code[6] oa_sar8_acore18_opt_0.sw_bitcell_opt_b4_0.bot 0.55445f
C2534 a_33846_33338# result[5] 0.02357f
C2535 a_31136_43726# VDD 0.16934f
C2536 sar_ctrl_async_phys_0.sg13g2_buf_1_2.X a_35384_32176# 0.24957f
C2537 sar_ctrl_async_phys_0.sg13g2_nand2_1_3.A VDD 1.07126f
C2538 a_28176_39830# VDD 0.08875f
C2539 a_32245_37447# a_32347_37447# 0.47795f
C2540 sar_ctrl_async_phys_0.sg13g2_nand2_1_3.A sar_ctrl_async_phys_0.sg13g2_buf_1_35.A 0.90319f
C2541 sar_ctrl_async_phys_0.sg13g2_a21oi_1_1.B1 sar_ctrl_async_phys_0.sg13g2_nor2b_1_0.A 0.05088f
C2542 sar_ctrl_async_phys_0.sg13g2_buf_1_3.A a_33440_32358# 0.01105f
C2543 sar_ctrl_async_phys_0.hold_req oa_sar8_acore18_opt_0.sw_tg_opt_1.bot 0.09393f
C2544 sar_ctrl_async_phys_0.sg13g2_a21oi_1_4.B1 sar_ctrl_async_phys_0.dac_code_n[4] 0.05338f
C2545 sar_ctrl_async_phys_0.sg13g2_nor4_1_0.Y sar_ctrl_async_phys_0.sg13g2_dlygate4sd3_1_8.A 0.02013f
C2546 sar_ctrl_async_phys_0.sg13g2_a21oi_1_0.A2 sar_ctrl_async_phys_0.bit_active[3] 0.04287f
C2547 sar_ctrl_async_phys_0.sg13g2_a21oi_1_6.A2 a_32991_45357# 0.04618f
C2548 sar_ctrl_async_phys_0.sg13g2_a21oi_1_6.B1 a_34228_44247# 0.01281f
C2549 sar_ctrl_async_phys_0.sg13g2_nor2_1_11.A a_30480_42854# 0.01901f
C2550 a_32251_45007# a_33248_45238# 0.03061f
C2551 sar_ctrl_async_phys_0.sg13g2_nand2_1_2.A a_35245_45936# 0.01779f
C2552 sar_ctrl_async_phys_0.sg13g2_dfrbpq_1_0.CLK a_30676_35928# 0.10259f
C2553 sar_ctrl_async_phys_0.sg13g2_buf_1_13.A a_33652_41528# 0.0135f
C2554 sar_ctrl_async_phys_0.sg13g2_dlygate4sd3_1_0.A a_28488_35965# 0.45808f
C2555 a_27624_35965# a_27894_35924# 0.26306f
C2556 sar_ctrl_async_phys_0.sg13g2_a21oi_1_2.B1 sar_ctrl_async_phys_0.sg13g2_nor2_1_10.Y 0.06013f
C2557 sar_ctrl_async_phys_0.sg13g2_nand2_1_2.A a_34459_44356# 0.02064f
C2558 sar_ctrl_async_phys_0.sg13g2_a21oi_1_0.B1 a_35456_44454# 0.03469f
C2559 sar_ctrl_async_phys_0.sg13g2_dfrbpq_1_9.RESET_B sar_ctrl_async_phys_0.sg13g2_nor2_1_1.Y 0.1277f
C2560 sar_ctrl_async_phys_0.sg13g2_a21oi_1_6.A2 a_33072_42854# 0.01858f
C2561 sar_ctrl_async_phys_0.sg13g2_nor2b_1_4.Y a_32580_43448# 0.24682f
C2562 sar_ctrl_async_phys_0.sg13g2_dlygate4sd3_1_3.A a_29238_41972# 0.01189f
C2563 sar_ctrl_async_phys_0.sg13g2_nand2_1_0.B sar_ctrl_async_phys_0.sg13g2_nor2_1_7.Y 0.12629f
C2564 sar_ctrl_async_phys_0.sg13g2_dfrbpq_1_9.RESET_B sar_ctrl_async_phys_0.sg13g2_a22oi_1_1.A2 0.21485f
C2565 sar_ctrl_async_phys_0.sg13g2_nor2b_1_4.Y sar_ctrl_async_phys_0.sg13g2_dfrbpq_1_9.D 0.08747f
C2566 sar_ctrl_async_phys_0.sg13g2_dfrbpq_1_0.CLK a_31195_39820# 0.01759f
C2567 sar_ctrl_async_phys_0.sg13g2_dfrbpq_1_0.CLK a_30027_39996# 0.02184f
C2568 a_34549_32911# a_34651_32911# 0.47795f
C2569 sar_ctrl_async_phys_0.sg13g2_a22oi_1_3.A2 sar_ctrl_async_phys_0.sg13g2_a22oi_1_0.A1 0.15072f
C2570 sar_ctrl_async_phys_0.dac_code[5] sar_ctrl_async_phys_0.dac_code[7] 0.23378f
C2571 m3_34580_n2380# m3_38288_n2380# 0.0157f
C2572 sar_ctrl_async_phys_0.sg13g2_buf_1_2.A a_34136_33688# 0.04658f
C2573 a_33368_44366# VDD 0.12744f
C2574 sar_ctrl_async_phys_0.sg13g2_dfrbpq_1_11.D a_31716_38912# 0.04916f
C2575 sar_ctrl_async_phys_0.dac_code_n[5] sar_ctrl_async_phys_0.dac_code[1] 0.06252f
C2576 sar_ctrl_async_phys_0.sg13g2_a21oi_1_0.A1 a_35482_39996# 0.04585f
C2577 sar_ctrl_async_phys_0.dac_code_n[1] sar_ctrl_async_phys_0.dac_code[4] 0.05494f
C2578 sar_ctrl_async_phys_0.sg13g2_buf_1_1.A result[5] 0.03402f
C2579 sar_ctrl_async_phys_0.sg13g2_a22oi_1_1.A2 a_31828_37440# 0.01779f
C2580 sar_ctrl_async_phys_0.sg13g2_a22oi_1_1.A2 sar_ctrl_async_phys_0.sg13g2_buf_1_5.A 0.10726f
C2581 sar_ctrl_async_phys_0.sg13g2_buf_1_8.A result[6] 0.25255f
C2582 a_35360_43726# VDD 0.16937f
C2583 a_30043_40471# VDD 0.20722f
C2584 sar_ctrl_async_phys_0.dac_code_n[0] oa_sar8_acore18_opt_0.sw_bitcell_opt_term_0.vin 0.39545f
C2585 sar_ctrl_async_phys_0.dac_code[6] oa_sar8_acore18_opt_0.sw_bitcell_opt_b0_0.bot 0.37274f
C2586 sar_ctrl_async_phys_0.dac_code_n[2] sar_ctrl_async_phys_0.dac_code_n[1] 28.652f
C2587 sar_ctrl_async_phys_0.sg13g2_dfrbpq_1_9.RESET_B a_34236_46472# 0.24507f
C2588 a_30964_46512# a_32223_46869# 0.01529f
C2589 sar_ctrl_async_phys_0.sg13g2_buf_1_14.A sar_ctrl_async_phys_0.bit_active[4] 0.91059f
C2590 sar_ctrl_async_phys_0.sg13g2_o21ai_1_1.B1 sar_ctrl_async_phys_0.sg13g2_a22oi_1_5.A2 0.19457f
C2591 sar_ctrl_async_phys_0.sample oa_sar8_acore18_opt_0.sw_bitcell_opt_b0_1.bot 1.57868f
C2592 sar_ctrl_async_phys_0.sg13g2_buf_1_4.A a_35962_35924# 0.05381f
C2593 sar_ctrl_async_phys_0.sg13g2_nor2_1_1.Y sar_ctrl_async_phys_0.sg13g2_a22oi_1_0.A2 0.14195f
C2594 sar_ctrl_async_phys_0.sg13g2_and2_1_0.B a_35962_35924# 0.12547f
C2595 sar_ctrl_async_phys_0.sg13g2_buf_1_3.A sar_ctrl_async_phys_0.sg13g2_buf_1_13.A 0.02428f
C2596 sar_ctrl_async_phys_0.sg13g2_nand2b_1_7.A_N a_35866_44532# 0.04799f
C2597 a_33109_45725# VDD 0.24774f
C2598 sar_ctrl_async_phys_0.sg13g2_a21oi_1_0.B1 sar_ctrl_async_phys_0.sg13g2_nand2b_1_1.Y 0.99294f
C2599 sar_ctrl_async_phys_0.sg13g2_nor2_1_2.A a_33558_36674# 0.02748f
C2600 sar_ctrl_async_phys_0.sg13g2_a21oi_1_1.B1 VDD 0.86228f
C2601 sar_ctrl_async_phys_0.sg13g2_buf_1_4.A a_36058_34412# 0.04867f
C2602 sar_ctrl_async_phys_0.sg13g2_nand2_1_2.A a_34363_43495# 0.01611f
C2603 sar_ctrl_async_phys_0.sg13g2_a21oi_1_0.B1 sar_ctrl_async_phys_0.sg13g2_nand2b_1_2.Y 0.73234f
C2604 sar_ctrl_async_phys_0.sg13g2_buf_1_3.A a_34042_40460# 0.05377f
C2605 w_39600_n9960# sar_ctrl_async_phys_0.dac_code[7] 0.02244f
C2606 sar_ctrl_async_phys_0.sg13g2_a21oi_1_1.B1 sar_ctrl_async_phys_0.sg13g2_buf_1_35.A 0.02612f
C2607 sar_ctrl_async_phys_0.dac_code_n[7] oa_sar8_acore18_opt_0.sw_bitcell_opt_b3_0.bot 0.0722f
C2608 sar_ctrl_async_phys_0.sg13g2_inv_1_1.A a_32687_32876# 0.1579f
C2609 sar_ctrl_async_phys_0.cmp_p a_30632_22281# 1.10635f
C2610 oa_sar8_acore18_opt_0.sw_tg_opt_1.bot vinp 0.12658f
C2611 a_30964_36349# a_31195_35935# 0.12701f
C2612 sar_ctrl_async_phys_0.sg13g2_nand3_1_0.A a_26184_39702# 0.45185f
C2613 sar_ctrl_async_phys_0.sg13g2_buf_1_6.A a_35288_38224# 0.24851f
C2614 sar_ctrl_async_phys_0.sg13g2_buf_1_32.A sar_ctrl_async_phys_0.dac_code_n[7] 0.03253f
C2615 sar_ctrl_async_phys_0.dac_code_n[2] vcm 0.06598f
C2616 sar_ctrl_async_phys_0.sg13g2_a21oi_1_5.B1 a_33940_44552# 0.02128f
C2617 sar_ctrl_async_phys_0.sg13g2_o21ai_1_1.B1 sar_ctrl_async_phys_0.sg13g2_nand2_1_3.B 0.12846f
C2618 sar_ctrl_async_phys_0.sg13g2_a22oi_1_0.B2 a_34549_30605# 0.01164f
C2619 sar_ctrl_async_phys_0.sg13g2_nand2b_1_1.Y sar_ctrl_async_phys_0.sg13g2_o21ai_1_1.B1 0.04764f
C2620 sar_ctrl_async_phys_0.sg13g2_dfrbpq_1_0.CLK sar_ctrl_async_phys_0.sg13g2_a22oi_1_0.B1 1.17389f
C2621 sar_ctrl_async_phys_0.sg13g2_a22oi_1_3.A2 sar_ctrl_async_phys_0.sg13g2_inv_1_3.Y 0.01044f
C2622 sar_ctrl_async_phys_0.sg13g2_a21oi_1_4.B1 sar_ctrl_async_phys_0.sg13g2_nand2_1_2.A 0.02389f
C2623 sar_ctrl_async_phys_0.sg13g2_a21oi_1_6.B1 a_35672_46508# 0.04152f
C2624 sar_ctrl_async_phys_0.sg13g2_nor2b_1_0.A sar_ctrl_async_phys_0.sg13g2_nor2_1_1.Y 0.01707f
C2625 sar_ctrl_async_phys_0.sg13g2_a22oi_1_1.A2 sar_ctrl_async_phys_0.sg13g2_nor2b_1_0.A 0.13062f
C2626 sar_ctrl_async_phys_0.sg13g2_nand2b_1_2.Y sar_ctrl_async_phys_0.sg13g2_o21ai_1_1.B1 0.02233f
C2627 sar_ctrl_async_phys_0.sg13g2_nor4_1_0.C sar_ctrl_async_phys_0.sg13g2_dfrbpq_1_9.Q 0.03649f
C2628 sar_ctrl_async_phys_0.sg13g2_a21oi_1_0.B1 a_35168_41430# 0.02044f
C2629 sar_ctrl_async_phys_0.sg13g2_buf_1_5.A sar_ctrl_async_phys_0.sg13g2_a22oi_1_1.Y 0.07783f
C2630 sar_ctrl_async_phys_0.dac_code[3] oa_sar8_acore18_opt_0.sw_tg_opt_0.bot 0.88659f
C2631 sar_ctrl_async_phys_0.sg13g2_dfrbpq_1_0.CLK a_30139_43495# 0.03291f
C2632 a_34549_30605# a_34420_30639# 0.01562f
C2633 a_31093_39677# a_30964_39711# 0.01562f
C2634 sar_ctrl_async_phys_0.sg13g2_nand3_1_0.Y a_27206_39326# 0.05687f
C2635 a_32991_35239# VDD 0.1809f
C2636 sar_ctrl_async_phys_0.sg13g2_buf_1_33.A a_36056_41972# 0.04616f
C2637 sar_ctrl_async_phys_0.sg13g2_buf_1_25.A result[4] 0.34601f
C2638 sar_ctrl_async_phys_0.sg13g2_nor2_1_12.B sar_ctrl_async_phys_0.sg13g2_dlygate4sd3_1_4.A 0.03968f
C2639 sar_ctrl_async_phys_0.sg13g2_buf_1_13.X sar_ctrl_async_phys_0.sg13g2_buf_1_20.A 0.07728f
C2640 sar_ctrl_async_phys_0.sg13g2_dfrbpq_1_0.CLK a_34459_44356# 0.03696f
C2641 a_20412_n9612# a_21332_n9711# 0.23797f
C2642 a_33344_37678# VDD 0.17178f
C2643 sar_ctrl_async_phys_0.sg13g2_dfrbpq_1_2.Q sar_ctrl_async_phys_0.sg13g2_a21oi_1_1.Y 0.16201f
C2644 a_31477_44213# VDD 0.24283f
C2645 sar_ctrl_async_phys_0.sg13g2_a22oi_1_0.B1 a_34895_32460# 0.06148f
C2646 sar_ctrl_async_phys_0.sg13g2_nor2_1_4.Y a_26566_41996# 0.05084f
C2647 sar_ctrl_async_phys_0.sg13g2_dfrbpq_1_0.CLK sar_ctrl_async_phys_0.sg13g2_a21oi_1_0.A1 1.58048f
C2648 sar_ctrl_async_phys_0.dac_code[6] a_35948_n9612# 1.03492f
C2649 sar_ctrl_async_phys_0.sg13g2_a21oi_1_5.B1 sar_ctrl_async_phys_0.cmp_valid 0.1153f
C2650 sar_ctrl_async_phys_0.sg13g2_o21ai_1_1.B1 a_35168_41430# 0.10165f
C2651 oa_sar8_acore18_opt_0.sw_bitcell_opt_term_0.vin m3_60844_n2380# 0.05057f
C2652 sar_ctrl_async_phys_0.sg13g2_a22oi_1_1.A2 a_32635_40471# 0.01547f
C2653 sar_ctrl_async_phys_0.sg13g2_a21oi_1_6.B1 a_33914_44457# 0.01866f
C2654 a_31291_31399# a_32288_31630# 0.03061f
C2655 a_30507_35204# a_30384_35294# 0.01108f
C2656 sar_ctrl_async_phys_0.sg13g2_buf_1_5.A sar_ctrl_async_phys_0.sg13g2_inv_1_0.A 0.1769f
C2657 oa_sar8_acore18_opt_0.sw_bitcell_opt_b3_1.bot a_20412_n9612# 0.02079f
C2658 oa_sar8_acore18_opt_0.sw_tg_opt_1.bot VDD 1.11363f
C2659 sar_ctrl_async_phys_0.sample oa_sar8_acore18_opt_0.sw_bitcell_opt_b4_1.bot 1.76782f
C2660 sar_ctrl_async_phys_0.sg13g2_nand2_1_3.A a_35245_45266# 0.29543f
C2661 a_35648_33142# VDD 0.17045f
C2662 sar_ctrl_async_phys_0.sg13g2_nor2_1_4.Y a_26570_42690# 0.0612f
C2663 sar_ctrl_async_phys_0.sg13g2_a21oi_1_0.A1 a_31640_41342# 0.01078f
C2664 sar_ctrl_async_phys_0.sg13g2_buf_1_13.A a_31802_37404# 0.02038f
C2665 sar_ctrl_async_phys_0.sg13g2_a21oi_1_6.B1 a_34132_43909# 0.02385f
C2666 sar_ctrl_async_phys_0.sg13g2_and2_1_0.B a_34453_35935# 0.01107f
C2667 sar_ctrl_async_phys_0.sg13g2_a21oi_1_0.A1 a_29236_38952# 0.019f
C2668 sar_ctrl_async_phys_0.sg13g2_dlygate4sd3_1_9.X a_26666_38912# 0.41101f
C2669 a_35053_40730# a_35135_40830# 0.01117f
C2670 sar_ctrl_async_phys_0.sg13g2_nand2_1_1.B a_35053_40730# 0.1766f
C2671 sar_ctrl_async_phys_0.sg13g2_a22oi_1_0.A1 a_30480_32986# 0.01945f
C2672 sar_ctrl_async_phys_0.sg13g2_nor2_1_6.A sar_ctrl_async_phys_0.sg13g2_nand2_1_0.B 0.11068f
C2673 a_34904_46508# sar_ctrl_async_phys_0.sg13g2_dfrbpq_1_9.Q 0.05009f
C2674 a_34042_40460# sar_ctrl_async_phys_0.sg13g2_nand2_1_1.B 0.11661f
C2675 sar_ctrl_async_phys_0.sg13g2_buf_1_2.A a_33754_37436# 0.01567f
C2676 sar_ctrl_async_phys_0.sg13g2_a22oi_1_0.A2 sar_ctrl_async_phys_0.sg13g2_inv_1_0.A 0.02355f
C2677 sar_ctrl_async_phys_0.sg13g2_buf_1_14.A a_35962_35924# 0.02342f
C2678 sar_ctrl_async_phys_0.dac_code_n[7] oa_sar8_acore18_opt_0.sw_bitcell_opt_term_0.bot 0.07986f
C2679 sar_ctrl_async_phys_0.dac_code_n[0] sar_ctrl_async_phys_0.dac_code[2] 0.06405f
C2680 sar_ctrl_async_phys_0.sg13g2_dfrbpq_1_0.CLK sar_ctrl_async_phys_0.sg13g2_buf_1_4.A 0.17267f
C2681 sar_ctrl_async_phys_0.sg13g2_nor2_1_1.Y sar_ctrl_async_phys_0.sg13g2_nor2b_1_3.Y 0.0145f
C2682 sar_ctrl_async_phys_0.sg13g2_buf_1_5.A a_31898_32361# 0.01636f
C2683 a_25680_39034# track 0.01781f
C2684 sar_ctrl_async_phys_0.sg13g2_a22oi_1_1.A2 sar_ctrl_async_phys_0.sg13g2_nor2b_1_3.Y 0.02716f
C2685 a_30650_35892# a_30676_35928# 0.36952f
C2686 a_31924_32456# a_32443_32260# 0.34114f
C2687 sar_ctrl_async_phys_0.sg13g2_buf_1_13.X sar_ctrl_async_phys_0.sg13g2_nor2_1_0.A 0.09997f
C2688 sar_ctrl_async_phys_0.sg13g2_buf_1_13.A sar_ctrl_async_phys_0.sg13g2_nor2_1_0.A 0.68571f
C2689 sar_ctrl_async_phys_0.sg13g2_a21oi_1_6.B1 a_35672_47296# 0.2768f
C2690 a_31483_46519# a_32480_46750# 0.03061f
C2691 sar_ctrl_async_phys_0.sg13g2_nor2_1_10.B sar_ctrl_async_phys_0.sg13g2_buf_1_0.A 0.41477f
C2692 sar_ctrl_async_phys_0.sg13g2_nor2_1_1.Y VDD 0.67154f
C2693 a_34765_42242# sar_ctrl_async_phys_0.sg13g2_a21oi_1_2.B1 0.1863f
C2694 a_35772_41936# a_36056_41972# 0.09867f
C2695 sar_ctrl_async_phys_0.sg13g2_dfrbpq_1_11.D a_31841_39775# 0.01287f
C2696 sar_ctrl_async_phys_0.sg13g2_a22oi_1_1.A2 VDD 1.48441f
C2697 sar_ctrl_async_phys_0.sg13g2_buf_1_6.A sar_ctrl_async_phys_0.bit_active[5] 0.11524f
C2698 sar_ctrl_async_phys_0.sg13g2_buf_1_35.A sar_ctrl_async_phys_0.sg13g2_nor2_1_1.Y 0.01958f
C2699 sar_ctrl_async_phys_0.dac_code_n[5] sar_ctrl_async_phys_0.dac_code[4] 0.06252f
C2700 sar_ctrl_async_phys_0.sg13g2_dfrbpq_1_0.CLK sar_ctrl_async_phys_0.sg13g2_buf_1_8.A 0.05404f
C2701 sar_ctrl_async_phys_0.sg13g2_nand2b_1_1.Y sar_ctrl_async_phys_0.sg13g2_buf_1_6.A 0.83633f
C2702 sar_ctrl_async_phys_0.sg13g2_buf_1_35.A sar_ctrl_async_phys_0.sg13g2_a22oi_1_1.A2 0.01716f
C2703 sar_ctrl_async_phys_0.dac_code_n[7] m3_38288_n2380# 0.03354f
C2704 sar_ctrl_async_phys_0.sg13g2_dfrbpq_1_0.CLK a_29334_43922# 0.01767f
C2705 a_34132_30944# a_34651_30748# 0.34114f
C2706 sar_ctrl_async_phys_0.sg13g2_a22oi_1_0.B1 sar_ctrl_async_phys_0.sg13g2_buf_1_2.X 0.16894f
C2707 sar_ctrl_async_phys_0.sg13g2_buf_1_3.A sar_ctrl_async_phys_0.sg13g2_a22oi_1_2.A2 0.34131f
C2708 sar_ctrl_async_phys_0.sg13g2_nand2b_1_2.Y sar_ctrl_async_phys_0.sg13g2_buf_1_6.A 0.04187f
C2709 a_31446_35162# VDD 0.77428f
C2710 a_31093_39677# a_31195_39820# 0.47622f
C2711 sar_ctrl_async_phys_0.dac_code[3] m3_48572_n2380# 0.04448f
C2712 sar_ctrl_async_phys_0.sg13g2_dfrbpq_1_0.CLK a_32692_46064# 0.09682f
C2713 sar_ctrl_async_phys_0.sg13g2_a21oi_1_1.Y a_33846_33338# 0.04753f
C2714 sar_ctrl_async_phys_0.sg13g2_dfrbpq_1_22.D a_30390_39698# 0.29076f
C2715 a_30650_39921# a_30676_40016# 0.36952f
C2716 sar_ctrl_async_phys_0.dac_code_n[7] oa_sar8_acore18_opt_0.bstrap_opt_w2_c1200_1.gb 0.22148f
C2717 sar_ctrl_async_phys_0.dac_code_n[2] sar_ctrl_async_phys_0.dac_code_n[5] 0.14629f
C2718 sar_ctrl_async_phys_0.sg13g2_buf_1_13.X a_31933_43832# 0.28471f
C2719 VDD result[1] 0.20796f
C2720 sar_ctrl_async_phys_0.sg13g2_nand2_1_3.A a_35672_42760# 0.01475f
C2721 sar_ctrl_async_phys_0.sg13g2_buf_1_2.A result[4] 0.02253f
C2722 sar_ctrl_async_phys_0.sg13g2_nor4_1_0.C sar_ctrl_async_phys_0.sg13g2_o21ai_1_1.A2 0.02755f
C2723 sar_ctrl_async_phys_0.sg13g2_nor2b_1_0.A a_34596_40424# 0.06063f
C2724 a_33183_32215# VDD 0.17628f
C2725 sar_ctrl_async_phys_0.dac_code_n[7] oa_sar8_acore18_opt_0.sw_bitcell_opt_b1_1.bot 0.16095f
C2726 a_34236_46472# VDD 0.22033f
C2727 sar_ctrl_async_phys_0.sg13g2_o21ai_1_1.B1 a_33626_41433# 0.26264f
C2728 oa_sar8_acore18_opt_0.sw_bitcell_opt_term_0.vin m3_34580_n2380# 0.05057f
C2729 sar_ctrl_async_phys_0.sg13g2_a22oi_1_1.A2 a_31830_40898# 0.02893f
C2730 sar_ctrl_async_phys_0.sg13g2_nand2_1_3.B a_34520_42760# 0.02016f
C2731 sar_ctrl_async_phys_0.sg13g2_buf_1_13.X sar_ctrl_async_phys_0.sg13g2_and2_1_5.X 0.19146f
C2732 sar_ctrl_async_phys_0.sg13g2_and2_1_5.X sar_ctrl_async_phys_0.sg13g2_buf_1_13.A 0.01457f
C2733 sar_ctrl_async_phys_0.sg13g2_dfrbpq_1_2.Q sar_ctrl_async_phys_0.sg13g2_buf_1_22.A 0.02974f
C2734 sar_ctrl_async_phys_0.sg13g2_buf_1_13.X sar_ctrl_async_phys_0.sg13g2_buf_1_16.A 0.04175f
C2735 sar_ctrl_async_phys_0.sg13g2_nor4_1_0.C sar_ctrl_async_phys_0.sg13g2_a21oi_1_7.Y 0.01848f
C2736 a_28008_23477# oa_sar8_acore18_opt_0.sw_tg_opt_0.bot 0.84269f
C2737 oa_sar8_acore18_opt_0.sw_tg_opt_1.bot a_26184_21025# 0.8014f
C2738 sar_ctrl_async_phys_0.sg13g2_buf_1_25.A sar_ctrl_async_phys_0.sg13g2_a22oi_1_5.Y 0.51288f
C2739 a_35648_30846# VDD 0.16813f
C2740 sar_ctrl_async_phys_0.sg13g2_nand2b_1_2.Y a_34520_42760# 0.01944f
C2741 sar_ctrl_async_phys_0.sg13g2_and2_1_5.X a_35053_40730# 0.01209f
C2742 a_30671_32876# VDD 0.30337f
C2743 sar_ctrl_async_phys_0.sg13g2_a21oi_1_5.B1 sar_ctrl_async_phys_0.sg13g2_buf_1_3.A 0.02178f
C2744 sar_ctrl_async_phys_0.sg13g2_a21oi_1_1.B1 a_35245_45266# 0.3169f
C2745 sar_ctrl_async_phys_0.sg13g2_nor4_1_0.C sar_ctrl_async_phys_0.sg13g2_buf_1_32.A 0.05453f
C2746 sar_ctrl_async_phys_0.bit_active[1] result[7] 0.03731f
C2747 a_31034_44457# a_31477_44213# 0.02242f
C2748 sar_ctrl_async_phys_0.sg13g2_nor2_1_11.Y a_30774_44234# 0.27282f
C2749 sar_ctrl_async_phys_0.sg13g2_inv_1_5.Y sar_ctrl_async_phys_0.sg13g2_inv_1_5.A 0.08186f
C2750 sar_ctrl_async_phys_0.sg13g2_buf_1_13.A sar_ctrl_async_phys_0.sg13g2_buf_1_23.A 0.01981f
C2751 sar_ctrl_async_phys_0.dac_code_n[5] a_36156_45710# 0.02101f
C2752 sar_ctrl_async_phys_0.sg13g2_a22oi_1_1.Y VDD 0.49984f
C2753 a_32635_40471# a_33375_40821# 0.26905f
C2754 sar_ctrl_async_phys_0.sg13g2_a21oi_1_1.Y a_34731_37436# 0.17802f
C2755 a_30229_33629# a_30100_33663# 0.01562f
C2756 a_25596_43448# sar_ctrl_async_phys_0.sg13g2_nor2_1_13.Y 0.26353f
C2757 sar_ctrl_async_phys_0.sg13g2_buf_1_33.A sar_ctrl_async_phys_0.dac_code[3] 0.25519f
C2758 sar_ctrl_async_phys_0.sg13g2_a21oi_1_3.A2 a_35952_39901# 0.25323f
C2759 sar_ctrl_async_phys_0.sg13g2_a22oi_1_0.B1 sar_ctrl_async_phys_0.sg13g2_inv_1_2.A 0.39807f
C2760 sar_ctrl_async_phys_0.dac_code[3] sar_ctrl_async_phys_0.dac_code[5] 0.84643f
C2761 sar_ctrl_async_phys_0.sg13g2_a21oi_1_2.A2 a_31261_38232# 0.27841f
C2762 VDD result[2] 0.2997f
C2763 sar_ctrl_async_phys_0.sg13g2_buf_1_4.A a_33818_36897# 0.01631f
C2764 sar_ctrl_async_phys_0.sg13g2_dfrbpq_1_0.CLK a_32347_37447# 0.01997f
C2765 sar_ctrl_async_phys_0.sg13g2_dfrbpq_1_0.CLK a_31060_44552# 0.09101f
C2766 sar_ctrl_async_phys_0.sg13g2_nand2_1_0.B sar_ctrl_async_phys_0.sg13g2_dlygate4sd3_1_1.X 0.14779f
C2767 sar_ctrl_async_phys_0.bit_active[0] sar_ctrl_async_phys_0.bit_active[1] 0.11588f
C2768 sar_ctrl_async_phys_0.sg13g2_dlygate4sd3_1_1.X a_28862_36863# 0.16603f
C2769 sar_ctrl_async_phys_0.sg13g2_dlygate4sd3_1_5.A sar_ctrl_async_phys_0.sg13g2_dlygate4sd3_1_4.X 0.03088f
C2770 a_33464_30664# result[0] 0.09521f
C2771 sar_ctrl_async_phys_0.sg13g2_inv_1_9.Y sar_ctrl_async_phys_0.sg13g2_dlygate4sd3_1_7.X 0.0562f
C2772 sar_ctrl_async_phys_0.sg13g2_nor4_1_0.Y VDD 0.65895f
C2773 sar_ctrl_async_phys_0.sg13g2_a21oi_1_2.B1 sar_ctrl_async_phys_0.sg13g2_dfrbpq_1_11.D 0.05813f
C2774 sar_ctrl_async_phys_0.dac_code_n[6] oa_sar8_acore18_opt_0.sw_bitcell_opt_term_0.gb 0.15158f
C2775 sar_ctrl_async_phys_0.sg13g2_dfrbpq_1_0.CLK sar_ctrl_async_phys_0.sg13g2_buf_1_14.A 0.27922f
C2776 oa_sar8_acore18_opt_0.sw_bitcell_opt_b5_0.bot oa_sar8_acore18_opt_0.sw_bitcell_opt_term_0.VSS 2.09854f
C2777 sar_ctrl_async_phys_0.dac_code_n[3] oa_sar8_acore18_opt_0.sw_bitcell_opt_term_0.gb 0.06524f
C2778 sar_ctrl_async_phys_0.sg13g2_nor2_1_0.Y a_32400_41413# 0.03906f
C2779 sar_ctrl_async_phys_0.sg13g2_and2_1_5.X a_34800_39034# 0.0218f
C2780 sar_ctrl_async_phys_0.sg13g2_o21ai_1_1.B1 sar_ctrl_async_phys_0.sg13g2_a21oi_1_7.A2 0.04721f
C2781 sar_ctrl_async_phys_0.sg13g2_dfrbpq_1_0.CLK a_29941_40471# 0.31552f
C2782 sar_ctrl_async_phys_0.sg13g2_dfrbpq_1_17.D a_30772_31392# 0.0143f
C2783 sar_ctrl_async_phys_0.hold_req oa_sar8_acore18_opt_0.sw_bitcell_opt_b5_0.bot 0.08873f
C2784 sar_ctrl_async_phys_0.dac_code[6] oa_sar8_acore18_opt_0.sw_bitcell_opt_b7_0.bot 2.37893f
C2785 sar_ctrl_async_phys_0.sg13g2_dfrbpq_1_11.D sar_ctrl_async_phys_0.sg13g2_dfrbpq_1_22.D 0.10912f
C2786 sar_ctrl_async_phys_0.sg13g2_nor2_1_7.A sar_ctrl_async_phys_0.sg13g2_dlygate4sd3_1_0.X 0.03601f
C2787 sar_ctrl_async_phys_0.sg13g2_a21oi_1_0.B1 sar_ctrl_async_phys_0.sg13g2_dfrbpq_1_2.Q 0.01078f
C2788 sar_ctrl_async_phys_0.sg13g2_a21oi_1_7.A2 a_32792_41342# 0.01787f
C2789 sar_ctrl_async_phys_0.sg13g2_dfrbpq_1_0.CLK a_34651_32911# 0.01595f
C2790 sar_ctrl_async_phys_0.sg13g2_a21oi_1_0.A1 a_35697_40808# 0.01199f
C2791 a_31546_43484# sar_ctrl_async_phys_0.sg13g2_a21oi_1_4.A2 0.13046f
C2792 sar_ctrl_async_phys_0.sg13g2_nand2_1_3.A a_35245_42242# 0.35258f
C2793 oa_sar8_acore18_opt_0.bstrap_opt_w2_c1200_1.out a_20412_n9612# 0.06429f
C2794 oa_sar8_acore18_opt_0.sw_bitcell_opt_term_0.trkb oa_sar8_acore18_opt_0.sw_bitcell_opt_term_0.gb 9.49663f
C2795 sar_ctrl_async_phys_0.sg13g2_inv_1_0.A VDD 0.20635f
C2796 sar_ctrl_async_phys_0.sg13g2_a22oi_1_2.A2 sar_ctrl_async_phys_0.sg13g2_nand2_1_1.B 1.394f
C2797 a_26566_41996# a_26454_41972# 0.55452f
C2798 sar_ctrl_async_phys_0.sg13g2_nor2b_1_3.Y a_34596_40424# 0.24823f
C2799 sar_ctrl_async_phys_0.sg13g2_nor2b_1_3.Y a_33375_40821# 0.01539f
C2800 sar_ctrl_async_phys_0.sg13g2_a21oi_1_5.B1 sar_ctrl_async_phys_0.sg13g2_buf_1_20.A 0.06415f
C2801 a_36056_32176# result[4] 0.0101f
C2802 a_26364_45710# VDD 0.28924f
C2803 a_33276_42686# VDD 0.22337f
C2804 a_26454_39702# VDD 0.22632f
C2805 sar_ctrl_async_phys_0.sg13g2_o21ai_1_1.B1 a_29238_40898# 0.1186f
C2806 sar_ctrl_async_phys_0.sg13g2_buf_1_2.X sar_ctrl_async_phys_0.sg13g2_buf_1_8.A 0.07528f
C2807 sar_ctrl_async_phys_0.sg13g2_buf_1_8.A a_33080_31388# 0.25857f
C2808 sar_ctrl_async_phys_0.sg13g2_a21oi_1_5.B1 a_35000_45878# 0.02517f
C2809 sar_ctrl_async_phys_0.sg13g2_o21ai_1_1.B1 a_28130_40838# 0.05026f
C2810 sar_ctrl_async_phys_0.sg13g2_a21oi_1_6.B1 sar_ctrl_async_phys_0.sg13g2_dfrbpq_1_9.RESET_B 0.01403f
C2811 sar_ctrl_async_phys_0.sg13g2_nand3b_1_0.Y sar_ctrl_async_phys_0.sg13g2_nor2_1_5.B 0.30683f
C2812 sar_ctrl_async_phys_0.sg13g2_a22oi_1_3.A2 a_32991_35239# 0.0257f
C2813 sar_ctrl_async_phys_0.sg13g2_buf_1_35.A a_33276_42686# 0.24828f
C2814 a_34596_40424# VDD 0.19499f
C2815 sar_ctrl_async_phys_0.sg13g2_buf_1_44.A sar_ctrl_async_phys_0.sg13g2_nand2_1_6.B 0.09862f
C2816 sar_ctrl_async_phys_0.sg13g2_nor2_1_3.B sar_ctrl_async_phys_0.sg13g2_nor2_1_3.Y 0.18464f
C2817 w_39600_n9960# sar_ctrl_async_phys_0.dac_code[3] 0.04487f
C2818 sar_ctrl_async_phys_0.dac_code_n[7] oa_sar8_acore18_opt_0.sw_bitcell_opt_b5_1.bot 0.11261f
C2819 a_33375_40821# VDD 0.16776f
C2820 a_31328_33870# VDD 0.16903f
C2821 a_35199_44311# a_35456_44454# 0.34468f
C2822 a_34459_44356# a_34228_44247# 0.12701f
C2823 a_33940_44552# a_35105_44311# 0.43239f
C2824 sar_ctrl_async_phys_0.sg13g2_a21oi_1_0.A1 a_31093_39677# 0.02316f
C2825 sar_ctrl_async_phys_0.sg13g2_dfrbpq_1_9.Q sar_ctrl_async_phys_0.sg13g2_nand2_1_6.B 0.02184f
C2826 sar_ctrl_async_phys_0.sg13g2_dfrbpq_1_9.RESET_B sar_ctrl_async_phys_0.sg13g2_nor2_1_11.Y 0.10652f
C2827 sar_ctrl_async_phys_0.sg13g2_o21ai_1_1.B1 sar_ctrl_async_phys_0.sg13g2_dfrbpq_1_2.Q 0.05899f
C2828 a_31898_32361# VDD 0.09536f
C2829 sar_ctrl_async_phys_0.dac_code_n[4] sar_ctrl_async_phys_0.sg13g2_nand2_1_2.A 0.4955f
C2830 oa_sar8_acore18_opt_0.sw_bitcell_opt_b4_0.bot oa_sar8_acore18_opt_0.sw_bitcell_opt_term_0.gb 0.62633f
C2831 sar_ctrl_async_phys_0.sg13g2_dfrbpq_1_9.RESET_B sar_ctrl_async_phys_0.sg13g2_nand2_1_2.B 0.03649f
C2832 sar_ctrl_async_phys_0.sg13g2_nor2_1_4.Y sar_ctrl_async_phys_0.sg13g2_nor4_1_0.C 0.02942f
C2833 sar_ctrl_async_phys_0.dac_code_n[1] sar_ctrl_async_phys_0.sample 0.04488f
C2834 sar_ctrl_async_phys_0.sg13g2_buf_1_6.A a_33626_41433# 0.01539f
C2835 a_34106_30849# VDD 0.09607f
C2836 sar_ctrl_async_phys_0.sg13g2_nor2_1_7.A a_28368_36877# 0.13174f
C2837 sar_ctrl_async_phys_0.sg13g2_nand2_1_0.B VDD 0.61504f
C2838 sar_ctrl_async_phys_0.sg13g2_nor2_1_0.Y sar_ctrl_async_phys_0.sg13g2_a21oi_1_2.B1 0.01495f
C2839 a_28862_36863# VDD 0.18804f
C2840 sar_ctrl_async_phys_0.sg13g2_o21ai_1_1.B1 a_32580_43448# 0.01978f
C2841 sar_ctrl_async_phys_0.dac_code[1] m3_54868_n2380# 0.04365f
C2842 sar_ctrl_async_phys_0.sg13g2_a22oi_1_5.Y a_29332_32456# 0.02407f
C2843 oa_sar8_acore18_opt_0.sw_tg_opt_1.bot oa_sar8_acore18_opt_0.sw_bitcell_opt_b7_1.VSS 0.03121f
C2844 a_32116_40464# a_32404_40885# 0.43707f
C2845 sar_ctrl_async_phys_0.sg13g2_buf_1_33.A sar_ctrl_async_phys_0.sg13g2_nand2_1_3.Y 0.0145f
C2846 a_29812_33968# a_30331_33772# 0.34114f
C2847 a_26174_42911# VDD 0.18891f
C2848 sar_ctrl_async_phys_0.sg13g2_nand2_1_3.Y sar_ctrl_async_phys_0.dac_code[5] 0.78279f
C2849 sar_ctrl_async_phys_0.sg13g2_inv_1_2.A sar_ctrl_async_phys_0.sg13g2_buf_1_8.A 0.4571f
C2850 sar_ctrl_async_phys_0.sg13g2_dfrbpq_1_0.CLK a_32245_37447# 0.24849f
C2851 sar_ctrl_async_phys_0.sg13g2_dfrbpq_1_0.CLK sar_ctrl_async_phys_0.sg13g2_nor2_1_3.B 0.13495f
C2852 sar_ctrl_async_phys_0.sg13g2_nand2b_1_0.A_N sar_ctrl_async_phys_0.sg13g2_nand2b_1_0.Y 0.02268f
C2853 sar_ctrl_async_phys_0.sample vcm 1.92707f
C2854 sar_ctrl_async_phys_0.sg13g2_a21oi_1_0.B1 sar_ctrl_async_phys_0.sg13g2_a21oi_1_1.Y 0.08672f
C2855 oa_sar8_acore18_opt_0.sw_bitcell_opt_b1_0.bot oa_sar8_acore18_opt_0.sw_bitcell_opt_term_0.VSS 1.49696f
C2856 sar_ctrl_async_phys_0.sg13g2_nand2b_1_1.Y a_35199_44311# 0.01472f
C2857 sar_ctrl_async_phys_0.sg13g2_buf_1_13.A sar_ctrl_async_phys_0.sg13g2_nor2_1_15.Y 0.23551f
C2858 sar_ctrl_async_phys_0.sg13g2_buf_1_4.A a_35672_33688# 0.01344f
C2859 sar_ctrl_async_phys_0.hold_req oa_sar8_acore18_opt_0.sw_bitcell_opt_b1_0.bot 0.11752f
C2860 sar_ctrl_async_phys_0.dac_code_n[6] sar_ctrl_async_phys_0.sg13g2_buf_1_44.A 0.03549f
C2861 a_34328_41972# sar_ctrl_async_phys_0.sg13g2_nand2b_1_3.Y 0.26587f
C2862 sar_ctrl_async_phys_0.sg13g2_and2_1_5.X sar_ctrl_async_phys_0.sg13g2_a22oi_1_2.A2 0.03699f
C2863 sar_ctrl_async_phys_0.sg13g2_a21oi_1_1.Y a_34420_34837# 0.0178f
C2864 sar_ctrl_async_phys_0.sg13g2_a22oi_1_2.A2 sar_ctrl_async_phys_0.sg13g2_buf_1_16.A 0.03017f
C2865 sar_ctrl_async_phys_0.dac_code_n[1] sar_ctrl_async_phys_0.dac_code[6] 0.20753f
C2866 sar_ctrl_async_phys_0.sg13g2_a22oi_1_0.A2 a_34132_34416# 0.04524f
C2867 sar_ctrl_async_phys_0.sg13g2_buf_1_2.A a_28977_36864# 0.04098f
C2868 sar_ctrl_async_phys_0.dac_code_n[4] oa_sar8_acore18_opt_0.sw_tg_opt_0.bot 0.84386f
C2869 sar_ctrl_async_phys_0.sg13g2_nor2_1_1.Y sar_ctrl_async_phys_0.sg13g2_a22oi_1_3.A2 0.14077f
C2870 sar_ctrl_async_phys_0.sg13g2_dfrbpq_1_0.CLK a_34549_32911# 0.26502f
C2871 sar_ctrl_async_phys_0.sg13g2_a22oi_1_0.A2 a_35103_36751# 0.01412f
C2872 a_29908_43909# a_30139_43495# 0.12701f
C2873 sar_ctrl_async_phys_0.sg13g2_buf_1_14.A sar_ctrl_async_phys_0.dac_code[5] 0.09395f
C2874 sar_ctrl_async_phys_0.dac_code_n[3] sar_ctrl_async_phys_0.sg13g2_dfrbpq_1_9.Q 0.64612f
C2875 sar_ctrl_async_phys_0.sg13g2_a21oi_1_7.A2 sar_ctrl_async_phys_0.sg13g2_buf_1_6.A 0.06669f
C2876 sar_ctrl_async_phys_0.sg13g2_a22oi_1_1.A2 sar_ctrl_async_phys_0.sg13g2_a22oi_1_3.A2 0.08429f
C2877 a_27249_39888# VDD 0.23064f
C2878 sar_ctrl_async_phys_0.sg13g2_buf_1_7.A a_33359_32876# 0.08223f
C2879 sar_ctrl_async_phys_0.sg13g2_a22oi_1_2.A2 sar_ctrl_async_phys_0.sg13g2_buf_1_23.A 0.03924f
C2880 oa_sar8_acore18_opt_0.sw_bitcell_opt_term_0.gb m3_57896_n2380# 1.40567f
C2881 sar_ctrl_async_phys_0.sg13g2_nand2_1_3.B sar_ctrl_async_phys_0.dac_code_n[7] 0.02614f
C2882 sar_ctrl_async_phys_0.sg13g2_a22oi_1_5.A2 a_30783_40821# 0.03644f
C2883 sar_ctrl_async_phys_0.sg13g2_dfrbpq_1_0.CLK sar_ctrl_async_phys_0.sg13g2_inv_1_5.A 0.69455f
C2884 sar_ctrl_async_phys_0.sg13g2_nand2b_1_1.Y sar_ctrl_async_phys_0.dac_code_n[7] 0.02255f
C2885 sar_ctrl_async_phys_0.sg13g2_buf_1_2.X a_34651_32911# 0.43415f
C2886 sar_ctrl_async_phys_0.sg13g2_dfrbpq_1_0.CLK sar_ctrl_async_phys_0.sg13g2_buf_1_0.A 1.27021f
C2887 sar_ctrl_async_phys_0.sg13g2_nor2_1_4.Y a_26673_40726# 0.0235f
C2888 sar_ctrl_async_phys_0.dac_code_n[7] oa_sar8_acore18_opt_0.sw_bitcell_opt_term_0.vin 0.049f
C2889 sar_ctrl_async_phys_0.sg13g2_nand2_1_3.A a_33940_44552# 0.01086f
C2890 sar_ctrl_async_phys_0.sg13g2_nand2b_1_2.Y sar_ctrl_async_phys_0.dac_code_n[7] 0.67323f
C2891 oa_sar8_acore18_opt_0.sw_tg_opt_1.bot oa_sar8_acore18_opt_0.sw_bitcell_opt_b2_1.bot 1.78339f
C2892 a_32090_40428# VDD 0.0958f
C2893 sar_ctrl_async_phys_0.sg13g2_buf_1_3.A sar_ctrl_async_phys_0.sg13g2_a22oi_1_0.A1 0.18462f
C2894 oa_sar8_acore18_opt_0.sw_bitcell_opt_b0_0.bot oa_sar8_acore18_opt_0.sw_bitcell_opt_term_0.gb 0.60585f
C2895 sar_ctrl_async_phys_0.sg13g2_a22oi_1_1.A2 a_31935_36285# 0.03904f
C2896 a_34357_44213# a_34459_44356# 0.47622f
C2897 sar_ctrl_async_phys_0.sg13g2_a22oi_1_0.A2 a_35384_32176# 0.03165f
C2898 sar_ctrl_async_phys_0.cmp_fire a_28008_23477# 0.83464f
C2899 a_35952_39901# VDD 0.38985f
C2900 sar_ctrl_async_phys_0.sg13g2_nand2_1_3.B sar_ctrl_async_phys_0.sg13g2_nor2_1_2.Y 0.03769f
C2901 a_36152_36806# VDD 0.12573f
C2902 sar_ctrl_async_phys_0.sg13g2_nand2b_1_1.Y sar_ctrl_async_phys_0.sg13g2_nor2_1_2.Y 0.01714f
C2903 sar_ctrl_async_phys_0.sg13g2_nor2b_1_0.A a_33556_40016# 0.04644f
C2904 sar_ctrl_async_phys_0.dac_code[0] oa_sar8_acore18_opt_0.sw_bitcell_opt_b5_0.bot 0.7413f
C2905 sar_ctrl_async_phys_0.sg13g2_dfrbpq_1_2.Q sar_ctrl_async_phys_0.sg13g2_buf_1_6.A 0.02144f
C2906 sar_ctrl_async_phys_0.cmp_n oa_sar8_acore18_opt_0.sw_tg_opt_1.bot 0.15381f
C2907 sar_ctrl_async_phys_0.sg13g2_a22oi_1_1.A2 a_32602_39996# 0.04357f
C2908 a_35295_36285# a_35201_36285# 0.28931f
C2909 a_35463_31435# VDD 0.7744f
C2910 sar_ctrl_async_phys_0.sg13g2_nand2b_1_1.Y a_35770_43484# 0.06114f
C2911 a_34136_33688# result[5] 0.24516f
C2912 sar_ctrl_async_phys_0.dac_code[7] oa_sar8_acore18_opt_0.sw_bitcell_opt_term_0.VSS 1.54742f
C2913 sar_ctrl_async_phys_0.sg13g2_a22oi_1_1.A2 a_31706_35385# 0.03871f
C2914 sar_ctrl_async_phys_0.hold_req sar_ctrl_async_phys_0.dac_code[7] 0.13327f
C2915 oa_sar8_acore18_opt_0.sw_bitcell_opt_b5_0.bot VDD 3.8844f
C2916 w_16692_n9960# oa_sar8_acore18_opt_0.sw_tg_opt_1.bot 0.09929f
C2917 a_31830_40898# a_32090_40428# 0.75507f
C2918 a_31706_35385# a_31446_35162# 0.75507f
C2919 sar_ctrl_async_phys_0.sg13g2_dfrbpq_1_0.CLK a_33632_40702# 0.01016f
C2920 a_30783_40821# a_31450_40460# 0.0894f
C2921 a_35391_34773# a_35297_34773# 0.28931f
C2922 sar_ctrl_async_phys_0.sg13g2_nand2b_1_1.Y a_34911_41287# 0.05022f
C2923 sar_ctrl_async_phys_0.sg13g2_a21oi_1_2.A2 a_30752_39190# 0.01063f
C2924 a_28856_32270# VDD 0.15711f
C2925 sar_ctrl_async_phys_0.sg13g2_a22oi_1_1.A2 a_31732_45000# 0.02477f
C2926 sar_ctrl_async_phys_0.sg13g2_nor2_1_10.B a_29236_38952# 0.01946f
C2927 sar_ctrl_async_phys_0.dac_code_n[4] a_35725_45266# 0.0326f
C2928 sar_ctrl_async_phys_0.sg13g2_buf_1_3.A sar_ctrl_async_phys_0.sg13g2_buf_1_7.A 0.19319f
C2929 sar_ctrl_async_phys_0.sg13g2_a21oi_1_0.A1 a_35313_37784# 0.01366f
C2930 sar_ctrl_async_phys_0.sg13g2_nand2b_1_2.Y a_34911_41287# 0.04341f
C2931 a_29350_41996# a_29238_41972# 0.55452f
C2932 oa_sar8_acore18_opt_0.sw_bitcell_opt_b6_0.bot oa_sar8_acore18_opt_0.sw_bitcell_opt_b5_0.bot 13.8916f
C2933 sar_ctrl_async_phys_0.dac_code[0] sar_ctrl_async_phys_0.sg13g2_nand2_1_2.B 0.16082f
C2934 sar_ctrl_async_phys_0.cmp_fault VDD 0.30621f
C2935 sar_ctrl_async_phys_0.sg13g2_a21oi_1_1.Y a_33844_36992# 0.01396f
C2936 sar_ctrl_async_phys_0.sg13g2_a21oi_1_0.B1 sar_ctrl_async_phys_0.sg13g2_buf_1_22.A 0.02694f
C2937 sar_ctrl_async_phys_0.sg13g2_a22oi_1_0.A2 sar_ctrl_async_phys_0.sg13g2_nor2b_1_1.B_N 0.18765f
C2938 sar_ctrl_async_phys_0.sg13g2_a21oi_1_6.B1 VDD 0.88896f
C2939 a_29334_43922# a_29908_43909# 0.31978f
C2940 a_29620_43488# a_30037_43495# 0.37583f
C2941 sar_ctrl_async_phys_0.sg13g2_buf_1_3.A sar_ctrl_async_phys_0.sg13g2_inv_1_3.Y 1.10747f
C2942 a_34520_47296# VDD 0.21798f
C2943 sar_ctrl_async_phys_0.sg13g2_nor2_1_11.A a_29594_43452# 0.02349f
C2944 a_26558_40727# sar_ctrl_async_phys_0.sg13g2_dlygate4sd3_1_4.A 0.01247f
C2945 sar_ctrl_async_phys_0.dac_code_n[5] sar_ctrl_async_phys_0.sample 0.04464f
C2946 sar_ctrl_async_phys_0.sg13g2_dfrbpq_1_9.Q sar_ctrl_async_phys_0.sg13g2_nand2b_1_7.A_N 0.15222f
C2947 sar_ctrl_async_phys_0.sg13g2_a21oi_1_0.A2 a_36152_36806# 0.0243f
C2948 sar_ctrl_async_phys_0.sg13g2_a21oi_1_6.B1 sar_ctrl_async_phys_0.sg13g2_buf_1_35.A 0.0267f
C2949 sar_ctrl_async_phys_0.sg13g2_buf_1_2.X a_35391_30703# 0.13776f
C2950 oa_sar8_acore18_opt_0.sw_bitcell_opt_term_0.gb a_35948_n9612# 3.45673f
C2951 a_33211_45868# a_33951_45823# 0.26905f
C2952 a_32341_32117# a_32212_32151# 0.01562f
C2953 sar_ctrl_async_phys_0.sg13g2_buf_1_2.X a_34549_32911# 0.03723f
C2954 sar_ctrl_async_phys_0.sg13g2_nor2_1_11.Y VDD 0.35756f
C2955 sar_ctrl_async_phys_0.sg13g2_buf_1_4.A a_35672_35200# 0.01226f
C2956 sar_ctrl_async_phys_0.sg13g2_nand2_1_2.B VDD 0.62523f
C2957 oa_sar8_acore18_opt_0.sw_tg_opt_1.bot oa_sar8_acore18_opt_0.sw_bitcell_opt_b6_1.bot 29.8359f
C2958 a_33276_42686# sar_ctrl_async_phys_0.sg13g2_a22oi_1_3.A2 0.05768f
C2959 a_33652_41528# a_34817_41287# 0.43239f
C2960 a_34911_41287# a_35168_41430# 0.34468f
C2961 a_34171_41332# a_33940_41223# 0.12701f
C2962 sar_ctrl_async_phys_0.sg13g2_buf_1_35.A sar_ctrl_async_phys_0.sg13g2_nand2_1_2.B 0.01003f
C2963 sar_ctrl_async_phys_0.sg13g2_buf_1_2.X sar_ctrl_async_phys_0.sg13g2_inv_1_5.A 0.02352f
C2964 a_35664_37695# a_36056_37436# 0.04376f
C2965 sar_ctrl_async_phys_0.sg13g2_buf_1_0.A sar_ctrl_async_phys_0.sg13g2_buf_1_2.X 0.047f
C2966 a_34132_34416# VDD 0.07298f
C2967 a_33556_40016# VDD 0.07775f
C2968 sar_ctrl_async_phys_0.sg13g2_inv_1_10.Y sar_ctrl_async_phys_0.sg13g2_nor2_1_12.A 0.0178f
C2969 sar_ctrl_async_phys_0.dac_code[0] oa_sar8_acore18_opt_0.sw_bitcell_opt_b1_0.bot 0.15553f
C2970 a_25596_47222# sar_ctrl_async_phys_0.hold_req 0.24585f
C2971 a_35103_36751# VDD 0.17375f
C2972 sar_ctrl_async_phys_0.sg13g2_a22oi_1_2.A2 sar_ctrl_async_phys_0.sg13g2_nor2_1_15.Y 0.18801f
C2973 sar_ctrl_async_phys_0.sg13g2_a22oi_1_3.A2 a_33375_40821# 0.029f
C2974 sar_ctrl_async_phys_0.dac_code_n[6] oa_sar8_acore18_opt_0.sw_bitcell_opt_b3_0.bot 0.08014f
C2975 w_39600_n9960# vinn 0.01233f
C2976 sar_ctrl_async_phys_0.sg13g2_nor4_1_0.C sar_ctrl_async_phys_0.sg13g2_a22oi_1_5.A2 0.02306f
C2977 sar_ctrl_async_phys_0.sg13g2_nand2b_1_0.A_N sar_ctrl_async_phys_0.sg13g2_nor2_1_7.B 0.14182f
C2978 a_25488_40546# VDD 0.06694f
C2979 sar_ctrl_async_phys_0.dac_code_n[3] oa_sar8_acore18_opt_0.sw_bitcell_opt_b3_0.bot 0.42408f
C2980 sar_ctrl_async_phys_0.dac_code[2] sar_ctrl_async_phys_0.dac_code_n[7] 0.06341f
C2981 sar_ctrl_async_phys_0.sg13g2_nor2_1_2.Y a_33844_43488# 0.02804f
C2982 sar_ctrl_async_phys_0.sg13g2_nor2b_1_4.Y a_31546_43484# 0.0178f
C2983 a_34036_35928# a_35201_36285# 0.43239f
C2984 sar_ctrl_async_phys_0.sg13g2_nor2_1_1.A sar_ctrl_async_phys_0.sg13g2_a22oi_1_0.A2 0.05886f
C2985 sar_ctrl_async_phys_0.sg13g2_a22oi_1_0.A1 sar_ctrl_async_phys_0.sg13g2_buf_1_9.A 0.19229f
C2986 oa_sar8_acore18_opt_0.sw_bitcell_opt_term_0.trkb oa_sar8_acore18_opt_0.sw_bitcell_opt_b3_0.bot 1.40269f
C2987 oa_sar8_acore18_opt_0.sw_bitcell_opt_b1_0.bot VDD 2.50993f
C2988 sar_ctrl_async_phys_0.sg13g2_a22oi_1_0.A1 a_31247_33292# 0.01927f
C2989 a_31947_41508# VDD 0.23289f
C2990 sar_ctrl_async_phys_0.sg13g2_inv_1_1.Y a_31823_32876# 0.02813f
C2991 sar_ctrl_async_phys_0.sg13g2_buf_1_13.X a_32192_39918# 0.03092f
C2992 a_34132_43909# a_34363_43495# 0.12701f
C2993 sar_ctrl_async_phys_0.dac_code_n[4] sar_ctrl_async_phys_0.dac_code[5] 0.06328f
C2994 sar_ctrl_async_phys_0.dac_code_n[5] sar_ctrl_async_phys_0.dac_code[6] 0.17632f
C2995 a_29653_38959# VDD 0.24331f
C2996 a_35384_32176# VDD 0.2812f
C2997 sar_ctrl_async_phys_0.sg13g2_buf_1_13.A a_32888_36806# 0.01776f
C2998 sar_ctrl_async_phys_0.sg13g2_dfrbpq_1_0.CLK sar_ctrl_async_phys_0.sg13g2_nand2_1_2.A 0.66895f
C2999 sar_ctrl_async_phys_0.sg13g2_nor4_1_0.Y a_26280_41214# 0.0121f
C3000 a_25596_41174# sar_ctrl_async_phys_0.cmp_fire 0.24585f
C3001 sar_ctrl_async_phys_0.sg13g2_a21oi_1_1.B1 sar_ctrl_async_phys_0.cmp_valid 0.03146f
C3002 sar_ctrl_async_phys_0.sg13g2_buf_1_6.A sar_ctrl_async_phys_0.bit_active[2] 0.02995f
C3003 a_34132_34416# a_35391_34773# 0.01529f
C3004 sar_ctrl_async_phys_0.sg13g2_nor2_1_2.Y a_33626_41433# 0.0138f
C3005 sar_ctrl_async_phys_0.sg13g2_nor4_1_0.C sar_ctrl_async_phys_0.sg13g2_nand2_1_3.B 0.02164f
C3006 oa_sar8_acore18_opt_0.sw_tg_opt_1.bot oa_sar8_acore18_opt_0.sw_bitcell_opt_term_1.bot 3.91342f
C3007 sar_ctrl_async_phys_0.sg13g2_nor4_1_0.C sar_ctrl_async_phys_0.sg13g2_nand2b_1_1.Y 0.01704f
C3008 sar_ctrl_async_phys_0.sg13g2_buf_1_0.A a_30830_35166# 0.08283f
C3009 sar_ctrl_async_phys_0.sg13g2_dfrbpq_1_9.D a_31446_45434# 0.27504f
C3010 sar_ctrl_async_phys_0.sample track 0.05333f
C3011 oa_sar8_acore18_opt_0.sw_bitcell_opt_b4_0.bot oa_sar8_acore18_opt_0.sw_bitcell_opt_b3_0.bot 16.5916f
C3012 oa_sar8_acore18_opt_0.sw_bitcell_opt_b5_0.bot oa_sar8_acore18_opt_0.sw_bitcell_opt_b2_0.bot 0.56024f
C3013 oa_sar8_acore18_opt_0.sw_bitcell_opt_b6_0.bot oa_sar8_acore18_opt_0.sw_bitcell_opt_b1_0.bot 0.51889f
C3014 sar_ctrl_async_phys_0.sg13g2_a21oi_1_0.B1 sar_ctrl_async_phys_0.sg13g2_o21ai_1_1.B1 0.02116f
C3015 a_35103_36751# a_35009_36751# 0.28931f
C3016 m3_51760_n2380# VDD 0.02113f
C3017 sar_ctrl_async_phys_0.sg13g2_nor4_1_0.C sar_ctrl_async_phys_0.sg13g2_nand2b_1_2.Y 0.02935f
C3018 sar_ctrl_async_phys_0.sg13g2_buf_1_2.X a_31071_33727# 0.14423f
C3019 sar_ctrl_async_phys_0.sg13g2_nor2b_1_0.A sar_ctrl_async_phys_0.sg13g2_nor2_1_1.A 0.31259f
C3020 sar_ctrl_async_phys_0.sg13g2_buf_1_2.X a_30497_32215# 0.01063f
C3021 sar_ctrl_async_phys_0.sg13g2_nand2_1_3.Y a_35402_42726# 0.01864f
C3022 sar_ctrl_async_phys_0.dac_code[0] sar_ctrl_async_phys_0.dac_code[7] 0.14614f
C3023 sar_ctrl_async_phys_0.dac_code_n[4] a_20412_n9612# 1.21641f
C3024 sar_ctrl_async_phys_0.sg13g2_nand2_1_3.A sar_ctrl_async_phys_0.dac_code[1] 0.9416f
C3025 sar_ctrl_async_phys_0.sg13g2_buf_1_6.A sar_ctrl_async_phys_0.sg13g2_buf_1_1.A 0.02684f
C3026 a_32149_35141# a_32897_35239# 0.01058f
C3027 sar_ctrl_async_phys_0.sg13g2_a22oi_1_0.A1 sar_ctrl_async_phys_0.sg13g2_buf_1_16.A 0.67951f
C3028 a_34615_31475# a_34767_31359# 0.47622f
C3029 sar_ctrl_async_phys_0.sg13g2_buf_1_13.A sar_ctrl_async_phys_0.sg13g2_nor2_1_2.A 0.01839f
C3030 a_32406_45746# a_32692_46064# 0.41329f
C3031 sar_ctrl_async_phys_0.sg13g2_buf_1_9.A sar_ctrl_async_phys_0.sg13g2_buf_1_7.A 0.01615f
C3032 w_39600_n9960# sar_ctrl_async_phys_0.dac_code_n[4] 0.11956f
C3033 a_21332_n9711# vinp 0.80795f
C3034 sar_ctrl_async_phys_0.sg13g2_nor2_1_10.B a_30830_35166# 0.49637f
C3035 a_34069_41189# a_34171_41332# 0.47622f
C3036 sar_ctrl_async_phys_0.sg13g2_nor2b_1_0.A a_30676_35928# 0.01372f
C3037 a_36058_32900# result[5] 0.01243f
C3038 sar_ctrl_async_phys_0.sg13g2_a22oi_1_1.Y a_30772_31392# 0.02775f
C3039 sar_ctrl_async_phys_0.sg13g2_buf_1_23.A sar_ctrl_async_phys_0.sg13g2_a22oi_1_0.A1 1.79632f
C3040 sar_ctrl_async_phys_0.sg13g2_nor2_1_0.Y a_31579_44356# 0.01177f
C3041 sar_ctrl_async_phys_0.sg13g2_dfrbpq_1_0.CLK sar_ctrl_async_phys_0.sg13g2_nor2_1_3.Y 0.24651f
C3042 sar_ctrl_async_phys_0.dac_code[7] VDD 6.09643f
C3043 sar_ctrl_async_phys_0.sg13g2_nor2_1_1.Y a_33948_41936# 0.03584f
C3044 sar_ctrl_async_phys_0.dac_code_n[6] oa_sar8_acore18_opt_0.sw_bitcell_opt_term_0.bot 0.08783f
C3045 sar_ctrl_async_phys_0.sg13g2_inv_1_3.Y sar_ctrl_async_phys_0.sg13g2_buf_1_9.A 0.12875f
C3046 sar_ctrl_async_phys_0.sg13g2_buf_1_16.A a_30384_35294# 0.01104f
C3047 sar_ctrl_async_phys_0.sg13g2_o21ai_1_1.B1 a_29755_38959# 0.43079f
C3048 sar_ctrl_async_phys_0.sg13g2_nor2b_1_1.B_N VDD 0.55697f
C3049 sar_ctrl_async_phys_0.dac_code_n[3] oa_sar8_acore18_opt_0.sw_bitcell_opt_term_0.bot 0.11466f
C3050 sar_ctrl_async_phys_0.hold_req oa_sar8_acore18_opt_0.sw_bitcell_opt_b7_1.bot 2.98608f
C3051 sar_ctrl_async_phys_0.sg13g2_nor2_1_10.B a_30650_35892# 0.02205f
C3052 sar_ctrl_async_phys_0.sg13g2_inv_1_1.Y a_31924_32456# 0.02893f
C3053 sar_ctrl_async_phys_0.sg13g2_nand2_1_3.A sar_ctrl_async_phys_0.sg13g2_buf_1_20.A 0.03203f
C3054 a_31579_44356# a_32319_44311# 0.26905f
C3055 sar_ctrl_async_phys_0.sg13g2_nor2b_1_0.A a_31195_39820# 0.02959f
C3056 sar_ctrl_async_phys_0.sg13g2_buf_1_6.A sar_ctrl_async_phys_0.sg13g2_buf_1_22.A 0.04983f
C3057 sar_ctrl_async_phys_0.sg13g2_buf_1_2.X sar_ctrl_async_phys_0.sg13g2_inv_1_5.Y 0.23808f
C3058 a_29236_38952# a_30401_39309# 0.43239f
C3059 sar_ctrl_async_phys_0.sg13g2_dfrbpq_1_9.RESET_B a_30139_43495# 0.43226f
C3060 a_35245_45936# a_35327_45750# 0.01117f
C3061 sar_ctrl_async_phys_0.sg13g2_buf_1_13.X a_30390_36362# 0.0157f
C3062 sar_ctrl_async_phys_0.sg13g2_nor2_1_3.A a_26160_37522# 0.01851f
C3063 a_33750_36362# a_34324_36349# 0.31978f
C3064 oa_sar8_acore18_opt_0.sw_bitcell_opt_term_0.trkb oa_sar8_acore18_opt_0.sw_bitcell_opt_term_0.bot 1.34511f
C3065 a_33464_31388# VDD 0.2197f
C3066 sar_ctrl_async_phys_0.sg13g2_dfrbpq_1_2.Q sar_ctrl_async_phys_0.dac_code_n[7] 0.01386f
C3067 a_34904_46508# sar_ctrl_async_phys_0.sg13g2_nand2b_1_2.Y 0.25019f
C3068 result[4] result[5] 0.11079f
C3069 sar_ctrl_async_phys_0.sg13g2_dfrbpq_1_9.RESET_B a_34459_44356# 0.4208f
C3070 sar_ctrl_async_phys_0.sg13g2_buf_1_13.X sar_ctrl_async_phys_0.sg13g2_dlygate4sd3_1_7.X 0.01998f
C3071 sar_ctrl_async_phys_0.dac_code[7] oa_sar8_acore18_opt_0.sw_bitcell_opt_b6_0.bot 1.24101f
C3072 sar_ctrl_async_phys_0.bit_active[6] a_35288_38224# 0.01699f
C3073 sar_ctrl_async_phys_0.sg13g2_nor2_1_10.B a_29808_39830# 0.02475f
C3074 sar_ctrl_async_phys_0.sg13g2_nand2b_1_7.A_N sar_ctrl_async_phys_0.sg13g2_buf_1_32.A 0.11825f
C3075 sar_ctrl_async_phys_0.sg13g2_a22oi_1_0.B1 sar_ctrl_async_phys_0.sg13g2_buf_1_5.A 0.801f
C3076 a_33818_43452# a_33844_43488# 0.36952f
C3077 sar_ctrl_async_phys_0.sg13g2_dfrbpq_1_0.CLK a_30584_44366# 0.01408f
C3078 a_27032_39034# VDD 0.13717f
C3079 sar_ctrl_async_phys_0.sg13g2_dfrbpq_1_0.CLK a_34453_35935# 0.29802f
C3080 sar_ctrl_async_phys_0.dac_code_n[6] m3_38288_n2380# 0.04765f
C3081 sar_ctrl_async_phys_0.sg13g2_buf_1_26.X sar_ctrl_async_phys_0.sg13g2_nor2_1_3.A 1.07405f
C3082 sar_ctrl_async_phys_0.sg13g2_buf_1_13.X sar_ctrl_async_phys_0.sg13g2_dlygate4sd3_1_5.A 0.33074f
C3083 sar_ctrl_async_phys_0.sg13g2_dlygate4sd3_1_5.A sar_ctrl_async_phys_0.sg13g2_and2_1_2.X 0.0534f
C3084 sar_ctrl_async_phys_0.sg13g2_inv_1_2.Y a_33846_33338# 0.27024f
C3085 sar_ctrl_async_phys_0.sg13g2_nor2_1_2.Y sar_ctrl_async_phys_0.sg13g2_dfrbpq_1_2.Q 1.32375f
C3086 sar_ctrl_async_phys_0.sg13g2_nand2b_1_0.A_N sar_ctrl_async_phys_0.sg13g2_o21ai_1_1.A2 0.72338f
C3087 sar_ctrl_async_phys_0.dac_code_n[6] oa_sar8_acore18_opt_0.bstrap_opt_w2_c1200_1.gb 0.14954f
C3088 a_29524_40464# a_29812_40885# 0.43707f
C3089 oa_sar8_acore18_opt_0.sw_bitcell_opt_b7_0.bot oa_sar8_acore18_opt_0.sw_bitcell_opt_term_0.gb 0.94077f
C3090 a_33846_34850# a_34549_34423# 0.02432f
C3091 sar_ctrl_async_phys_0.sg13g2_buf_1_2.A a_33558_36674# 0.11461f
C3092 oa_sar8_acore18_opt_0.sw_bitcell_opt_b4_0.bot oa_sar8_acore18_opt_0.sw_bitcell_opt_term_0.bot 0.76686f
C3093 oa_sar8_acore18_opt_0.sw_bitcell_opt_b3_0.bot oa_sar8_acore18_opt_0.sw_bitcell_opt_b0_0.bot 0.40513f
C3094 oa_sar8_acore18_opt_0.sw_bitcell_opt_b2_0.bot oa_sar8_acore18_opt_0.sw_bitcell_opt_b1_0.bot 17.5681f
C3095 sar_ctrl_async_phys_0.sg13g2_a22oi_1_5.A2 sar_ctrl_async_phys_0.sg13g2_a22oi_1_5.Y 0.01503f
C3096 sar_ctrl_async_phys_0.dac_code_n[3] oa_sar8_acore18_opt_0.bstrap_opt_w2_c1200_1.gb 0.12632f
C3097 sar_ctrl_async_phys_0.sg13g2_a22oi_1_0.A2 sar_ctrl_async_phys_0.sg13g2_a22oi_1_0.B1 0.01276f
C3098 sar_ctrl_async_phys_0.sg13g2_nand3b_1_0.Y sar_ctrl_async_phys_0.sg13g2_dlygate4sd3_1_0.X 0.04773f
C3099 sar_ctrl_async_phys_0.sg13g2_dlygate4sd3_1_5.A track 0.47342f
C3100 oa_sar8_acore18_opt_0.sw_bitcell_opt_term_0.trkb m3_38288_n2380# 0.03859f
C3101 sar_ctrl_async_phys_0.sg13g2_nor2_1_1.A VDD 0.51926f
C3102 a_34363_36796# a_35360_36894# 0.02979f
C3103 a_33558_36674# a_34132_36687# 0.31978f
C3104 sar_ctrl_async_phys_0.sg13g2_a21oi_1_0.A1 sar_ctrl_async_phys_0.sg13g2_a21oi_1_3.A2 0.87922f
C3105 a_21332_n9711# VDD 0.8295f
C3106 sar_ctrl_async_phys_0.sg13g2_a21oi_1_5.B1 a_34765_45266# 0.0217f
C3107 sar_ctrl_async_phys_0.dac_code_n[6] oa_sar8_acore18_opt_0.sw_bitcell_opt_b1_1.bot 0.06598f
C3108 oa_sar8_acore18_opt_0.sw_bitcell_opt_term_0.trkb oa_sar8_acore18_opt_0.bstrap_opt_w2_c1200_1.gb 7.21267f
C3109 sar_ctrl_async_phys_0.sg13g2_inv_1_0.Y a_36056_32176# 0.1035f
C3110 sar_ctrl_async_phys_0.sg13g2_a21oi_1_0.B1 sar_ctrl_async_phys_0.sg13g2_buf_1_6.A 0.49615f
C3111 sar_ctrl_async_phys_0.dac_code_n[3] oa_sar8_acore18_opt_0.sw_bitcell_opt_b1_1.bot 0.06598f
C3112 sar_ctrl_async_phys_0.sg13g2_nor4_1_0.C a_28680_40460# 0.01968f
C3113 sar_ctrl_async_phys_0.sg13g2_o21ai_1_1.B1 a_33530_39921# 0.25515f
C3114 a_30200_35294# VDD 0.1366f
C3115 sar_ctrl_async_phys_0.hold_req oa_sar8_acore18_opt_0.bstrap_opt_w2_c1200_1.out 0.06588f
C3116 a_25496_39830# VDD 0.13116f
C3117 a_25596_47222# VDD 0.2853f
C3118 sar_ctrl_async_phys_0.dac_code[3] oa_sar8_acore18_opt_0.sw_bitcell_opt_term_0.VSS 1.12902f
C3119 sar_ctrl_async_phys_0.sg13g2_nand2b_1_7.A_N a_36152_45082# 0.02034f
C3120 a_35245_45266# sar_ctrl_async_phys_0.sg13g2_nand2_1_2.B 0.17923f
C3121 sar_ctrl_async_phys_0.sg13g2_a22oi_1_1.A2 a_32576_44454# 0.02236f
C3122 sar_ctrl_async_phys_0.sg13g2_a21oi_1_7.Y a_31841_39775# 0.01379f
C3123 oa_sar8_acore18_opt_0.sw_bitcell_opt_term_0.trkb oa_sar8_acore18_opt_0.sw_bitcell_opt_b1_1.bot 1.3958f
C3124 sar_ctrl_async_phys_0.sg13g2_buf_1_2.X a_35557_31435# 0.24283f
C3125 sar_ctrl_async_phys_0.sg13g2_a21oi_1_1.B1 sar_ctrl_async_phys_0.dac_code[1] 0.01754f
C3126 sar_ctrl_async_phys_0.hold_req sar_ctrl_async_phys_0.dac_code[3] 0.11624f
C3127 a_34636_31749# a_34615_31475# 0.34114f
C3128 oa_sar8_acore18_opt_0.sw_bitcell_opt_b2_0.bot m3_51760_n2380# 1.59913f
C3129 oa_sar8_acore18_opt_0.sw_bitcell_opt_b3_1.bot VDD 3.01881f
C3130 sar_ctrl_async_phys_0.sg13g2_dfrbpq_1_0.CLK a_29236_38952# 0.09619f
C3131 sar_ctrl_async_phys_0.sg13g2_buf_1_20.A a_35360_43726# 0.01061f
C3132 sar_ctrl_async_phys_0.sg13g2_a21oi_1_0.A1 sar_ctrl_async_phys_0.sg13g2_a22oi_1_0.A2 0.21611f
C3133 sar_ctrl_async_phys_0.sg13g2_dfrbpq_1_0.CLK sar_ctrl_async_phys_0.sg13g2_inv_1_10.Y 0.09977f
C3134 a_30676_35928# VDD 0.07488f
C3135 a_36056_41972# VDD 0.21853f
C3136 sar_ctrl_async_phys_0.sg13g2_dfrbpq_1_9.RESET_B a_34363_43495# 0.42055f
C3137 sar_ctrl_async_phys_0.sg13g2_buf_1_22.A sar_ctrl_async_phys_0.sg13g2_buf_1_21.A 0.06652f
C3138 sar_ctrl_async_phys_0.sg13g2_buf_1_23.A sar_ctrl_async_phys_0.bit_active[3] 0.04908f
C3139 sar_ctrl_async_phys_0.sg13g2_o21ai_1_1.B1 sar_ctrl_async_phys_0.sg13g2_buf_1_6.A 0.09232f
C3140 sar_ctrl_async_phys_0.sg13g2_buf_1_3.A a_32991_35239# 0.01291f
C3141 sar_ctrl_async_phys_0.sg13g2_inv_1_0.Y a_34636_31749# 0.01268f
C3142 sar_ctrl_async_phys_0.sg13g2_nand2_1_0.B sar_ctrl_async_phys_0.sg13g2_nor2_1_5.B 0.02987f
C3143 sar_ctrl_async_phys_0.sg13g2_nor2b_1_0.A sar_ctrl_async_phys_0.sg13g2_nand2b_1_3.Y 0.226f
C3144 sar_ctrl_async_phys_0.sg13g2_nor4_1_0.Y sar_ctrl_async_phys_0.sg13g2_nor2_1_12.B 0.01424f
C3145 a_31195_39820# VDD 0.20623f
C3146 a_30027_39996# VDD 0.2948f
C3147 a_32116_37861# a_32347_37447# 0.12701f
C3148 sar_ctrl_async_phys_0.sg13g2_inv_1_2.Y a_33752_33688# 0.02182f
C3149 sar_ctrl_async_phys_0.sg13g2_a22oi_1_2.A2 sar_ctrl_async_phys_0.sg13g2_a22oi_1_0.Y 0.30264f
C3150 a_30774_44234# a_31060_44552# 0.41329f
C3151 sar_ctrl_async_phys_0.sg13g2_o21ai_1_1.B1 a_32251_45007# 0.01844f
C3152 sar_ctrl_async_phys_0.sg13g2_a22oi_1_3.A2 a_33556_40016# 0.03998f
C3153 sar_ctrl_async_phys_0.sg13g2_buf_1_13.X sar_ctrl_async_phys_0.sg13g2_dfrbpq_1_11.D 0.33732f
C3154 a_29210_38916# a_29653_38959# 0.02242f
C3155 a_28950_39386# a_29524_39373# 0.31978f
C3156 sar_ctrl_async_phys_0.sg13g2_dfrbpq_1_9.RESET_B a_29334_43922# 0.08922f
C3157 sar_ctrl_async_phys_0.sg13g2_a21oi_1_1.B1 sar_ctrl_async_phys_0.sg13g2_buf_1_20.A 0.0277f
C3158 sar_ctrl_async_phys_0.sg13g2_nor2_1_1.Y a_33652_41528# 0.02991f
C3159 sar_ctrl_async_phys_0.dac_code[5] oa_sar8_acore18_opt_0.sw_tg_opt_0.bot 0.88851f
C3160 sar_ctrl_async_phys_0.sg13g2_nand2b_1_1.Y sar_ctrl_async_phys_0.sg13g2_nand2b_1_2.A_N 0.06065f
C3161 sar_ctrl_async_phys_0.sg13g2_buf_1_2.X a_29306_32361# 0.25877f
C3162 a_35672_38948# VDD 0.26746f
C3163 a_30384_31474# VDD 0.08211f
C3164 sar_ctrl_async_phys_0.sg13g2_dfrbpq_1_9.RESET_B a_32692_46064# 0.02398f
C3165 a_36056_33688# VDD 0.21753f
C3166 sar_ctrl_async_phys_0.sg13g2_a21oi_1_4.B1 sar_ctrl_async_phys_0.sg13g2_dfrbpq_1_9.RESET_B 0.01591f
C3167 sar_ctrl_async_phys_0.dac_code[7] oa_sar8_acore18_opt_0.sw_bitcell_opt_b2_0.bot 0.28022f
C3168 sar_ctrl_async_phys_0.sg13g2_nor2_1_2.Y sar_ctrl_async_phys_0.sg13g2_a21oi_1_1.Y 0.1428f
C3169 sar_ctrl_async_phys_0.sg13g2_nor2b_1_0.A sar_ctrl_async_phys_0.sg13g2_a21oi_1_0.A1 1.15342f
C3170 sar_ctrl_async_phys_0.sg13g2_a22oi_1_0.A2 sar_ctrl_async_phys_0.sg13g2_buf_1_4.A 0.0245f
C3171 sar_ctrl_async_phys_0.sg13g2_a22oi_1_0.A2 sar_ctrl_async_phys_0.sg13g2_and2_1_0.B 1.0782f
C3172 a_33558_43922# a_33844_43488# 0.41329f
C3173 sar_ctrl_async_phys_0.sg13g2_buf_1_5.A sar_ctrl_async_phys_0.sg13g2_buf_1_8.A 0.27131f
C3174 oa_sar8_acore18_opt_0.sw_bitcell_opt_b3_0.bot a_35948_n9612# 0.03603f
C3175 sar_ctrl_async_phys_0.sg13g2_dfrbpq_1_0.CLK a_32602_35924# 0.07984f
C3176 sar_ctrl_async_phys_0.cmp_fire oa_sar8_acore18_opt_0.sw_tg_opt_0.bot 0.17887f
C3177 sar_ctrl_async_phys_0.sg13g2_nor2_1_4.Y sar_ctrl_async_phys_0.sg13g2_buf_1_26.X 0.8903f
C3178 sar_ctrl_async_phys_0.sg13g2_nor2_1_13.Y sar_ctrl_async_phys_0.sg13g2_dlygate4sd3_1_6.X 0.01747f
C3179 sar_ctrl_async_phys_0.bit_active[6] sar_ctrl_async_phys_0.bit_active[5] 0.0941f
C3180 sar_ctrl_async_phys_0.sg13g2_a22oi_1_5.A2 sar_ctrl_async_phys_0.sg13g2_a21oi_1_2.A2 0.13046f
C3181 oa_sar8_acore18_opt_0.sw_bitcell_opt_b0_0.bot oa_sar8_acore18_opt_0.sw_bitcell_opt_term_0.bot 19.5876f
C3182 sar_ctrl_async_phys_0.sg13g2_dfrbpq_1_2.Q a_33754_37436# 0.11503f
C3183 sar_ctrl_async_phys_0.dac_code_n[1] oa_sar8_acore18_opt_0.sw_bitcell_opt_term_0.gb 0.09676f
C3184 a_29524_40464# a_29941_40471# 0.37583f
C3185 sar_ctrl_async_phys_0.sg13g2_buf_1_34.A sar_ctrl_async_phys_0.sg13g2_buf_1_44.A 0.38297f
C3186 sar_ctrl_async_phys_0.sg13g2_a21oi_1_1.B1 sar_ctrl_async_phys_0.sg13g2_nand2_1_1.B 0.02543f
C3187 sar_ctrl_async_phys_0.sg13g2_nand2_1_3.A sar_ctrl_async_phys_0.dac_code[4] 0.18407f
C3188 sar_ctrl_async_phys_0.sg13g2_nor4_1_0.C sar_ctrl_async_phys_0.sg13g2_a21oi_1_7.A2 0.01737f
C3189 sar_ctrl_async_phys_0.sg13g2_buf_1_32.A a_34093_42912# 0.0156f
C3190 sar_ctrl_async_phys_0.sg13g2_dfrbpq_1_9.Q sar_ctrl_async_phys_0.sg13g2_buf_1_34.A 0.10674f
C3191 sar_ctrl_async_phys_0.dac_code[0] a_36152_43570# 0.01665f
C3192 sar_ctrl_async_phys_0.dac_code_n[6] oa_sar8_acore18_opt_0.sw_bitcell_opt_b5_1.bot 0.07638f
C3193 sar_ctrl_async_phys_0.sg13g2_a22oi_1_0.A2 sar_ctrl_async_phys_0.sg13g2_buf_1_8.A 0.02096f
C3194 a_33558_36674# a_34261_36653# 0.02454f
C3195 a_34420_33325# a_34651_32911# 0.12701f
C3196 sar_ctrl_async_phys_0.sg13g2_buf_1_13.X sar_ctrl_async_phys_0.sg13g2_nand2_1_0.Y 0.0109f
C3197 sar_ctrl_async_phys_0.sg13g2_a22oi_1_5.A2 a_29812_33968# 0.04604f
C3198 sar_ctrl_async_phys_0.sg13g2_dfrbpq_1_0.CLK sar_ctrl_async_phys_0.sg13g2_buf_1_2.X 1.78449f
C3199 sar_ctrl_async_phys_0.sg13g2_nor2b_1_0.A sar_ctrl_async_phys_0.sg13g2_buf_1_4.A 0.48003f
C3200 sar_ctrl_async_phys_0.sg13g2_a21oi_1_2.B1 sar_ctrl_async_phys_0.sg13g2_a21oi_1_7.Y 0.01647f
C3201 oa_sar8_acore18_opt_0.bstrap_opt_w2_c1200_1.out vinp 0.70055f
C3202 sar_ctrl_async_phys_0.sg13g2_nor4_1_0.C a_29238_40898# 0.01131f
C3203 a_29912_31474# VDD 0.14258f
C3204 sar_ctrl_async_phys_0.sg13g2_nor2_1_4.Y a_30964_46512# 0.01117f
C3205 oa_sar8_acore18_opt_0.sw_bitcell_opt_term_0.trkb oa_sar8_acore18_opt_0.sw_bitcell_opt_b5_1.bot 1.51334f
C3206 oa_sar8_acore18_opt_0.sw_bitcell_opt_b7_1.bot VDD 8.98218f
C3207 sar_ctrl_async_phys_0.sg13g2_a22oi_1_0.A1 a_34319_32120# 0.01955f
C3208 a_36152_43570# VDD 0.12572f
C3209 sar_ctrl_async_phys_0.sg13g2_buf_1_3.A sar_ctrl_async_phys_0.sg13g2_nor2_1_1.Y 3.40375f
C3210 a_32149_35141# a_32251_35284# 0.47622f
C3211 sar_ctrl_async_phys_0.sg13g2_nand2b_1_1.Y sar_ctrl_async_phys_0.sg13g2_nand2_1_6.B 0.11638f
C3212 a_35552_36166# sar_ctrl_async_phys_0.bit_active[3] 0.02839f
C3213 sar_ctrl_async_phys_0.sg13g2_a22oi_1_0.A1 a_34010_35892# 0.0138f
C3214 a_34055_31352# a_34636_31749# 0.01529f
C3215 sar_ctrl_async_phys_0.sg13g2_a21oi_1_7.Y sar_ctrl_async_phys_0.sg13g2_dfrbpq_1_22.D 0.13237f
C3216 sar_ctrl_async_phys_0.sg13g2_dfrbpq_1_9.RESET_B a_31060_44552# 0.41339f
C3217 sar_ctrl_async_phys_0.sg13g2_buf_1_13.X sar_ctrl_async_phys_0.sg13g2_nor2_1_0.Y 2.23235f
C3218 sar_ctrl_async_phys_0.sg13g2_nor2_1_2.A a_33648_36010# 0.02795f
C3219 sar_ctrl_async_phys_0.sg13g2_a21oi_1_0.B1 a_34904_38224# 0.05148f
C3220 sar_ctrl_async_phys_0.sg13g2_nand2b_1_2.Y sar_ctrl_async_phys_0.sg13g2_nand2_1_6.B 0.05639f
C3221 sar_ctrl_async_phys_0.sg13g2_a22oi_1_0.B1 VDD 1.89948f
C3222 sar_ctrl_async_phys_0.sg13g2_nand2_1_3.Y sar_ctrl_async_phys_0.sg13g2_a21oi_1_3.A2 0.03303f
C3223 sar_ctrl_async_phys_0.sg13g2_nor4_1_0.C sar_ctrl_async_phys_0.sg13g2_dfrbpq_1_2.Q 0.01313f
C3224 sar_ctrl_async_phys_0.sg13g2_dfrbpq_1_0.CLK a_32149_45007# 0.25773f
C3225 sar_ctrl_async_phys_0.sg13g2_nand2b_1_3.Y VDD 0.37866f
C3226 sar_ctrl_async_phys_0.sg13g2_dfrbpq_1_9.RESET_B sar_ctrl_async_phys_0.sg13g2_buf_1_14.A 0.01004f
C3227 a_36056_46508# sar_ctrl_async_phys_0.dac_code[0] 0.2552f
C3228 sar_ctrl_async_phys_0.sg13g2_a22oi_1_0.A1 a_33846_34850# 0.03793f
C3229 a_30139_43495# VDD 0.20601f
C3230 sar_ctrl_async_phys_0.sg13g2_a22oi_1_0.A1 a_34363_36796# 0.05254f
C3231 sar_ctrl_async_phys_0.sg13g2_buf_1_35.A sar_ctrl_async_phys_0.sg13g2_nand2b_1_3.Y 0.02012f
C3232 sar_ctrl_async_phys_0.sg13g2_a22oi_1_2.A2 sar_ctrl_async_phys_0.sg13g2_a22oi_1_1.B2 0.35004f
C3233 a_35245_45936# VDD 0.29151f
C3234 a_30037_43495# a_30785_43845# 0.01058f
C3235 a_32245_37447# a_32116_37861# 0.01562f
C3236 a_31828_37440# a_32347_37447# 0.34102f
C3237 sar_ctrl_async_phys_0.sg13g2_inv_1_0.A a_33359_32876# 0.17071f
C3238 sar_ctrl_async_phys_0.sg13g2_a21oi_1_4.B1 sar_ctrl_async_phys_0.sg13g2_nor2b_1_0.A 0.1134f
C3239 a_34459_44356# VDD 0.20637f
C3240 sar_ctrl_async_phys_0.sg13g2_nor2b_1_0.A a_34171_41332# 0.04445f
C3241 sar_ctrl_async_phys_0.sg13g2_buf_1_14.A sar_ctrl_async_phys_0.sg13g2_a21oi_1_3.A2 0.01738f
C3242 a_31935_36285# a_31841_36285# 0.28931f
C3243 sar_ctrl_async_phys_0.sg13g2_buf_1_3.A a_33183_32215# 0.03579f
C3244 a_36056_46508# VDD 0.21878f
C3245 a_34236_46472# sar_ctrl_async_phys_0.sg13g2_buf_1_3.A 0.27375f
C3246 sar_ctrl_async_phys_0.sg13g2_a21oi_1_0.A1 VDD 1.93911f
C3247 a_35672_47296# sar_ctrl_async_phys_0.dac_code_n[4] 0.24511f
C3248 sar_ctrl_async_phys_0.dac_code[5] m3_48572_n2380# 0.05732f
C3249 sar_ctrl_async_phys_0.sg13g2_nor4_1_0.Y a_26662_41278# 0.01f
C3250 sar_ctrl_async_phys_0.dac_code[0] sar_ctrl_async_phys_0.dac_code[3] 0.21891f
C3251 sar_ctrl_async_phys_0.sg13g2_dfrbpq_1_11.D a_32116_40464# 0.02265f
C3252 sar_ctrl_async_phys_0.sg13g2_buf_1_35.A sar_ctrl_async_phys_0.sg13g2_a21oi_1_0.A1 0.03498f
C3253 sar_ctrl_async_phys_0.sg13g2_a21oi_1_6.A2 a_33248_45238# 0.01142f
C3254 sar_ctrl_async_phys_0.sg13g2_nor2_1_11.A a_30296_42854# 0.01075f
C3255 a_32149_45007# a_32897_45357# 0.01058f
C3256 sar_ctrl_async_phys_0.sg13g2_nand2_1_2.A a_34618_46044# 0.024f
C3257 sar_ctrl_async_phys_0.sg13g2_a21oi_1_1.B1 sar_ctrl_async_phys_0.sg13g2_and2_1_5.X 0.03205f
C3258 sar_ctrl_async_phys_0.sg13g2_buf_1_13.A a_33366_41210# 0.05366f
C3259 sar_ctrl_async_phys_0.sg13g2_inv_1_9.Y sar_ctrl_async_phys_0.sg13g2_o21ai_1_1.A2 0.02219f
C3260 sar_ctrl_async_phys_0.sg13g2_buf_1_20.A sar_ctrl_async_phys_0.sg13g2_nor2_1_1.Y 0.0365f
C3261 oa_sar8_acore18_opt_0.bstrap_opt_w2_c1200_1.out VDD 4.07597f
C3262 sar_ctrl_async_phys_0.sg13g2_a22oi_1_1.A2 sar_ctrl_async_phys_0.sg13g2_buf_1_20.A 0.14647f
C3263 sar_ctrl_async_phys_0.sg13g2_nor2_1_2.Y sar_ctrl_async_phys_0.sg13g2_buf_1_22.A 0.03887f
C3264 sar_ctrl_async_phys_0.sg13g2_nand2_1_2.A a_34357_44213# 0.03968f
C3265 sar_ctrl_async_phys_0.sg13g2_nand2b_1_1.Y sar_ctrl_async_phys_0.dac_code_n[6] 0.02637f
C3266 sar_ctrl_async_phys_0.sg13g2_a21oi_1_0.B1 a_35199_44311# 0.01995f
C3267 sar_ctrl_async_phys_0.dac_code[2] sar_ctrl_async_phys_0.sg13g2_nand2b_1_2.A_N 0.0604f
C3268 sar_ctrl_async_phys_0.dac_code[3] VDD 4.56395f
C3269 sar_ctrl_async_phys_0.dac_code_n[6] oa_sar8_acore18_opt_0.sw_bitcell_opt_term_0.vin 0.07198f
C3270 oa_sar8_acore18_opt_0.sw_bitcell_opt_b0_1.bot oa_sar8_acore18_opt_0.bstrap_opt_w2_c1200_1.gb 0.64235f
C3271 a_31935_39775# a_31841_39775# 0.28931f
C3272 a_36056_35200# VDD 0.21856f
C3273 sar_ctrl_async_phys_0.dac_code_n[3] sar_ctrl_async_phys_0.sg13g2_nand2b_1_1.Y 0.02006f
C3274 sar_ctrl_async_phys_0.sg13g2_nand2_1_2.A a_35672_46508# 0.01358f
C3275 sar_ctrl_async_phys_0.dac_code_n[1] sar_ctrl_async_phys_0.sg13g2_buf_1_44.A 0.01822f
C3276 sar_ctrl_async_phys_0.sg13g2_dfrbpq_1_0.CLK a_31093_39677# 0.26154f
C3277 sar_ctrl_async_phys_0.dac_code_n[0] sar_ctrl_async_phys_0.dac_code_n[7] 0.13499f
C3278 sar_ctrl_async_phys_0.sg13g2_a21oi_1_1.B1 sar_ctrl_async_phys_0.sg13g2_buf_1_23.A 1.93533f
C3279 sar_ctrl_async_phys_0.sg13g2_dlygate4sd3_1_7.X sar_ctrl_async_phys_0.sg13g2_dlygate4sd3_1_4.A 0.03498f
C3280 sar_ctrl_async_phys_0.dac_code_n[3] oa_sar8_acore18_opt_0.sw_bitcell_opt_term_0.vin 0.05835f
C3281 sar_ctrl_async_phys_0.sg13g2_a22oi_1_0.A2 a_34651_32911# 0.0147f
C3282 sar_ctrl_async_phys_0.sg13g2_buf_1_35.A sar_ctrl_async_phys_0.dac_code[3] 0.08317f
C3283 sar_ctrl_async_phys_0.dac_code_n[1] sar_ctrl_async_phys_0.sg13g2_dfrbpq_1_9.Q 0.08309f
C3284 a_34132_32904# a_34651_32911# 0.34102f
C3285 a_34549_32911# a_34420_33325# 0.01562f
C3286 sar_ctrl_async_phys_0.sg13g2_buf_1_3.A result[2] 0.0565f
C3287 sar_ctrl_async_phys_0.sg13g2_a21oi_1_0.A1 a_31830_40898# 0.01737f
C3288 sar_ctrl_async_phys_0.sg13g2_buf_1_4.A VDD 0.7402f
C3289 sar_ctrl_async_phys_0.sg13g2_and2_1_0.B VDD 0.59548f
C3290 sar_ctrl_async_phys_0.sg13g2_buf_1_13.X sar_ctrl_async_phys_0.sg13g2_a22oi_1_2.B1 0.32664f
C3291 sar_ctrl_async_phys_0.sg13g2_a22oi_1_3.A2 sar_ctrl_async_phys_0.sg13g2_nor2_1_1.A 0.07456f
C3292 sar_ctrl_async_phys_0.sg13g2_dfrbpq_1_0.CLK a_31189_31399# 0.27126f
C3293 oa_sar8_acore18_opt_0.sw_bitcell_opt_b0_1.bot oa_sar8_acore18_opt_0.sw_bitcell_opt_b1_1.bot 14.7249f
C3294 oa_sar8_acore18_opt_0.sw_bitcell_opt_term_0.trkb oa_sar8_acore18_opt_0.sw_bitcell_opt_term_0.vin 13.1742f
C3295 sar_ctrl_async_phys_0.sg13g2_a21oi_1_1.B1 sar_ctrl_async_phys_0.dac_code_n[2] 0.07716f
C3296 sar_ctrl_async_phys_0.sg13g2_nor2_1_10.B a_30944_35166# 0.01635f
C3297 sar_ctrl_async_phys_0.sg13g2_a21oi_1_0.B1 sar_ctrl_async_phys_0.dac_code_n[7] 0.01942f
C3298 sar_ctrl_async_phys_0.dac_code[3] oa_sar8_acore18_opt_0.sw_bitcell_opt_b6_0.bot 1.17374f
C3299 a_34363_43495# VDD 0.20628f
C3300 sar_ctrl_async_phys_0.sg13g2_a22oi_1_2.B1 a_31738_33948# 0.04524f
C3301 sar_ctrl_async_phys_0.sg13g2_a21oi_1_4.B1 sar_ctrl_async_phys_0.dac_code[0] 0.1069f
C3302 sar_ctrl_async_phys_0.sg13g2_nor2b_1_0.A sar_ctrl_async_phys_0.sg13g2_buf_1_14.A 0.05673f
C3303 sar_ctrl_async_phys_0.sg13g2_a21oi_1_1.Y result[4] 0.01136f
C3304 a_31381_46519# a_31483_46519# 0.47795f
C3305 sar_ctrl_async_phys_0.sg13g2_dlygate4sd3_1_8.A sar_ctrl_async_phys_0.sg13g2_nor2_1_12.A 0.01044f
C3306 sar_ctrl_async_phys_0.sg13g2_buf_1_3.A sar_ctrl_async_phys_0.sg13g2_inv_1_0.A 0.53535f
C3307 sar_ctrl_async_phys_0.sg13g2_buf_1_8.A VDD 0.6693f
C3308 a_33846_33338# result[4] 0.04723f
C3309 a_36056_38224# sar_ctrl_async_phys_0.dac_code[7] 0.24507f
C3310 sar_ctrl_async_phys_0.sg13g2_a21oi_1_0.A1 sar_ctrl_async_phys_0.sg13g2_a21oi_1_0.A2 0.2778f
C3311 sar_ctrl_async_phys_0.sg13g2_buf_1_6.A sar_ctrl_async_phys_0.sg13g2_buf_1_21.A 0.73887f
C3312 sar_ctrl_async_phys_0.sg13g2_and2_1_0.B a_35295_36285# 0.0434f
C3313 sar_ctrl_async_phys_0.sg13g2_nor2_1_0.Y a_32116_40464# 0.0284f
C3314 a_29334_43922# VDD 0.78161f
C3315 oa_sar8_acore18_opt_0.sw_bitcell_opt_b3_1.bot oa_sar8_acore18_opt_0.sw_bitcell_opt_b7_1.VSS 1.7475f
C3316 oa_sar8_acore18_opt_0.sw_bitcell_opt_b7_0.bot oa_sar8_acore18_opt_0.sw_bitcell_opt_b3_0.bot 0.96639f
C3317 sar_ctrl_async_phys_0.sg13g2_a21oi_1_0.A1 a_31162_38948# 0.01193f
C3318 oa_sar8_acore18_opt_0.sw_bitcell_opt_term_0.vin oa_sar8_acore18_opt_0.sw_bitcell_opt_b4_0.bot 4.0259f
C3319 a_32692_46064# VDD 0.0722f
C3320 sar_ctrl_async_phys_0.sg13g2_a22oi_1_1.A2 sar_ctrl_async_phys_0.sg13g2_nor2_1_0.A 0.24678f
C3321 sar_ctrl_async_phys_0.sg13g2_a21oi_1_4.B1 VDD 0.68868f
C3322 sar_ctrl_async_phys_0.sg13g2_inv_1_3.Y a_33089_32215# 0.01129f
C3323 a_31828_37440# a_32245_37447# 0.37583f
C3324 a_34904_47296# VDD 0.21798f
C3325 sar_ctrl_async_phys_0.sg13g2_nor2_1_1.A a_33210_36972# 0.0148f
C3326 a_34171_41332# VDD 0.20674f
C3327 sar_ctrl_async_phys_0.sg13g2_buf_1_4.A a_35391_34773# 0.01247f
C3328 sar_ctrl_async_phys_0.sg13g2_a21oi_1_4.B1 sar_ctrl_async_phys_0.sg13g2_buf_1_35.A 0.35826f
C3329 sar_ctrl_async_phys_0.dac_code_n[5] oa_sar8_acore18_opt_0.sw_bitcell_opt_term_0.gb 0.1574f
C3330 sar_ctrl_async_phys_0.sg13g2_and2_1_0.B a_35009_36751# 0.01248f
C3331 sar_ctrl_async_phys_0.sg13g2_buf_1_1.A busy 0.01483f
C3332 a_30676_35928# a_31935_36285# 0.01529f
C3333 a_32443_32260# a_33440_32358# 0.02979f
C3334 sar_ctrl_async_phys_0.sg13g2_a22oi_1_0.A1 sar_ctrl_async_phys_0.sg13g2_a22oi_1_0.Y 0.72942f
C3335 a_30783_40821# a_30689_40821# 0.28931f
C3336 sar_ctrl_async_phys_0.sg13g2_a21oi_1_6.B1 a_33940_44552# 0.01087f
C3337 sar_ctrl_async_phys_0.sg13g2_o21ai_1_1.B1 sar_ctrl_async_phys_0.sg13g2_nor2_1_2.Y 0.01756f
C3338 sar_ctrl_async_phys_0.sg13g2_a21oi_1_5.B1 a_33654_44234# 0.03047f
C3339 sar_ctrl_async_phys_0.sg13g2_nor2_1_4.Y sar_ctrl_async_phys_0.sg13g2_dlygate4sd3_1_4.X 0.01622f
C3340 a_31446_45434# a_32251_45007# 0.097f
C3341 sar_ctrl_async_phys_0.sg13g2_a22oi_1_0.B2 a_34132_30944# 0.01036f
C3342 w_39600_n9960# sar_ctrl_async_phys_0.dac_code[5] 0.20213f
C3343 sar_ctrl_async_phys_0.sg13g2_a21oi_1_0.A2 sar_ctrl_async_phys_0.sg13g2_buf_1_4.A 0.20473f
C3344 sar_ctrl_async_phys_0.sg13g2_buf_1_2.X sar_ctrl_async_phys_0.sg13g2_inv_1_2.A 0.02568f
C3345 sar_ctrl_async_phys_0.sg13g2_a21oi_1_0.B1 a_34911_41287# 0.01068f
C3346 oa_sar8_acore18_opt_0.sw_bitcell_opt_b4_1.bot oa_sar8_acore18_opt_0.bstrap_opt_w2_c1200_1.gb 0.67477f
C3347 sar_ctrl_async_phys_0.sg13g2_nand2_1_2.B a_33940_44552# 0.02515f
C3348 sar_ctrl_async_phys_0.sg13g2_nand2_1_1.Y a_35595_40460# 0.02657f
C3349 sar_ctrl_async_phys_0.sg13g2_nor2_1_4.Y sar_ctrl_async_phys_0.sg13g2_inv_1_9.Y 0.12576f
C3350 sar_ctrl_async_phys_0.sg13g2_buf_1_5.A sar_ctrl_async_phys_0.sg13g2_inv_1_5.A 0.38536f
C3351 sar_ctrl_async_phys_0.sg13g2_nor2_1_2.A sar_ctrl_async_phys_0.sg13g2_a22oi_1_0.A1 0.50045f
C3352 sar_ctrl_async_phys_0.sg13g2_nand2_1_3.Y VDD 0.61789f
C3353 a_34132_30944# a_34420_30639# 0.43707f
C3354 sar_ctrl_async_phys_0.sg13g2_nor2b_1_4.Y a_30785_43845# 0.01753f
C3355 sar_ctrl_async_phys_0.dac_code_n[2] oa_sar8_acore18_opt_0.sw_tg_opt_1.bot 0.07593f
C3356 a_30676_40016# a_30964_39711# 0.43707f
C3357 sar_ctrl_async_phys_0.sg13g2_o21ai_1_1.B1 a_30783_40821# 0.15138f
C3358 a_33752_33688# result[4] 0.24516f
C3359 sar_ctrl_async_phys_0.sg13g2_nand2b_1_1.Y sar_ctrl_async_phys_0.sg13g2_nand2b_1_7.A_N 0.41151f
C3360 sar_ctrl_async_phys_0.sg13g2_a22oi_1_0.A2 a_34549_32911# 0.02504f
C3361 sar_ctrl_async_phys_0.sg13g2_buf_1_35.A sar_ctrl_async_phys_0.sg13g2_nand2_1_3.Y 0.03252f
C3362 a_33252_36642# sar_ctrl_async_phys_0.sg13g2_nor2b_1_1.B_N 0.26291f
C3363 sar_ctrl_async_phys_0.sg13g2_nor2_1_1.Y sar_ctrl_async_phys_0.sg13g2_and2_1_5.X 0.01442f
C3364 a_34132_32904# a_34549_32911# 0.37583f
C3365 sar_ctrl_async_phys_0.sg13g2_nor2_1_6.A sar_ctrl_async_phys_0.sg13g2_nor2_1_10.B 0.11122f
C3366 sar_ctrl_async_phys_0.sg13g2_dfrbpq_1_0.CLK a_34357_44213# 0.29074f
C3367 sar_ctrl_async_phys_0.sg13g2_buf_1_14.A sar_ctrl_async_phys_0.sg13g2_nor2b_1_3.Y 0.19054f
C3368 oa_sar8_acore18_opt_0.sw_bitcell_opt_b0_1.bot oa_sar8_acore18_opt_0.sw_bitcell_opt_b5_1.bot 0.36922f
C3369 oa_sar8_acore18_opt_0.sw_bitcell_opt_b2_1.bot oa_sar8_acore18_opt_0.sw_bitcell_opt_b3_1.bot 14.0443f
C3370 oa_sar8_acore18_opt_0.sw_bitcell_opt_b1_1.bot oa_sar8_acore18_opt_0.sw_bitcell_opt_b4_1.bot 1.12054f
C3371 sar_ctrl_async_phys_0.sg13g2_nand2b_1_2.Y sar_ctrl_async_phys_0.sg13g2_nand2b_1_7.A_N 0.02909f
C3372 a_32347_37447# VDD 0.20917f
C3373 sar_ctrl_async_phys_0.dac_code_n[4] oa_sar8_acore18_opt_0.sw_bitcell_opt_term_0.VSS 0.01969f
C3374 sar_ctrl_async_phys_0.sg13g2_a22oi_1_1.A2 sar_ctrl_async_phys_0.sg13g2_buf_1_16.A 0.16955f
C3375 sar_ctrl_async_phys_0.cmp_fault sar_ctrl_async_phys_0.cmp_valid 0.22673f
C3376 a_31060_44552# VDD 0.0723f
C3377 sar_ctrl_async_phys_0.sg13g2_a22oi_1_0.B1 a_34319_32460# 0.07219f
C3378 sar_ctrl_async_phys_0.sg13g2_nor2_1_4.Y a_26184_42013# 0.02185f
C3379 sar_ctrl_async_phys_0.sg13g2_a21oi_1_6.B1 sar_ctrl_async_phys_0.cmp_valid 0.03153f
C3380 sar_ctrl_async_phys_0.dac_code[3] oa_sar8_acore18_opt_0.sw_bitcell_opt_b2_0.bot 0.1569f
C3381 a_34520_47296# sar_ctrl_async_phys_0.cmp_valid 0.25543f
C3382 sar_ctrl_async_phys_0.hold_req sar_ctrl_async_phys_0.dac_code_n[4] 0.05309f
C3383 sar_ctrl_async_phys_0.dac_code_n[6] sar_ctrl_async_phys_0.dac_code[2] 0.06252f
C3384 sar_ctrl_async_phys_0.sg13g2_o21ai_1_1.B1 a_34911_41287# 0.13293f
C3385 oa_sar8_acore18_opt_0.sw_bitcell_opt_term_0.vin m3_57896_n2380# 0.05057f
C3386 sar_ctrl_async_phys_0.sg13g2_a22oi_1_1.A2 a_32404_40885# 0.02511f
C3387 sar_ctrl_async_phys_0.sg13g2_buf_1_14.A VDD 0.74534f
C3388 sar_ctrl_async_phys_0.dac_code_n[3] sar_ctrl_async_phys_0.dac_code[2] 1.94715f
C3389 sar_ctrl_async_phys_0.sg13g2_buf_1_2.X a_31189_31399# 0.05068f
C3390 a_29941_40471# VDD 0.27195f
C3391 sar_ctrl_async_phys_0.sg13g2_buf_1_35.A sar_ctrl_async_phys_0.sg13g2_buf_1_14.A 0.02657f
C3392 sar_ctrl_async_phys_0.sg13g2_nand2_1_3.A a_34765_45266# 0.25747f
C3393 a_34651_32911# VDD 0.2067f
C3394 sar_ctrl_async_phys_0.dac_code[2] oa_sar8_acore18_opt_0.sw_bitcell_opt_term_0.trkb 1.87273f
C3395 sar_ctrl_async_phys_0.sg13g2_nand3_1_0.A VDD 0.45957f
C3396 sar_ctrl_async_phys_0.sg13g2_nor2_1_4.Y a_26289_42912# 0.04525f
C3397 oa_sar8_acore18_opt_0.sw_bitcell_opt_b7_0.bot oa_sar8_acore18_opt_0.sw_bitcell_opt_term_0.bot 1.12023f
C3398 oa_sar8_acore18_opt_0.sw_bitcell_opt_b7_1.bot oa_sar8_acore18_opt_0.sw_bitcell_opt_b7_1.VSS 2.53864f
C3399 oa_sar8_acore18_opt_0.sw_bitcell_opt_term_0.vin oa_sar8_acore18_opt_0.sw_bitcell_opt_b0_0.bot 3.83256f
C3400 sar_ctrl_async_phys_0.sg13g2_a22oi_1_3.A2 sar_ctrl_async_phys_0.sg13g2_a22oi_1_0.B1 0.19164f
C3401 sar_ctrl_async_phys_0.sg13g2_and2_1_0.B a_34036_35928# 0.04423f
C3402 sar_ctrl_async_phys_0.dac_code_n[1] oa_sar8_acore18_opt_0.sw_bitcell_opt_b3_0.bot 0.06138f
C3403 w_16692_n9960# oa_sar8_acore18_opt_0.sw_bitcell_opt_b3_1.bot 0.02733f
C3404 a_35053_40730# a_34896_40546# 0.01157f
C3405 sar_ctrl_async_phys_0.sg13g2_a22oi_1_0.Y sar_ctrl_async_phys_0.sg13g2_inv_1_3.Y 0.20091f
C3406 sar_ctrl_async_phys_0.sg13g2_buf_1_2.A a_33087_37797# 0.14943f
C3407 sar_ctrl_async_phys_0.sg13g2_nor2_1_1.A a_33252_36642# 0.29373f
C3408 sar_ctrl_async_phys_0.sg13g2_a21oi_1_7.A2 a_32533_40471# 0.02763f
C3409 sar_ctrl_async_phys_0.sg13g2_nor2b_1_0.A sar_ctrl_async_phys_0.sg13g2_buf_1_0.A 0.04878f
C3410 sar_ctrl_async_phys_0.sg13g2_a22oi_1_2.A2 sar_ctrl_async_phys_0.sg13g2_a22oi_1_2.B1 0.05924f
C3411 sar_ctrl_async_phys_0.sg13g2_buf_1_9.A sar_ctrl_async_phys_0.sg13g2_inv_1_0.A 0.01417f
C3412 a_30390_36362# a_31093_35935# 0.02432f
C3413 sar_ctrl_async_phys_0.sg13g2_a21oi_1_4.B1 a_36056_47296# 0.26706f
C3414 sar_ctrl_async_phys_0.sg13g2_a22oi_1_0.A1 sar_ctrl_async_phys_0.sg13g2_a22oi_1_1.B2 0.48558f
C3415 a_31924_32456# a_32341_32117# 0.3749f
C3416 a_31638_32138# a_32443_32260# 0.097f
C3417 sar_ctrl_async_phys_0.dac_code_n[5] sar_ctrl_async_phys_0.sg13g2_buf_1_44.A 0.03097f
C3418 sar_ctrl_async_phys_0.sg13g2_buf_1_13.X a_31261_38232# 0.14813f
C3419 sar_ctrl_async_phys_0.sg13g2_buf_1_13.X a_29701_36874# 0.06281f
C3420 sar_ctrl_async_phys_0.dac_code[2] oa_sar8_acore18_opt_0.sw_bitcell_opt_b4_0.bot 0.38033f
C3421 sar_ctrl_async_phys_0.sg13g2_dlygate4sd3_1_3.A a_28774_41278# 0.16512f
C3422 sar_ctrl_async_phys_0.sg13g2_dlygate4sd3_1_5.A sar_ctrl_async_phys_0.sg13g2_nand3_1_0.Y 0.04369f
C3423 sar_ctrl_async_phys_0.sg13g2_a21oi_1_0.A1 sar_ctrl_async_phys_0.sg13g2_a22oi_1_3.A2 0.78121f
C3424 a_36056_38948# sar_ctrl_async_phys_0.dac_code[6] 0.09541f
C3425 a_33085_43832# VDD 0.39095f
C3426 a_34765_42242# a_34847_42342# 0.01117f
C3427 sar_ctrl_async_phys_0.sg13g2_buf_1_2.A a_35391_33261# 0.03102f
C3428 sar_ctrl_async_phys_0.sg13g2_buf_1_35.A a_33085_43832# 0.14833f
C3429 sar_ctrl_async_phys_0.sg13g2_nor2_1_2.Y sar_ctrl_async_phys_0.sg13g2_buf_1_6.A 0.02063f
C3430 sar_ctrl_async_phys_0.sg13g2_nor4_1_0.C sar_ctrl_async_phys_0.sg13g2_a21oi_1_0.B1 0.05874f
C3431 sar_ctrl_async_phys_0.sg13g2_a22oi_1_0.A1 sar_ctrl_async_phys_0.bit_active[0] 0.13759f
C3432 a_34132_30944# a_34549_30605# 0.3749f
C3433 a_33846_30626# a_34651_30748# 0.097f
C3434 sar_ctrl_async_phys_0.sg13g2_a21oi_1_6.A2 sar_ctrl_async_phys_0.sg13g2_nand2_1_3.B 0.47608f
C3435 a_30676_40016# a_31195_39820# 0.34114f
C3436 sar_ctrl_async_phys_0.dac_code[3] m3_45264_n2380# 0.05703f
C3437 sar_ctrl_async_phys_0.sg13g2_buf_1_14.A sar_ctrl_async_phys_0.sg13g2_a21oi_1_0.A2 0.16029f
C3438 sar_ctrl_async_phys_0.sg13g2_buf_1_5.A result[6] 0.02823f
C3439 oa_sar8_acore18_opt_0.sw_bitcell_opt_b3_1.bot oa_sar8_acore18_opt_0.sw_bitcell_opt_b6_1.bot 0.52491f
C3440 oa_sar8_acore18_opt_0.sw_bitcell_opt_b4_1.bot oa_sar8_acore18_opt_0.sw_bitcell_opt_b5_1.bot 8.59316f
C3441 oa_sar8_acore18_opt_0.bstrap_opt_w2_c1200_1.out oa_sar8_acore18_opt_0.sw_bitcell_opt_b7_1.VSS 0.11679f
C3442 oa_sar8_acore18_opt_0.sw_bitcell_opt_b2_1.bot oa_sar8_acore18_opt_0.sw_bitcell_opt_b7_1.bot 1.15895f
C3443 a_34520_42760# sar_ctrl_async_phys_0.dac_code_n[7] 0.03888f
C3444 a_30650_39921# a_30390_39698# 0.75507f
C3445 sar_ctrl_async_phys_0.sg13g2_dfrbpq_1_0.CLK a_34069_41189# 0.2554f
C3446 a_31644_36638# a_31352_36806# 0.01f
C3447 VDD vinn 0.2997f
C3448 sar_ctrl_async_phys_0.sg13g2_a22oi_1_5.A2 sar_ctrl_async_phys_0.sg13g2_a21oi_1_2.B1 0.02676f
C3449 sar_ctrl_async_phys_0.sg13g2_buf_1_22.A sar_ctrl_async_phys_0.bit_active[7] 0.02575f
C3450 a_28862_36863# sar_ctrl_async_phys_0.sg13g2_dlygate4sd3_1_0.X 0.02322f
C3451 a_28977_36864# a_29258_36642# 0.26306f
C3452 a_32245_37447# VDD 0.25338f
C3453 sar_ctrl_async_phys_0.sg13g2_nor2_1_3.B VDD 0.73902f
C3454 sar_ctrl_async_phys_0.sg13g2_buf_1_8.A a_34319_32460# 0.08456f
C3455 sar_ctrl_async_phys_0.sg13g2_a22oi_1_3.A2 sar_ctrl_async_phys_0.sg13g2_buf_1_4.A 0.01998f
C3456 sar_ctrl_async_phys_0.sg13g2_dfrbpq_1_9.RESET_B sar_ctrl_async_phys_0.sg13g2_nand2_1_2.A 0.02921f
C3457 sar_ctrl_async_phys_0.sg13g2_nand2_1_3.A sar_ctrl_async_phys_0.sg13g2_nand2_1_1.Y 0.0118f
C3458 sar_ctrl_async_phys_0.sg13g2_a22oi_1_5.A2 sar_ctrl_async_phys_0.sg13g2_dfrbpq_1_22.D 0.12193f
C3459 sar_ctrl_async_phys_0.sg13g2_buf_1_13.X sar_ctrl_async_phys_0.sg13g2_nor2_1_7.B 0.91771f
C3460 sar_ctrl_async_phys_0.sg13g2_nor4_1_0.C sar_ctrl_async_phys_0.sg13g2_o21ai_1_1.B1 0.34113f
C3461 sar_ctrl_async_phys_0.dac_code[1] oa_sar8_acore18_opt_0.sw_bitcell_opt_b5_0.bot 0.7608f
C3462 oa_sar8_acore18_opt_0.sw_bitcell_opt_term_0.vin a_35948_n9612# 0.0636f
C3463 sar_ctrl_async_phys_0.sg13g2_a22oi_1_1.B2 sar_ctrl_async_phys_0.sg13g2_buf_1_7.A 0.10726f
C3464 sar_ctrl_async_phys_0.sg13g2_nand2_1_3.B a_34093_42912# 0.17747f
C3465 a_30486_31826# a_31291_31399# 0.097f
C3466 a_28008_23477# a_26184_21025# 0.69491f
C3467 sar_ctrl_async_phys_0.sg13g2_buf_1_6.A a_34911_41287# 0.01198f
C3468 a_35391_30703# VDD 0.17142f
C3469 sar_ctrl_async_phys_0.sg13g2_a21oi_1_6.B1 sar_ctrl_async_phys_0.sg13g2_buf_1_3.A 0.52761f
C3470 a_34549_32911# VDD 0.24761f
C3471 sar_ctrl_async_phys_0.dac_code_n[1] oa_sar8_acore18_opt_0.sw_bitcell_opt_term_0.bot 0.42797f
C3472 sar_ctrl_async_phys_0.sg13g2_a21oi_1_1.B1 a_34765_45266# 0.09907f
C3473 sar_ctrl_async_phys_0.sg13g2_inv_1_3.Y sar_ctrl_async_phys_0.sg13g2_a22oi_1_1.B2 0.0156f
C3474 a_31034_44457# a_31060_44552# 0.36952f
C3475 sar_ctrl_async_phys_0.sg13g2_nor2b_1_1.B_N a_35280_35365# 0.10493f
C3476 sar_ctrl_async_phys_0.sg13g2_a22oi_1_0.B1 a_30507_35204# 0.03297f
C3477 sar_ctrl_async_phys_0.sg13g2_buf_1_25.A a_31638_32138# 0.04741f
C3478 sar_ctrl_async_phys_0.sg13g2_inv_1_5.A VDD 0.21359f
C3479 sar_ctrl_async_phys_0.sg13g2_nand2b_1_1.Y sar_ctrl_async_phys_0.sg13g2_a21oi_1_2.B1 0.29061f
C3480 sar_ctrl_async_phys_0.sg13g2_buf_1_0.A VDD 0.70674f
C3481 sar_ctrl_async_phys_0.sg13g2_a22oi_1_1.A2 sar_ctrl_async_phys_0.sg13g2_nor2_1_15.Y 0.01593f
C3482 a_32635_40471# a_33632_40702# 0.03061f
C3483 a_29812_33968# a_30100_33663# 0.43707f
C3484 sar_ctrl_async_phys_0.sg13g2_a21oi_1_3.A2 a_35482_39996# 0.12139f
C3485 sar_ctrl_async_phys_0.sg13g2_nand2b_1_2.Y sar_ctrl_async_phys_0.sg13g2_a21oi_1_2.B1 0.16634f
C3486 sar_ctrl_async_phys_0.sg13g2_a21oi_1_4.B1 sar_ctrl_async_phys_0.sg13g2_a22oi_1_3.A2 0.01289f
C3487 sar_ctrl_async_phys_0.sg13g2_dfrbpq_1_0.CLK a_30774_44234# 0.02132f
C3488 sar_ctrl_async_phys_0.sg13g2_nand2_1_0.B a_28368_36877# 0.28894f
C3489 oa_sar8_acore18_opt_0.bstrap_opt_w2_c1200_1.out oa_sar8_acore18_opt_0.sw_bitcell_opt_b2_1.bot 3.94653f
C3490 oa_sar8_acore18_opt_0.sw_bitcell_opt_term_1.bot oa_sar8_acore18_opt_0.sw_bitcell_opt_b3_1.bot 0.4909f
C3491 sar_ctrl_async_phys_0.dac_code_n[4] sar_ctrl_async_phys_0.dac_code[0] 0.6115f
C3492 sar_ctrl_async_phys_0.dac_code[2] oa_sar8_acore18_opt_0.sw_bitcell_opt_b0_0.bot 0.15607f
C3493 sar_ctrl_async_phys_0.sg13g2_a21oi_1_5.B1 a_33675_43020# 0.01493f
C3494 sar_ctrl_async_phys_0.sg13g2_buf_1_13.X a_25990_40484# 0.02693f
C3495 a_33080_30664# result[0] 0.24585f
C3496 a_25596_41174# VDD 0.29289f
C3497 sar_ctrl_async_phys_0.sg13g2_a21oi_1_2.B1 a_31450_40460# 0.11503f
C3498 sar_ctrl_async_phys_0.dac_code_n[1] m3_38288_n2380# 0.04007f
C3499 sar_ctrl_async_phys_0.sg13g2_a21oi_1_7.Y a_31732_35480# 0.02554f
C3500 sar_ctrl_async_phys_0.sg13g2_dfrbpq_1_0.CLK a_29524_40464# 0.10271f
C3501 sar_ctrl_async_phys_0.sg13g2_dfrbpq_1_17.D a_30746_31356# 0.01061f
C3502 sar_ctrl_async_phys_0.sg13g2_a22oi_1_0.B2 a_34615_31475# 0.05735f
C3503 sar_ctrl_async_phys_0.bit_active[4] VDD 0.22744f
C3504 sar_ctrl_async_phys_0.dac_code_n[1] oa_sar8_acore18_opt_0.bstrap_opt_w2_c1200_1.gb 0.1221f
C3505 sar_ctrl_async_phys_0.sg13g2_nor2_1_7.A a_29701_36874# 0.17754f
C3506 sar_ctrl_async_phys_0.sg13g2_buf_1_4.A done 0.02552f
C3507 sar_ctrl_async_phys_0.dac_code_n[4] VDD 4.92751f
C3508 sar_ctrl_async_phys_0.sg13g2_nand2_1_3.A a_34765_42242# 0.28252f
C3509 sar_ctrl_async_phys_0.sg13g2_a22oi_1_0.B1 a_30480_32986# 0.01152f
C3510 sar_ctrl_async_phys_0.dac_code[3] sar_ctrl_async_phys_0.cmp_n 0.07708f
C3511 a_26184_42013# a_26454_41972# 0.26306f
C3512 sar_ctrl_async_phys_0.sg13g2_nor2_1_10.B VDD 0.60046f
C3513 sar_ctrl_async_phys_0.bit_active[0] sar_ctrl_async_phys_0.bit_active[3] 0.01368f
C3514 sar_ctrl_async_phys_0.sg13g2_a21oi_1_6.B1 sar_ctrl_async_phys_0.sg13g2_buf_1_20.A 0.03882f
C3515 sar_ctrl_async_phys_0.sg13g2_buf_1_6.A busy 0.2613f
C3516 oa_sar8_acore18_opt_0.sw_tg_opt_0.bot oa_sar8_acore18_opt_0.sw_bitcell_opt_term_0.VSS 0.03903f
C3517 oa_sar8_acore18_opt_0.sw_bitcell_opt_b6_1.bot oa_sar8_acore18_opt_0.sw_bitcell_opt_b7_1.bot 11.0588f
C3518 sar_ctrl_async_phys_0.dac_code_n[4] sar_ctrl_async_phys_0.sg13g2_buf_1_35.A 0.02416f
C3519 sar_ctrl_async_phys_0.sg13g2_dfrbpq_1_2.Q a_34075_39820# 0.05344f
C3520 a_31563_43020# VDD 0.3033f
C3521 a_26184_39702# VDD 0.3091f
C3522 sar_ctrl_async_phys_0.dac_code_n[1] oa_sar8_acore18_opt_0.sw_bitcell_opt_b1_1.bot 1.3067f
C3523 w_16692_n9960# oa_sar8_acore18_opt_0.bstrap_opt_w2_c1200_1.out 0.03635f
C3524 sar_ctrl_async_phys_0.hold_req oa_sar8_acore18_opt_0.sw_tg_opt_0.bot 9.37779f
C3525 VDD result[0] 0.10464f
C3526 a_26168_38318# a_26352_38318# 0.0524f
C3527 sar_ctrl_async_phys_0.sg13g2_nand2_1_2.B sar_ctrl_async_phys_0.sg13g2_buf_1_20.A 0.11105f
C3528 sar_ctrl_async_phys_0.sg13g2_nor2_1_3.B a_27120_37522# 0.01275f
C3529 a_33632_40702# VDD 0.16937f
C3530 a_31071_33727# VDD 0.17395f
C3531 sar_ctrl_async_phys_0.dac_code_n[5] oa_sar8_acore18_opt_0.sw_bitcell_opt_b3_0.bot 0.08014f
C3532 a_34357_44213# a_34228_44247# 0.01562f
C3533 sar_ctrl_async_phys_0.sg13g2_a21oi_1_0.A1 a_30676_40016# 0.03802f
C3534 sar_ctrl_async_phys_0.dac_code[1] oa_sar8_acore18_opt_0.sw_bitcell_opt_b1_0.bot 1.44578f
C3535 sar_ctrl_async_phys_0.dac_code_n[4] oa_sar8_acore18_opt_0.sw_bitcell_opt_b6_0.bot 0.90747f
C3536 sar_ctrl_async_phys_0.sg13g2_a22oi_1_3.A2 a_32347_37447# 0.02547f
C3537 sar_ctrl_async_phys_0.sg13g2_nor2_1_4.Y a_34136_47296# 0.25757f
C3538 a_34636_31749# result[3] 0.03632f
C3539 sar_ctrl_async_phys_0.sg13g2_buf_1_22.A sar_ctrl_async_phys_0.bit_active[6] 0.24161f
C3540 sar_ctrl_async_phys_0.sg13g2_nor4_1_0.C sar_ctrl_async_phys_0.sg13g2_buf_1_6.A 0.01742f
C3541 sar_ctrl_async_phys_0.sg13g2_dfrbpq_1_0.CLK sar_ctrl_async_phys_0.sg13g2_nor2_1_6.A 0.81615f
C3542 a_33464_30664# VDD 0.22028f
C3543 sar_ctrl_async_phys_0.sg13g2_nor2_1_7.B sar_ctrl_async_phys_0.sg13g2_nor2_1_7.A 0.0616f
C3544 sar_ctrl_async_phys_0.sg13g2_dfrbpq_1_9.RESET_B sar_ctrl_async_phys_0.sg13g2_dfrbpq_1_0.CLK 3.16694f
C3545 sar_ctrl_async_phys_0.sg13g2_nor2_1_12.A VDD 0.4378f
C3546 a_26352_38318# VDD 0.06779f
C3547 sar_ctrl_async_phys_0.sg13g2_a21oi_1_0.A1 sar_ctrl_async_phys_0.sg13g2_nor2_1_5.B 0.10926f
C3548 sar_ctrl_async_phys_0.sg13g2_buf_1_13.X sar_ctrl_async_phys_0.sg13g2_buf_1_2.A 0.37407f
C3549 sar_ctrl_async_phys_0.sg13g2_buf_1_13.A sar_ctrl_async_phys_0.sg13g2_buf_1_2.A 1.24112f
C3550 sar_ctrl_async_phys_0.dac_code[2] a_35948_n9612# 2.16982f
C3551 sar_ctrl_async_phys_0.sg13g2_a21oi_1_0.A2 sar_ctrl_async_phys_0.bit_active[4] 0.01446f
C3552 a_35672_42760# sar_ctrl_async_phys_0.sg13g2_nand2_1_3.Y 0.02394f
C3553 a_29526_33650# a_30331_33772# 0.097f
C3554 sar_ctrl_async_phys_0.sg13g2_a21oi_1_0.B1 sar_ctrl_async_phys_0.sg13g2_nand2b_1_2.A_N 0.07775f
C3555 a_29812_33968# a_30229_33629# 0.3749f
C3556 oa_sar8_acore18_opt_0.bstrap_opt_w2_c1200_1.out oa_sar8_acore18_opt_0.sw_bitcell_opt_b6_1.bot 4.26916f
C3557 oa_sar8_acore18_opt_0.sw_bitcell_opt_term_1.bot oa_sar8_acore18_opt_0.sw_bitcell_opt_b7_1.bot 1.34622f
C3558 VDD result[6] 0.16568f
C3559 a_29786_33873# sar_ctrl_async_phys_0.sg13g2_inv_1_5.Y 0.01391f
C3560 sar_ctrl_async_phys_0.sg13g2_dfrbpq_1_0.CLK a_31828_37440# 0.08027f
C3561 sar_ctrl_async_phys_0.sg13g2_dfrbpq_1_0.CLK sar_ctrl_async_phys_0.sg13g2_buf_1_5.A 0.55809f
C3562 sar_ctrl_async_phys_0.sg13g2_o21ai_1_1.A2 sar_ctrl_async_phys_0.sg13g2_and2_1_2.X 0.07715f
C3563 sar_ctrl_async_phys_0.sg13g2_nor2_1_6.A a_29236_38952# 0.07088f
C3564 sar_ctrl_async_phys_0.sg13g2_buf_1_13.X sar_ctrl_async_phys_0.sg13g2_nor2_1_3.A 0.36678f
C3565 sar_ctrl_async_phys_0.sg13g2_inv_1_5.Y VDD 0.43856f
C3566 a_35952_39901# sar_ctrl_async_phys_0.sg13g2_buf_1_23.A 0.10429f
C3567 a_30848_32358# a_31258_32436# 0.10373f
C3568 sar_ctrl_async_phys_0.sg13g2_nand2b_1_0.A_N a_28130_40838# 0.01109f
C3569 sar_ctrl_async_phys_0.sg13g2_a22oi_1_0.A2 a_34453_35935# 0.03118f
C3570 sar_ctrl_async_phys_0.sg13g2_a21oi_1_2.A2 sar_ctrl_async_phys_0.sg13g2_buf_1_22.A 0.05635f
C3571 sar_ctrl_async_phys_0.sg13g2_buf_1_3.A sar_ctrl_async_phys_0.sg13g2_nor2b_1_1.B_N 0.31214f
C3572 sar_ctrl_async_phys_0.sg13g2_buf_1_13.A sar_ctrl_async_phys_0.sg13g2_a21oi_1_7.Y 0.01646f
C3573 sar_ctrl_async_phys_0.sg13g2_o21ai_1_1.A2 track 0.29415f
C3574 sar_ctrl_async_phys_0.sg13g2_buf_1_13.X sar_ctrl_async_phys_0.sg13g2_a21oi_1_7.Y 0.78709f
C3575 sar_ctrl_async_phys_0.sg13g2_buf_1_34.A sar_ctrl_async_phys_0.sg13g2_nand2b_1_1.Y 0.02344f
C3576 sar_ctrl_async_phys_0.sg13g2_a22oi_1_0.A1 sar_ctrl_async_phys_0.sg13g2_a22oi_1_2.B1 1.38549f
C3577 sar_ctrl_async_phys_0.sg13g2_nand2_1_2.A sar_ctrl_async_phys_0.dac_code[0] 0.20504f
C3578 sar_ctrl_async_phys_0.sg13g2_nor2_1_3.A track 0.48508f
C3579 sar_ctrl_async_phys_0.sg13g2_buf_1_3.A a_33464_31388# 0.01148f
C3580 sar_ctrl_async_phys_0.sg13g2_dfrbpq_1_0.CLK sar_ctrl_async_phys_0.sg13g2_a22oi_1_0.A2 1.28437f
C3581 sar_ctrl_async_phys_0.sg13g2_a21oi_1_0.B1 sar_ctrl_async_phys_0.bit_active[6] 0.46129f
C3582 sar_ctrl_async_phys_0.dac_code[1] sar_ctrl_async_phys_0.dac_code[7] 0.57898f
C3583 sar_ctrl_async_phys_0.sg13g2_dfrbpq_1_0.CLK a_34132_32904# 0.07868f
C3584 oa_sar8_acore18_opt_0.sw_bitcell_opt_b7_0.bot oa_sar8_acore18_opt_0.sw_bitcell_opt_term_0.vin 4.23458f
C3585 sar_ctrl_async_phys_0.sample oa_sar8_acore18_opt_0.sw_tg_opt_1.bot 2.09748f
C3586 sar_ctrl_async_phys_0.sg13g2_a21oi_1_7.A2 a_32400_41413# 0.12014f
C3587 sar_ctrl_async_phys_0.dac_code[4] oa_sar8_acore18_opt_0.sw_bitcell_opt_b5_0.bot 0.61154f
C3588 sar_ctrl_async_phys_0.sg13g2_nor2_1_2.Y sar_ctrl_async_phys_0.dac_code_n[7] 0.01072f
C3589 oa_sar8_acore18_opt_0.sw_bitcell_opt_term_0.gb m3_54868_n2380# 1.44533f
C3590 a_33183_32215# a_33089_32215# 0.28931f
C3591 sar_ctrl_async_phys_0.sg13g2_a22oi_1_5.A2 a_31040_40702# 0.03369f
C3592 a_36056_47296# sar_ctrl_async_phys_0.dac_code_n[4] 0.08995f
C3593 sar_ctrl_async_phys_0.sg13g2_buf_1_2.X a_34420_33325# 0.01487f
C3594 a_35962_35924# VDD 0.37823f
C3595 sar_ctrl_async_phys_0.sg13g2_nand2_1_2.A VDD 1.04309f
C3596 sar_ctrl_async_phys_0.sg13g2_nand2_1_3.A a_35578_41508# 0.0187f
C3597 sar_ctrl_async_phys_0.sg13g2_buf_1_6.A sar_ctrl_async_phys_0.bit_active[7] 0.07626f
C3598 sar_ctrl_async_phys_0.dac_code_n[5] oa_sar8_acore18_opt_0.sw_bitcell_opt_term_0.bot 0.09612f
C3599 sar_ctrl_async_phys_0.dac_code_n[4] oa_sar8_acore18_opt_0.sw_bitcell_opt_b2_0.bot 0.0829f
C3600 a_30830_35166# a_30944_35166# 0.0308f
C3601 sar_ctrl_async_phys_0.sg13g2_a22oi_1_1.A2 a_32192_36166# 0.02708f
C3602 sar_ctrl_async_phys_0.dac_code_n[2] oa_sar8_acore18_opt_0.sw_bitcell_opt_b5_0.bot 0.487f
C3603 a_33940_44552# a_34459_44356# 0.34114f
C3604 a_36056_37436# sar_ctrl_async_phys_0.bit_active[5] 0.24598f
C3605 sar_ctrl_async_phys_0.sg13g2_a22oi_1_0.A2 a_34895_32460# 0.01538f
C3606 a_36058_34412# VDD 0.37732f
C3607 sar_ctrl_async_phys_0.sg13g2_a21oi_1_0.B1 sar_ctrl_async_phys_0.sg13g2_nand2_1_6.B 0.7968f
C3608 a_35482_39996# VDD 0.38099f
C3609 oa_sar8_acore18_opt_0.sw_bitcell_opt_term_1.bot oa_sar8_acore18_opt_0.bstrap_opt_w2_c1200_1.out 3.86071f
C3610 sar_ctrl_async_phys_0.sg13g2_buf_1_3.A sar_ctrl_async_phys_0.sg13g2_nor2_1_1.A 0.49814f
C3611 sar_ctrl_async_phys_0.sg13g2_buf_1_20.A sar_ctrl_async_phys_0.dac_code[7] 0.77779f
C3612 sar_ctrl_async_phys_0.sg13g2_a22oi_1_3.A2 a_32245_37447# 0.01655f
C3613 sar_ctrl_async_phys_0.sg13g2_a21oi_1_5.B1 sar_ctrl_async_phys_0.sg13g2_dfrbpq_1_9.Q 0.5043f
C3614 sar_ctrl_async_phys_0.sg13g2_dfrbpq_1_0.CLK sar_ctrl_async_phys_0.sg13g2_nor2b_1_0.A 2.59776f
C3615 a_31716_38912# sar_ctrl_async_phys_0.sg13g2_buf_1_22.A 0.27381f
C3616 sar_ctrl_async_phys_0.sg13g2_a22oi_1_0.A1 a_33168_32986# 0.02036f
C3617 a_35295_36285# a_35962_35924# 0.0894f
C3618 sar_ctrl_async_phys_0.sg13g2_nand2_1_3.Y a_35245_42242# 0.0443f
C3619 a_35557_31435# VDD 0.09574f
C3620 sar_ctrl_async_phys_0.sg13g2_dfrbpq_1_9.RESET_B a_30678_46946# 0.11631f
C3621 sar_ctrl_async_phys_0.sg13g2_a22oi_1_2.B1 sar_ctrl_async_phys_0.sg13g2_buf_1_7.A 0.09556f
C3622 sar_ctrl_async_phys_0.sg13g2_dfrbpq_1_0.CLK a_28651_39740# 0.04902f
C3623 sar_ctrl_async_phys_0.dac_code_n[5] m3_38288_n2380# 0.04765f
C3624 sar_ctrl_async_phys_0.sg13g2_buf_1_13.X a_31640_34498# 0.01823f
C3625 sar_ctrl_async_phys_0.dac_code[0] oa_sar8_acore18_opt_0.sw_tg_opt_0.bot 0.94493f
C3626 sar_ctrl_async_phys_0.sg13g2_and2_1_5.X a_33556_40016# 0.01057f
C3627 sar_ctrl_async_phys_0.sg13g2_buf_1_16.A a_34132_34416# 0.04737f
C3628 a_35103_43845# a_35009_43845# 0.28931f
C3629 sar_ctrl_async_phys_0.sg13g2_nor2b_1_0.A a_31640_41342# 0.01733f
C3630 sar_ctrl_async_phys_0.sg13g2_a21oi_1_2.B1 sar_ctrl_async_phys_0.sg13g2_a21oi_1_7.A2 0.01576f
C3631 sar_ctrl_async_phys_0.sg13g2_o21ai_1_1.A2 a_27530_39666# 0.06683f
C3632 sar_ctrl_async_phys_0.sg13g2_a21oi_1_6.B1 sar_ctrl_async_phys_0.dac_code_n[2] 0.20358f
C3633 sar_ctrl_async_phys_0.dac_code_n[5] oa_sar8_acore18_opt_0.bstrap_opt_w2_c1200_1.gb 0.1313f
C3634 sar_ctrl_async_phys_0.sg13g2_buf_1_2.A sar_ctrl_async_phys_0.sg13g2_nor2_1_7.A 0.47785f
C3635 sar_ctrl_async_phys_0.sg13g2_a22oi_1_2.B1 sar_ctrl_async_phys_0.sg13g2_inv_1_3.Y 0.06882f
C3636 sar_ctrl_async_phys_0.sg13g2_o21ai_1_1.B1 sar_ctrl_async_phys_0.sg13g2_a21oi_1_2.A2 0.01937f
C3637 sar_ctrl_async_phys_0.dac_code[5] oa_sar8_acore18_opt_0.sw_bitcell_opt_term_0.VSS 1.32817f
C3638 sar_ctrl_async_phys_0.dac_code_n[0] sar_ctrl_async_phys_0.dac_code_n[6] 0.14233f
C3639 sar_ctrl_async_phys_0.sg13g2_inv_1_2.A a_34420_33325# 0.01328f
C3640 sar_ctrl_async_phys_0.sg13g2_dfrbpq_1_0.CLK a_32635_40471# 0.02038f
C3641 a_31040_40702# a_31450_40460# 0.10373f
C3642 sar_ctrl_async_phys_0.sg13g2_a22oi_1_3.A2 sar_ctrl_async_phys_0.sg13g2_buf_1_0.A 0.03082f
C3643 a_35391_34773# a_36058_34412# 0.0894f
C3644 sar_ctrl_async_phys_0.sg13g2_dfrbpq_1_2.Q a_34093_42912# 0.01032f
C3645 sar_ctrl_async_phys_0.sg13g2_nor2_1_3.Y VDD 0.60765f
C3646 a_33556_40016# sar_ctrl_async_phys_0.sg13g2_buf_1_23.A 0.01251f
C3647 a_33973_39677# a_34721_39775# 0.01058f
C3648 a_35072_39918# a_35482_39996# 0.10373f
C3649 a_33914_44457# a_34357_44213# 0.02242f
C3650 a_29332_32456# a_30591_32215# 0.01529f
C3651 sar_ctrl_async_phys_0.hold_req sar_ctrl_async_phys_0.dac_code[5] 0.11185f
C3652 sar_ctrl_async_phys_0.sg13g2_nor2_1_4.Y sar_ctrl_async_phys_0.sg13g2_buf_1_13.X 0.44478f
C3653 sar_ctrl_async_phys_0.dac_code_n[0] sar_ctrl_async_phys_0.dac_code_n[3] 0.15355f
C3654 sar_ctrl_async_phys_0.sg13g2_nor2_1_4.Y a_26566_39766# 0.05084f
C3655 oa_sar8_acore18_opt_0.sw_tg_opt_0.bot VDD 0.75123f
C3656 sar_ctrl_async_phys_0.dac_code_n[5] oa_sar8_acore18_opt_0.sw_bitcell_opt_b1_1.bot 0.06598f
C3657 sar_ctrl_async_phys_0.sg13g2_a21oi_1_2.B1 a_29238_40898# 0.05374f
C3658 a_29306_32361# VDD 0.09447f
C3659 sar_ctrl_async_phys_0.sg13g2_a22oi_1_1.A2 a_31706_44964# 0.01521f
C3660 sar_ctrl_async_phys_0.sg13g2_and2_1_5.X a_31947_41508# 0.08711f
C3661 sar_ctrl_async_phys_0.sg13g2_nor2_1_4.Y sar_ctrl_async_phys_0.sg13g2_and2_1_2.X 1.16614f
C3662 sar_ctrl_async_phys_0.sg13g2_a21oi_1_0.A1 a_34833_37784# 0.01006f
C3663 sar_ctrl_async_phys_0.sg13g2_buf_1_2.X sar_ctrl_async_phys_0.sg13g2_buf_1_5.A 0.35614f
C3664 sar_ctrl_async_phys_0.sg13g2_dfrbpq_1_9.RESET_B a_32149_45007# 0.03507f
C3665 a_28968_42013# a_29238_41972# 0.26306f
C3666 sar_ctrl_async_phys_0.sg13g2_buf_1_13.X a_28950_39386# 0.03268f
C3667 sar_ctrl_async_phys_0.dac_code_n[0] oa_sar8_acore18_opt_0.sw_bitcell_opt_term_0.trkb 2.06857f
C3668 sar_ctrl_async_phys_0.sg13g2_nor2b_1_4.Y a_30872_45082# 0.03647f
C3669 sar_ctrl_async_phys_0.sg13g2_o21ai_1_1.B1 a_32533_40471# 0.05086f
C3670 sar_ctrl_async_phys_0.dac_code_n[1] sar_ctrl_async_phys_0.sg13g2_nand2b_1_1.Y 0.01561f
C3671 a_33944_47390# VDD 0.13931f
C3672 sar_ctrl_async_phys_0.sg13g2_nor2_1_4.Y track 0.09427f
C3673 sar_ctrl_async_phys_0.hold_req sar_ctrl_async_phys_0.cmp_fire 0.06648f
C3674 sar_ctrl_async_phys_0.dac_code_n[1] oa_sar8_acore18_opt_0.sw_bitcell_opt_term_0.vin 0.17064f
C3675 a_35288_47296# VDD 0.21882f
C3676 a_29594_43452# a_30037_43495# 0.02242f
C3677 sar_ctrl_async_phys_0.sg13g2_dfrbpq_1_2.Q sar_ctrl_async_phys_0.sg13g2_a21oi_1_2.B1 0.0119f
C3678 sar_ctrl_async_phys_0.sg13g2_a21oi_1_7.Y a_32116_40464# 0.0501f
C3679 sar_ctrl_async_phys_0.dac_code[4] oa_sar8_acore18_opt_0.sw_bitcell_opt_b1_0.bot 0.1489f
C3680 sar_ctrl_async_phys_0.dac_code_n[1] sar_ctrl_async_phys_0.sg13g2_nand2b_1_2.Y 0.24334f
C3681 sar_ctrl_async_phys_0.sg13g2_a21oi_1_0.B1 sar_ctrl_async_phys_0.dac_code_n[3] 0.03319f
C3682 sar_ctrl_async_phys_0.sg13g2_inv_1_2.Y result[4] 0.40425f
C3683 sar_ctrl_async_phys_0.sg13g2_dfrbpq_1_9.Q a_34040_45082# 0.02787f
C3684 sar_ctrl_async_phys_0.sg13g2_a22oi_1_2.A2 sar_ctrl_async_phys_0.sg13g2_buf_1_2.A 0.05284f
C3685 a_25990_40484# sar_ctrl_async_phys_0.sg13g2_dlygate4sd3_1_4.A 0.15773f
C3686 sar_ctrl_async_phys_0.sg13g2_buf_1_21.A sar_ctrl_async_phys_0.bit_active[7] 0.32412f
C3687 a_35418_31668# a_35463_31435# 0.31978f
C3688 sar_ctrl_async_phys_0.sg13g2_nor2_1_3.B a_27206_39326# 0.07484f
C3689 oa_sar8_acore18_opt_0.sw_bitcell_opt_term_0.gb a_35028_n9612# 0.84767f
C3690 a_31924_32456# a_32212_32151# 0.43707f
C3691 oa_sar8_acore18_opt_0.sw_tg_opt_0.bot oa_sar8_acore18_opt_0.sw_bitcell_opt_b6_0.bot 29.8992f
C3692 sar_ctrl_async_phys_0.sg13g2_a22oi_1_0.A2 sar_ctrl_async_phys_0.sg13g2_buf_1_2.X 0.0166f
C3693 sar_ctrl_async_phys_0.sg13g2_nor2b_1_3.Y a_33270_39698# 0.27448f
C3694 sar_ctrl_async_phys_0.sg13g2_buf_1_2.X a_34132_32904# 0.38019f
C3695 a_30584_44366# VDD 0.16507f
C3696 sar_ctrl_async_phys_0.sg13g2_dfrbpq_1_0.CLK sar_ctrl_async_phys_0.sg13g2_nor2b_1_3.Y 0.55115f
C3697 a_34453_35935# VDD 0.24403f
C3698 sar_ctrl_async_phys_0.dac_code_n[4] oa_sar8_acore18_opt_0.sw_bitcell_opt_b7_1.VSS 1.21041f
C3699 sar_ctrl_async_phys_0.dac_code_n[2] oa_sar8_acore18_opt_0.sw_bitcell_opt_b1_0.bot 0.08325f
C3700 sar_ctrl_async_phys_0.sg13g2_buf_1_34.A sar_ctrl_async_phys_0.dac_code[2] 0.30119f
C3701 sar_ctrl_async_phys_0.sg13g2_and2_1_0.B a_35280_35365# 0.27844f
C3702 a_33276_42686# a_33072_42854# 0.01048f
C3703 a_34069_41189# a_33940_41223# 0.01562f
C3704 sar_ctrl_async_phys_0.dac_code_n[0] oa_sar8_acore18_opt_0.sw_bitcell_opt_b4_0.bot 0.0869f
C3705 sar_ctrl_async_phys_0.dac_code[2] oa_sar8_acore18_opt_0.sw_bitcell_opt_b7_0.bot 2.35818f
C3706 sar_ctrl_async_phys_0.sg13g2_buf_1_13.X sar_ctrl_async_phys_0.sg13g2_dfrbpq_1_1.D 0.08735f
C3707 sar_ctrl_async_phys_0.sg13g2_buf_1_0.A a_31706_35385# 0.01253f
C3708 a_34106_34380# VDD 0.09601f
C3709 a_33270_39698# VDD 0.77756f
C3710 sar_ctrl_async_phys_0.sg13g2_inv_1_6.Y a_29332_32456# 0.01363f
C3711 sar_ctrl_async_phys_0.sg13g2_dfrbpq_1_0.CLK VDD 6.0354f
C3712 sar_ctrl_async_phys_0.sg13g2_a22oi_1_3.A2 a_33632_40702# 0.01271f
C3713 sar_ctrl_async_phys_0.sg13g2_buf_1_6.A sar_ctrl_async_phys_0.bit_active[6] 0.08377f
C3714 a_25878_40460# VDD 0.23028f
C3715 sar_ctrl_async_phys_0.sg13g2_buf_1_13.X a_31195_35935# 0.0401f
C3716 sar_ctrl_async_phys_0.sg13g2_nor2b_1_4.Y a_30879_43845# 0.05144f
C3717 sar_ctrl_async_phys_0.sg13g2_nor2_1_2.Y a_33818_43452# 0.02129f
C3718 sar_ctrl_async_phys_0.sg13g2_a22oi_1_1.A2 a_32580_36642# 0.05057f
C3719 a_34136_33688# result[4] 0.0888f
C3720 sar_ctrl_async_phys_0.sg13g2_buf_1_5.A sar_ctrl_async_phys_0.sg13g2_inv_1_2.A 0.01121f
C3721 sar_ctrl_async_phys_0.sg13g2_nor4_1_0.C sar_ctrl_async_phys_0.dac_code_n[7] 0.01826f
C3722 a_31640_41342# VDD 0.16037f
C3723 sar_ctrl_async_phys_0.sg13g2_dfrbpq_1_2.Q a_34520_38224# 0.28945f
C3724 sar_ctrl_async_phys_0.sg13g2_buf_1_13.X a_31935_39775# 0.01965f
C3725 a_33844_43488# a_35103_43845# 0.01529f
C3726 sar_ctrl_async_phys_0.sg13g2_a21oi_1_4.B1 sar_ctrl_async_phys_0.cmp_valid 0.0648f
C3727 sar_ctrl_async_phys_0.sg13g2_buf_1_3.A sar_ctrl_async_phys_0.sg13g2_a22oi_1_0.B1 0.38026f
C3728 a_29236_38952# VDD 0.07293f
C3729 sar_ctrl_async_phys_0.sg13g2_a22oi_1_1.A2 sar_ctrl_async_phys_0.sg13g2_a22oi_1_1.B2 0.15773f
C3730 a_34895_32460# VDD 0.30319f
C3731 a_34904_47296# sar_ctrl_async_phys_0.cmp_valid 0.10663f
C3732 sar_ctrl_async_phys_0.sg13g2_inv_1_10.Y VDD 0.38386f
C3733 sar_ctrl_async_phys_0.sg13g2_a21oi_1_0.B1 a_34075_39820# 0.02878f
C3734 sar_ctrl_async_phys_0.sg13g2_buf_1_13.X a_25596_43448# 0.01177f
C3735 a_35725_45266# VDD 0.24701f
C3736 sar_ctrl_async_phys_0.sg13g2_buf_1_3.A sar_ctrl_async_phys_0.sg13g2_nand2b_1_3.Y 0.03067f
C3737 sar_ctrl_async_phys_0.sg13g2_buf_1_2.A a_34549_34423# 0.03823f
C3738 sar_ctrl_async_phys_0.dac_code[4] sar_ctrl_async_phys_0.dac_code[7] 0.07521f
C3739 sar_ctrl_async_phys_0.sg13g2_dfrbpq_1_0.CLK a_31830_40898# 0.01328f
C3740 sar_ctrl_async_phys_0.sg13g2_inv_1_2.A a_34132_32904# 0.0251f
C3741 sar_ctrl_async_phys_0.dac_code_n[5] oa_sar8_acore18_opt_0.sw_bitcell_opt_b5_1.bot 1.32572f
C3742 sar_ctrl_async_phys_0.sg13g2_nor4_1_0.C sar_ctrl_async_phys_0.sg13g2_nor2_1_2.Y 0.01786f
C3743 a_34549_34423# a_34651_34423# 0.47795f
C3744 sar_ctrl_async_phys_0.sg13g2_buf_1_2.A a_35360_36894# 0.10172f
C3745 sar_ctrl_async_phys_0.dac_code_n[4] oa_sar8_acore18_opt_0.sw_bitcell_opt_b2_1.bot 0.06598f
C3746 a_33556_40016# a_34815_39775# 0.01529f
C3747 sar_ctrl_async_phys_0.sg13g2_dfrbpq_1_0.CLK a_29851_32260# 0.02013f
C3748 sar_ctrl_async_phys_0.sg13g2_buf_1_0.A a_30507_35204# 0.01927f
C3749 oa_sar8_acore18_opt_0.sw_bitcell_opt_term_0.trkb m3_60844_n2380# 0.03859f
C3750 sar_ctrl_async_phys_0.sg13g2_buf_1_23.A sar_ctrl_async_phys_0.sg13g2_nor2b_1_1.B_N 0.8714f
C3751 m3_48572_n2380# VDD 0.02229f
C3752 sar_ctrl_async_phys_0.sg13g2_a21oi_1_5.B1 sar_ctrl_async_phys_0.sg13g2_buf_1_32.A 0.01695f
C3753 sar_ctrl_async_phys_0.dac_code_n[2] sar_ctrl_async_phys_0.dac_code[7] 0.13169f
C3754 sar_ctrl_async_phys_0.dac_code[1] sar_ctrl_async_phys_0.sg13g2_nand2b_1_3.Y 0.03366f
C3755 sar_ctrl_async_phys_0.dac_code_n[4] sar_ctrl_async_phys_0.cmp_n 0.0682f
C3756 sar_ctrl_async_phys_0.sg13g2_buf_1_3.A sar_ctrl_async_phys_0.sg13g2_a21oi_1_0.A1 0.01755f
C3757 sar_ctrl_async_phys_0.sg13g2_o21ai_1_1.A2 sar_ctrl_async_phys_0.sg13g2_dlygate4sd3_1_4.A 0.25757f
C3758 sar_ctrl_async_phys_0.sg13g2_o21ai_1_1.B1 a_34075_39820# 0.42048f
C3759 sar_ctrl_async_phys_0.sg13g2_inv_1_3.Y a_32443_32260# 0.02636f
C3760 oa_sar8_acore18_opt_0.sw_tg_opt_0.bot oa_sar8_acore18_opt_0.sw_bitcell_opt_b2_0.bot 1.82922f
C3761 sar_ctrl_async_phys_0.sg13g2_nor2b_1_0.A a_30830_35166# 0.0301f
C3762 a_29701_36874# a_29862_36682# 0.01251f
C3763 a_31732_35480# a_32897_35239# 0.43239f
C3764 a_32251_35284# a_32020_35175# 0.12701f
C3765 sar_ctrl_async_phys_0.sg13g2_buf_1_13.A a_35288_38224# 0.26462f
C3766 sar_ctrl_async_phys_0.sg13g2_a21oi_1_0.B1 sar_ctrl_async_phys_0.sg13g2_nand2b_1_7.A_N 0.02963f
C3767 a_34526_31826# a_34767_31359# 0.01058f
C3768 sar_ctrl_async_phys_0.sg13g2_a22oi_1_0.A1 sar_ctrl_async_phys_0.sg13g2_buf_1_25.A 0.14574f
C3769 sar_ctrl_async_phys_0.sg13g2_buf_1_13.X a_31064_38318# 0.01922f
C3770 a_32602_35924# VDD 0.38316f
C3771 sar_ctrl_async_phys_0.dac_code_n[0] oa_sar8_acore18_opt_0.sw_bitcell_opt_b0_0.bot 0.40215f
C3772 w_16692_n9960# sar_ctrl_async_phys_0.dac_code_n[4] 0.02244f
C3773 a_32666_45969# sar_ctrl_async_phys_0.sg13g2_o21ai_1_1.B1 0.23764f
C3774 a_20412_n9612# vinp 0.98838f
C3775 sar_ctrl_async_phys_0.sg13g2_inv_1_5.A a_30480_32986# 0.01975f
C3776 sar_ctrl_async_phys_0.sg13g2_a22oi_1_0.A1 a_30331_33772# 0.01206f
C3777 sar_ctrl_async_phys_0.sg13g2_nor2_1_10.B a_30507_35204# 0.13115f
C3778 sar_ctrl_async_phys_0.dac_code[0] sar_ctrl_async_phys_0.sg13g2_buf_1_33.A 0.03624f
C3779 a_33652_41528# a_34171_41332# 0.34114f
C3780 sar_ctrl_async_phys_0.sg13g2_nor2b_1_0.A a_30650_35892# 0.01389f
C3781 a_35391_33261# result[5] 0.0125f
C3782 sar_ctrl_async_phys_0.sg13g2_dlygate4sd3_1_9.X sar_ctrl_async_phys_0.sg13g2_dlygate4sd3_1_4.X 0.3148f
C3783 sar_ctrl_async_phys_0.dac_code[0] sar_ctrl_async_phys_0.dac_code[5] 0.97853f
C3784 sar_ctrl_async_phys_0.dac_code_n[1] sar_ctrl_async_phys_0.dac_code[2] 0.05494f
C3785 sar_ctrl_async_phys_0.sg13g2_a22oi_1_1.Y a_30746_31356# 0.03786f
C3786 sar_ctrl_async_phys_0.bit_active[6] sar_ctrl_async_phys_0.sg13g2_buf_1_21.A 0.05862f
C3787 sar_ctrl_async_phys_0.sg13g2_dlygate4sd3_1_7.X sar_ctrl_async_phys_0.sg13g2_nor4_1_0.Y 0.69656f
C3788 sar_ctrl_async_phys_0.sg13g2_a22oi_1_1.B2 sar_ctrl_async_phys_0.sg13g2_a22oi_1_1.Y 0.19697f
C3789 a_30678_46946# VDD 0.78444f
C3790 a_33818_36897# VDD 0.09553f
C3791 a_33087_37797# a_32993_37797# 0.28931f
C3792 sar_ctrl_async_phys_0.sg13g2_inv_1_1.Y a_31638_32138# 0.3239f
C3793 sar_ctrl_async_phys_0.sg13g2_buf_1_3.A sar_ctrl_async_phys_0.sg13g2_buf_1_4.A 0.02667f
C3794 sar_ctrl_async_phys_0.sg13g2_nor2b_1_0.A a_31093_39677# 0.04531f
C3795 sar_ctrl_async_phys_0.sg13g2_a21oi_1_1.Y a_34520_38224# 0.0164f
C3796 sar_ctrl_async_phys_0.sg13g2_buf_1_2.X a_29786_33873# 0.23922f
C3797 a_29524_39373# a_29755_38959# 0.12701f
C3798 a_35245_45936# a_35000_45878# 0.01096f
C3799 sar_ctrl_async_phys_0.sg13g2_buf_1_33.A VDD 0.55104f
C3800 a_34036_35928# a_34453_35935# 0.37583f
C3801 sar_ctrl_async_phys_0.sg13g2_nor2_1_2.Y a_33558_43922# 0.05013f
C3802 sar_ctrl_async_phys_0.dac_code[5] VDD 5.3347f
C3803 sar_ctrl_async_phys_0.sg13g2_buf_1_2.X VDD 10.3937f
C3804 a_33080_31388# VDD 0.21876f
C3805 sar_ctrl_async_phys_0.dac_code[1] sar_ctrl_async_phys_0.dac_code[3] 0.21859f
C3806 a_34520_46508# sar_ctrl_async_phys_0.sg13g2_nand2b_1_2.Y 0.04338f
C3807 sar_ctrl_async_phys_0.sg13g2_buf_1_35.A sar_ctrl_async_phys_0.sg13g2_buf_1_33.A 0.15352f
C3808 sar_ctrl_async_phys_0.sg13g2_buf_1_13.X sar_ctrl_async_phys_0.sg13g2_a21oi_1_4.A2 0.13679f
C3809 sar_ctrl_async_phys_0.sg13g2_buf_1_20.A sar_ctrl_async_phys_0.sg13g2_a21oi_1_0.A1 0.01278f
C3810 sar_ctrl_async_phys_0.sg13g2_dfrbpq_1_9.RESET_B a_34357_44213# 0.03476f
C3811 sar_ctrl_async_phys_0.bit_active[2] sar_ctrl_async_phys_0.bit_active[1] 0.08584f
C3812 sar_ctrl_async_phys_0.sg13g2_dfrbpq_1_0.CLK a_31034_44457# 0.01398f
C3813 sar_ctrl_async_phys_0.sg13g2_buf_1_13.X a_31644_36638# 0.24739f
C3814 sar_ctrl_async_phys_0.sg13g2_dfrbpq_1_0.CLK a_34036_35928# 0.07739f
C3815 sar_ctrl_async_phys_0.sg13g2_buf_1_13.A a_31644_36638# 0.25754f
C3816 a_26544_38389# sar_ctrl_async_phys_0.sg13g2_nor2_1_3.A 0.10846f
C3817 oa_sar8_acore18_opt_0.sw_bitcell_opt_b5_0.bot m3_41836_n2380# 1.76659f
C3818 sar_ctrl_async_phys_0.cmp_fire VDD 8.48843f
C3819 sar_ctrl_async_phys_0.sg13g2_buf_1_3.A sar_ctrl_async_phys_0.sg13g2_buf_1_8.A 0.04948f
C3820 a_36056_41972# sar_ctrl_async_phys_0.dac_code[4] 0.24512f
C3821 sar_ctrl_async_phys_0.dac_code_n[5] oa_sar8_acore18_opt_0.sw_bitcell_opt_term_0.vin 0.11076f
C3822 sar_ctrl_async_phys_0.sg13g2_buf_1_25.A sar_ctrl_async_phys_0.sg13g2_buf_1_7.A 0.01405f
C3823 sar_ctrl_async_phys_0.sg13g2_a22oi_1_1.B2 sar_ctrl_async_phys_0.sg13g2_inv_1_0.A 0.01385f
C3824 a_32149_45007# VDD 0.25488f
C3825 sar_ctrl_async_phys_0.dac_code[5] oa_sar8_acore18_opt_0.sw_bitcell_opt_b6_0.bot 1.19314f
C3826 a_33846_34850# a_34132_34416# 0.41329f
C3827 sar_ctrl_async_phys_0.sg13g2_a22oi_1_5.Y a_30486_31826# 0.02702f
C3828 w_39600_n9960# sar_ctrl_async_phys_0.dac_code[0] 0.10836f
C3829 sar_ctrl_async_phys_0.dac_code_n[0] oa_sar8_acore18_opt_0.sw_bitcell_opt_b0_1.bot 1.30615f
C3830 sar_ctrl_async_phys_0.sg13g2_buf_1_13.X sar_ctrl_async_phys_0.sg13g2_a22oi_1_5.A2 0.51622f
C3831 sar_ctrl_async_phys_0.sg13g2_nor2_1_10.B sar_ctrl_async_phys_0.sg13g2_nor2_1_5.B 0.42814f
C3832 sar_ctrl_async_phys_0.sg13g2_a21oi_1_4.B1 sar_ctrl_async_phys_0.sg13g2_buf_1_3.A 0.04026f
C3833 sar_ctrl_async_phys_0.sg13g2_nand3b_1_0.Y a_29701_36874# 0.20328f
C3834 sar_ctrl_async_phys_0.sg13g2_o21ai_1_1.B1 sar_ctrl_async_phys_0.sg13g2_nand2b_1_0.A_N 0.09989f
C3835 oa_sar8_acore18_opt_0.sw_bitcell_opt_term_0.trkb m3_34580_n2380# 0.03859f
C3836 sar_ctrl_async_phys_0.sg13g2_buf_1_20.A sar_ctrl_async_phys_0.dac_code[3] 1.11567f
C3837 sar_ctrl_async_phys_0.sg13g2_a22oi_1_0.B1 a_34106_32868# 0.01881f
C3838 a_34363_36796# a_35103_36751# 0.26905f
C3839 sar_ctrl_async_phys_0.sg13g2_a21oi_1_6.B1 a_34765_45266# 0.3259f
C3840 a_35391_33261# a_35297_33261# 0.28931f
C3841 a_20412_n9612# VDD 1.41542f
C3842 sar_ctrl_async_phys_0.sg13g2_inv_1_3.Y sar_ctrl_async_phys_0.sg13g2_buf_1_25.A 0.01181f
C3843 sar_ctrl_async_phys_0.sg13g2_a22oi_1_0.B1 sar_ctrl_async_phys_0.sg13g2_buf_1_9.A 0.13792f
C3844 sar_ctrl_async_phys_0.sg13g2_a21oi_1_0.A1 sar_ctrl_async_phys_0.sg13g2_nand2_1_1.B 0.03947f
C3845 m3_57896_n2380# m3_60844_n2380# 0.0157f
C3846 sar_ctrl_async_phys_0.sg13g2_buf_1_26.X a_26630_37814# 0.10818f
C3847 sar_ctrl_async_phys_0.sg13g2_inv_1_9.Y sar_ctrl_async_phys_0.sg13g2_dlygate4sd3_1_6.X 0.01743f
C3848 sar_ctrl_async_phys_0.sg13g2_nor2_1_0.Y sar_ctrl_async_phys_0.sg13g2_a22oi_1_1.A2 2.61089f
C3849 sar_ctrl_async_phys_0.sg13g2_buf_1_1.A sar_ctrl_async_phys_0.bit_active[1] 0.55191f
C3850 sar_ctrl_async_phys_0.sg13g2_buf_1_2.X a_29851_32260# 0.48039f
C3851 a_30830_35166# VDD 0.1059f
C3852 sar_ctrl_async_phys_0.dac_code_n[0] a_35948_n9612# 0.0551f
C3853 w_39600_n9960# VDD 1.20689f
C3854 a_35245_45266# a_35327_45366# 0.01117f
C3855 a_32251_35284# a_33248_35382# 0.02979f
C3856 sar_ctrl_async_phys_0.sg13g2_a22oi_1_1.A2 a_32319_44311# 0.01849f
C3857 sar_ctrl_async_phys_0.sg13g2_inv_1_2.A VDD 0.21182f
C3858 a_36058_34412# done 0.01216f
C3859 sar_ctrl_async_phys_0.sg13g2_dfrbpq_1_9.RESET_B a_33914_44457# 0.26698f
C3860 sar_ctrl_async_phys_0.sg13g2_nor2_1_4.Y sar_ctrl_async_phys_0.sg13g2_dlygate4sd3_1_4.A 0.0359f
C3861 a_34268_31826# a_34615_31475# 0.02979f
C3862 a_34636_31749# a_34526_31826# 0.43239f
C3863 sar_ctrl_async_phys_0.sg13g2_dfrbpq_1_9.RESET_B a_32986_44532# 0.01429f
C3864 sar_ctrl_async_phys_0.sg13g2_buf_1_20.A a_34363_43495# 0.01425f
C3865 oa_sar8_acore18_opt_0.sw_bitcell_opt_b4_0.bot m3_34580_n2380# 0.02484f
C3866 sar_ctrl_async_phys_0.sg13g2_dfrbpq_1_22.D sar_ctrl_async_phys_0.sg13g2_buf_1_22.A 0.05071f
C3867 sar_ctrl_async_phys_0.sg13g2_dlygate4sd3_1_6.X a_26184_42013# 0.4069f
C3868 sar_ctrl_async_phys_0.sg13g2_dfrbpq_1_0.CLK a_27984_41342# 0.01766f
C3869 a_30650_35892# VDD 0.09663f
C3870 sar_ctrl_async_phys_0.sg13g2_a22oi_1_0.A1 sar_ctrl_async_phys_0.sg13g2_buf_1_2.A 0.19247f
C3871 sar_ctrl_async_phys_0.sg13g2_dfrbpq_1_0.CLK a_33658_44996# 0.06947f
C3872 a_35772_41936# VDD 0.22089f
C3873 sar_ctrl_async_phys_0.sg13g2_o21ai_1_1.A2 a_27304_38928# 0.01075f
C3874 sar_ctrl_async_phys_0.sg13g2_nand2_1_3.B sar_ctrl_async_phys_0.sg13g2_buf_1_13.A 0.06284f
C3875 sar_ctrl_async_phys_0.sg13g2_nand2b_1_1.Y sar_ctrl_async_phys_0.sg13g2_buf_1_13.X 0.01911f
C3876 sar_ctrl_async_phys_0.sg13g2_nand2b_1_1.Y sar_ctrl_async_phys_0.sg13g2_buf_1_13.A 0.01741f
C3877 sar_ctrl_async_phys_0.sg13g2_nor2b_1_0.A a_34328_41972# 0.0242f
C3878 sar_ctrl_async_phys_0.sg13g2_buf_1_35.A a_35772_41936# 0.2616f
C3879 a_31093_39677# VDD 0.24806f
C3880 a_32400_41413# a_32792_41342# 0.01798f
C3881 sar_ctrl_async_phys_0.dac_code_n[4] oa_sar8_acore18_opt_0.sw_bitcell_opt_term_1.bot 0.06773f
C3882 sar_ctrl_async_phys_0.sg13g2_a21oi_1_6.A2 sar_ctrl_async_phys_0.sg13g2_o21ai_1_1.B1 1.00907f
C3883 sar_ctrl_async_phys_0.sg13g2_nand2b_1_1.Y a_35053_40730# 0.2845f
C3884 a_29808_39830# VDD 0.07536f
C3885 sar_ctrl_async_phys_0.sg13g2_a21oi_1_4.B1 sar_ctrl_async_phys_0.sg13g2_buf_1_20.A 0.04371f
C3886 sar_ctrl_async_phys_0.sg13g2_a22oi_1_3.A2 a_33270_39698# 0.01181f
C3887 sar_ctrl_async_phys_0.sg13g2_dfrbpq_1_0.CLK sar_ctrl_async_phys_0.sg13g2_a22oi_1_3.A2 0.20449f
C3888 sar_ctrl_async_phys_0.sg13g2_nand2b_1_2.Y a_35053_40730# 0.01879f
C3889 a_35952_39901# sar_ctrl_async_phys_0.dac_code[6] 0.03406f
C3890 a_29210_38916# a_29236_38952# 0.36952f
C3891 sar_ctrl_async_phys_0.sg13g2_nor2_1_1.Y a_33366_41210# 0.02692f
C3892 sar_ctrl_async_phys_0.sg13g2_a22oi_1_0.B1 sar_ctrl_async_phys_0.sg13g2_buf_1_16.A 1.08016f
C3893 a_31189_31399# VDD 0.24903f
C3894 a_35672_33688# VDD 0.21969f
C3895 sar_ctrl_async_phys_0.dac_code[1] sar_ctrl_async_phys_0.sg13g2_nand2_1_3.Y 0.03069f
C3896 sar_ctrl_async_phys_0.sg13g2_a21oi_1_7.Y sar_ctrl_async_phys_0.sg13g2_a22oi_1_0.A1 0.20935f
C3897 sar_ctrl_async_phys_0.sg13g2_buf_1_3.A sar_ctrl_async_phys_0.sg13g2_buf_1_14.A 0.06637f
C3898 sar_ctrl_async_phys_0.sg13g2_nor2b_1_0.A a_31140_42690# 0.06199f
C3899 sar_ctrl_async_phys_0.sg13g2_a21oi_1_0.B1 sar_ctrl_async_phys_0.sg13g2_a21oi_1_2.B1 0.20953f
C3900 sar_ctrl_async_phys_0.sg13g2_buf_1_2.A a_31093_35935# 0.03514f
C3901 sar_ctrl_async_phys_0.sg13g2_o21ai_1_1.A2 sar_ctrl_async_phys_0.sg13g2_nand3_1_0.Y 0.49191f
C3902 a_33558_43922# a_33818_43452# 0.75507f
C3903 sar_ctrl_async_phys_0.sg13g2_dfrbpq_1_17.D a_30872_30758# 0.02888f
C3904 sar_ctrl_async_phys_0.sg13g2_inv_1_9.Y sar_ctrl_async_phys_0.sg13g2_dlygate4sd3_1_3.A 0.01635f
C3905 sar_ctrl_async_phys_0.sg13g2_dfrbpq_1_0.CLK a_31935_36285# 0.03377f
C3906 sar_ctrl_async_phys_0.cmp_fire a_26184_21025# 0.84644f
C3907 sar_ctrl_async_phys_0.sg13g2_dfrbpq_1_9.Q sar_ctrl_async_phys_0.sg13g2_nand2_1_3.A 0.36584f
C3908 sar_ctrl_async_phys_0.sg13g2_nor2_1_4.Y a_26544_38389# 0.03772f
C3909 sar_ctrl_async_phys_0.sg13g2_nor2_1_13.Y a_25820_43020# 0.01369f
C3910 sar_ctrl_async_phys_0.dac_code[5] oa_sar8_acore18_opt_0.sw_bitcell_opt_b2_0.bot 0.16249f
C3911 sar_ctrl_async_phys_0.dac_code[6] oa_sar8_acore18_opt_0.sw_bitcell_opt_b5_0.bot 0.65555f
C3912 a_29498_40428# a_29941_40471# 0.02242f
C3913 sar_ctrl_async_phys_0.sg13g2_a21oi_1_0.A1 sar_ctrl_async_phys_0.sg13g2_and2_1_5.X 0.07025f
C3914 sar_ctrl_async_phys_0.cmp_n oa_sar8_acore18_opt_0.sw_tg_opt_0.bot 0.42046f
C3915 sar_ctrl_async_phys_0.sg13g2_a22oi_1_1.A2 sar_ctrl_async_phys_0.sg13g2_a22oi_1_2.B1 0.17301f
C3916 a_30678_46946# a_31252_46933# 0.31978f
C3917 a_30964_46512# a_31381_46519# 0.37583f
C3918 sar_ctrl_async_phys_0.sg13g2_buf_1_20.A sar_ctrl_async_phys_0.sg13g2_nand2_1_3.Y 1.42982f
C3919 a_33558_36674# a_33844_36992# 0.41329f
C3920 sar_ctrl_async_phys_0.sg13g2_o21ai_1_1.B1 sar_ctrl_async_phys_0.sg13g2_a21oi_1_2.B1 0.13144f
C3921 m3_45264_n2380# m3_48572_n2380# 0.0157f
C3922 sar_ctrl_async_phys_0.sg13g2_a21oi_1_7.Y a_31093_35935# 0.02494f
C3923 sar_ctrl_async_phys_0.sg13g2_a22oi_1_0.B2 result[3] 0.02894f
C3924 sar_ctrl_async_phys_0.sg13g2_dfrbpq_1_11.D a_32156_38948# 0.01398f
C3925 sar_ctrl_async_phys_0.dac_code_n[5] sar_ctrl_async_phys_0.dac_code[2] 0.06252f
C3926 sar_ctrl_async_phys_0.sg13g2_buf_1_9.A sar_ctrl_async_phys_0.sg13g2_buf_1_8.A 0.93833f
C3927 sar_ctrl_async_phys_0.sg13g2_a21oi_1_0.A1 sar_ctrl_async_phys_0.dac_code[4] 0.0173f
C3928 sar_ctrl_async_phys_0.sg13g2_a21oi_1_0.A1 sar_ctrl_async_phys_0.sg13g2_buf_1_23.A 0.02882f
C3929 sar_ctrl_async_phys_0.sg13g2_nor2_1_12.A sar_ctrl_async_phys_0.sg13g2_nor2_1_12.B 0.18581f
C3930 sar_ctrl_async_phys_0.dac_code_n[2] a_35245_45936# 0.01253f
C3931 sar_ctrl_async_phys_0.cmp_valid sar_ctrl_async_phys_0.dac_code_n[4] 0.01391f
C3932 a_33850_32436# result[4] 0.01873f
C3933 sar_ctrl_async_phys_0.sg13g2_o21ai_1_1.B1 sar_ctrl_async_phys_0.sg13g2_dfrbpq_1_22.D 0.16228f
C3934 a_31732_35480# a_32251_35284# 0.34114f
C3935 a_34055_31352# a_34268_31826# 0.34468f
C3936 sar_ctrl_async_phys_0.sg13g2_dfrbpq_1_9.RESET_B a_30774_44234# 0.12635f
C3937 sar_ctrl_async_phys_0.sg13g2_buf_1_20.A sar_ctrl_async_phys_0.sg13g2_buf_1_14.A 2.84511f
C3938 a_33085_43832# a_32888_43570# 0.01798f
C3939 a_28758_35924# VDD 0.22626f
C3940 sar_ctrl_async_phys_0.sg13g2_nand2_1_3.Y sar_ctrl_async_phys_0.sg13g2_nand2_1_1.B 0.04624f
C3941 sar_ctrl_async_phys_0.sg13g2_dfrbpq_1_0.CLK a_31732_45000# 0.10834f
C3942 a_34328_41972# VDD 0.22516f
C3943 sar_ctrl_async_phys_0.dac_code[3] sar_ctrl_async_phys_0.dac_code[4] 7.64228f
C3944 w_39600_n9960# oa_sar8_acore18_opt_0.sw_bitcell_opt_b2_0.bot 0.01162f
C3945 sar_ctrl_async_phys_0.sg13g2_a22oi_1_0.A1 a_34261_36653# 0.01111f
C3946 sar_ctrl_async_phys_0.sg13g2_nand2_1_0.B sar_ctrl_async_phys_0.sg13g2_nand2_1_0.Y 0.21911f
C3947 sar_ctrl_async_phys_0.dac_code_n[2] oa_sar8_acore18_opt_0.bstrap_opt_w2_c1200_1.out 1.7059f
C3948 a_34618_46044# VDD 0.37996f
C3949 sar_ctrl_async_phys_0.sg13g2_nor2_1_1.Y a_33675_43020# 0.0388f
C3950 a_29620_43488# a_30785_43845# 0.43239f
C3951 a_32400_41413# sar_ctrl_async_phys_0.sg13g2_buf_1_6.A 0.26712f
C3952 a_31828_37440# a_32116_37861# 0.43707f
C3953 sar_ctrl_async_phys_0.sg13g2_buf_1_23.A sar_ctrl_async_phys_0.sg13g2_buf_1_4.A 0.07676f
C3954 sar_ctrl_async_phys_0.sg13g2_nor2_1_2.Y a_33844_39711# 0.02141f
C3955 a_34357_44213# VDD 0.24559f
C3956 sar_ctrl_async_phys_0.sg13g2_buf_1_23.A sar_ctrl_async_phys_0.sg13g2_and2_1_0.B 0.07931f
C3957 sar_ctrl_async_phys_0.dac_code_n[2] sar_ctrl_async_phys_0.dac_code[3] 0.06321f
C3958 a_28376_39034# a_28560_39034# 0.0524f
C3959 sar_ctrl_async_phys_0.sg13g2_nor2b_1_0.A a_34069_41189# 0.03937f
C3960 a_31935_36285# a_32602_35924# 0.0894f
C3961 sar_ctrl_async_phys_0.dac_code_n[6] sar_ctrl_async_phys_0.dac_code_n[7] 25.2692f
C3962 a_35672_46508# VDD 0.26693f
C3963 a_31140_42690# VDD 0.19172f
C3964 a_34236_46472# a_33944_46594# 0.01f
C3965 sar_ctrl_async_phys_0.sg13g2_buf_1_14.A sar_ctrl_async_phys_0.sg13g2_nand2_1_1.B 1.65231f
C3966 sar_ctrl_async_phys_0.sg13g2_nor2_1_3.Y sar_ctrl_async_phys_0.sg13g2_nor2_1_5.B 0.11327f
C3967 sar_ctrl_async_phys_0.sg13g2_buf_1_2.A sar_ctrl_async_phys_0.sg13g2_nand3b_1_0.Y 0.06932f
C3968 sar_ctrl_async_phys_0.dac_code_n[3] sar_ctrl_async_phys_0.dac_code_n[7] 0.1317f
C3969 sar_ctrl_async_phys_0.sg13g2_dfrbpq_1_11.D a_32090_40428# 0.0278f
C3970 sar_ctrl_async_phys_0.sg13g2_a22oi_1_3.A2 sar_ctrl_async_phys_0.sg13g2_buf_1_2.X 0.0197f
C3971 sar_ctrl_async_phys_0.sg13g2_a21oi_1_6.A2 a_32251_45007# 0.02355f
C3972 a_31732_45000# a_32897_45357# 0.43239f
C3973 a_32020_45421# a_32251_45007# 0.12701f
C3974 sar_ctrl_async_phys_0.sg13g2_a21oi_1_4.B1 sar_ctrl_async_phys_0.sg13g2_and2_1_5.X 0.0749f
C3975 sar_ctrl_async_phys_0.sg13g2_a22oi_1_0.B2 a_36058_30924# 0.12508f
C3976 sar_ctrl_async_phys_0.sg13g2_nor2_1_0.A a_32347_37447# 0.02367f
C3977 sar_ctrl_async_phys_0.sg13g2_nand2_1_2.A a_34208_45966# 0.01298f
C3978 sar_ctrl_async_phys_0.dac_code_n[7] oa_sar8_acore18_opt_0.sw_bitcell_opt_term_0.trkb 2.23075f
C3979 sar_ctrl_async_phys_0.sg13g2_buf_1_20.A a_33085_43832# 0.01967f
C3980 sar_ctrl_async_phys_0.dac_code_n[0] oa_sar8_acore18_opt_0.sw_bitcell_opt_b7_0.bot 1.14414f
C3981 sar_ctrl_async_phys_0.dac_code[6] oa_sar8_acore18_opt_0.sw_bitcell_opt_b1_0.bot 0.17902f
C3982 sar_ctrl_async_phys_0.sg13g2_nor2_1_4.Y sar_ctrl_async_phys_0.sg13g2_nand3_1_0.Y 0.02126f
C3983 sar_ctrl_async_phys_0.sg13g2_buf_1_29.A sar_ctrl_async_phys_0.sg13g2_nor2_1_4.Y 0.2508f
C3984 sar_ctrl_async_phys_0.sg13g2_a21oi_1_1.B1 sar_ctrl_async_phys_0.sg13g2_dfrbpq_1_9.Q 0.26702f
C3985 sar_ctrl_async_phys_0.sg13g2_nand2_1_2.A a_33940_44552# 0.04401f
C3986 sar_ctrl_async_phys_0.sg13g2_nand2_1_2.B a_35866_44532# 0.12712f
C3987 sar_ctrl_async_phys_0.sg13g2_nand2b_1_1.Y sar_ctrl_async_phys_0.sg13g2_a22oi_1_2.A2 0.02277f
C3988 a_35391_30703# a_35297_30703# 0.28931f
C3989 sar_ctrl_async_phys_0.sg13g2_dlygate4sd3_1_3.A a_28968_42013# 0.41585f
C3990 a_35672_35200# VDD 0.2631f
C3991 sar_ctrl_async_phys_0.sg13g2_dfrbpq_1_0.CLK a_30676_40016# 0.07965f
C3992 sar_ctrl_async_phys_0.sg13g2_nand2b_1_2.Y sar_ctrl_async_phys_0.sg13g2_a22oi_1_2.A2 0.19323f
C3993 sar_ctrl_async_phys_0.sg13g2_buf_1_3.A sar_ctrl_async_phys_0.sg13g2_buf_1_0.A 0.08587f
C3994 sar_ctrl_async_phys_0.sg13g2_a22oi_1_2.B1 sar_ctrl_async_phys_0.sg13g2_inv_1_0.A 0.11457f
C3995 a_34132_32904# a_34420_33325# 0.43707f
C3996 sar_ctrl_async_phys_0.sg13g2_inv_1_2.A a_34319_32460# 0.16822f
C3997 a_33914_44457# VDD 0.09659f
C3998 sar_ctrl_async_phys_0.sg13g2_dlygate4sd3_1_5.A a_25488_40546# 0.02661f
C3999 a_34308_37400# VDD 0.18681f
C4000 sar_ctrl_async_phys_0.sg13g2_o21ai_1_1.A2 a_28176_39830# 0.01714f
C4001 a_32986_44532# VDD 0.37991f
C4002 sar_ctrl_async_phys_0.sg13g2_dfrbpq_1_0.CLK a_30772_31392# 0.08754f
C4003 sar_ctrl_async_phys_0.dac_code_n[7] oa_sar8_acore18_opt_0.sw_bitcell_opt_b4_0.bot 0.15199f
C4004 sar_ctrl_async_phys_0.sg13g2_a21oi_1_2.B1 sar_ctrl_async_phys_0.sg13g2_buf_1_6.A 0.41168f
C4005 sar_ctrl_async_phys_0.sg13g2_a21oi_1_4.B1 sar_ctrl_async_phys_0.dac_code_n[2] 0.02464f
C4006 sar_ctrl_async_phys_0.sg13g2_nor2b_1_4.Y sar_ctrl_async_phys_0.sg13g2_buf_1_13.X 0.04344f
C4007 a_35672_42760# sar_ctrl_async_phys_0.sg13g2_buf_1_33.A 0.01063f
C4008 a_34093_42912# a_34520_42760# 0.08015f
C4009 a_31706_35385# sar_ctrl_async_phys_0.sg13g2_buf_1_2.X 0.25335f
C4010 sar_ctrl_async_phys_0.sg13g2_nor2_1_7.Y VDD 0.28706f
C4011 sar_ctrl_async_phys_0.hold_req oa_sar8_acore18_opt_0.sw_bitcell_opt_term_0.VSS 1.93568f
C4012 sar_ctrl_async_phys_0.sg13g2_a21oi_1_5.B1 sar_ctrl_async_phys_0.sg13g2_nand2_1_3.B 0.24396f
C4013 sar_ctrl_async_phys_0.sg13g2_nor4_1_0.Y sar_ctrl_async_phys_0.sg13g2_nand2b_1_0.Y 0.37672f
C4014 a_30964_46512# a_31483_46519# 0.34102f
C4015 sar_ctrl_async_phys_0.sg13g2_dlygate4sd3_1_8.A a_26954_40424# 0.41941f
C4016 sar_ctrl_async_phys_0.sg13g2_buf_1_13.X a_31256_37522# 0.02757f
C4017 sar_ctrl_async_phys_0.sg13g2_a21oi_1_5.B1 sar_ctrl_async_phys_0.sg13g2_nand2b_1_2.Y 0.24126f
C4018 sar_ctrl_async_phys_0.sg13g2_buf_1_13.X sar_ctrl_async_phys_0.sg13g2_a21oi_1_7.A2 0.20672f
C4019 sar_ctrl_async_phys_0.sg13g2_nand2_1_3.Y sar_ctrl_async_phys_0.dac_code[4] 0.38588f
C4020 sar_ctrl_async_phys_0.sg13g2_and2_1_0.B a_35552_36166# 0.01328f
C4021 sar_ctrl_async_phys_0.sg13g2_nor2_1_0.Y a_32090_40428# 0.02453f
C4022 sar_ctrl_async_phys_0.sg13g2_a21oi_1_0.A1 a_30495_39309# 0.01676f
C4023 a_32406_45746# VDD 0.78437f
C4024 a_35672_47296# VDD 0.21798f
C4025 sar_ctrl_async_phys_0.sg13g2_buf_1_14.A sar_ctrl_async_phys_0.sg13g2_and2_1_5.X 0.03769f
C4026 a_31802_37404# a_32245_37447# 0.02242f
C4027 sar_ctrl_async_phys_0.sg13g2_nor2_1_1.A a_32888_36806# 0.01028f
C4028 a_34069_41189# VDD 0.24698f
C4029 sar_ctrl_async_phys_0.sg13g2_buf_1_4.A a_35648_34654# 0.01485f
C4030 sar_ctrl_async_phys_0.dac_code[6] sar_ctrl_async_phys_0.dac_code[7] 4.1527f
C4031 sar_ctrl_async_phys_0.sg13g2_nor2_1_2.Y a_34075_39820# 0.03096f
C4032 sar_ctrl_async_phys_0.dac_code[5] sar_ctrl_async_phys_0.cmp_n 0.07134f
C4033 sar_ctrl_async_phys_0.sg13g2_a21oi_1_0.B1 a_35103_43845# 0.01635f
C4034 sar_ctrl_async_phys_0.dac_code_n[4] sar_ctrl_async_phys_0.dac_code[1] 0.06321f
C4035 a_31093_35935# a_31195_35935# 0.47795f
C4036 a_32443_32260# a_33183_32215# 0.26905f
C4037 a_34651_30748# result[1] 0.02546f
C4038 sar_ctrl_async_phys_0.sg13g2_dlygate4sd3_1_8.A VDD 0.34947f
C4039 sar_ctrl_async_phys_0.sg13g2_buf_1_14.A sar_ctrl_async_phys_0.dac_code[4] 0.065f
C4040 sar_ctrl_async_phys_0.sg13g2_a21oi_1_6.B1 a_33654_44234# 0.04763f
C4041 sar_ctrl_async_phys_0.sg13g2_nor2_1_11.Y sar_ctrl_async_phys_0.sg13g2_nor2_1_11.A 0.20922f
C4042 sar_ctrl_async_phys_0.sg13g2_a22oi_1_0.A2 sar_ctrl_async_phys_0.sg13g2_buf_1_5.A 0.01876f
C4043 sar_ctrl_async_phys_0.sg13g2_buf_1_13.A sar_ctrl_async_phys_0.sg13g2_dfrbpq_1_2.Q 0.03521f
C4044 sar_ctrl_async_phys_0.cmp_fire sar_ctrl_async_phys_0.cmp_n 1.23f
C4045 a_31732_45000# a_32149_45007# 0.37583f
C4046 a_31446_45434# a_32020_45421# 0.31978f
C4047 sar_ctrl_async_phys_0.sg13g2_a22oi_1_0.B2 a_33846_30626# 0.02435f
C4048 sar_ctrl_async_phys_0.sg13g2_nor2_1_0.A a_32245_37447# 0.0133f
C4049 sar_ctrl_async_phys_0.sg13g2_dfrbpq_1_0.CLK a_27504_36010# 0.02762f
C4050 sar_ctrl_async_phys_0.dac_code_n[0] sar_ctrl_async_phys_0.dac_code_n[1] 29.4348f
C4051 oa_sar8_acore18_opt_0.sw_bitcell_opt_b2_1.bot a_20412_n9612# 0.04144f
C4052 sar_ctrl_async_phys_0.sample oa_sar8_acore18_opt_0.sw_bitcell_opt_b3_1.bot 1.70439f
C4053 sar_ctrl_async_phys_0.sg13g2_buf_1_20.A sar_ctrl_async_phys_0.bit_active[4] 0.02708f
C4054 sar_ctrl_async_phys_0.sg13g2_a22oi_1_2.A2 a_32993_37797# 0.01641f
C4055 a_35288_38224# sar_ctrl_async_phys_0.sg13g2_a22oi_1_0.A1 0.08912f
C4056 sar_ctrl_async_phys_0.sg13g2_nand2_1_1.Y a_36074_40830# 0.01548f
C4057 a_33846_30626# a_34420_30639# 0.31978f
C4058 a_34651_30748# a_35648_30846# 0.02979f
C4059 a_31195_39820# a_32192_39918# 0.02979f
C4060 a_30390_39698# a_30964_39711# 0.31978f
C4061 sar_ctrl_async_phys_0.sg13g2_o21ai_1_1.B1 a_31040_40702# 0.10954f
C4062 sar_ctrl_async_phys_0.sg13g2_a21oi_1_2.B1 sar_ctrl_async_phys_0.sg13g2_buf_1_21.A 0.10959f
C4063 sar_ctrl_async_phys_0.sg13g2_a22oi_1_0.A1 sar_ctrl_async_phys_0.sg13g2_inv_1_1.Y 0.03737f
C4064 sar_ctrl_async_phys_0.sg13g2_a22oi_1_0.A2 a_34132_32904# 0.03626f
C4065 a_26558_40727# sar_ctrl_async_phys_0.sg13g2_nand3_1_0.A 0.15609f
C4066 a_34106_32868# a_34549_32911# 0.02242f
C4067 sar_ctrl_async_phys_0.sg13g2_dfrbpq_1_0.CLK a_33940_44552# 0.07567f
C4068 sar_ctrl_async_phys_0.dac_code_n[7] oa_sar8_acore18_opt_0.sw_bitcell_opt_b0_0.bot 0.0722f
C4069 sar_ctrl_async_phys_0.bit_active[6] sar_ctrl_async_phys_0.bit_active[7] 0.14457f
C4070 sar_ctrl_async_phys_0.sg13g2_nand2b_1_7.A_N a_35770_43484# 0.11503f
C4071 a_30774_44234# VDD 0.78071f
C4072 a_35288_47296# sar_ctrl_async_phys_0.cmp_valid 0.01433f
C4073 sar_ctrl_async_phys_0.sg13g2_o21ai_1_1.B1 a_33211_45868# 0.42048f
C4074 sar_ctrl_async_phys_0.sg13g2_a21oi_1_6.B1 sar_ctrl_async_phys_0.sg13g2_nor2_1_0.Y 0.11144f
C4075 sar_ctrl_async_phys_0.sg13g2_nor2b_1_0.A a_31828_37440# 0.04335f
C4076 oa_sar8_acore18_opt_0.sw_bitcell_opt_term_0.vin m3_54868_n2380# 0.05057f
C4077 w_16692_n9960# a_20412_n9612# 5.07759f
C4078 sar_ctrl_async_phys_0.dac_code_n[0] vcm 0.07392f
C4079 a_35402_39318# sar_ctrl_async_phys_0.sg13g2_buf_1_21.A 0.01656f
C4080 a_26566_39766# sar_ctrl_async_phys_0.sg13g2_dlygate4sd3_1_9.X 0.15762f
C4081 sar_ctrl_async_phys_0.sg13g2_buf_1_2.X a_30772_31392# 0.42953f
C4082 a_31060_31813# a_31291_31399# 0.12701f
C4083 sar_ctrl_async_phys_0.sg13g2_inv_1_10.Y sar_ctrl_async_phys_0.sg13g2_nor2_1_12.B 0.019f
C4084 sar_ctrl_async_phys_0.sg13g2_nand3_1_0.C sar_ctrl_async_phys_0.sg13g2_dlygate4sd3_1_4.X 0.18639f
C4085 sar_ctrl_async_phys_0.sg13g2_and2_1_2.X sar_ctrl_async_phys_0.sg13g2_dlygate4sd3_1_9.X 0.03116f
C4086 a_30507_35204# a_30830_35166# 0.43036f
C4087 a_29524_40464# VDD 0.07706f
C4088 sar_ctrl_async_phys_0.sg13g2_nor2_1_7.B a_28506_37436# 0.01297f
C4089 sar_ctrl_async_phys_0.sg13g2_nand2_1_1.Y a_35672_38948# 0.27752f
C4090 sar_ctrl_async_phys_0.sg13g2_buf_1_13.A a_31542_37874# 0.01301f
C4091 sar_ctrl_async_phys_0.sg13g2_nor2b_1_0.A sar_ctrl_async_phys_0.sg13g2_a22oi_1_0.A2 0.28015f
C4092 sar_ctrl_async_phys_0.sg13g2_dlygate4sd3_1_9.X track 0.02737f
C4093 a_35672_33688# done 0.09118f
C4094 sar_ctrl_async_phys_0.sg13g2_a21oi_1_5.B1 a_33844_43488# 0.01014f
C4095 sar_ctrl_async_phys_0.sg13g2_nor2b_1_1.B_N sar_ctrl_async_phys_0.bit_active[0] 0.29989f
C4096 sar_ctrl_async_phys_0.sg13g2_and2_1_2.X a_26666_38912# 0.01528f
C4097 sar_ctrl_async_phys_0.sg13g2_buf_1_3.A sar_ctrl_async_phys_0.sg13g2_nand2_1_2.A 0.06457f
C4098 sar_ctrl_async_phys_0.sg13g2_buf_1_2.A a_33344_37678# 0.10991f
C4099 sar_ctrl_async_phys_0.sg13g2_nor2_1_1.A a_32580_36642# 0.01946f
C4100 a_31071_33727# a_30977_33727# 0.28931f
C4101 sar_ctrl_async_phys_0.sg13g2_a21oi_1_7.A2 a_32116_40464# 0.01491f
C4102 sar_ctrl_async_phys_0.sg13g2_buf_1_4.A a_34363_36796# 0.01679f
C4103 sar_ctrl_async_phys_0.sg13g2_buf_1_13.A sar_ctrl_async_phys_0.sg13g2_a21oi_1_1.Y 0.47914f
C4104 sar_ctrl_async_phys_0.sg13g2_dfrbpq_1_0.CLK a_32576_44454# 0.02998f
C4105 sar_ctrl_async_phys_0.sg13g2_a22oi_1_0.A1 a_34520_33688# 0.0209f
C4106 sar_ctrl_async_phys_0.sg13g2_nand2_1_3.A sar_ctrl_async_phys_0.sg13g2_nand2_1_2.Y 0.04936f
C4107 a_26666_38912# track 0.01198f
C4108 sar_ctrl_async_phys_0.sg13g2_and2_1_0.B a_34363_36796# 0.03268f
C4109 sar_ctrl_async_phys_0.sg13g2_a22oi_1_5.A2 sar_ctrl_async_phys_0.sg13g2_a22oi_1_0.A1 0.32439f
C4110 a_30390_36362# a_30676_35928# 0.41329f
C4111 a_31638_32138# a_32341_32117# 0.02454f
C4112 sar_ctrl_async_phys_0.dac_code_n[7] oa_sar8_acore18_opt_0.sw_bitcell_opt_b0_1.bot 0.15253f
C4113 sar_ctrl_async_phys_0.sg13g2_buf_1_25.A a_30671_32876# 0.08501f
C4114 sar_ctrl_async_phys_0.sg13g2_dlygate4sd3_1_3.A a_28662_41214# 0.01023f
C4115 sar_ctrl_async_phys_0.sg13g2_dlygate4sd3_1_5.A a_25496_39830# 0.01103f
C4116 sar_ctrl_async_phys_0.dac_code[0] oa_sar8_acore18_opt_0.sw_bitcell_opt_term_0.VSS 0.99386f
C4117 oa_sar8_acore18_opt_0.sw_bitcell_opt_b7_0.bot m3_34580_n2380# 1.93437f
C4118 sar_ctrl_async_phys_0.sg13g2_nand2_1_2.A sar_ctrl_async_phys_0.dac_code[1] 0.0242f
C4119 a_35672_38948# sar_ctrl_async_phys_0.dac_code[6] 0.25658f
C4120 sar_ctrl_async_phys_0.sample oa_sar8_acore18_opt_0.sw_bitcell_opt_b7_1.bot 2.35718f
C4121 sar_ctrl_async_phys_0.hold_req sar_ctrl_async_phys_0.dac_code[0] 0.12424f
C4122 sar_ctrl_async_phys_0.sg13g2_buf_1_25.A sar_ctrl_async_phys_0.sg13g2_a22oi_1_1.Y 0.18833f
C4123 sar_ctrl_async_phys_0.sg13g2_nor2_1_6.A VDD 0.98892f
C4124 sar_ctrl_async_phys_0.sg13g2_buf_1_16.A sar_ctrl_async_phys_0.sg13g2_buf_1_0.A 0.28151f
C4125 sar_ctrl_async_phys_0.sg13g2_buf_1_6.A a_36056_37436# 0.02246f
C4126 sar_ctrl_async_phys_0.sg13g2_buf_1_13.X sar_ctrl_async_phys_0.sg13g2_dlygate4sd3_1_6.X 0.19472f
C4127 sar_ctrl_async_phys_0.sg13g2_dfrbpq_1_9.RESET_B VDD 7.92904f
C4128 sar_ctrl_async_phys_0.dac_code_n[7] a_35948_n9612# 0.04308f
C4129 sar_ctrl_async_phys_0.sg13g2_a21oi_1_7.A2 sar_ctrl_async_phys_0.sg13g2_a22oi_1_2.A2 0.13113f
C4130 a_33846_30626# a_34549_30605# 0.02454f
C4131 oa_sar8_acore18_opt_0.sw_bitcell_opt_term_0.VSS VDD 1.10249f
C4132 a_30676_40016# a_31093_39677# 0.3749f
C4133 a_30390_39698# a_31195_39820# 0.097f
C4134 a_34904_46508# sar_ctrl_async_phys_0.dac_code_n[3] 0.24512f
C4135 sar_ctrl_async_phys_0.hold_req VDD 0.93949f
C4136 sar_ctrl_async_phys_0.sg13g2_dfrbpq_1_0.CLK a_33652_41528# 0.08465f
C4137 sar_ctrl_async_phys_0.sg13g2_a21oi_1_3.A2 VDD 0.43122f
C4138 sar_ctrl_async_phys_0.sg13g2_nand2_1_2.A sar_ctrl_async_phys_0.sg13g2_buf_1_20.A 0.02364f
C4139 sar_ctrl_async_phys_0.sg13g2_a22oi_1_0.B1 sar_ctrl_async_phys_0.sg13g2_a22oi_1_0.Y 0.22202f
C4140 sar_ctrl_async_phys_0.sg13g2_a22oi_1_1.Y a_30872_30758# 0.01607f
C4141 a_31828_37440# VDD 0.07559f
C4142 sar_ctrl_async_phys_0.sg13g2_buf_1_5.A VDD 0.73372f
C4143 a_26385_39214# VDD 0.2274f
C4144 sar_ctrl_async_phys_0.sg13g2_buf_1_8.A a_33089_32215# 0.01346f
C4145 sar_ctrl_async_phys_0.sg13g2_a22oi_1_5.A2 a_30650_39921# 0.03475f
C4146 sar_ctrl_async_phys_0.sg13g2_nor2_1_2.Y a_34093_42912# 0.03751f
C4147 oa_sar8_acore18_opt_0.sw_bitcell_opt_term_0.vin a_35028_n9612# 0.04547f
C4148 sar_ctrl_async_phys_0.sg13g2_nor2_1_10.B sar_ctrl_async_phys_0.sg13g2_buf_1_16.A 0.04184f
C4149 sar_ctrl_async_phys_0.sg13g2_a22oi_1_1.A2 sar_ctrl_async_phys_0.sg13g2_buf_1_2.A 0.07059f
C4150 oa_sar8_acore18_opt_0.sw_bitcell_opt_b6_0.bot oa_sar8_acore18_opt_0.sw_bitcell_opt_term_0.VSS 2.28853f
C4151 a_30772_31392# a_31189_31399# 0.37583f
C4152 sar_ctrl_async_phys_0.sg13g2_dfrbpq_1_2.Q sar_ctrl_async_phys_0.sg13g2_a22oi_1_2.A2 0.01736f
C4153 a_30486_31826# a_31060_31813# 0.31978f
C4154 sar_ctrl_async_phys_0.hold_req oa_sar8_acore18_opt_0.sw_bitcell_opt_b6_0.bot 0.13089f
C4155 sar_ctrl_async_phys_0.dac_code_n[4] sar_ctrl_async_phys_0.dac_code[4] 0.06321f
C4156 sar_ctrl_async_phys_0.sg13g2_a22oi_1_0.A2 VDD 0.59924f
C4157 a_34132_32904# VDD 0.07326f
C4158 sar_ctrl_async_phys_0.sg13g2_a21oi_1_0.A1 sar_ctrl_async_phys_0.sg13g2_nand2_1_1.Y 0.25549f
C4159 oa_sar8_acore18_opt_0.sw_bitcell_opt_term_1.bot a_20412_n9612# 0.36795f
C4160 sar_ctrl_async_phys_0.sample oa_sar8_acore18_opt_0.bstrap_opt_w2_c1200_1.out 0.83538f
C4161 sar_ctrl_async_phys_0.sg13g2_buf_1_13.X sar_ctrl_async_phys_0.sg13g2_nor2_1_5.Y 0.01718f
C4162 sar_ctrl_async_phys_0.dac_code[1] oa_sar8_acore18_opt_0.sw_tg_opt_0.bot 0.90081f
C4163 sar_ctrl_async_phys_0.sg13g2_nor4_1_0.C sar_ctrl_async_phys_0.sg13g2_nand2b_1_7.A_N 0.02111f
C4164 a_31034_44457# a_30774_44234# 0.75507f
C4165 sar_ctrl_async_phys_0.sg13g2_nor2_1_2.Y sar_ctrl_async_phys_0.sg13g2_a21oi_1_2.B1 0.01179f
C4166 sar_ctrl_async_phys_0.sg13g2_a22oi_1_5.Y a_30848_32358# 0.02041f
C4167 sar_ctrl_async_phys_0.sg13g2_nor2b_1_1.B_N a_34808_35200# 0.26039f
C4168 sar_ctrl_async_phys_0.sg13g2_inv_1_0.Y result[4] 0.01526f
C4169 sar_ctrl_async_phys_0.dac_code_n[2] sar_ctrl_async_phys_0.dac_code_n[4] 3.18975f
C4170 sar_ctrl_async_phys_0.dac_code_n[0] sar_ctrl_async_phys_0.dac_code_n[5] 0.16844f
C4171 a_34520_46508# sar_ctrl_async_phys_0.sg13g2_a21oi_1_0.B1 0.26069f
C4172 a_32533_40471# a_33281_40821# 0.01058f
C4173 a_30331_33772# a_31328_33870# 0.02979f
C4174 a_29526_33650# a_30100_33663# 0.31978f
C4175 sar_ctrl_async_phys_0.sg13g2_a22oi_1_1.A2 sar_ctrl_async_phys_0.sg13g2_a21oi_1_7.Y 0.65107f
C4176 sar_ctrl_async_phys_0.sg13g2_nor2b_1_0.A sar_ctrl_async_phys_0.sg13g2_nor2b_1_3.Y 0.30068f
C4177 sar_ctrl_async_phys_0.sg13g2_buf_1_4.A a_32888_36806# 0.02245f
C4178 sar_ctrl_async_phys_0.sg13g2_a21oi_1_0.A1 a_35672_38224# 0.02481f
C4179 sar_ctrl_async_phys_0.sg13g2_nor2_1_7.B sar_ctrl_async_phys_0.sg13g2_nand2_1_0.B 0.12455f
C4180 sar_ctrl_async_phys_0.dac_code_n[7] oa_sar8_acore18_opt_0.sw_bitcell_opt_b4_1.bot 0.11279f
C4181 sar_ctrl_async_phys_0.sg13g2_buf_1_13.X a_25608_40501# 0.03001f
C4182 sar_ctrl_async_phys_0.sg13g2_a22oi_1_0.B1 a_30390_36362# 0.27778f
C4183 sar_ctrl_async_phys_0.sg13g2_buf_1_3.A a_33270_39698# 0.04146f
C4184 sar_ctrl_async_phys_0.sg13g2_dfrbpq_1_0.CLK sar_ctrl_async_phys_0.sg13g2_buf_1_3.A 0.06244f
C4185 sar_ctrl_async_phys_0.sg13g2_a22oi_1_0.A1 result[5] 0.05802f
C4186 oa_sar8_acore18_opt_0.sw_bitcell_opt_b5_0.bot oa_sar8_acore18_opt_0.sw_bitcell_opt_term_0.gb 0.78567f
C4187 sar_ctrl_async_phys_0.sg13g2_a21oi_1_7.Y a_31446_35162# 0.05518f
C4188 sar_ctrl_async_phys_0.sg13g2_nor2b_1_0.A VDD 2.28667f
C4189 sar_ctrl_async_phys_0.sg13g2_nand2b_1_3.Y a_34765_42242# 0.3022f
C4190 sar_ctrl_async_phys_0.sg13g2_buf_1_13.A sar_ctrl_async_phys_0.sg13g2_buf_1_22.A 0.07504f
C4191 sar_ctrl_async_phys_0.sg13g2_a21oi_1_0.A1 sar_ctrl_async_phys_0.dac_code[6] 0.01684f
C4192 sar_ctrl_async_phys_0.sg13g2_buf_1_13.X sar_ctrl_async_phys_0.sg13g2_buf_1_22.A 0.91132f
C4193 sar_ctrl_async_phys_0.sg13g2_nor2_1_7.A a_29258_36642# 0.0344f
C4194 sar_ctrl_async_phys_0.sg13g2_nor2_1_5.Y a_28026_36972# 0.01358f
C4195 sar_ctrl_async_phys_0.sg13g2_buf_1_35.A sar_ctrl_async_phys_0.sg13g2_nor2b_1_0.A 0.04718f
C4196 sar_ctrl_async_phys_0.sg13g2_nor4_1_0.C sar_ctrl_async_phys_0.sg13g2_nand2b_1_0.A_N 0.16621f
C4197 sar_ctrl_async_phys_0.sg13g2_a22oi_1_0.A2 a_35009_36751# 0.01327f
C4198 a_30879_43845# a_31546_43484# 0.0894f
C4199 sar_ctrl_async_phys_0.sg13g2_a22oi_1_0.A1 a_34424_35200# 0.04186f
C4200 a_28651_39740# VDD 0.2458f
C4201 sar_ctrl_async_phys_0.sg13g2_inv_1_9.Y a_26570_42690# 0.41f
C4202 sar_ctrl_async_phys_0.sg13g2_a21oi_1_2.B1 a_34911_41287# 0.01211f
C4203 sar_ctrl_async_phys_0.sg13g2_dlygate4sd3_1_1.X VDD 0.27939f
C4204 sar_ctrl_async_phys_0.sg13g2_nor2b_1_3.Y a_32635_40471# 0.02269f
C4205 sar_ctrl_async_phys_0.sg13g2_dfrbpq_1_2.Q a_33973_39677# 0.02581f
C4206 sar_ctrl_async_phys_0.sg13g2_a22oi_1_0.B1 sar_ctrl_async_phys_0.sg13g2_a22oi_1_1.B2 0.37896f
C4207 VDD vinp 0.29538f
C4208 sar_ctrl_async_phys_0.sg13g2_nand2_1_3.A a_36336_41342# 0.01625f
C4209 sar_ctrl_async_phys_0.sg13g2_nor2_1_2.Y a_34520_38224# 0.05524f
C4210 sar_ctrl_async_phys_0.sg13g2_nand2_1_3.A a_35456_44454# 0.01213f
C4211 sar_ctrl_async_phys_0.dac_code[3] sar_ctrl_async_phys_0.dac_code[6] 0.13268f
C4212 sar_ctrl_async_phys_0.sg13g2_nor2_1_2.A sar_ctrl_async_phys_0.sg13g2_buf_1_4.A 0.02379f
C4213 sar_ctrl_async_phys_0.sg13g2_nor2_1_3.B a_26728_37416# 0.01075f
C4214 sar_ctrl_async_phys_0.sg13g2_a22oi_1_0.Y sar_ctrl_async_phys_0.sg13g2_buf_1_8.A 0.02195f
C4215 a_32635_40471# VDD 0.20706f
C4216 a_33940_44552# a_34228_44247# 0.43707f
C4217 sar_ctrl_async_phys_0.sg13g2_dfrbpq_1_9.RESET_B a_31034_44457# 0.26483f
C4218 oa_sar8_acore18_opt_0.sw_bitcell_opt_b2_0.bot oa_sar8_acore18_opt_0.sw_bitcell_opt_term_0.VSS 1.61769f
C4219 sar_ctrl_async_phys_0.sg13g2_nor2_1_13.Y sar_ctrl_async_phys_0.sg13g2_inv_1_9.Y 0.15869f
C4220 a_34767_31359# result[2] 0.01186f
C4221 sar_ctrl_async_phys_0.sg13g2_dfrbpq_1_0.CLK sar_ctrl_async_phys_0.sg13g2_buf_1_20.A 0.02496f
C4222 sar_ctrl_async_phys_0.hold_req oa_sar8_acore18_opt_0.sw_bitcell_opt_b2_0.bot 0.10875f
C4223 sar_ctrl_async_phys_0.sg13g2_nor4_1_0.Y sar_ctrl_async_phys_0.sg13g2_o21ai_1_1.A2 0.03339f
C4224 a_33080_30664# VDD 0.2186f
C4225 sar_ctrl_async_phys_0.sg13g2_a21oi_1_0.B1 sar_ctrl_async_phys_0.sg13g2_buf_1_13.A 0.02399f
C4226 a_26954_40424# VDD 0.34508f
C4227 a_26289_42912# a_26570_42690# 0.26306f
C4228 a_26168_38318# VDD 0.13506f
C4229 oa_sar8_acore18_opt_0.sw_tg_opt_1.bot oa_sar8_acore18_opt_0.bstrap_opt_w2_c1200_1.gb 0.22022f
C4230 sar_ctrl_async_phys_0.dac_code[0] VDD 4.11082f
C4231 sar_ctrl_async_phys_0.sg13g2_nor2b_1_3.Y VDD 0.38673f
C4232 sar_ctrl_async_phys_0.sg13g2_buf_1_34.A sar_ctrl_async_phys_0.dac_code_n[7] 0.01857f
C4233 a_36056_42760# sar_ctrl_async_phys_0.dac_code[2] 0.08923f
C4234 a_31830_40898# a_32635_40471# 0.097f
C4235 sar_ctrl_async_phys_0.sg13g2_nor2_1_7.A sar_ctrl_async_phys_0.sg13g2_nor2_1_5.Y 0.28556f
C4236 sar_ctrl_async_phys_0.dac_code[0] sar_ctrl_async_phys_0.sg13g2_buf_1_35.A 2.49598f
C4237 a_34093_42912# a_34175_42726# 0.01117f
C4238 a_29526_33650# a_30229_33629# 0.02454f
C4239 sar_ctrl_async_phys_0.sg13g2_nor2b_1_0.A a_31162_38948# 0.01053f
C4240 sar_ctrl_async_phys_0.dac_code_n[7] oa_sar8_acore18_opt_0.sw_bitcell_opt_b7_0.bot 1.39746f
C4241 sar_ctrl_async_phys_0.sg13g2_nand2_1_3.A sar_ctrl_async_phys_0.sg13g2_nand2_1_3.B 0.0661f
C4242 sar_ctrl_async_phys_0.sg13g2_buf_1_4.A a_32580_36642# 0.26355f
C4243 sar_ctrl_async_phys_0.sg13g2_dfrbpq_1_0.CLK sar_ctrl_async_phys_0.sg13g2_nand2_1_1.B 0.38754f
C4244 sar_ctrl_async_phys_0.sg13g2_nand2b_1_1.Y sar_ctrl_async_phys_0.sg13g2_nand2_1_3.A 0.38387f
C4245 sar_ctrl_async_phys_0.sg13g2_nor2_1_6.A a_29210_38916# 0.02369f
C4246 oa_sar8_acore18_opt_0.sw_tg_opt_1.bot oa_sar8_acore18_opt_0.sw_bitcell_opt_b1_1.bot 1.04956f
C4247 a_29786_33873# VDD 0.09788f
C4248 oa_sar8_acore18_opt_0.sw_bitcell_opt_b1_0.bot oa_sar8_acore18_opt_0.sw_bitcell_opt_term_0.gb 0.61173f
C4249 a_35482_39996# sar_ctrl_async_phys_0.sg13g2_buf_1_23.A 0.01372f
C4250 sar_ctrl_async_phys_0.dac_code_n[3] sar_ctrl_async_phys_0.sg13g2_nand2_1_6.B 0.49038f
C4251 sar_ctrl_async_phys_0.sg13g2_buf_1_13.X sar_ctrl_async_phys_0.sg13g2_o21ai_1_1.B1 0.40401f
C4252 a_30591_32215# a_31258_32436# 0.0894f
C4253 sar_ctrl_async_phys_0.sg13g2_o21ai_1_1.B1 sar_ctrl_async_phys_0.sg13g2_buf_1_13.A 1.00081f
C4254 a_29749_32117# a_30497_32215# 0.01058f
C4255 sar_ctrl_async_phys_0.sg13g2_nand2_1_3.Y sar_ctrl_async_phys_0.sg13g2_nand2_1_1.Y 0.02105f
C4256 sar_ctrl_async_phys_0.sg13g2_a22oi_1_0.A2 a_34036_35928# 0.03271f
C4257 sar_ctrl_async_phys_0.dac_code_n[2] sar_ctrl_async_phys_0.sg13g2_nand2_1_2.A 1.49369f
C4258 sar_ctrl_async_phys_0.sg13g2_nand2b_1_1.Y a_34817_41287# 0.01794f
C4259 sar_ctrl_async_phys_0.sg13g2_nand2b_1_2.Y sar_ctrl_async_phys_0.sg13g2_nand2_1_3.A 0.38296f
C4260 sar_ctrl_async_phys_0.sg13g2_buf_1_3.A a_33818_36897# 0.02739f
C4261 sar_ctrl_async_phys_0.dac_code[0] oa_sar8_acore18_opt_0.sw_bitcell_opt_b6_0.bot 1.1725f
C4262 a_33948_41936# a_34328_41972# 0.0495f
C4263 sar_ctrl_async_phys_0.sg13g2_buf_1_13.X a_29755_38959# 0.02582f
C4264 sar_ctrl_async_phys_0.sg13g2_buf_1_35.A VDD 0.6492f
C4265 sar_ctrl_async_phys_0.sg13g2_buf_1_3.A sar_ctrl_async_phys_0.sg13g2_buf_1_2.X 0.11258f
C4266 sar_ctrl_async_phys_0.sg13g2_nand2_1_0.B sar_ctrl_async_phys_0.sg13g2_buf_1_2.A 0.1737f
C4267 sar_ctrl_async_phys_0.sg13g2_buf_1_3.A a_33080_31388# 0.01259f
C4268 sar_ctrl_async_phys_0.sg13g2_buf_1_4.A result[7] 0.02627f
C4269 sar_ctrl_async_phys_0.bit_active[1] busy 0.03326f
C4270 sar_ctrl_async_phys_0.sg13g2_buf_1_2.A a_28862_36863# 0.05012f
C4271 a_29620_43488# a_30879_43845# 0.01529f
C4272 sar_ctrl_async_phys_0.sg13g2_dfrbpq_1_0.CLK sar_ctrl_async_phys_0.sg13g2_nor2_1_0.A 0.15188f
C4273 sar_ctrl_async_phys_0.sg13g2_a21oi_1_7.Y a_31328_33870# 0.04982f
C4274 sar_ctrl_async_phys_0.sg13g2_dfrbpq_1_0.CLK sar_ctrl_async_phys_0.sg13g2_dlygate4sd3_1_0.X 0.01075f
C4275 sar_ctrl_async_phys_0.sg13g2_nor2_1_11.A a_30139_43495# 0.045f
C4276 sar_ctrl_async_phys_0.sg13g2_nor4_1_0.C sar_ctrl_async_phys_0.sg13g2_a21oi_1_2.B1 4.93636f
C4277 a_36056_35200# sar_ctrl_async_phys_0.bit_active[0] 0.01179f
C4278 sar_ctrl_async_phys_0.sg13g2_buf_1_13.X a_26630_37814# 0.05388f
C4279 sar_ctrl_async_phys_0.sg13g2_dfrbpq_1_0.CLK sar_ctrl_async_phys_0.sg13g2_buf_1_9.A 0.18731f
C4280 sar_ctrl_async_phys_0.sg13g2_a21oi_1_0.A1 sar_ctrl_async_phys_0.sg13g2_dfrbpq_1_11.D 0.13476f
C4281 oa_sar8_acore18_opt_0.sw_bitcell_opt_term_0.gb m3_51760_n2380# 1.48499f
C4282 a_34208_45966# a_34618_46044# 0.10373f
C4283 oa_sar8_acore18_opt_0.sw_bitcell_opt_b6_0.bot VDD 4.11698f
C4284 a_35295_36285# VDD 0.175f
C4285 sar_ctrl_async_phys_0.sg13g2_nor2_1_7.Y sar_ctrl_async_phys_0.sg13g2_nor2_1_5.B 0.01318f
C4286 sar_ctrl_async_phys_0.sg13g2_buf_1_4.A sar_ctrl_async_phys_0.bit_active[0] 0.02574f
C4287 sar_ctrl_async_phys_0.sg13g2_buf_1_33.A sar_ctrl_async_phys_0.dac_code[1] 0.01939f
C4288 sar_ctrl_async_phys_0.sg13g2_a22oi_1_1.B2 sar_ctrl_async_phys_0.sg13g2_buf_1_8.A 0.80216f
C4289 sar_ctrl_async_phys_0.dac_code[1] sar_ctrl_async_phys_0.dac_code[5] 0.27276f
C4290 sar_ctrl_async_phys_0.sg13g2_nand2_1_3.Y sar_ctrl_async_phys_0.dac_code[6] 0.49983f
C4291 sar_ctrl_async_phys_0.sg13g2_and2_1_0.B sar_ctrl_async_phys_0.bit_active[0] 0.0532f
C4292 sar_ctrl_async_phys_0.sg13g2_nand2_1_2.A a_36156_45710# 0.26128f
C4293 sar_ctrl_async_phys_0.sg13g2_dfrbpq_1_1.D a_31446_35162# 0.3019f
C4294 a_30830_35166# a_30733_35166# 0.01625f
C4295 sar_ctrl_async_phys_0.sg13g2_a22oi_1_0.A1 sar_ctrl_async_phys_0.sg13g2_a22oi_1_0.B2 0.19557f
C4296 a_31830_40898# VDD 0.77444f
C4297 sar_ctrl_async_phys_0.sg13g2_a22oi_1_0.Y a_34651_32911# 0.03211f
C4298 a_33654_44234# a_34459_44356# 0.097f
C4299 a_33940_44552# a_34357_44213# 0.3749f
C4300 sar_ctrl_async_phys_0.sg13g2_a21oi_1_6.B1 sar_ctrl_async_phys_0.sg13g2_buf_1_44.A 0.01716f
C4301 sar_ctrl_async_phys_0.dac_code[4] oa_sar8_acore18_opt_0.sw_tg_opt_0.bot 0.88445f
C4302 a_35391_34773# VDD 0.17438f
C4303 a_33552_44366# sar_ctrl_async_phys_0.sg13g2_nor2_1_2.Y 0.02826f
C4304 a_35072_39918# VDD 0.16953f
C4305 a_29851_32260# VDD 0.20494f
C4306 sar_ctrl_async_phys_0.sg13g2_a21oi_1_0.A1 a_35578_41508# 0.05972f
C4307 sar_ctrl_async_phys_0.hold_req oa_sar8_acore18_opt_0.sw_bitcell_opt_b7_1.VSS 1.96992f
C4308 sar_ctrl_async_phys_0.sg13g2_nand2_1_3.B a_33368_44366# 0.0243f
C4309 sar_ctrl_async_phys_0.sg13g2_a22oi_1_3.A2 a_31828_37440# 0.03992f
C4310 sar_ctrl_async_phys_0.sg13g2_a21oi_1_6.B1 sar_ctrl_async_phys_0.sg13g2_dfrbpq_1_9.Q 0.8931f
C4311 a_34636_31749# result[2] 0.01905f
C4312 sar_ctrl_async_phys_0.sg13g2_a22oi_1_2.A2 sar_ctrl_async_phys_0.sg13g2_buf_1_22.A 0.02964f
C4313 sar_ctrl_async_phys_0.dac_code_n[3] sar_ctrl_async_phys_0.dac_code_n[6] 0.2133f
C4314 a_35552_36166# a_35962_35924# 0.10373f
C4315 sar_ctrl_async_phys_0.dac_code_n[2] oa_sar8_acore18_opt_0.sw_tg_opt_0.bot 0.23301f
C4316 sar_ctrl_async_phys_0.dac_code[7] oa_sar8_acore18_opt_0.sw_bitcell_opt_term_0.gb 0.41252f
C4317 sar_ctrl_async_phys_0.sg13g2_buf_1_14.A sar_ctrl_async_phys_0.dac_code[6] 0.02988f
C4318 sar_ctrl_async_phys_0.sg13g2_nor2_1_4.Y sar_ctrl_async_phys_0.sg13g2_nor4_1_0.Y 0.02487f
C4319 sar_ctrl_async_phys_0.sg13g2_buf_1_20.A sar_ctrl_async_phys_0.sg13g2_buf_1_33.A 0.01995f
C4320 sar_ctrl_async_phys_0.sg13g2_buf_1_20.A sar_ctrl_async_phys_0.dac_code[5] 0.05761f
C4321 sar_ctrl_async_phys_0.sg13g2_nor2_1_10.Y sar_ctrl_async_phys_0.sg13g2_nor2_1_10.B 0.17393f
C4322 sar_ctrl_async_phys_0.sg13g2_buf_1_3.A sar_ctrl_async_phys_0.sg13g2_inv_1_2.A 1.08513f
C4323 sar_ctrl_async_phys_0.dac_code_n[6] oa_sar8_acore18_opt_0.sw_bitcell_opt_term_0.trkb 2.0677f
C4324 sar_ctrl_async_phys_0.sg13g2_a21oi_1_0.A2 VDD 0.54151f
C4325 sar_ctrl_async_phys_0.sg13g2_dfrbpq_1_2.Q sar_ctrl_async_phys_0.sg13g2_a22oi_1_0.A1 0.85221f
C4326 sar_ctrl_async_phys_0.sg13g2_buf_1_13.A a_33530_39921# 0.01413f
C4327 sar_ctrl_async_phys_0.sg13g2_dfrbpq_1_0.CLK sar_ctrl_async_phys_0.sg13g2_and2_1_5.X 0.03604f
C4328 sar_ctrl_async_phys_0.sg13g2_buf_1_16.A a_34106_34380# 0.01463f
C4329 a_35103_43845# a_35770_43484# 0.0894f
C4330 sar_ctrl_async_phys_0.dac_code_n[3] oa_sar8_acore18_opt_0.sw_bitcell_opt_term_0.trkb 1.8925f
C4331 sar_ctrl_async_phys_0.sg13g2_buf_1_23.A a_34453_35935# 0.01314f
C4332 a_31162_38948# VDD 0.3793f
C4333 sar_ctrl_async_phys_0.sg13g2_dfrbpq_1_0.CLK sar_ctrl_async_phys_0.sg13g2_buf_1_16.A 0.03207f
C4334 sar_ctrl_async_phys_0.sg13g2_o21ai_1_1.A2 a_27249_39888# 0.03258f
C4335 a_35288_47296# sar_ctrl_async_phys_0.dac_code_n[2] 0.2458f
C4336 sar_ctrl_async_phys_0.sg13g2_buf_1_26.X a_26681_38232# 0.01002f
C4337 sar_ctrl_async_phys_0.dac_code_n[1] sar_ctrl_async_phys_0.dac_code_n[7] 0.12099f
C4338 oa_sar8_acore18_opt_0.sw_tg_opt_1.bot oa_sar8_acore18_opt_0.sw_bitcell_opt_b5_1.bot 15.0257f
C4339 w_39600_n9960# sar_ctrl_async_phys_0.dac_code[1] 0.04601f
C4340 a_31040_40702# a_30783_40821# 0.34468f
C4341 a_35648_34654# a_36058_34412# 0.10373f
C4342 a_27120_37522# VDD 0.08569f
C4343 a_34075_39820# a_33844_39711# 0.12701f
C4344 a_33556_40016# a_34721_39775# 0.43239f
C4345 a_34815_39775# a_35482_39996# 0.0894f
C4346 sar_ctrl_async_phys_0.sg13g2_nor2_1_0.Y sar_ctrl_async_phys_0.sg13g2_a21oi_1_0.A1 0.03396f
C4347 a_33914_44457# a_33940_44552# 0.36952f
C4348 sar_ctrl_async_phys_0.sg13g2_a21oi_1_1.B1 sar_ctrl_async_phys_0.sg13g2_nand2_1_3.B 0.02406f
C4349 sar_ctrl_async_phys_0.sg13g2_dfrbpq_1_0.CLK sar_ctrl_async_phys_0.sg13g2_buf_1_23.A 0.03113f
C4350 sar_ctrl_async_phys_0.sg13g2_nor2_1_4.Y a_26364_45710# 0.03206f
C4351 sar_ctrl_async_phys_0.sg13g2_a21oi_1_1.B1 sar_ctrl_async_phys_0.sg13g2_nand2b_1_1.Y 0.07297f
C4352 sar_ctrl_async_phys_0.sg13g2_nor2_1_4.Y a_26454_39702# 0.04228f
C4353 a_26184_21025# VDD 0.75713f
C4354 sar_ctrl_async_phys_0.dac_code[0] oa_sar8_acore18_opt_0.sw_bitcell_opt_b2_0.bot 0.48387f
C4355 sar_ctrl_async_phys_0.sg13g2_a21oi_1_1.B1 sar_ctrl_async_phys_0.sg13g2_nand2b_1_2.Y 0.08401f
C4356 sar_ctrl_async_phys_0.dac_code_n[6] oa_sar8_acore18_opt_0.sw_bitcell_opt_b4_0.bot 0.32255f
C4357 sar_ctrl_async_phys_0.sg13g2_buf_1_3.A a_34228_44247# 0.01336f
C4358 sar_ctrl_async_phys_0.sg13g2_buf_1_13.A sar_ctrl_async_phys_0.sg13g2_buf_1_6.A 0.03f
C4359 sar_ctrl_async_phys_0.sg13g2_dfrbpq_1_9.RESET_B a_31732_45000# 0.38365f
C4360 sar_ctrl_async_phys_0.sg13g2_buf_1_13.X a_28560_39034# 0.0167f
C4361 sar_ctrl_async_phys_0.sg13g2_o21ai_1_1.B1 a_32116_40464# 0.37917f
C4362 sar_ctrl_async_phys_0.dac_code_n[3] oa_sar8_acore18_opt_0.sw_bitcell_opt_b4_0.bot 0.45582f
C4363 a_36056_47296# VDD 0.21644f
C4364 sar_ctrl_async_phys_0.sg13g2_a21oi_1_0.B1 sar_ctrl_async_phys_0.sg13g2_a22oi_1_2.A2 0.02079f
C4365 sar_ctrl_async_phys_0.sg13g2_buf_1_6.A a_35053_40730# 0.28872f
C4366 sar_ctrl_async_phys_0.sg13g2_nor2b_1_0.A sar_ctrl_async_phys_0.sg13g2_a22oi_1_3.A2 0.16974f
C4367 a_29594_43452# a_29620_43488# 0.36952f
C4368 sar_ctrl_async_phys_0.sg13g2_a22oi_1_1.A2 sar_ctrl_async_phys_0.sg13g2_inv_1_1.Y 0.07104f
C4369 sar_ctrl_async_phys_0.sg13g2_a21oi_1_7.Y a_32090_40428# 0.01427f
C4370 sar_ctrl_async_phys_0.sg13g2_inv_1_3.Y sar_ctrl_async_phys_0.sg13g2_a22oi_1_0.B2 0.06599f
C4371 sar_ctrl_async_phys_0.sg13g2_nor2_1_11.A a_29334_43922# 0.29105f
C4372 sar_ctrl_async_phys_0.sg13g2_a22oi_1_0.A1 sar_ctrl_async_phys_0.sg13g2_inv_1_1.A 0.38914f
C4373 oa_sar8_acore18_opt_0.sw_bitcell_opt_term_0.trkb oa_sar8_acore18_opt_0.sw_bitcell_opt_b4_0.bot 1.42453f
C4374 a_35280_35365# a_35672_35200# 0.04376f
C4375 a_32991_35239# a_32897_35239# 0.28931f
C4376 sar_ctrl_async_phys_0.sg13g2_buf_1_6.A a_36336_39830# 0.01534f
C4377 oa_sar8_acore18_opt_0.sw_bitcell_opt_b2_0.bot VDD 2.76646f
C4378 a_34767_31359# a_35463_31435# 0.02454f
C4379 a_32692_46064# a_33951_45823# 0.01529f
C4380 a_31638_32138# a_32212_32151# 0.31978f
C4381 sar_ctrl_async_phys_0.dac_code_n[7] vcm 0.07208f
C4382 sar_ctrl_async_phys_0.hold_req sar_ctrl_async_phys_0.cmp_n 0.26913f
C4383 sar_ctrl_async_phys_0.sg13g2_nor2b_1_3.Y a_33168_39830# 0.02821f
C4384 sar_ctrl_async_phys_0.sg13g2_buf_1_2.X a_34106_32868# 0.24187f
C4385 a_31034_44457# VDD 0.09718f
C4386 a_34036_35928# VDD 0.07206f
C4387 sar_ctrl_async_phys_0.sg13g2_a21oi_1_5.B1 sar_ctrl_async_phys_0.dac_code_n[0] 0.05981f
C4388 sar_ctrl_async_phys_0.sg13g2_buf_1_2.X sar_ctrl_async_phys_0.sg13g2_buf_1_9.A 0.04972f
C4389 a_33652_41528# a_33940_41223# 0.43707f
C4390 sar_ctrl_async_phys_0.sg13g2_buf_1_9.A a_33080_31388# 0.02223f
C4391 sar_ctrl_async_phys_0.sg13g2_a22oi_1_0.Y a_34549_32911# 0.04665f
C4392 sar_ctrl_async_phys_0.sg13g2_a22oi_1_0.A2 done 0.07128f
C4393 sar_ctrl_async_phys_0.sg13g2_nand3_1_0.Y sar_ctrl_async_phys_0.sg13g2_dlygate4sd3_1_9.X 0.02462f
C4394 a_35664_37695# sar_ctrl_async_phys_0.sg13g2_buf_1_4.A 0.10859f
C4395 sar_ctrl_async_phys_0.sg13g2_a22oi_1_0.B1 sar_ctrl_async_phys_0.sg13g2_a22oi_1_2.B1 0.68691f
C4396 sar_ctrl_async_phys_0.sg13g2_o21ai_1_1.B1 sar_ctrl_async_phys_0.sg13g2_a22oi_1_2.A2 0.6344f
C4397 sar_ctrl_async_phys_0.dac_code[6] vinn 0.10725f
C4398 a_33168_39830# VDD 0.06924f
C4399 sar_ctrl_async_phys_0.sg13g2_inv_1_6.Y a_29046_32138# 0.27899f
C4400 sar_ctrl_async_phys_0.sg13g2_buf_1_13.X sar_ctrl_async_phys_0.sg13g2_nand3_1_0.C 0.19269f
C4401 a_29306_32361# a_29749_32117# 0.02242f
C4402 sar_ctrl_async_phys_0.sg13g2_buf_1_14.A sar_ctrl_async_phys_0.bit_active[0] 0.02162f
C4403 sar_ctrl_async_phys_0.dac_code[4] m3_48572_n2380# 0.02484f
C4404 sar_ctrl_async_phys_0.sg13g2_nand3_1_0.C sar_ctrl_async_phys_0.sg13g2_and2_1_2.X 0.25851f
C4405 oa_sar8_acore18_opt_0.sw_bitcell_opt_b5_0.bot oa_sar8_acore18_opt_0.sw_bitcell_opt_b3_0.bot 0.83214f
C4406 oa_sar8_acore18_opt_0.sw_bitcell_opt_b6_0.bot oa_sar8_acore18_opt_0.sw_bitcell_opt_b2_0.bot 0.51681f
C4407 a_32576_44454# a_32986_44532# 0.10373f
C4408 sar_ctrl_async_phys_0.sg13g2_a21oi_1_5.B1 sar_ctrl_async_phys_0.sg13g2_a21oi_1_0.B1 0.02366f
C4409 sar_ctrl_async_phys_0.sg13g2_nor2_1_4.Y a_26174_42911# 0.01469f
C4410 sar_ctrl_async_phys_0.sg13g2_a21oi_1_1.Y sar_ctrl_async_phys_0.sg13g2_a22oi_1_0.A1 2.38032f
C4411 a_30495_39309# a_30401_39309# 0.28931f
C4412 sar_ctrl_async_phys_0.sg13g2_buf_1_13.X a_30964_36349# 0.022f
C4413 sar_ctrl_async_phys_0.sg13g2_nor2b_1_4.Y a_31136_43726# 0.03141f
C4414 a_34036_35928# a_35295_36285# 0.01529f
C4415 sar_ctrl_async_phys_0.sg13g2_a22oi_1_0.A1 a_33846_33338# 0.01298f
C4416 sar_ctrl_async_phys_0.sg13g2_nand3_1_0.C track 0.14129f
C4417 sar_ctrl_async_phys_0.dac_code_n[4] sar_ctrl_async_phys_0.sample 0.04464f
C4418 a_34261_43495# a_34363_43495# 0.47795f
C4419 sar_ctrl_async_phys_0.sg13g2_nand2_1_3.Y a_35578_41508# 0.01237f
C4420 a_35672_47296# sar_ctrl_async_phys_0.cmp_valid 0.0108f
C4421 a_29210_38916# VDD 0.09624f
C4422 a_34319_32460# VDD 0.30319f
C4423 sar_ctrl_async_phys_0.sg13g2_a21oi_1_4.B1 sar_ctrl_async_phys_0.sg13g2_nor2_1_0.Y 0.02179f
C4424 a_27984_41342# VDD 0.07684f
C4425 sar_ctrl_async_phys_0.sg13g2_a21oi_1_0.B1 a_33973_39677# 0.01254f
C4426 sar_ctrl_async_phys_0.sg13g2_a22oi_1_1.Y sar_ctrl_async_phys_0.sg13g2_inv_1_1.Y 0.06853f
C4427 a_35245_45266# VDD 0.24057f
C4428 sar_ctrl_async_phys_0.sg13g2_a21oi_1_5.B1 sar_ctrl_async_phys_0.sg13g2_o21ai_1_1.B1 0.4102f
C4429 sar_ctrl_async_phys_0.sg13g2_buf_1_2.A a_34132_34416# 0.41797f
C4430 a_33658_44996# VDD 0.37958f
C4431 sar_ctrl_async_phys_0.sg13g2_inv_1_2.A a_34106_32868# 0.02451f
C4432 sar_ctrl_async_phys_0.sg13g2_a22oi_1_3.A2 sar_ctrl_async_phys_0.sg13g2_nor2b_1_3.Y 0.0149f
C4433 a_34132_34416# a_34651_34423# 0.34102f
C4434 a_34549_34423# a_34420_34837# 0.01562f
C4435 sar_ctrl_async_phys_0.sg13g2_buf_1_2.A a_35103_36751# 0.1343f
C4436 sar_ctrl_async_phys_0.sg13g2_buf_1_16.A sar_ctrl_async_phys_0.sg13g2_buf_1_2.X 0.02283f
C4437 a_28008_23477# a_30632_22281# 0.69494f
C4438 sar_ctrl_async_phys_0.dac_code_n[6] oa_sar8_acore18_opt_0.sw_bitcell_opt_b0_0.bot 0.08014f
C4439 sar_ctrl_async_phys_0.sg13g2_dfrbpq_1_0.CLK a_29749_32117# 0.25706f
C4440 oa_sar8_acore18_opt_0.sw_bitcell_opt_term_0.trkb m3_57896_n2380# 0.03859f
C4441 sar_ctrl_async_phys_0.sg13g2_buf_1_23.A a_33818_36897# 0.01026f
C4442 sar_ctrl_async_phys_0.sg13g2_a21oi_1_6.B1 sar_ctrl_async_phys_0.sg13g2_buf_1_32.A 1.5219f
C4443 m3_45264_n2380# VDD 0.02402f
C4444 sar_ctrl_async_phys_0.dac_code_n[3] oa_sar8_acore18_opt_0.sw_bitcell_opt_b0_0.bot 0.10702f
C4445 sar_ctrl_async_phys_0.hold_req oa_sar8_acore18_opt_0.sw_bitcell_opt_b6_1.bot 0.29336f
C4446 sar_ctrl_async_phys_0.sg13g2_buf_1_33.A sar_ctrl_async_phys_0.dac_code[4] 0.35433f
C4447 sar_ctrl_async_phys_0.sg13g2_a22oi_1_3.A2 VDD 1.13595f
C4448 sar_ctrl_async_phys_0.dac_code[4] sar_ctrl_async_phys_0.dac_code[5] 3.90196f
C4449 sar_ctrl_async_phys_0.sg13g2_buf_1_2.X a_29620_32151# 0.04196f
C4450 oa_sar8_acore18_opt_0.sw_bitcell_opt_term_0.trkb oa_sar8_acore18_opt_0.sw_bitcell_opt_b0_0.bot 1.35188f
C4451 sar_ctrl_async_phys_0.sg13g2_o21ai_1_1.B1 a_33973_39677# 0.03474f
C4452 oa_sar8_acore18_opt_0.sw_bitcell_opt_b7_1.VSS VDD 1.10471f
C4453 sar_ctrl_async_phys_0.sg13g2_a21oi_1_2.B1 sar_ctrl_async_phys_0.bit_active[6] 0.03049f
C4454 sar_ctrl_async_phys_0.sg13g2_nand2_1_2.A a_34765_45266# 0.0366f
C4455 sar_ctrl_async_phys_0.sg13g2_nand2_1_3.B sar_ctrl_async_phys_0.sg13g2_nor2_1_1.Y 0.02721f
C4456 sar_ctrl_async_phys_0.sg13g2_buf_1_35.A sar_ctrl_async_phys_0.sg13g2_a22oi_1_3.A2 0.02122f
C4457 sar_ctrl_async_phys_0.sg13g2_nand2b_1_1.Y sar_ctrl_async_phys_0.sg13g2_nor2_1_1.Y 0.01712f
C4458 a_29701_36874# a_29760_36682# 0.01242f
C4459 a_32149_35141# a_32020_35175# 0.01562f
C4460 a_33248_35382# a_33658_35460# 0.10373f
C4461 sar_ctrl_async_phys_0.sg13g2_buf_1_2.A a_35384_32176# 0.26353f
C4462 sar_ctrl_async_phys_0.sg13g2_buf_1_13.A a_34904_38224# 0.01602f
C4463 sar_ctrl_async_phys_0.sg13g2_nand2b_1_1.Y sar_ctrl_async_phys_0.sg13g2_a22oi_1_1.A2 0.01757f
C4464 a_34636_31749# a_35463_31435# 0.41329f
C4465 sar_ctrl_async_phys_0.dac_code_n[2] sar_ctrl_async_phys_0.dac_code[5] 0.06321f
C4466 sar_ctrl_async_phys_0.dac_code_n[4] sar_ctrl_async_phys_0.dac_code[6] 0.20098f
C4467 sar_ctrl_async_phys_0.sg13g2_a22oi_1_0.A2 a_35288_33688# 0.02924f
C4468 a_31935_36285# VDD 0.1752f
C4469 sar_ctrl_async_phys_0.sg13g2_a22oi_1_0.A1 a_30229_33629# 0.01226f
C4470 a_33366_41210# a_34171_41332# 0.097f
C4471 a_33652_41528# a_34069_41189# 0.3749f
C4472 sar_ctrl_async_phys_0.sg13g2_a21oi_1_0.A1 a_33675_43020# 0.03315f
C4473 sar_ctrl_async_phys_0.sg13g2_nand3_1_0.Y a_25896_39706# 0.01478f
C4474 a_27134_39887# sar_ctrl_async_phys_0.sg13g2_dlygate4sd3_1_4.X 0.15631f
C4475 sar_ctrl_async_phys_0.sg13g2_nor2_1_0.Y a_31060_44552# 0.01446f
C4476 sar_ctrl_async_phys_0.sg13g2_buf_1_26.X sar_ctrl_async_phys_0.cmp_p 0.01044f
C4477 sar_ctrl_async_phys_0.sg13g2_buf_1_16.A a_30830_35166# 0.12819f
C4478 oa_sar8_acore18_opt_0.sw_bitcell_opt_b5_0.bot oa_sar8_acore18_opt_0.sw_bitcell_opt_term_0.bot 0.43012f
C4479 oa_sar8_acore18_opt_0.sw_bitcell_opt_b3_0.bot oa_sar8_acore18_opt_0.sw_bitcell_opt_b1_0.bot 0.41752f
C4480 oa_sar8_acore18_opt_0.sw_bitcell_opt_b4_0.bot oa_sar8_acore18_opt_0.sw_bitcell_opt_b0_0.bot 1.24095f
C4481 sar_ctrl_async_phys_0.sg13g2_buf_1_0.A a_34904_33688# 0.25827f
C4482 a_32602_39996# VDD 0.38206f
C4483 sar_ctrl_async_phys_0.sg13g2_a21oi_1_7.Y a_31947_41508# 0.1571f
C4484 w_16692_n9960# vinp 0.01233f
C4485 a_33087_37797# a_33754_37436# 0.0894f
C4486 sar_ctrl_async_phys_0.sg13g2_nor2_1_10.B a_30390_36362# 0.03517f
C4487 a_31060_44552# a_32319_44311# 0.01529f
C4488 sar_ctrl_async_phys_0.sg13g2_inv_1_1.Y a_31898_32361# 0.02446f
C4489 sar_ctrl_async_phys_0.dac_code_n[5] sar_ctrl_async_phys_0.dac_code_n[7] 0.12926f
C4490 sar_ctrl_async_phys_0.sg13g2_buf_1_6.A sar_ctrl_async_phys_0.sg13g2_a22oi_1_2.A2 0.2328f
C4491 sar_ctrl_async_phys_0.sg13g2_nor2b_1_0.A a_30676_40016# 0.01553f
C4492 sar_ctrl_async_phys_0.sg13g2_buf_1_3.A a_33914_44457# 0.02736f
C4493 sar_ctrl_async_phys_0.sg13g2_dlygate4sd3_1_4.X a_26270_39215# 0.01747f
C4494 sar_ctrl_async_phys_0.dac_code_n[6] oa_sar8_acore18_opt_0.sw_bitcell_opt_b0_1.bot 0.06598f
C4495 sar_ctrl_async_phys_0.sg13g2_nor2b_1_0.A a_33252_36642# 0.0594f
C4496 a_29236_38952# a_30495_39309# 0.01529f
C4497 a_34618_46044# a_35000_45878# 0.01012f
C4498 a_35672_42760# VDD 0.26763f
C4499 a_34010_35892# a_34453_35935# 0.02242f
C4500 a_31706_35385# VDD 0.09611f
C4501 a_32698_31388# VDD 0.37968f
C4502 w_39600_n9960# sar_ctrl_async_phys_0.dac_code[4] 0.04487f
C4503 sar_ctrl_async_phys_0.dac_code_n[3] oa_sar8_acore18_opt_0.sw_bitcell_opt_b0_1.bot 0.06598f
C4504 sar_ctrl_async_phys_0.dac_code_n[2] a_20412_n9612# 1.21641f
C4505 sar_ctrl_async_phys_0.sg13g2_a21oi_1_2.A2 sar_ctrl_async_phys_0.sg13g2_dfrbpq_1_22.D 0.3624f
C4506 sar_ctrl_async_phys_0.sg13g2_buf_1_3.A a_34132_43909# 0.01282f
C4507 a_26662_41278# sar_ctrl_async_phys_0.sg13g2_dlygate4sd3_1_8.A 0.15627f
C4508 sar_ctrl_async_phys_0.dac_code[0] sar_ctrl_async_phys_0.cmp_n 0.07678f
C4509 sar_ctrl_async_phys_0.sg13g2_dfrbpq_1_9.RESET_B a_33940_44552# 0.42165f
C4510 sar_ctrl_async_phys_0.sg13g2_nand2b_1_7.A_N a_34224_45082# 0.01664f
C4511 oa_sar8_acore18_opt_0.sw_bitcell_opt_term_0.trkb oa_sar8_acore18_opt_0.sw_bitcell_opt_b0_1.bot 1.3864f
C4512 sar_ctrl_async_phys_0.sg13g2_buf_1_0.A sar_ctrl_async_phys_0.bit_active[0] 0.08512f
C4513 VDD done 0.21969f
C4514 oa_sar8_acore18_opt_0.sw_bitcell_opt_b2_1.bot VDD 2.81891f
C4515 a_27206_39326# VDD 0.01185f
C4516 sar_ctrl_async_phys_0.dac_code_n[6] a_35948_n9612# 0.05089f
C4517 w_39600_n9960# sar_ctrl_async_phys_0.dac_code_n[2] 0.04379f
C4518 a_26280_41214# VDD 0.36118f
C4519 a_32890_46508# VDD 0.38385f
C4520 sar_ctrl_async_phys_0.dac_code_n[3] a_35948_n9612# 1.18417f
C4521 a_31732_45000# VDD 0.07447f
C4522 a_29238_40898# a_30043_40471# 0.097f
C4523 a_33846_34850# a_34106_34380# 0.75507f
C4524 sar_ctrl_async_phys_0.sg13g2_buf_1_2.A sar_ctrl_async_phys_0.sg13g2_nor2b_1_1.B_N 0.04768f
C4525 sar_ctrl_async_phys_0.cmp_n VDD 6.82098f
C4526 a_36056_38224# VDD 0.21706f
C4527 a_33530_39921# a_33973_39677# 0.02242f
C4528 sar_ctrl_async_phys_0.sg13g2_nor2_1_5.B sar_ctrl_async_phys_0.sg13g2_dlygate4sd3_1_1.X 0.01664f
C4529 sar_ctrl_async_phys_0.sg13g2_nand3b_1_0.Y a_29258_36642# 0.07536f
C4530 oa_sar8_acore18_opt_0.sw_bitcell_opt_term_0.trkb a_35948_n9612# 0.80047f
C4531 a_32120_38318# VDD 0.16675f
C4532 a_35391_33261# a_36058_32900# 0.0894f
C4533 sar_ctrl_async_phys_0.bit_active[0] sar_ctrl_async_phys_0.bit_active[4] 0.01616f
C4534 sar_ctrl_async_phys_0.bit_active[2] sar_ctrl_async_phys_0.bit_active[3] 0.13753f
C4535 sar_ctrl_async_phys_0.sg13g2_a21oi_1_7.Y a_31841_36285# 0.01543f
C4536 sar_ctrl_async_phys_0.sg13g2_buf_1_2.X a_29749_32117# 0.06321f
C4537 a_30507_35204# VDD 0.85801f
C4538 a_34904_46508# sar_ctrl_async_phys_0.dac_code_n[1] 0.09529f
C4539 sar_ctrl_async_phys_0.dac_code[3] oa_sar8_acore18_opt_0.sw_bitcell_opt_term_0.gb 0.19973f
C4540 w_16692_n9960# VDD 1.20674f
C4541 sar_ctrl_async_phys_0.dac_code[7] oa_sar8_acore18_opt_0.sw_bitcell_opt_b3_0.bot 0.30298f
C4542 a_32251_35284# a_32991_35239# 0.26905f
C4543 sar_ctrl_async_phys_0.sg13g2_a21oi_1_4.B1 a_33675_43020# 0.04524f
C4544 oa_sar8_acore18_opt_0.sw_bitcell_opt_b0_0.bot m3_57896_n2380# 1.5154f
C4545 a_35391_34773# done 0.014f
C4546 sar_ctrl_async_phys_0.sg13g2_a22oi_1_0.A1 a_34324_36349# 0.01646f
C4547 sar_ctrl_async_phys_0.sg13g2_buf_1_13.X sar_ctrl_async_phys_0.sg13g2_nor2_1_13.Y 0.27036f
C4548 sar_ctrl_async_phys_0.sg13g2_buf_1_2.X a_35418_31668# 0.01807f
C4549 a_34055_31352# a_34615_31475# 0.26905f
C4550 sar_ctrl_async_phys_0.sg13g2_buf_1_6.A a_35360_36894# 0.03746f
C4551 sar_ctrl_async_phys_0.sg13g2_dfrbpq_1_9.RESET_B a_32576_44454# 0.10826f
C4552 sar_ctrl_async_phys_0.sg13g2_nor2_1_1.Y a_33844_43488# 0.04483f
C4553 sar_ctrl_async_phys_0.sg13g2_a21oi_1_0.B1 sar_ctrl_async_phys_0.sg13g2_a22oi_1_0.A1 0.16336f
C4554 oa_sar8_acore18_opt_0.sw_bitcell_opt_b4_0.bot a_35948_n9612# 0.04172f
C4555 sar_ctrl_async_phys_0.sg13g2_dfrbpq_1_22.D a_31716_38912# 0.25488f
C4556 sar_ctrl_async_phys_0.sg13g2_a21oi_1_1.B1 sar_ctrl_async_phys_0.sg13g2_dfrbpq_1_2.Q 0.01945f
C4557 a_34136_47296# sar_ctrl_async_phys_0.sg13g2_nor4_1_0.C 0.01535f
C4558 sar_ctrl_async_phys_0.sg13g2_dfrbpq_1_0.CLK a_32991_45357# 0.02359f
C4559 a_35245_42242# VDD 0.24013f
C4560 sar_ctrl_async_phys_0.sg13g2_nand2_1_3.B a_33276_42686# 0.03395f
C4561 oa_sar8_acore18_opt_0.sw_bitcell_opt_b1_0.bot oa_sar8_acore18_opt_0.sw_bitcell_opt_term_0.bot 0.37848f
C4562 sar_ctrl_async_phys_0.sg13g2_nor2_1_6.A a_29048_40546# 0.03945f
C4563 sar_ctrl_async_phys_0.sg13g2_nor2_1_1.A sar_ctrl_async_phys_0.sg13g2_buf_1_2.A 0.1122f
C4564 sar_ctrl_async_phys_0.sg13g2_nand2_1_2.B sar_ctrl_async_phys_0.sg13g2_nand2_1_2.Y 0.24642f
C4565 a_30676_40016# VDD 0.07223f
C4566 a_30879_43845# a_30785_43845# 0.28931f
C4567 sar_ctrl_async_phys_0.sg13g2_nor2_1_2.Y a_34042_40460# 0.02153f
C4568 sar_ctrl_async_phys_0.sg13g2_a21oi_1_6.A2 a_32666_45969# 0.03786f
C4569 sar_ctrl_async_phys_0.sg13g2_nand2b_1_1.Y a_34596_40424# 0.03997f
C4570 a_33252_36642# VDD 0.23747f
C4571 sar_ctrl_async_phys_0.dac_code_n[6] oa_sar8_acore18_opt_0.sw_bitcell_opt_b4_1.bot 0.06598f
C4572 sar_ctrl_async_phys_0.sample oa_sar8_acore18_opt_0.sw_tg_opt_0.bot 2.11094f
C4573 a_30480_32986# VDD 0.07899f
C4574 a_28950_39386# a_29653_38959# 0.02432f
C4575 a_33109_45725# a_33857_45823# 0.01058f
C4576 sar_ctrl_async_phys_0.sg13g2_nor2_1_1.Y a_33626_41433# 0.01371f
C4577 result[4] result[3] 0.15032f
C4578 result[7] result[6] 0.10732f
C4579 a_30772_31392# VDD 0.07224f
C4580 sar_ctrl_async_phys_0.sg13g2_a22oi_1_0.B1 sar_ctrl_async_phys_0.sg13g2_buf_1_25.A 0.46714f
C4581 a_35288_33688# VDD 0.22015f
C4582 sar_ctrl_async_phys_0.sg13g2_nor2_1_12.B a_28651_39740# 0.05509f
C4583 sar_ctrl_async_phys_0.sg13g2_nor2_1_5.Y sar_ctrl_async_phys_0.sg13g2_nand3b_1_0.Y 0.08458f
C4584 oa_sar8_acore18_opt_0.sw_bitcell_opt_term_0.trkb oa_sar8_acore18_opt_0.sw_bitcell_opt_b4_1.bot 1.46626f
C4585 oa_sar8_acore18_opt_0.sw_bitcell_opt_b6_1.bot VDD 4.42027f
C4586 sar_ctrl_async_phys_0.sg13g2_a22oi_1_0.B1 a_30331_33772# 0.04744f
C4587 sar_ctrl_async_phys_0.sg13g2_buf_1_2.A a_30676_35928# 0.40363f
C4588 sar_ctrl_async_phys_0.sg13g2_nor2_1_5.B VDD 0.74359f
C4589 a_32991_45357# a_32897_45357# 0.28931f
C4590 sar_ctrl_async_phys_0.sg13g2_buf_1_0.A a_34808_35200# 0.01787f
C4591 sar_ctrl_async_phys_0.sg13g2_dfrbpq_1_0.CLK a_32192_36166# 0.03239f
C4592 sar_ctrl_async_phys_0.sg13g2_buf_1_8.A a_32443_32260# 0.0118f
C4593 sar_ctrl_async_phys_0.sg13g2_nor2_1_13.Y a_25496_42854# 0.01072f
C4594 sar_ctrl_async_phys_0.sg13g2_a21oi_1_0.A1 a_35211_37436# 0.04082f
C4595 a_29498_40428# a_29524_40464# 0.36952f
C4596 a_36056_46508# sar_ctrl_async_phys_0.sg13g2_buf_1_44.A 0.26281f
C4597 sar_ctrl_async_phys_0.cmp_n a_26184_21025# 1.17508f
C4598 a_31140_42690# sar_ctrl_async_phys_0.sg13g2_and2_1_5.X 0.27188f
C4599 a_30938_46476# a_31381_46519# 0.02242f
C4600 sar_ctrl_async_phys_0.sg13g2_a22oi_1_2.A2 sar_ctrl_async_phys_0.sg13g2_inv_1_2.Y 0.23256f
C4601 sar_ctrl_async_phys_0.sg13g2_nor2b_1_4.Y sar_ctrl_async_phys_0.sg13g2_a22oi_1_1.A2 0.06288f
C4602 sar_ctrl_async_phys_0.sg13g2_nor4_1_0.C a_34520_46508# 0.01082f
C4603 sar_ctrl_async_phys_0.sg13g2_a22oi_1_1.A2 a_32251_35284# 0.01134f
C4604 sar_ctrl_async_phys_0.sg13g2_a21oi_1_7.Y a_30676_35928# 0.03267f
C4605 sar_ctrl_async_phys_0.dac_code[6] oa_sar8_acore18_opt_0.sw_tg_opt_0.bot 0.92346f
C4606 sar_ctrl_async_phys_0.dac_code[7] oa_sar8_acore18_opt_0.sw_bitcell_opt_term_0.bot 0.11923f
C4607 sar_ctrl_async_phys_0.sg13g2_a21oi_1_1.B1 sar_ctrl_async_phys_0.sg13g2_a21oi_1_1.Y 0.3255f
C4608 sar_ctrl_async_phys_0.sg13g2_o21ai_1_1.B1 a_30650_39921# 0.26863f
C4609 a_31446_35162# a_32251_35284# 0.097f
C4610 a_31732_35480# a_32149_35141# 0.3749f
C4611 sar_ctrl_async_phys_0.sg13g2_a22oi_1_1.A2 sar_ctrl_async_phys_0.sg13g2_a21oi_1_7.A2 1.11536f
C4612 sar_ctrl_async_phys_0.sg13g2_a21oi_1_7.Y a_31195_39820# 0.02524f
C4613 sar_ctrl_async_phys_0.sg13g2_dfrbpq_1_0.CLK sar_ctrl_async_phys_0.sg13g2_a22oi_1_0.Y 0.54201f
C4614 sar_ctrl_async_phys_0.sg13g2_a22oi_1_0.A1 a_33750_36362# 0.04032f
C4615 a_33936_31675# a_34268_31826# 0.10373f
C4616 sar_ctrl_async_phys_0.dac_code_n[2] a_35672_46508# 0.01969f
C4617 sar_ctrl_async_phys_0.sg13g2_buf_1_4.A a_35211_37436# 0.08898f
C4618 a_27504_36010# VDD 0.08336f
C4619 sar_ctrl_async_phys_0.sg13g2_dfrbpq_1_9.RESET_B sar_ctrl_async_phys_0.sg13g2_buf_1_3.A 0.79125f
C4620 oa_sar8_acore18_opt_0.sw_bitcell_opt_term_1.bot VDD 3.79006f
C4621 sar_ctrl_async_phys_0.sg13g2_dfrbpq_1_0.CLK a_31706_44964# 0.03073f
C4622 a_33948_41936# VDD 0.22602f
C4623 sar_ctrl_async_phys_0.sg13g2_and2_1_0.B a_36336_36010# 0.01383f
C4624 sar_ctrl_async_phys_0.sg13g2_buf_1_34.A sar_ctrl_async_phys_0.dac_code_n[6] 2.6097f
C4625 sar_ctrl_async_phys_0.sg13g2_buf_1_23.A a_35672_35200# 0.26686f
C4626 sar_ctrl_async_phys_0.dac_code_n[6] oa_sar8_acore18_opt_0.sw_bitcell_opt_b7_0.bot 2.0842f
C4627 sar_ctrl_async_phys_0.sg13g2_a22oi_1_0.A1 a_33844_36992# 0.01173f
C4628 sar_ctrl_async_phys_0.sg13g2_nor2_1_12.B VDD 0.65601f
C4629 sar_ctrl_async_phys_0.dac_code_n[3] sar_ctrl_async_phys_0.sg13g2_buf_1_34.A 0.02971f
C4630 a_34208_45966# VDD 0.16922f
C4631 sar_ctrl_async_phys_0.dac_code_n[3] oa_sar8_acore18_opt_0.sw_bitcell_opt_b7_0.bot 2.23254f
C4632 sar_ctrl_async_phys_0.sg13g2_a22oi_1_0.B2 result[1] 0.94713f
C4633 sar_ctrl_async_phys_0.sg13g2_a22oi_1_0.Y a_34895_32460# 0.17766f
C4634 sar_ctrl_async_phys_0.sg13g2_nor2_1_1.Y sar_ctrl_async_phys_0.sg13g2_dfrbpq_1_2.Q 0.50463f
C4635 a_28662_41214# a_28774_41278# 0.55452f
C4636 a_33940_44552# VDD 0.07243f
C4637 sar_ctrl_async_phys_0.sg13g2_buf_1_23.A a_34308_37400# 0.29991f
C4638 sar_ctrl_async_phys_0.sg13g2_buf_1_3.A sar_ctrl_async_phys_0.sg13g2_buf_1_5.A 0.01611f
C4639 sar_ctrl_async_phys_0.sg13g2_nor2b_1_0.A a_33652_41528# 0.012f
C4640 sar_ctrl_async_phys_0.sg13g2_buf_1_14.A a_34896_40546# 0.01948f
C4641 a_32192_36166# a_32602_35924# 0.10373f
C4642 a_33440_32358# a_33850_32436# 0.10373f
C4643 oa_sar8_acore18_opt_0.sw_bitcell_opt_term_0.trkb oa_sar8_acore18_opt_0.sw_bitcell_opt_b7_0.bot 1.5146f
C4644 sar_ctrl_async_phys_0.dac_code[5] m3_41836_n2380# 0.04394f
C4645 sar_ctrl_async_phys_0.dac_code[1] oa_sar8_acore18_opt_0.sw_bitcell_opt_term_0.VSS 1.00987f
C4646 sar_ctrl_async_phys_0.sg13g2_buf_1_25.A sar_ctrl_async_phys_0.sg13g2_buf_1_8.A 1.19421f
C4647 sar_ctrl_async_phys_0.sg13g2_nor2_1_11.Y sar_ctrl_async_phys_0.sg13g2_a21oi_1_4.A2 0.01805f
C4648 sar_ctrl_async_phys_0.sg13g2_buf_1_2.A sar_ctrl_async_phys_0.sg13g2_a22oi_1_0.B1 0.07823f
C4649 sar_ctrl_async_phys_0.hold_req sar_ctrl_async_phys_0.dac_code[1] 0.12491f
C4650 sar_ctrl_async_phys_0.sg13g2_nor2_1_0.A a_32116_37861# 0.02772f
C4651 sar_ctrl_async_phys_0.sg13g2_nor4_1_0.C sar_ctrl_async_phys_0.sg13g2_buf_1_13.X 0.02513f
C4652 sar_ctrl_async_phys_0.sg13g2_nor4_1_0.C sar_ctrl_async_phys_0.sg13g2_buf_1_13.A 0.01184f
C4653 sar_ctrl_async_phys_0.sg13g2_buf_1_3.A sar_ctrl_async_phys_0.sg13g2_a22oi_1_0.A2 0.12713f
C4654 sar_ctrl_async_phys_0.sg13g2_a21oi_1_0.B1 sar_ctrl_async_phys_0.sg13g2_nand2_1_3.A 1.62365f
C4655 sar_ctrl_async_phys_0.sg13g2_nor4_1_0.C sar_ctrl_async_phys_0.sg13g2_and2_1_2.X 0.08119f
C4656 sar_ctrl_async_phys_0.sg13g2_a22oi_1_1.A2 a_32580_43448# 0.04587f
C4657 sar_ctrl_async_phys_0.sg13g2_nor2_1_2.Y sar_ctrl_async_phys_0.sg13g2_a22oi_1_2.A2 0.01988f
C4658 sar_ctrl_async_phys_0.sg13g2_a22oi_1_1.A2 sar_ctrl_async_phys_0.sg13g2_dfrbpq_1_9.D 0.23059f
C4659 sar_ctrl_async_phys_0.sg13g2_nand2_1_2.B a_35456_44454# 0.03075f
C4660 sar_ctrl_async_phys_0.sg13g2_dfrbpq_1_9.RESET_B sar_ctrl_async_phys_0.sg13g2_buf_1_20.A 0.13193f
C4661 sar_ctrl_async_phys_0.sg13g2_a21oi_1_6.A2 a_32715_43020# 0.10207f
C4662 oa_sar8_acore18_opt_0.sw_bitcell_opt_b2_1.bot oa_sar8_acore18_opt_0.sw_bitcell_opt_b7_1.VSS 1.62509f
C4663 a_35280_35365# VDD 0.38681f
C4664 oa_sar8_acore18_opt_0.sw_bitcell_opt_b7_0.bot oa_sar8_acore18_opt_0.sw_bitcell_opt_b4_0.bot 1.23226f
C4665 oa_sar8_acore18_opt_0.sw_bitcell_opt_term_0.vin oa_sar8_acore18_opt_0.sw_bitcell_opt_b5_0.bot 4.11337f
C4666 sar_ctrl_async_phys_0.sg13g2_dfrbpq_1_0.CLK a_30390_39698# 0.01839f
C4667 sar_ctrl_async_phys_0.cmp_valid VDD 0.19667f
C4668 sar_ctrl_async_phys_0.sg13g2_nor2_1_11.Y sar_ctrl_async_phys_0.sg13g2_a22oi_1_5.A2 0.16257f
C4669 sar_ctrl_async_phys_0.sg13g2_dfrbpq_1_0.CLK a_32580_36642# 0.02917f
C4670 sar_ctrl_async_phys_0.sg13g2_a22oi_1_1.A2 sar_ctrl_async_phys_0.sg13g2_inv_1_1.A 0.06807f
C4671 sar_ctrl_async_phys_0.sg13g2_a22oi_1_0.B2 result[2] 0.403f
C4672 sar_ctrl_async_phys_0.sg13g2_a21oi_1_7.Y sar_ctrl_async_phys_0.sg13g2_a22oi_1_0.B1 0.04134f
C4673 a_32576_44454# VDD 0.16911f
C4674 sar_ctrl_async_phys_0.sg13g2_dfrbpq_1_0.CLK a_34904_33688# 0.04678f
C4675 a_35672_47296# sar_ctrl_async_phys_0.dac_code_n[2] 0.08923f
C4676 sar_ctrl_async_phys_0.dac_code[6] m3_48572_n2380# 0.05582f
C4677 oa_sar8_acore18_opt_0.bstrap_opt_w2_c1200_1.gb a_21332_n9711# 0.85251f
C4678 sar_ctrl_async_phys_0.sg13g2_dfrbpq_1_0.CLK sar_ctrl_async_phys_0.sg13g2_a22oi_1_1.B2 0.27582f
C4679 sar_ctrl_async_phys_0.sg13g2_buf_1_3.A sar_ctrl_async_phys_0.sg13g2_nor2b_1_0.A 0.02365f
C4680 sar_ctrl_async_phys_0.sg13g2_dfrbpq_1_0.CLK result[7] 0.17501f
C4681 oa_sar8_acore18_opt_0.sw_bitcell_opt_term_0.gb vinn 1.71556f
C4682 sar_ctrl_async_phys_0.sg13g2_buf_1_2.X a_32031_31749# 0.14685f
C4683 a_31189_31399# a_31937_31749# 0.01058f
C4684 sar_ctrl_async_phys_0.sg13g2_a21oi_1_6.B1 sar_ctrl_async_phys_0.sg13g2_nand2_1_3.B 0.23677f
C4685 sar_ctrl_async_phys_0.sg13g2_a21oi_1_5.B1 sar_ctrl_async_phys_0.sg13g2_nor2_1_2.Y 0.15144f
C4686 sar_ctrl_async_phys_0.sg13g2_a21oi_1_6.B1 sar_ctrl_async_phys_0.sg13g2_nand2b_1_1.Y 0.27946f
C4687 a_29048_40546# VDD 0.15207f
C4688 sar_ctrl_async_phys_0.sg13g2_nor4_1_0.Y a_28130_40838# 0.02895f
C4689 oa_sar8_acore18_opt_0.sw_tg_opt_0.bot a_30632_22281# 0.8059f
C4690 sar_ctrl_async_phys_0.sg13g2_a21oi_1_1.B1 sar_ctrl_async_phys_0.sg13g2_buf_1_22.A 0.02693f
C4691 sar_ctrl_async_phys_0.sg13g2_nand2_1_1.Y sar_ctrl_async_phys_0.dac_code[5] 0.01893f
C4692 sar_ctrl_async_phys_0.sg13g2_inv_1_0.A sar_ctrl_async_phys_0.sg13g2_a22oi_1_0.B2 0.0249f
C4693 a_33359_32876# VDD 0.30334f
C4694 sar_ctrl_async_phys_0.sg13g2_nand3_1_0.C sar_ctrl_async_phys_0.sg13g2_nand3_1_0.Y 0.01089f
C4695 sar_ctrl_async_phys_0.sg13g2_a21oi_1_6.B1 sar_ctrl_async_phys_0.sg13g2_nand2b_1_2.Y 0.51569f
C4696 sar_ctrl_async_phys_0.sg13g2_buf_1_2.X sar_ctrl_async_phys_0.sg13g2_a22oi_1_0.Y 0.01839f
C4697 sar_ctrl_async_phys_0.sample sar_ctrl_async_phys_0.cmp_fire 10.0366f
C4698 sar_ctrl_async_phys_0.sg13g2_buf_1_6.A a_36056_38948# 0.0538f
C4699 sar_ctrl_async_phys_0.sg13g2_a21oi_1_0.A1 sar_ctrl_async_phys_0.sg13g2_a21oi_1_7.Y 0.48048f
C4700 oa_sar8_acore18_opt_0.sw_bitcell_opt_b3_1.bot oa_sar8_acore18_opt_0.bstrap_opt_w2_c1200_1.gb 0.65061f
C4701 sar_ctrl_async_phys_0.sg13g2_and2_1_0.B a_34555_35935# 0.0303f
C4702 sar_ctrl_async_phys_0.sg13g2_buf_1_32.A a_34459_44356# 0.01347f
C4703 sar_ctrl_async_phys_0.sg13g2_a21oi_1_0.A1 a_30752_39190# 0.01127f
C4704 sar_ctrl_async_phys_0.sg13g2_dfrbpq_1_0.CLK sar_ctrl_async_phys_0.bit_active[0] 0.0245f
C4705 sar_ctrl_async_phys_0.dac_code_n[1] sar_ctrl_async_phys_0.dac_code_n[6] 0.33928f
C4706 sar_ctrl_async_phys_0.sg13g2_nand2_1_2.B sar_ctrl_async_phys_0.sg13g2_nand2_1_3.B 0.06784f
C4707 sar_ctrl_async_phys_0.sg13g2_nand2b_1_1.Y sar_ctrl_async_phys_0.sg13g2_nand2_1_2.B 0.02709f
C4708 sar_ctrl_async_phys_0.sg13g2_nand2_1_1.B sar_ctrl_async_phys_0.sg13g2_a21oi_1_3.A2 0.03792f
C4709 sar_ctrl_async_phys_0.sg13g2_nor2_1_2.A a_33818_36897# 0.02001f
C4710 sar_ctrl_async_phys_0.sg13g2_buf_1_2.A sar_ctrl_async_phys_0.sg13g2_buf_1_4.A 0.39423f
C4711 sar_ctrl_async_phys_0.dac_code_n[1] sar_ctrl_async_phys_0.dac_code_n[3] 0.13701f
C4712 a_31802_37404# a_31828_37440# 0.36952f
C4713 sar_ctrl_async_phys_0.sg13g2_buf_1_2.A sar_ctrl_async_phys_0.sg13g2_and2_1_0.B 0.04166f
C4714 a_33652_41528# VDD 0.07206f
C4715 sar_ctrl_async_phys_0.sg13g2_inv_1_9.Y sar_ctrl_async_phys_0.sg13g2_nand2b_1_0.A_N 0.01986f
C4716 sar_ctrl_async_phys_0.sg13g2_nand2_1_2.A a_34261_43495# 0.03125f
C4717 sar_ctrl_async_phys_0.sg13g2_nand2_1_2.B a_35009_43845# 0.01968f
C4718 oa_sar8_acore18_opt_0.sw_bitcell_opt_b1_1.bot oa_sar8_acore18_opt_0.sw_bitcell_opt_b3_1.bot 0.43214f
C4719 oa_sar8_acore18_opt_0.sw_bitcell_opt_b0_1.bot oa_sar8_acore18_opt_0.sw_bitcell_opt_b4_1.bot 1.25674f
C4720 sar_ctrl_async_phys_0.sg13g2_a21oi_1_0.B1 a_35360_43726# 0.04279f
C4721 sar_ctrl_async_phys_0.dac_code_n[1] oa_sar8_acore18_opt_0.sw_bitcell_opt_term_0.trkb 1.83055f
C4722 a_31093_35935# a_30964_36349# 0.01562f
C4723 a_30676_35928# a_31195_35935# 0.34102f
C4724 sar_ctrl_async_phys_0.sg13g2_a21oi_1_1.B1 sar_ctrl_async_phys_0.dac_code_n[0] 0.32134f
C4725 a_32223_46869# a_32129_46869# 0.28931f
C4726 sar_ctrl_async_phys_0.dac_code[3] oa_sar8_acore18_opt_0.sw_bitcell_opt_b3_0.bot 1.92328f
C4727 a_34549_30605# result[1] 0.01939f
C4728 a_26662_41278# VDD 0.19027f
C4729 sar_ctrl_async_phys_0.sg13g2_buf_1_6.A sar_ctrl_async_phys_0.bit_active[3] 0.14096f
C4730 sar_ctrl_async_phys_0.sg13g2_nor2_1_11.Y a_30037_43495# 0.01934f
C4731 sar_ctrl_async_phys_0.dac_code[6] sar_ctrl_async_phys_0.dac_code[5] 5.54865f
C4732 sar_ctrl_async_phys_0.sg13g2_buf_1_2.A sar_ctrl_async_phys_0.sg13g2_buf_1_8.A 0.03657f
C4733 sar_ctrl_async_phys_0.sg13g2_dfrbpq_1_0.CLK sar_ctrl_async_phys_0.sg13g2_dfrbpq_1_11.D 0.38451f
C4734 a_31706_44964# a_32149_45007# 0.02242f
C4735 sar_ctrl_async_phys_0.sg13g2_buf_1_3.A a_33080_30664# 0.09188f
C4736 sar_ctrl_async_phys_0.sg13g2_nor2_1_0.A a_31828_37440# 0.03266f
C4737 sar_ctrl_async_phys_0.sg13g2_nor2b_1_0.A sar_ctrl_async_phys_0.sg13g2_buf_1_20.A 0.12923f
C4738 sar_ctrl_async_phys_0.sg13g2_buf_1_5.A sar_ctrl_async_phys_0.sg13g2_buf_1_9.A 1.30069f
C4739 sar_ctrl_async_phys_0.dac_code_n[6] vcm 0.06598f
C4740 sar_ctrl_async_phys_0.sg13g2_a21oi_1_1.B1 sar_ctrl_async_phys_0.sg13g2_a21oi_1_0.B1 0.05957f
C4741 oa_sar8_acore18_opt_0.sw_bitcell_opt_b6_1.bot oa_sar8_acore18_opt_0.sw_bitcell_opt_b7_1.VSS 2.29885f
C4742 oa_sar8_acore18_opt_0.sw_bitcell_opt_b7_0.bot oa_sar8_acore18_opt_0.sw_bitcell_opt_b0_0.bot 0.96897f
C4743 oa_sar8_acore18_opt_0.sw_bitcell_opt_term_0.vin oa_sar8_acore18_opt_0.sw_bitcell_opt_b1_0.bot 3.87886f
C4744 a_34904_38224# sar_ctrl_async_phys_0.sg13g2_a22oi_1_0.A1 0.24845f
C4745 sar_ctrl_async_phys_0.dac_code_n[3] vcm 0.06598f
C4746 a_34651_30748# a_35391_30703# 0.26905f
C4747 sar_ctrl_async_phys_0.dac_code_n[1] oa_sar8_acore18_opt_0.sw_bitcell_opt_b4_0.bot 0.08527f
C4748 sar_ctrl_async_phys_0.sg13g2_dfrbpq_1_0.CLK sar_ctrl_async_phys_0.sg13g2_nor2_1_11.A 0.52154f
C4749 sar_ctrl_async_phys_0.sg13g2_nor4_1_0.C a_32116_40464# 0.02041f
C4750 w_16692_n9960# oa_sar8_acore18_opt_0.sw_bitcell_opt_b2_1.bot 0.05461f
C4751 a_31195_39820# a_31935_39775# 0.26905f
C4752 sar_ctrl_async_phys_0.sg13g2_o21ai_1_1.B1 a_30043_40471# 0.47241f
C4753 sar_ctrl_async_phys_0.sg13g2_a22oi_1_0.Y sar_ctrl_async_phys_0.sg13g2_inv_1_2.A 0.09025f
C4754 sar_ctrl_async_phys_0.sg13g2_buf_1_3.A sar_ctrl_async_phys_0.sg13g2_nor2b_1_3.Y 0.01243f
C4755 a_34106_32868# a_34132_32904# 0.36952f
C4756 oa_sar8_acore18_opt_0.sw_bitcell_opt_term_0.trkb vcm 3.3216f
C4757 sar_ctrl_async_phys_0.dac_code_n[4] oa_sar8_acore18_opt_0.sw_bitcell_opt_term_0.gb 0.17205f
C4758 sar_ctrl_async_phys_0.sg13g2_buf_1_32.A a_34363_43495# 0.04306f
C4759 sar_ctrl_async_phys_0.sg13g2_buf_1_44.A a_35786_45750# 0.01479f
C4760 a_36056_47296# sar_ctrl_async_phys_0.cmp_valid 0.01098f
C4761 sar_ctrl_async_phys_0.sg13g2_a22oi_1_0.A1 sar_ctrl_async_phys_0.sg13g2_inv_1_2.Y 0.02866f
C4762 sar_ctrl_async_phys_0.sg13g2_o21ai_1_1.B1 a_33109_45725# 0.03459f
C4763 sar_ctrl_async_phys_0.sg13g2_a22oi_1_5.A2 a_30964_39711# 0.01834f
C4764 sar_ctrl_async_phys_0.sg13g2_buf_1_3.A VDD 1.62416f
C4765 sar_ctrl_async_phys_0.sg13g2_nor2b_1_0.A sar_ctrl_async_phys_0.sg13g2_nand2_1_1.B 0.03451f
C4766 sar_ctrl_async_phys_0.sg13g2_nor2b_1_0.A a_31802_37404# 0.02744f
C4767 sar_ctrl_async_phys_0.dac_code[0] sar_ctrl_async_phys_0.dac_code[1] 5.73647f
C4768 sar_ctrl_async_phys_0.dac_code[2] oa_sar8_acore18_opt_0.sw_bitcell_opt_b5_0.bot 0.78403f
C4769 sar_ctrl_async_phys_0.sg13g2_a21oi_1_1.B1 sar_ctrl_async_phys_0.sg13g2_o21ai_1_1.B1 0.01322f
C4770 oa_sar8_acore18_opt_0.sw_bitcell_opt_term_0.vin m3_51760_n2380# 0.05057f
C4771 sar_ctrl_async_phys_0.sg13g2_nand2_1_3.A sar_ctrl_async_phys_0.sg13g2_buf_1_6.A 0.01528f
C4772 a_32888_43570# VDD 0.13457f
C4773 sar_ctrl_async_phys_0.sg13g2_buf_1_3.A sar_ctrl_async_phys_0.sg13g2_buf_1_35.A 0.54936f
C4774 a_36056_38948# sar_ctrl_async_phys_0.sg13g2_buf_1_21.A 0.01667f
C4775 sar_ctrl_async_phys_0.sg13g2_buf_1_2.X a_30746_31356# 0.24345f
C4776 w_39600_n9960# sar_ctrl_async_phys_0.dac_code[6] 0.02212f
C4777 sar_ctrl_async_phys_0.sg13g2_and2_1_2.X a_27134_39887# 0.01135f
C4778 a_29498_40428# VDD 0.09696f
C4779 sar_ctrl_async_phys_0.sg13g2_nor4_1_0.C sar_ctrl_async_phys_0.sg13g2_a22oi_1_2.A2 0.01797f
C4780 sar_ctrl_async_phys_0.sg13g2_buf_1_35.A a_32888_43570# 0.01753f
C4781 sar_ctrl_async_phys_0.sg13g2_buf_1_2.X sar_ctrl_async_phys_0.sg13g2_a22oi_1_1.B2 0.08954f
C4782 sar_ctrl_async_phys_0.sg13g2_a22oi_1_1.B2 a_33080_31388# 0.09928f
C4783 oa_sar8_acore18_opt_0.sw_bitcell_opt_b7_1.bot oa_sar8_acore18_opt_0.bstrap_opt_w2_c1200_1.gb 0.98095f
C4784 sar_ctrl_async_phys_0.sg13g2_a21oi_1_4.B1 sar_ctrl_async_phys_0.sg13g2_buf_1_32.A 0.02231f
C4785 sar_ctrl_async_phys_0.cmp_fire sar_ctrl_async_phys_0.sg13g2_dlygate4sd3_1_5.A 0.26989f
C4786 sar_ctrl_async_phys_0.sg13g2_nor2_1_7.B sar_ctrl_async_phys_0.sg13g2_nor2_1_3.B 0.02512f
C4787 sar_ctrl_async_phys_0.sg13g2_buf_1_13.A a_33281_40821# 0.01106f
C4788 sar_ctrl_async_phys_0.sg13g2_a21oi_1_6.B1 a_33844_43488# 0.01064f
C4789 sar_ctrl_async_phys_0.dac_code[4] oa_sar8_acore18_opt_0.sw_bitcell_opt_term_0.VSS 1.21829f
C4790 sar_ctrl_async_phys_0.dac_code[1] VDD 4.12641f
C4791 a_27134_39887# track 0.05148f
C4792 a_35288_33688# done 0.2475f
C4793 sar_ctrl_async_phys_0.sg13g2_dfrbpq_1_0.CLK a_34808_35200# 0.0388f
C4794 sar_ctrl_async_phys_0.sg13g2_nor2b_1_0.A sar_ctrl_async_phys_0.sg13g2_nor2_1_0.A 0.19133f
C4795 sar_ctrl_async_phys_0.dac_code_n[0] oa_sar8_acore18_opt_0.sw_tg_opt_1.bot 0.09046f
C4796 sar_ctrl_async_phys_0.sg13g2_and2_1_2.X a_26270_39215# 0.05694f
C4797 sar_ctrl_async_phys_0.sg13g2_dfrbpq_1_0.CLK sar_ctrl_async_phys_0.sg13g2_nor2_1_0.Y 0.19437f
C4798 sar_ctrl_async_phys_0.hold_req sar_ctrl_async_phys_0.dac_code[4] 0.10808f
C4799 sar_ctrl_async_phys_0.sg13g2_a21oi_1_1.Y sar_ctrl_async_phys_0.sg13g2_inv_1_0.A 0.01587f
C4800 sar_ctrl_async_phys_0.sg13g2_buf_1_35.A sar_ctrl_async_phys_0.dac_code[1] 0.63007f
C4801 oa_sar8_acore18_opt_0.sw_bitcell_opt_term_1.bot oa_sar8_acore18_opt_0.sw_bitcell_opt_b7_1.VSS 1.40447f
C4802 oa_sar8_acore18_opt_0.sw_bitcell_opt_b1_1.bot oa_sar8_acore18_opt_0.sw_bitcell_opt_b7_1.bot 1.15779f
C4803 oa_sar8_acore18_opt_0.sw_bitcell_opt_b2_1.bot oa_sar8_acore18_opt_0.sw_bitcell_opt_b6_1.bot 0.51912f
C4804 oa_sar8_acore18_opt_0.sw_bitcell_opt_b3_1.bot oa_sar8_acore18_opt_0.sw_bitcell_opt_b5_1.bot 0.83733f
C4805 sar_ctrl_async_phys_0.dac_code[0] sar_ctrl_async_phys_0.sg13g2_buf_1_20.A 0.04984f
C4806 sar_ctrl_async_phys_0.sg13g2_buf_1_2.A a_32347_37447# 0.43933f
C4807 sar_ctrl_async_phys_0.sg13g2_nor2_1_1.Y sar_ctrl_async_phys_0.sg13g2_buf_1_22.A 0.01536f
C4808 sar_ctrl_async_phys_0.sg13g2_a21oi_1_3.A2 sar_ctrl_async_phys_0.sg13g2_buf_1_23.A 0.3225f
C4809 sar_ctrl_async_phys_0.sg13g2_nand2_1_2.B a_33844_43488# 0.0294f
C4810 sar_ctrl_async_phys_0.sg13g2_buf_1_4.A a_34261_36653# 0.01879f
C4811 sar_ctrl_async_phys_0.sg13g2_a22oi_1_1.A2 sar_ctrl_async_phys_0.sg13g2_buf_1_22.A 0.02881f
C4812 sar_ctrl_async_phys_0.dac_code_n[2] oa_sar8_acore18_opt_0.sw_bitcell_opt_term_0.VSS 0.0453f
C4813 sar_ctrl_async_phys_0.sg13g2_dfrbpq_1_0.CLK a_32319_44311# 0.02262f
C4814 sar_ctrl_async_phys_0.dac_code[7] oa_sar8_acore18_opt_0.sw_bitcell_opt_term_0.vin 2.6753f
C4815 sar_ctrl_async_phys_0.dac_code[3] oa_sar8_acore18_opt_0.sw_bitcell_opt_term_0.bot 0.16685f
C4816 sar_ctrl_async_phys_0.sg13g2_dlygate4sd3_1_1.X sar_ctrl_async_phys_0.sg13g2_dlygate4sd3_1_0.X 0.01248f
C4817 a_30390_36362# a_30650_35892# 0.75507f
C4818 a_31898_32361# a_32341_32117# 0.02242f
C4819 a_31638_32138# a_31924_32456# 0.41329f
C4820 sar_ctrl_async_phys_0.hold_req sar_ctrl_async_phys_0.dac_code_n[2] 0.05309f
C4821 sar_ctrl_async_phys_0.dac_code[1] oa_sar8_acore18_opt_0.sw_bitcell_opt_b6_0.bot 1.17468f
C4822 sar_ctrl_async_phys_0.sg13g2_dfrbpq_1_0.CLK a_34261_43495# 0.25542f
C4823 sar_ctrl_async_phys_0.sg13g2_nor4_1_0.C sar_ctrl_async_phys_0.sg13g2_a21oi_1_5.B1 0.06136f
C4824 sar_ctrl_async_phys_0.sg13g2_buf_1_20.A VDD 0.48765f
C4825 sar_ctrl_async_phys_0.sg13g2_buf_1_13.A sar_ctrl_async_phys_0.bit_active[6] 0.06843f
C4826 sar_ctrl_async_phys_0.sg13g2_dfrbpq_1_0.CLK a_28782_40460# 0.0145f
C4827 sar_ctrl_async_phys_0.sg13g2_buf_1_2.A a_34651_32911# 0.03026f
C4828 sar_ctrl_async_phys_0.sg13g2_a22oi_1_0.B2 a_35463_31435# 0.01363f
C4829 a_35000_45878# VDD 0.138f
C4830 sar_ctrl_async_phys_0.sg13g2_buf_1_23.A sar_ctrl_async_phys_0.sg13g2_a22oi_1_0.A2 0.04071f
C4831 a_31933_43832# sar_ctrl_async_phys_0.sg13g2_nor2b_1_0.A 0.01177f
C4832 sar_ctrl_async_phys_0.sg13g2_buf_1_35.A sar_ctrl_async_phys_0.sg13g2_buf_1_20.A 0.31213f
C4833 sar_ctrl_async_phys_0.dac_code_n[1] oa_sar8_acore18_opt_0.sw_bitcell_opt_b0_0.bot 0.06248f
C4834 sar_ctrl_async_phys_0.sg13g2_inv_1_3.Y sar_ctrl_async_phys_0.sg13g2_inv_1_2.Y 0.01815f
C4835 sar_ctrl_async_phys_0.sg13g2_inv_1_2.A sar_ctrl_async_phys_0.sg13g2_a22oi_1_1.B2 0.05943f
C4836 sar_ctrl_async_phys_0.sg13g2_nor2b_1_3.Y sar_ctrl_async_phys_0.sg13g2_nand2_1_1.B 0.07326f
C4837 sar_ctrl_async_phys_0.sg13g2_a22oi_1_1.Y a_31258_32436# 0.04643f
C4838 a_34106_30849# a_34549_30605# 0.02242f
C4839 a_33846_30626# a_34132_30944# 0.41329f
C4840 oa_sar8_acore18_opt_0.bstrap_opt_w2_c1200_1.out oa_sar8_acore18_opt_0.bstrap_opt_w2_c1200_1.gb 9.06338f
C4841 a_30390_39698# a_31093_39677# 0.02454f
C4842 sar_ctrl_async_phys_0.sg13g2_nor2b_1_0.A sar_ctrl_async_phys_0.sg13g2_and2_1_5.X 0.39287f
C4843 sar_ctrl_async_phys_0.sg13g2_buf_1_9.A a_33080_30664# 0.26497f
C4844 sar_ctrl_async_phys_0.sg13g2_nor2b_1_0.A sar_ctrl_async_phys_0.sg13g2_buf_1_16.A 0.02714f
C4845 sar_ctrl_async_phys_0.sg13g2_nand2_1_0.B a_29084_38484# 0.01398f
C4846 sar_ctrl_async_phys_0.sg13g2_nor4_1_0.C sar_ctrl_async_phys_0.sg13g2_dlygate4sd3_1_4.A 0.03669f
C4847 sar_ctrl_async_phys_0.sg13g2_nand2_1_1.B VDD 0.48709f
C4848 a_31802_37404# VDD 0.09647f
C4849 a_35199_44311# a_35105_44311# 0.28931f
C4850 oa_sar8_acore18_opt_0.sw_bitcell_opt_term_1.bot oa_sar8_acore18_opt_0.sw_bitcell_opt_b2_1.bot 0.36121f
C4851 oa_sar8_acore18_opt_0.bstrap_opt_w2_c1200_1.out oa_sar8_acore18_opt_0.sw_bitcell_opt_b1_1.bot 3.90438f
C4852 sar_ctrl_async_phys_0.dac_code_n[4] sar_ctrl_async_phys_0.sg13g2_buf_1_44.A 0.53274f
C4853 sar_ctrl_async_phys_0.dac_code[2] oa_sar8_acore18_opt_0.sw_bitcell_opt_b1_0.bot 0.15621f
C4854 a_28368_36877# sar_ctrl_async_phys_0.sg13g2_dlygate4sd3_1_1.X 0.18369f
C4855 sar_ctrl_async_phys_0.dac_code_n[5] sar_ctrl_async_phys_0.dac_code_n[6] 11.5154f
C4856 a_25680_39034# VDD 0.06935f
C4857 sar_ctrl_async_phys_0.sg13g2_buf_1_13.X sar_ctrl_async_phys_0.sg13g2_a21oi_1_2.A2 0.27861f
C4858 sar_ctrl_async_phys_0.sg13g2_a22oi_1_5.A2 a_31195_39820# 0.01203f
C4859 sar_ctrl_async_phys_0.cmp_fire a_30632_22281# 0.85224f
C4860 sar_ctrl_async_phys_0.sg13g2_nor2b_1_4.Y sar_ctrl_async_phys_0.sg13g2_nor2_1_11.Y 0.14456f
C4861 sar_ctrl_async_phys_0.dac_code_n[5] sar_ctrl_async_phys_0.dac_code_n[3] 0.17891f
C4862 sar_ctrl_async_phys_0.sg13g2_nor2b_1_0.A sar_ctrl_async_phys_0.sg13g2_buf_1_23.A 0.03946f
C4863 a_34615_31475# result[3] 0.01244f
C4864 a_30746_31356# a_31189_31399# 0.02242f
C4865 sar_ctrl_async_phys_0.sg13g2_a21oi_1_1.B1 sar_ctrl_async_phys_0.sg13g2_buf_1_6.A 0.15149f
C4866 sar_ctrl_async_phys_0.sg13g2_dfrbpq_1_0.CLK sar_ctrl_async_phys_0.sg13g2_a22oi_1_2.B1 0.77812f
C4867 sar_ctrl_async_phys_0.dac_code_n[5] oa_sar8_acore18_opt_0.sw_bitcell_opt_term_0.trkb 2.03605f
C4868 sar_ctrl_async_phys_0.sg13g2_a21oi_1_6.A2 a_33211_45868# 0.01403f
C4869 a_34106_32868# VDD 0.09606f
C4870 sar_ctrl_async_phys_0.sg13g2_a21oi_1_5.B1 a_34904_46508# 0.02845f
C4871 sar_ctrl_async_phys_0.sg13g2_nor2_1_0.A VDD 0.46215f
C4872 sar_ctrl_async_phys_0.sg13g2_a22oi_1_0.B1 sar_ctrl_async_phys_0.sg13g2_inv_1_1.Y 0.01256f
C4873 sar_ctrl_async_phys_0.sg13g2_dlygate4sd3_1_0.X VDD 0.36113f
C4874 sar_ctrl_async_phys_0.sg13g2_inv_1_0.Y result[3] 0.04437f
C4875 sar_ctrl_async_phys_0.sg13g2_o21ai_1_1.B1 sar_ctrl_async_phys_0.sg13g2_nor2_1_1.Y 0.90426f
C4876 a_26174_42911# sar_ctrl_async_phys_0.sg13g2_dlygate4sd3_1_6.X 0.15862f
C4877 sar_ctrl_async_phys_0.sg13g2_buf_1_9.A VDD 0.68104f
C4878 sar_ctrl_async_phys_0.sg13g2_a21oi_1_5.B1 a_33558_43922# 0.0251f
C4879 oa_sar8_acore18_opt_0.sw_bitcell_opt_b5_1.bot oa_sar8_acore18_opt_0.sw_bitcell_opt_b7_1.bot 1.18965f
C4880 sar_ctrl_async_phys_0.dac_code[2] m3_51760_n2380# 0.04372f
C4881 sar_ctrl_async_phys_0.sg13g2_a22oi_1_5.Y a_30591_32215# 0.04629f
C4882 sar_ctrl_async_phys_0.sg13g2_nor2b_1_1.B_N a_34424_35200# 0.01679f
C4883 sar_ctrl_async_phys_0.sg13g2_o21ai_1_1.B1 sar_ctrl_async_phys_0.sg13g2_a22oi_1_1.A2 0.30295f
C4884 sar_ctrl_async_phys_0.sg13g2_buf_1_20.A sar_ctrl_async_phys_0.sg13g2_a21oi_1_0.A2 0.02353f
C4885 sar_ctrl_async_phys_0.dac_code_n[1] oa_sar8_acore18_opt_0.sw_bitcell_opt_b0_1.bot 0.11923f
C4886 w_16692_n9960# oa_sar8_acore18_opt_0.sw_bitcell_opt_term_1.bot 0.17968f
C4887 a_34236_46472# sar_ctrl_async_phys_0.sg13g2_a21oi_1_0.B1 0.01488f
C4888 sar_ctrl_async_phys_0.sg13g2_a22oi_1_1.A2 a_32792_41342# 0.01103f
C4889 a_32116_40464# a_33281_40821# 0.43239f
C4890 a_32404_40885# a_32635_40471# 0.12701f
C4891 sar_ctrl_async_phys_0.sg13g2_buf_1_2.A a_32245_37447# 0.04205f
C4892 a_30331_33772# a_31071_33727# 0.26905f
C4893 sar_ctrl_async_phys_0.sg13g2_a21oi_1_0.A1 a_35288_38224# 0.01728f
C4894 sar_ctrl_async_phys_0.sg13g2_a21oi_1_4.B1 sar_ctrl_async_phys_0.sg13g2_nand2_1_2.Y 0.10148f
C4895 sar_ctrl_async_phys_0.sg13g2_a22oi_1_3.A2 a_33652_41528# 0.05282f
C4896 sar_ctrl_async_phys_0.dac_code_n[5] oa_sar8_acore18_opt_0.sw_bitcell_opt_b4_0.bot 0.24514f
C4897 sar_ctrl_async_phys_0.dac_code[1] oa_sar8_acore18_opt_0.sw_bitcell_opt_b2_0.bot 0.51157f
C4898 sar_ctrl_async_phys_0.dac_code_n[1] a_35948_n9612# 0.0499f
C4899 sar_ctrl_async_phys_0.sg13g2_o21ai_1_1.A2 sar_ctrl_async_phys_0.sg13g2_nor2_1_3.B 0.03003f
C4900 a_31933_43832# VDD 0.38759f
C4901 sar_ctrl_async_phys_0.sg13g2_buf_1_2.A a_34549_32911# 0.01444f
C4902 sar_ctrl_async_phys_0.sg13g2_dfrbpq_1_17.D a_30486_31826# 0.28382f
C4903 sar_ctrl_async_phys_0.sg13g2_and2_1_5.X sar_ctrl_async_phys_0.sg13g2_nor2b_1_3.Y 0.01727f
C4904 sar_ctrl_async_phys_0.sg13g2_nor2_1_10.Y a_29524_40464# 0.01117f
C4905 sar_ctrl_async_phys_0.sg13g2_nand2_1_0.B sar_ctrl_async_phys_0.sg13g2_nor2_1_5.Y 0.19665f
C4906 sar_ctrl_async_phys_0.sg13g2_nor2_1_3.B sar_ctrl_async_phys_0.sg13g2_nor2_1_3.A 0.18471f
C4907 sar_ctrl_async_phys_0.sg13g2_nor2_1_7.A a_28977_36864# 0.0177f
C4908 sar_ctrl_async_phys_0.sg13g2_dfrbpq_1_0.CLK sar_ctrl_async_phys_0.sg13g2_nand2b_1_0.Y 0.51543f
C4909 sar_ctrl_async_phys_0.dac_code[2] sar_ctrl_async_phys_0.dac_code[7] 0.18941f
C4910 sar_ctrl_async_phys_0.sg13g2_a21oi_1_7.A2 a_31947_41508# 0.07856f
C4911 a_31136_43726# a_31546_43484# 0.10373f
C4912 sar_ctrl_async_phys_0.sg13g2_nor2_1_0.Y a_32149_45007# 0.03505f
C4913 oa_sar8_acore18_opt_0.sw_tg_opt_0.bot oa_sar8_acore18_opt_0.sw_bitcell_opt_term_0.gb 0.14616f
C4914 sar_ctrl_async_phys_0.sg13g2_dlygate4sd3_1_4.A a_26673_40726# 0.01669f
C4915 sar_ctrl_async_phys_0.sg13g2_inv_1_9.Y a_26289_42912# 0.01976f
C4916 a_28368_36877# VDD 0.39164f
C4917 sar_ctrl_async_phys_0.dac_code[0] sar_ctrl_async_phys_0.dac_code[4] 0.19839f
C4918 sar_ctrl_async_phys_0.sg13g2_buf_1_2.A sar_ctrl_async_phys_0.sg13g2_buf_1_0.A 0.13487f
C4919 sar_ctrl_async_phys_0.sg13g2_dfrbpq_1_2.Q a_33556_40016# 0.01665f
C4920 sar_ctrl_async_phys_0.sg13g2_and2_1_5.X VDD 0.68609f
C4921 sar_ctrl_async_phys_0.sg13g2_buf_1_0.A a_34651_34423# 0.0655f
C4922 sar_ctrl_async_phys_0.sg13g2_a22oi_1_5.Y sar_ctrl_async_phys_0.sg13g2_inv_1_6.Y 0.14133f
C4923 sar_ctrl_async_phys_0.sg13g2_buf_1_16.A VDD 0.77909f
C4924 sar_ctrl_async_phys_0.sg13g2_a22oi_1_5.A2 sar_ctrl_async_phys_0.sg13g2_a22oi_1_0.B1 0.18135f
C4925 sar_ctrl_async_phys_0.sg13g2_nor2_1_0.Y a_32442_38484# 0.01676f
C4926 sar_ctrl_async_phys_0.sg13g2_nand2_1_3.A a_35199_44311# 0.03736f
C4927 sar_ctrl_async_phys_0.sg13g2_a22oi_1_0.A1 a_33754_37436# 0.01355f
C4928 sar_ctrl_async_phys_0.sg13g2_nor2_1_4.Y sar_ctrl_async_phys_0.sg13g2_nand3_1_0.A 0.23026f
C4929 sar_ctrl_async_phys_0.sg13g2_nand2_1_2.Y sar_ctrl_async_phys_0.sg13g2_nand2_1_3.Y 0.02506f
C4930 oa_sar8_acore18_opt_0.bstrap_opt_w2_c1200_1.out oa_sar8_acore18_opt_0.sw_bitcell_opt_b5_1.bot 4.17877f
C4931 oa_sar8_acore18_opt_0.sw_bitcell_opt_term_1.bot oa_sar8_acore18_opt_0.sw_bitcell_opt_b6_1.bot 0.66133f
C4932 sar_ctrl_async_phys_0.sg13g2_a21oi_1_4.A2 sar_ctrl_async_phys_0.sg13g2_a21oi_1_0.A1 0.21241f
C4933 sar_ctrl_async_phys_0.sg13g2_nor2_1_2.A a_34308_37400# 0.24903f
C4934 sar_ctrl_async_phys_0.dac_code_n[2] sar_ctrl_async_phys_0.dac_code[0] 0.08217f
C4935 a_33654_44234# a_34228_44247# 0.31978f
C4936 a_34459_44356# a_35456_44454# 0.02979f
C4937 sar_ctrl_async_phys_0.dac_code[4] VDD 4.91788f
C4938 sar_ctrl_async_phys_0.sg13g2_buf_1_23.A VDD 0.69068f
C4939 sar_ctrl_async_phys_0.sg13g2_inv_1_10.Y sar_ctrl_async_phys_0.sg13g2_nand2b_1_0.Y 0.01275f
C4940 sar_ctrl_async_phys_0.sg13g2_nor2_1_1.Y a_33530_39921# 0.0342f
C4941 a_34055_31352# result[3] 0.01361f
C4942 sar_ctrl_async_phys_0.sg13g2_a21oi_1_7.Y sar_ctrl_async_phys_0.sg13g2_inv_1_5.A 0.01187f
C4943 sar_ctrl_async_phys_0.sg13g2_buf_1_3.A sar_ctrl_async_phys_0.sg13g2_a22oi_1_3.A2 0.74254f
C4944 a_30296_42854# a_30480_42854# 0.0524f
C4945 sar_ctrl_async_phys_0.sg13g2_a22oi_1_1.A2 a_31832_34412# 0.01093f
C4946 sar_ctrl_async_phys_0.sg13g2_a21oi_1_7.Y sar_ctrl_async_phys_0.sg13g2_buf_1_0.A 0.02508f
C4947 sar_ctrl_async_phys_0.sg13g2_nand2_1_2.A sar_ctrl_async_phys_0.sg13g2_buf_1_44.A 0.48008f
C4948 a_35962_35924# a_36336_36010# 0.01061f
C4949 sar_ctrl_async_phys_0.sg13g2_nor2_1_6.A sar_ctrl_async_phys_0.sg13g2_nor2_1_10.Y 0.7876f
C4950 a_32696_30664# VDD 0.2891f
C4951 sar_ctrl_async_phys_0.sg13g2_a22oi_1_5.A2 sar_ctrl_async_phys_0.sg13g2_a21oi_1_0.A1 0.19883f
C4952 sar_ctrl_async_phys_0.dac_code_n[2] VDD 4.36118f
C4953 sar_ctrl_async_phys_0.sg13g2_nor2_1_10.B sar_ctrl_async_phys_0.sg13g2_buf_1_2.A 0.69501f
C4954 sar_ctrl_async_phys_0.sg13g2_o21ai_1_1.B1 sar_ctrl_async_phys_0.sg13g2_nor4_1_0.Y 0.04009f
C4955 sar_ctrl_async_phys_0.sg13g2_nand2_1_3.A sar_ctrl_async_phys_0.dac_code_n[7] 0.02436f
C4956 a_26558_40727# VDD 0.18854f
C4957 sar_ctrl_async_phys_0.sg13g2_dfrbpq_1_9.Q sar_ctrl_async_phys_0.sg13g2_nand2_1_2.A 0.28151f
C4958 sar_ctrl_async_phys_0.dac_code_n[2] sar_ctrl_async_phys_0.sg13g2_buf_1_35.A 0.01696f
C4959 sar_ctrl_async_phys_0.sg13g2_a21oi_1_0.B1 a_34596_40424# 0.02144f
C4960 sar_ctrl_async_phys_0.dac_code[4] oa_sar8_acore18_opt_0.sw_bitcell_opt_b6_0.bot 1.17468f
C4961 sar_ctrl_async_phys_0.sg13g2_buf_1_2.X sar_ctrl_async_phys_0.sg13g2_a22oi_1_2.B1 0.33025f
C4962 a_34904_38948# VDD 0.26428f
C4963 sar_ctrl_async_phys_0.sg13g2_nor2_1_1.Y sar_ctrl_async_phys_0.sg13g2_buf_1_6.A 0.01859f
C4964 a_31830_40898# a_32404_40885# 0.31978f
C4965 a_32116_40464# a_32533_40471# 0.37583f
C4966 sar_ctrl_async_phys_0.dac_code[0] a_36156_45710# 0.04333f
C4967 a_29526_33650# a_29812_33968# 0.41329f
C4968 sar_ctrl_async_phys_0.sg13g2_a22oi_1_1.A2 sar_ctrl_async_phys_0.sg13g2_buf_1_6.A 0.07119f
C4969 sar_ctrl_async_phys_0.dac_code_n[5] oa_sar8_acore18_opt_0.sw_bitcell_opt_b0_0.bot 0.08014f
C4970 sar_ctrl_async_phys_0.sg13g2_nand2b_1_2.Y sar_ctrl_async_phys_0.sg13g2_nand2b_1_3.Y 0.05948f
C4971 sar_ctrl_async_phys_0.dac_code_n[4] oa_sar8_acore18_opt_0.sw_bitcell_opt_b3_0.bot 0.0829f
C4972 sar_ctrl_async_phys_0.sg13g2_a22oi_1_0.A1 result[4] 0.04354f
C4973 sar_ctrl_async_phys_0.dac_code_n[2] oa_sar8_acore18_opt_0.sw_bitcell_opt_b6_0.bot 1.01149f
C4974 sar_ctrl_async_phys_0.sg13g2_o21ai_1_1.B1 a_33276_42686# 0.02079f
C4975 a_30591_32215# a_30848_32358# 0.34468f
C4976 a_29332_32456# a_30497_32215# 0.43239f
C4977 a_29851_32260# a_29620_32151# 0.12701f
C4978 sar_ctrl_async_phys_0.sg13g2_dfrbpq_1_0.CLK a_32443_32260# 0.04281f
C4979 sar_ctrl_async_phys_0.sg13g2_a22oi_1_1.A2 a_32251_45007# 0.0236f
C4980 sar_ctrl_async_phys_0.sg13g2_dfrbpq_1_9.RESET_B a_32991_45357# 0.13461f
C4981 sar_ctrl_async_phys_0.sg13g2_nand2b_1_2.Y a_34459_44356# 0.05149f
C4982 sar_ctrl_async_phys_0.sg13g2_nand2_1_3.B sar_ctrl_async_phys_0.sg13g2_a21oi_1_0.A1 0.57159f
C4983 a_36156_45710# VDD 0.2202f
C4984 sar_ctrl_async_phys_0.sg13g2_a21oi_1_1.Y a_34132_34416# 0.01136f
C4985 sar_ctrl_async_phys_0.sg13g2_nand2b_1_1.Y sar_ctrl_async_phys_0.sg13g2_a21oi_1_0.A1 0.90358f
C4986 sar_ctrl_async_phys_0.sg13g2_o21ai_1_1.B1 a_33375_40821# 0.17666f
C4987 sar_ctrl_async_phys_0.dac_code[2] a_36056_41972# 0.02711f
C4988 sar_ctrl_async_phys_0.sg13g2_buf_1_3.A a_32698_31388# 0.01809f
C4989 sar_ctrl_async_phys_0.sg13g2_dfrbpq_1_0.CLK a_34651_30748# 0.04225f
C4990 sar_ctrl_async_phys_0.sg13g2_nand2b_1_2.Y sar_ctrl_async_phys_0.sg13g2_a21oi_1_0.A1 0.14756f
C4991 sar_ctrl_async_phys_0.sg13g2_nor2_1_4.Y sar_ctrl_async_phys_0.sg13g2_nor2_1_3.B 0.04369f
C4992 sar_ctrl_async_phys_0.sg13g2_a22oi_1_0.A2 a_34363_36796# 0.02753f
C4993 a_36156_45710# sar_ctrl_async_phys_0.sg13g2_buf_1_35.A 0.25856f
C4994 a_30037_43495# a_30139_43495# 0.47795f
C4995 sar_ctrl_async_phys_0.sg13g2_a21oi_1_7.Y a_31071_33727# 0.02415f
C4996 sar_ctrl_async_phys_0.sg13g2_a22oi_1_2.A2 a_32533_40471# 0.03483f
C4997 a_35672_35200# sar_ctrl_async_phys_0.bit_active[0] 0.01136f
C4998 sar_ctrl_async_phys_0.sg13g2_nor2_1_12.A sar_ctrl_async_phys_0.sg13g2_o21ai_1_1.A2 0.10163f
C4999 oa_sar8_acore18_opt_0.sw_bitcell_opt_term_0.gb m3_48572_n2380# 1.52466f
C5000 a_33951_45823# a_34618_46044# 0.0894f
C5001 sar_ctrl_async_phys_0.sg13g2_buf_1_2.A result[6] 0.02768f
C5002 a_35552_36166# VDD 0.16971f
C5003 sar_ctrl_async_phys_0.sg13g2_a21oi_1_5.B1 sar_ctrl_async_phys_0.sg13g2_nand2_1_6.B 0.07764f
C5004 sar_ctrl_async_phys_0.sg13g2_a22oi_1_0.B1 result[5] 0.13735f
C5005 a_34911_41287# a_34817_41287# 0.28931f
C5006 sar_ctrl_async_phys_0.dac_code[3] oa_sar8_acore18_opt_0.sw_bitcell_opt_term_0.vin 1.79718f
C5007 sar_ctrl_async_phys_0.sg13g2_a22oi_1_0.A1 a_33850_32436# 0.01061f
C5008 sar_ctrl_async_phys_0.sg13g2_nor2_1_11.A a_31140_42690# 0.26818f
C5009 sar_ctrl_async_phys_0.sg13g2_buf_1_13.X sar_ctrl_async_phys_0.sg13g2_buf_1_26.X 0.37987f
C5010 a_33654_44234# a_34357_44213# 0.02454f
C5011 sar_ctrl_async_phys_0.sg13g2_dlygate4sd3_1_7.X sar_ctrl_async_phys_0.sg13g2_dlygate4sd3_1_8.A 0.02229f
C5012 a_35648_34654# VDD 0.17038f
C5013 sar_ctrl_async_phys_0.sg13g2_and2_1_2.X sar_ctrl_async_phys_0.sg13g2_buf_1_26.X 0.01539f
C5014 a_34815_39775# VDD 0.17454f
C5015 a_29749_32117# VDD 0.25358f
C5016 sar_ctrl_async_phys_0.sg13g2_a21oi_1_4.B1 sar_ctrl_async_phys_0.sg13g2_a22oi_1_5.A2 0.20621f
C5017 sar_ctrl_async_phys_0.dac_code_n[5] oa_sar8_acore18_opt_0.sw_bitcell_opt_b0_1.bot 0.06598f
C5018 sar_ctrl_async_phys_0.sg13g2_nor2b_1_3.Y sar_ctrl_async_phys_0.sg13g2_nor2_1_15.Y 0.1757f
C5019 sar_ctrl_async_phys_0.sg13g2_buf_1_7.A result[4] 0.05124f
C5020 sar_ctrl_async_phys_0.sg13g2_nor2_1_11.Y a_30714_43020# 0.01369f
C5021 sar_ctrl_async_phys_0.sg13g2_buf_1_26.X track 0.02666f
C5022 a_35552_36166# a_35295_36285# 0.34468f
C5023 sar_ctrl_async_phys_0.sg13g2_nand2b_1_0.A_N sar_ctrl_async_phys_0.sg13g2_and2_1_2.X 0.01256f
C5024 sar_ctrl_async_phys_0.dac_code_n[1] sar_ctrl_async_phys_0.sg13g2_buf_1_34.A 0.04131f
C5025 sar_ctrl_async_phys_0.dac_code[1] sar_ctrl_async_phys_0.cmp_n 0.07718f
C5026 sar_ctrl_async_phys_0.dac_code_n[1] oa_sar8_acore18_opt_0.sw_bitcell_opt_b7_0.bot 0.9807f
C5027 sar_ctrl_async_phys_0.dac_code[4] oa_sar8_acore18_opt_0.sw_bitcell_opt_b2_0.bot 0.1489f
C5028 sar_ctrl_async_phys_0.sg13g2_a21oi_1_1.B1 sar_ctrl_async_phys_0.dac_code_n[7] 0.03099f
C5029 sar_ctrl_async_phys_0.sg13g2_dfrbpq_1_0.CLK sar_ctrl_async_phys_0.sg13g2_nor2_1_7.B 0.58138f
C5030 sar_ctrl_async_phys_0.dac_code_n[5] a_35948_n9612# 0.0476f
C5031 sar_ctrl_async_phys_0.sg13g2_nor2_1_15.Y VDD 0.35127f
C5032 sar_ctrl_async_phys_0.sg13g2_nand2b_1_2.Y a_34363_43495# 0.04392f
C5033 a_35360_43726# a_35770_43484# 0.10373f
C5034 sar_ctrl_async_phys_0.sg13g2_a22oi_1_3.A2 sar_ctrl_async_phys_0.sg13g2_nor2_1_0.A 0.10319f
C5035 sar_ctrl_async_phys_0.sg13g2_buf_1_23.A a_34036_35928# 0.02392f
C5036 a_30495_39309# VDD 0.17399f
C5037 sar_ctrl_async_phys_0.sg13g2_dfrbpq_1_0.CLK sar_ctrl_async_phys_0.sg13g2_buf_1_25.A 0.14382f
C5038 sar_ctrl_async_phys_0.sg13g2_a22oi_1_3.A2 sar_ctrl_async_phys_0.sg13g2_buf_1_9.A 0.1073f
C5039 sar_ctrl_async_phys_0.sg13g2_dfrbpq_1_0.CLK sar_ctrl_async_phys_0.sg13g2_dfrbpq_1_9.Q 0.08935f
C5040 sar_ctrl_async_phys_0.dac_code_n[4] oa_sar8_acore18_opt_0.sw_bitcell_opt_term_0.bot 0.18779f
C5041 sar_ctrl_async_phys_0.dac_code[5] oa_sar8_acore18_opt_0.sw_bitcell_opt_term_0.gb 0.19615f
C5042 sar_ctrl_async_phys_0.dac_code_n[2] oa_sar8_acore18_opt_0.sw_bitcell_opt_b2_0.bot 0.0829f
C5043 sar_ctrl_async_phys_0.hold_req sar_ctrl_async_phys_0.sample 28.7208f
C5044 a_30043_40471# a_30783_40821# 0.26905f
C5045 sar_ctrl_async_phys_0.dac_code_n[0] oa_sar8_acore18_opt_0.sw_bitcell_opt_b5_0.bot 0.34793f
C5046 a_35648_34654# a_35391_34773# 0.34468f
C5047 sar_ctrl_async_phys_0.sg13g2_a21oi_1_4.B1 sar_ctrl_async_phys_0.sg13g2_nand2_1_3.B 0.14458f
C5048 sar_ctrl_async_phys_0.sg13g2_a21oi_1_4.B1 sar_ctrl_async_phys_0.sg13g2_nand2b_1_1.Y 0.02488f
C5049 a_26728_37416# VDD 0.0182f
C5050 a_33973_39677# a_33844_39711# 0.01562f
C5051 a_34815_39775# a_35072_39918# 0.34468f
C5052 sar_ctrl_async_phys_0.sg13g2_a21oi_1_6.A2 a_32980_45759# 0.01834f
C5053 a_33914_44457# a_33654_44234# 0.75507f
C5054 a_29749_32117# a_29851_32260# 0.47622f
C5055 sar_ctrl_async_phys_0.sg13g2_buf_1_0.A sar_ctrl_async_phys_0.sg13g2_dfrbpq_1_1.D 0.03623f
C5056 sar_ctrl_async_phys_0.sg13g2_dfrbpq_1_9.D a_31194_44996# 0.01284f
C5057 sar_ctrl_async_phys_0.sg13g2_nand2b_1_1.Y a_34171_41332# 0.02939f
C5058 sar_ctrl_async_phys_0.sg13g2_dfrbpq_1_9.RESET_B a_32223_46869# 0.13297f
C5059 sar_ctrl_async_phys_0.sg13g2_a21oi_1_4.B1 sar_ctrl_async_phys_0.sg13g2_nand2b_1_2.Y 0.06704f
C5060 sar_ctrl_async_phys_0.sg13g2_a22oi_1_1.A2 a_31446_45434# 0.02318f
C5061 sar_ctrl_async_phys_0.sg13g2_buf_1_7.A a_33850_32436# 0.01871f
C5062 sar_ctrl_async_phys_0.sg13g2_a21oi_1_5.B1 sar_ctrl_async_phys_0.dac_code_n[3] 0.52612f
C5063 sar_ctrl_async_phys_0.sg13g2_dfrbpq_1_9.RESET_B a_31706_44964# 0.26379f
C5064 sar_ctrl_async_phys_0.sg13g2_dlygate4sd3_1_9.X a_27032_39034# 0.0312f
C5065 sar_ctrl_async_phys_0.sg13g2_o21ai_1_1.B1 a_32090_40428# 0.2648f
C5066 sar_ctrl_async_phys_0.sg13g2_a21oi_1_3.A2 sar_ctrl_async_phys_0.sg13g2_nand2_1_1.Y 0.71048f
C5067 a_34357_44213# a_34261_43495# 0.02581f
C5068 sar_ctrl_async_phys_0.sg13g2_buf_1_2.X a_32443_32260# 0.4235f
C5069 sar_ctrl_async_phys_0.sg13g2_a21oi_1_1.Y sar_ctrl_async_phys_0.sg13g2_nor2b_1_1.B_N 0.20583f
C5070 a_36056_32176# result[6] 0.24535f
C5071 sar_ctrl_async_phys_0.sg13g2_nand2_1_2.A sar_ctrl_async_phys_0.sg13g2_buf_1_32.A 0.23361f
C5072 sar_ctrl_async_phys_0.sg13g2_buf_1_5.A sar_ctrl_async_phys_0.sg13g2_a22oi_1_0.Y 0.01804f
C5073 a_29334_43922# a_30037_43495# 0.02432f
C5074 sar_ctrl_async_phys_0.dac_code_n[4] m3_38288_n2380# 0.04834f
C5075 a_25990_40484# a_25878_40460# 0.55452f
C5076 sar_ctrl_async_phys_0.sg13g2_a22oi_1_0.A1 sar_ctrl_async_phys_0.sg13g2_a22oi_1_5.Y 0.30596f
C5077 sar_ctrl_async_phys_0.sg13g2_buf_1_2.X a_34651_30748# 0.4276f
C5078 a_34767_31359# a_35557_31435# 0.02242f
C5079 sar_ctrl_async_phys_0.dac_code_n[4] oa_sar8_acore18_opt_0.bstrap_opt_w2_c1200_1.gb 0.12881f
C5080 sar_ctrl_async_phys_0.sg13g2_a21oi_1_6.B1 sar_ctrl_async_phys_0.dac_code_n[0] 0.02733f
C5081 a_36336_45082# VDD 0.05621f
C5082 a_34010_35892# VDD 0.097f
C5083 sar_ctrl_async_phys_0.sg13g2_nor4_1_0.C a_28176_39830# 0.01267f
C5084 sar_ctrl_async_phys_0.sg13g2_nand2_1_3.B sar_ctrl_async_phys_0.sg13g2_nand2_1_3.Y 0.15854f
C5085 sar_ctrl_async_phys_0.sg13g2_nand2_1_0.Y sar_ctrl_async_phys_0.sg13g2_nor2_1_7.Y 0.46908f
C5086 sar_ctrl_async_phys_0.dac_code[6] oa_sar8_acore18_opt_0.sw_bitcell_opt_term_0.VSS 1.42606f
C5087 sar_ctrl_async_phys_0.sg13g2_nand2b_1_1.Y sar_ctrl_async_phys_0.sg13g2_nand2_1_3.Y 0.07605f
C5088 a_33366_41210# a_33940_41223# 0.31978f
C5089 sar_ctrl_async_phys_0.sg13g2_and2_1_5.X sar_ctrl_async_phys_0.sg13g2_a22oi_1_3.A2 0.01453f
C5090 a_34171_41332# a_35168_41430# 0.02979f
C5091 sar_ctrl_async_phys_0.sg13g2_buf_1_8.A result[5] 0.64965f
C5092 w_39600_n9960# oa_sar8_acore18_opt_0.sw_bitcell_opt_term_0.gb 3.49667f
C5093 sar_ctrl_async_phys_0.sg13g2_a22oi_1_3.A2 sar_ctrl_async_phys_0.sg13g2_buf_1_16.A 0.03168f
C5094 sar_ctrl_async_phys_0.sg13g2_a22oi_1_0.A2 sar_ctrl_async_phys_0.sg13g2_a22oi_1_0.Y 0.17864f
C5095 sar_ctrl_async_phys_0.sg13g2_a22oi_1_1.Y a_31291_31399# 0.01018f
C5096 sar_ctrl_async_phys_0.sg13g2_a22oi_1_0.Y a_34132_32904# 0.02068f
C5097 sar_ctrl_async_phys_0.dac_code_n[5] oa_sar8_acore18_opt_0.sw_bitcell_opt_b4_1.bot 0.10447f
C5098 sar_ctrl_async_phys_0.sg13g2_nand2b_1_2.Y sar_ctrl_async_phys_0.sg13g2_nand2_1_3.Y 0.90011f
C5099 sar_ctrl_async_phys_0.hold_req sar_ctrl_async_phys_0.dac_code[6] 0.12355f
C5100 sar_ctrl_async_phys_0.dac_code_n[4] oa_sar8_acore18_opt_0.sw_bitcell_opt_b1_1.bot 0.06598f
C5101 a_33846_34850# VDD 0.78151f
C5102 a_32984_39830# VDD 0.12983f
C5103 a_29306_32361# a_29332_32456# 0.36952f
C5104 sar_ctrl_async_phys_0.dac_code_n[7] oa_sar8_acore18_opt_0.sw_tg_opt_1.bot 0.07362f
C5105 sar_ctrl_async_phys_0.sg13g2_nor2_1_10.Y VDD 0.4158f
C5106 sar_ctrl_async_phys_0.sg13g2_a21oi_1_3.A2 sar_ctrl_async_phys_0.dac_code[6] 0.30728f
C5107 sar_ctrl_async_phys_0.dac_code[4] m3_45264_n2380# 0.0553f
C5108 a_34363_36796# VDD 0.20509f
C5109 sar_ctrl_async_phys_0.sg13g2_a21oi_1_6.B1 sar_ctrl_async_phys_0.sg13g2_a21oi_1_0.B1 0.27388f
C5110 a_32319_44311# a_32986_44532# 0.0894f
C5111 a_31477_44213# a_32225_44311# 0.01058f
C5112 a_25496_31388# sar_ctrl_async_phys_0.cmp_p 0.26592f
C5113 sar_ctrl_async_phys_0.sg13g2_nor2b_1_0.A a_32888_36806# 0.02019f
C5114 a_30495_39309# a_31162_38948# 0.0894f
C5115 sar_ctrl_async_phys_0.sg13g2_nor2_1_3.A sar_ctrl_async_phys_0.sg13g2_nor2_1_3.Y 0.09199f
C5116 sar_ctrl_async_phys_0.sg13g2_buf_1_14.A sar_ctrl_async_phys_0.bit_active[5] 0.03379f
C5117 a_34453_35935# a_34555_35935# 0.47795f
C5118 sar_ctrl_async_phys_0.sg13g2_nor2b_1_1.B_N sar_ctrl_async_phys_0.bit_active[2] 0.19166f
C5119 sar_ctrl_async_phys_0.sg13g2_nor2b_1_4.Y a_30139_43495# 0.01003f
C5120 sar_ctrl_async_phys_0.sg13g2_a22oi_1_0.A2 sar_ctrl_async_phys_0.sg13g2_nor2_1_2.A 0.08477f
C5121 sar_ctrl_async_phys_0.sg13g2_nor2_1_6.A a_29328_39830# 0.01988f
C5122 sar_ctrl_async_phys_0.sg13g2_buf_1_13.X sar_ctrl_async_phys_0.sg13g2_a21oi_1_2.B1 0.01774f
C5123 sar_ctrl_async_phys_0.sg13g2_nand2_1_3.B sar_ctrl_async_phys_0.sg13g2_buf_1_14.A 0.18148f
C5124 sar_ctrl_async_phys_0.sg13g2_buf_1_13.A sar_ctrl_async_phys_0.sg13g2_a21oi_1_2.B1 0.01596f
C5125 sar_ctrl_async_phys_0.dac_code[2] sar_ctrl_async_phys_0.dac_code[3] 1.39146f
C5126 sar_ctrl_async_phys_0.sg13g2_nand2b_1_1.Y sar_ctrl_async_phys_0.sg13g2_buf_1_14.A 0.04126f
C5127 sar_ctrl_async_phys_0.sg13g2_a21oi_1_0.B1 sar_ctrl_async_phys_0.sg13g2_nand2_1_2.B 0.93477f
C5128 sar_ctrl_async_phys_0.sg13g2_nor2_1_0.A a_32120_38318# 0.02171f
C5129 oa_sar8_acore18_opt_0.sw_tg_opt_0.bot oa_sar8_acore18_opt_0.sw_bitcell_opt_b3_0.bot 3.26795f
C5130 sar_ctrl_async_phys_0.sg13g2_buf_1_2.A a_34453_35935# 0.03538f
C5131 sar_ctrl_async_phys_0.bit_active[6] sar_ctrl_async_phys_0.sg13g2_a22oi_1_0.A1 0.04257f
C5132 sar_ctrl_async_phys_0.sg13g2_nand2b_1_2.Y sar_ctrl_async_phys_0.sg13g2_buf_1_14.A 0.0196f
C5133 a_33844_43488# a_34363_43495# 0.34102f
C5134 a_34261_43495# a_34132_43909# 0.01562f
C5135 sar_ctrl_async_phys_0.sg13g2_nand2_1_3.Y a_35168_41430# 0.02721f
C5136 sar_ctrl_async_phys_0.sg13g2_a22oi_1_0.B1 sar_ctrl_async_phys_0.sg13g2_a22oi_1_0.B2 0.08475f
C5137 sar_ctrl_async_phys_0.sg13g2_nor2_1_0.Y a_32406_45746# 0.2868f
C5138 sar_ctrl_async_phys_0.sg13g2_buf_1_13.X a_31352_36806# 0.04125f
C5139 sar_ctrl_async_phys_0.sg13g2_buf_1_13.X sar_ctrl_async_phys_0.sg13g2_dfrbpq_1_22.D 0.12689f
C5140 sar_ctrl_async_phys_0.sg13g2_dfrbpq_1_0.CLK a_34555_35935# 0.04856f
C5141 sar_ctrl_async_phys_0.dac_code[0] m3_41836_n2380# 0.05621f
C5142 sar_ctrl_async_phys_0.dac_code_n[2] oa_sar8_acore18_opt_0.sw_bitcell_opt_b7_1.VSS 1.045f
C5143 a_27800_41342# VDD 0.13633f
C5144 sar_ctrl_async_phys_0.sg13g2_a21oi_1_0.B1 a_33556_40016# 0.02425f
C5145 sar_ctrl_async_phys_0.sg13g2_a21oi_1_6.B1 sar_ctrl_async_phys_0.sg13g2_o21ai_1_1.B1 0.78167f
C5146 sar_ctrl_async_phys_0.sg13g2_nor2b_1_4.Y sar_ctrl_async_phys_0.sg13g2_a21oi_1_0.A1 0.05213f
C5147 sar_ctrl_async_phys_0.dac_code_n[0] oa_sar8_acore18_opt_0.sw_bitcell_opt_b1_0.bot 0.18225f
C5148 a_34765_45266# VDD 0.24155f
C5149 sar_ctrl_async_phys_0.sg13g2_buf_1_3.A a_33948_41936# 0.27532f
C5150 sar_ctrl_async_phys_0.sg13g2_buf_1_2.A a_34106_34380# 0.27021f
C5151 a_32991_45357# VDD 0.17442f
C5152 sar_ctrl_async_phys_0.sg13g2_dfrbpq_1_0.CLK sar_ctrl_async_phys_0.sg13g2_buf_1_2.A 0.19271f
C5153 a_34132_34416# a_34420_34837# 0.43707f
C5154 sar_ctrl_async_phys_0.sg13g2_dfrbpq_1_0.CLK a_34651_34423# 0.03909f
C5155 a_33973_39677# a_34075_39820# 0.47622f
C5156 sar_ctrl_async_phys_0.sg13g2_buf_1_3.A a_34208_45966# 0.02877f
C5157 sar_ctrl_async_phys_0.sg13g2_buf_1_2.X sar_ctrl_async_phys_0.sg13g2_buf_1_25.A 0.75026f
C5158 sar_ctrl_async_phys_0.sg13g2_dfrbpq_1_0.CLK a_29332_32456# 0.07766f
C5159 oa_sar8_acore18_opt_0.sw_bitcell_opt_term_0.trkb m3_54868_n2380# 0.03859f
C5160 sar_ctrl_async_phys_0.sg13g2_a22oi_1_0.B1 a_32687_32876# 0.05919f
C5161 a_35360_36894# a_35770_36972# 0.10373f
C5162 m3_41836_n2380# VDD 0.02576f
C5163 sar_ctrl_async_phys_0.sg13g2_buf_1_3.A a_33940_44552# 0.03261f
C5164 sar_ctrl_async_phys_0.sg13g2_buf_1_2.X a_30331_33772# 0.42115f
C5165 sar_ctrl_async_phys_0.sg13g2_buf_1_6.A a_35201_36285# 0.01622f
C5166 sar_ctrl_async_phys_0.sg13g2_a21oi_1_0.A1 sar_ctrl_async_phys_0.sg13g2_a21oi_1_7.A2 0.18293f
C5167 sar_ctrl_async_phys_0.sg13g2_a21oi_1_5.B1 sar_ctrl_async_phys_0.sg13g2_nand2b_1_7.A_N 0.01583f
C5168 a_33072_42854# VDD 0.07655f
C5169 sar_ctrl_async_phys_0.dac_code_n[1] vcm 0.06635f
C5170 sar_ctrl_async_phys_0.sg13g2_buf_1_5.A sar_ctrl_async_phys_0.sg13g2_a22oi_1_1.B2 0.02567f
C5171 sar_ctrl_async_phys_0.sg13g2_dfrbpq_1_0.CLK a_34767_31359# 0.27256f
C5172 sar_ctrl_async_phys_0.sg13g2_nor2_1_2.Y sar_ctrl_async_phys_0.sg13g2_nor2_1_1.Y 0.14951f
C5173 sar_ctrl_async_phys_0.sg13g2_o21ai_1_1.B1 a_33556_40016# 0.374f
C5174 sar_ctrl_async_phys_0.sg13g2_dfrbpq_1_0.CLK sar_ctrl_async_phys_0.sg13g2_nor2_1_3.A 0.01204f
C5175 sar_ctrl_async_phys_0.sg13g2_buf_1_35.A a_33072_42854# 0.01185f
C5176 sar_ctrl_async_phys_0.sg13g2_nand2_1_3.B a_33085_43832# 0.03477f
C5177 sar_ctrl_async_phys_0.sg13g2_dfrbpq_1_2.Q sar_ctrl_async_phys_0.sg13g2_nand2b_1_3.Y 0.16631f
C5178 sar_ctrl_async_phys_0.sg13g2_inv_1_3.Y a_31924_32456# 0.02095f
C5179 sar_ctrl_async_phys_0.sg13g2_buf_1_6.A a_35297_34773# 0.01131f
C5180 a_32991_35239# a_33658_35460# 0.0894f
C5181 a_31732_35480# a_32020_35175# 0.43707f
C5182 sar_ctrl_async_phys_0.sg13g2_buf_1_6.A a_35952_39901# 0.16405f
C5183 sar_ctrl_async_phys_0.sg13g2_dfrbpq_1_0.CLK sar_ctrl_async_phys_0.sg13g2_a21oi_1_7.Y 0.18063f
C5184 a_34636_31749# a_35557_31435# 0.36952f
C5185 a_32192_36166# VDD 0.16923f
C5186 sar_ctrl_async_phys_0.dac_code_n[5] sar_ctrl_async_phys_0.sg13g2_buf_1_34.A 0.03806f
C5187 sar_ctrl_async_phys_0.sg13g2_dfrbpq_1_0.CLK sar_ctrl_async_phys_0.sg13g2_buf_1_32.A 0.01293f
C5188 sar_ctrl_async_phys_0.dac_code_n[5] oa_sar8_acore18_opt_0.sw_bitcell_opt_b7_0.bot 1.76276f
C5189 sar_ctrl_async_phys_0.sg13g2_nor4_1_0.C sar_ctrl_async_phys_0.sg13g2_a21oi_1_1.B1 3.48057f
C5190 sar_ctrl_async_phys_0.sg13g2_a22oi_1_0.A1 a_29812_33968# 0.0136f
C5191 sar_ctrl_async_phys_0.sg13g2_buf_1_13.X sar_ctrl_async_phys_0.sg13g2_dlygate4sd3_1_4.X 0.17844f
C5192 a_33366_41210# a_34069_41189# 0.02454f
C5193 sar_ctrl_async_phys_0.sg13g2_nor2b_1_0.A a_30390_36362# 0.04183f
C5194 a_34651_32911# result[5] 0.01518f
C5195 sar_ctrl_async_phys_0.sg13g2_a22oi_1_0.A2 result[7] 0.16956f
C5196 sar_ctrl_async_phys_0.sg13g2_a22oi_1_1.Y a_30486_31826# 0.05306f
C5197 sar_ctrl_async_phys_0.sg13g2_inv_1_10.Y sar_ctrl_async_phys_0.sg13g2_o21ai_1_1.A2 0.22839f
C5198 sar_ctrl_async_phys_0.sg13g2_and2_1_2.X sar_ctrl_async_phys_0.sg13g2_dlygate4sd3_1_4.X 0.70072f
C5199 sar_ctrl_async_phys_0.dac_code[4] sar_ctrl_async_phys_0.cmp_n 0.07718f
C5200 sar_ctrl_async_phys_0.sg13g2_buf_1_26.X a_25496_31388# 0.25068f
C5201 sar_ctrl_async_phys_0.dac_code_n[2] oa_sar8_acore18_opt_0.sw_bitcell_opt_b2_1.bot 1.30837f
C5202 sar_ctrl_async_phys_0.sg13g2_nand2_1_2.A sar_ctrl_async_phys_0.sg13g2_nand2_1_2.Y 0.31839f
C5203 sar_ctrl_async_phys_0.sg13g2_a22oi_1_5.Y sar_ctrl_async_phys_0.sg13g2_dfrbpq_1_17.D 0.062f
C5204 sar_ctrl_async_phys_0.sg13g2_a21oi_1_0.A1 sar_ctrl_async_phys_0.sg13g2_dfrbpq_1_2.Q 0.62265f
C5205 sar_ctrl_async_phys_0.sg13g2_buf_1_16.A a_30507_35204# 0.15192f
C5206 sar_ctrl_async_phys_0.sg13g2_nor2_1_5.B sar_ctrl_async_phys_0.sg13g2_dlygate4sd3_1_0.X 0.09681f
C5207 sar_ctrl_async_phys_0.sg13g2_o21ai_1_1.B1 a_29653_38959# 0.04488f
C5208 sar_ctrl_async_phys_0.sg13g2_buf_1_0.A a_34520_33688# 0.01158f
C5209 a_32192_39918# VDD 0.16997f
C5210 sar_ctrl_async_phys_0.sg13g2_a21oi_1_7.Y a_31640_41342# 0.01132f
C5211 sar_ctrl_async_phys_0.sg13g2_a22oi_1_5.A2 sar_ctrl_async_phys_0.sg13g2_inv_1_5.A 0.01799f
C5212 sar_ctrl_async_phys_0.sg13g2_a22oi_1_5.A2 sar_ctrl_async_phys_0.sg13g2_buf_1_0.A 0.05151f
C5213 sar_ctrl_async_phys_0.sg13g2_buf_1_13.X sar_ctrl_async_phys_0.sg13g2_inv_1_9.Y 0.13939f
C5214 a_32888_36806# VDD 0.13665f
C5215 oa_sar8_acore18_opt_0.sw_bitcell_opt_term_0.vin vinn 0.73522f
C5216 a_33344_37678# a_33754_37436# 0.10373f
C5217 sar_ctrl_async_phys_0.sg13g2_dlygate4sd3_1_4.X track 1.36804f
C5218 sar_ctrl_async_phys_0.sample VDD 4.33512f
C5219 sar_ctrl_async_phys_0.sg13g2_inv_1_2.A sar_ctrl_async_phys_0.sg13g2_buf_1_25.A 0.01957f
C5220 sar_ctrl_async_phys_0.dac_code_n[0] sar_ctrl_async_phys_0.dac_code[7] 0.13858f
C5221 sar_ctrl_async_phys_0.sg13g2_a22oi_1_0.B1 sar_ctrl_async_phys_0.sg13g2_inv_1_1.A 0.55738f
C5222 sar_ctrl_async_phys_0.sg13g2_nor2b_1_0.A a_32580_36642# 0.07085f
C5223 a_29653_38959# a_29755_38959# 0.47795f
C5224 sar_ctrl_async_phys_0.dac_code_n[2] sar_ctrl_async_phys_0.cmp_n 0.0682f
C5225 sar_ctrl_async_phys_0.sg13g2_a22oi_1_0.A2 sar_ctrl_async_phys_0.bit_active[0] 0.0262f
C5226 sar_ctrl_async_phys_0.sg13g2_dfrbpq_1_9.RESET_B sar_ctrl_async_phys_0.sg13g2_nor2_1_11.A 0.19905f
C5227 a_34010_35892# a_34036_35928# 0.36952f
C5228 a_32031_31749# VDD 0.17053f
C5229 sar_ctrl_async_phys_0.sg13g2_dfrbpq_1_9.RESET_B a_33951_45823# 0.04295f
C5230 sar_ctrl_async_phys_0.sg13g2_nand2_1_3.Y sar_ctrl_async_phys_0.dac_code[2] 0.0233f
C5231 oa_sar8_acore18_opt_0.sw_tg_opt_0.bot oa_sar8_acore18_opt_0.sw_bitcell_opt_term_0.bot 0.70986f
C5232 sar_ctrl_async_phys_0.sg13g2_inv_1_9.Y track 0.08891f
C5233 sar_ctrl_async_phys_0.sg13g2_a21oi_1_4.B1 sar_ctrl_async_phys_0.sg13g2_nor2b_1_4.Y 0.0117f
C5234 sar_ctrl_async_phys_0.sg13g2_a21oi_1_4.A2 a_31563_43020# 0.1058f
C5235 a_34040_45082# a_34224_45082# 0.0524f
C5236 sar_ctrl_async_phys_0.sg13g2_nand2_1_1.Y VDD 0.57764f
C5237 sar_ctrl_async_phys_0.sg13g2_dfrbpq_1_9.RESET_B a_33654_44234# 0.11536f
C5238 sar_ctrl_async_phys_0.sg13g2_a22oi_1_0.Y VDD 0.21354f
C5239 oa_sar8_acore18_opt_0.sw_bitcell_opt_b3_0.bot m3_48572_n2380# 1.64099f
C5240 w_16692_n9960# sar_ctrl_async_phys_0.dac_code_n[2] 0.02245f
C5241 sar_ctrl_async_phys_0.sg13g2_nor2_1_4.Y a_33944_47390# 0.0334f
C5242 a_34261_36653# a_34453_35935# 0.01774f
C5243 sar_ctrl_async_phys_0.sg13g2_buf_1_3.A a_33359_32876# 0.01856f
C5244 a_32223_46869# VDD 0.18139f
C5245 sar_ctrl_async_phys_0.sg13g2_nand2b_1_0.A_N sar_ctrl_async_phys_0.sg13g2_dlygate4sd3_1_4.A 0.05053f
C5246 sar_ctrl_async_phys_0.dac_code[0] sar_ctrl_async_phys_0.dac_code[6] 0.14172f
C5247 a_31706_44964# VDD 0.09412f
C5248 sar_ctrl_async_phys_0.sg13g2_a22oi_1_5.A2 sar_ctrl_async_phys_0.sg13g2_nor2_1_10.B 1.87392f
C5249 a_29238_40898# a_29812_40885# 0.31978f
C5250 sar_ctrl_async_phys_0.sg13g2_a21oi_1_1.Y sar_ctrl_async_phys_0.sg13g2_a22oi_1_0.B1 0.02516f
C5251 sar_ctrl_async_phys_0.sg13g2_buf_1_2.A a_33818_36897# 0.26061f
C5252 a_35672_38224# VDD 0.21896f
C5253 a_25496_34412# VDD 0.22258f
C5254 a_32984_39830# a_33168_39830# 0.0524f
C5255 a_33530_39921# a_33556_40016# 0.36952f
C5256 sar_ctrl_async_phys_0.sg13g2_a22oi_1_5.A2 a_31563_43020# 0.15995f
C5257 sar_ctrl_async_phys_0.sg13g2_nor2_1_5.B a_28368_36877# 0.01499f
C5258 sar_ctrl_async_phys_0.sg13g2_nand2_1_3.A sar_ctrl_async_phys_0.sg13g2_nand2b_1_2.A_N 0.8733f
C5259 sar_ctrl_async_phys_0.sg13g2_nor2_1_2.A VDD 0.40847f
C5260 oa_sar8_acore18_opt_0.sw_bitcell_opt_term_0.trkb a_35028_n9612# 0.70727f
C5261 sar_ctrl_async_phys_0.sg13g2_a22oi_1_0.B1 a_33846_33338# 0.02342f
C5262 sar_ctrl_async_phys_0.sg13g2_dfrbpq_1_0.CLK a_34261_36653# 0.25136f
C5263 a_33844_36992# a_35103_36751# 0.01529f
C5264 a_35648_33142# a_36058_32900# 0.10373f
C5265 sar_ctrl_async_phys_0.sg13g2_a21oi_1_5.B1 sar_ctrl_async_phys_0.sg13g2_a21oi_1_6.A2 0.05124f
C5266 sar_ctrl_async_phys_0.sg13g2_buf_1_2.A sar_ctrl_async_phys_0.sg13g2_buf_1_2.X 0.0488f
C5267 m3_54868_n2380# m3_57896_n2380# 0.0157f
C5268 sar_ctrl_async_phys_0.sg13g2_inv_1_9.Y a_25496_42854# 0.02058f
C5269 sar_ctrl_async_phys_0.sg13g2_a22oi_1_5.A2 a_31071_33727# 0.0154f
C5270 sar_ctrl_async_phys_0.dac_code[6] VDD 5.61334f
C5271 sar_ctrl_async_phys_0.sg13g2_buf_1_2.X a_29332_32456# 0.43587f
C5272 sar_ctrl_async_phys_0.sg13g2_buf_1_1.A a_36056_33688# 0.02044f
C5273 sar_ctrl_async_phys_0.sg13g2_dfrbpq_1_0.CLK a_34636_31749# 0.0805f
C5274 a_34520_46508# sar_ctrl_async_phys_0.dac_code_n[1] 0.24586f
C5275 sar_ctrl_async_phys_0.sg13g2_dfrbpq_1_9.RESET_B sar_ctrl_async_phys_0.sg13g2_nor2_1_0.Y 0.05223f
C5276 a_35725_45266# a_36152_45082# 0.0144f
C5277 sar_ctrl_async_phys_0.sg13g2_a21oi_1_2.B1 sar_ctrl_async_phys_0.sg13g2_a22oi_1_2.A2 0.06641f
C5278 sar_ctrl_async_phys_0.bit_active[5] sar_ctrl_async_phys_0.bit_active[4] 0.11791f
C5279 a_34765_45266# a_34847_45366# 0.01117f
C5280 sar_ctrl_async_phys_0.sg13g2_buf_1_2.X a_34767_31359# 0.04792f
C5281 sar_ctrl_async_phys_0.sg13g2_a21oi_1_0.A1 sar_ctrl_async_phys_0.sg13g2_a21oi_1_1.Y 0.22949f
C5282 a_34055_31352# a_34526_31826# 0.28931f
C5283 sar_ctrl_async_phys_0.sg13g2_buf_1_6.A a_35103_36751# 0.02646f
C5284 sar_ctrl_async_phys_0.sg13g2_dfrbpq_1_9.RESET_B a_32319_44311# 0.14841f
C5285 sar_ctrl_async_phys_0.sg13g2_dfrbpq_1_0.CLK a_28950_39386# 0.01684f
C5286 a_26544_38389# sar_ctrl_async_phys_0.sg13g2_buf_1_26.X 0.25477f
C5287 sar_ctrl_async_phys_0.dac_code_n[4] sar_ctrl_async_phys_0.sg13g2_nand2b_1_1.Y 0.13009f
C5288 sar_ctrl_async_phys_0.sg13g2_a21oi_1_4.B1 sar_ctrl_async_phys_0.sg13g2_dfrbpq_1_2.Q 0.04237f
C5289 sar_ctrl_async_phys_0.sg13g2_nor2_1_1.Y a_33818_43452# 0.04033f
C5290 sar_ctrl_async_phys_0.sg13g2_nor2b_1_4.Y a_31060_44552# 0.05336f
C5291 a_30390_36362# VDD 0.78634f
C5292 sar_ctrl_async_phys_0.sg13g2_dfrbpq_1_2.Q a_34171_41332# 0.04455f
C5293 sar_ctrl_async_phys_0.dac_code_n[4] oa_sar8_acore18_opt_0.sw_bitcell_opt_term_0.vin 0.05585f
C5294 sar_ctrl_async_phys_0.dac_code_n[5] sar_ctrl_async_phys_0.dac_code_n[1] 0.1429f
C5295 sar_ctrl_async_phys_0.sg13g2_dfrbpq_1_0.CLK a_33248_45238# 0.01781f
C5296 sar_ctrl_async_phys_0.dac_code[5] oa_sar8_acore18_opt_0.sw_bitcell_opt_b3_0.bot 0.55628f
C5297 a_34765_42242# VDD 0.24206f
C5298 sar_ctrl_async_phys_0.sg13g2_a21oi_1_7.Y sar_ctrl_async_phys_0.sg13g2_buf_1_2.X 1.88792f
C5299 a_34549_32911# result[5] 0.01096f
C5300 sar_ctrl_async_phys_0.sg13g2_dfrbpq_1_9.RESET_B a_34261_43495# 0.03567f
C5301 sar_ctrl_async_phys_0.dac_code[6] oa_sar8_acore18_opt_0.sw_bitcell_opt_b6_0.bot 2.63211f
C5302 sar_ctrl_async_phys_0.sg13g2_dlygate4sd3_1_7.X VDD 0.49566f
C5303 a_30390_39698# VDD 0.77573f
C5304 a_29328_39830# VDD 0.06995f
C5305 a_32580_36642# VDD 0.19412f
C5306 a_32245_37447# a_32993_37797# 0.01058f
C5307 sar_ctrl_async_phys_0.sg13g2_nor2_1_11.A sar_ctrl_async_phys_0.sg13g2_nor2b_1_0.A 0.29972f
C5308 sar_ctrl_async_phys_0.sg13g2_dlygate4sd3_1_5.A VDD 0.37757f
C5309 a_35866_44532# VDD 0.38055f
C5310 a_28950_39386# a_29236_38952# 0.41329f
C5311 a_32692_46064# a_33857_45823# 0.43239f
C5312 sar_ctrl_async_phys_0.sg13g2_nand2_1_3.A sar_ctrl_async_phys_0.sg13g2_nand2_1_6.B 0.27332f
C5313 sar_ctrl_async_phys_0.sg13g2_nor4_1_0.C sar_ctrl_async_phys_0.sg13g2_nor2_1_1.Y 0.01326f
C5314 a_33211_45868# a_32980_45759# 0.12701f
C5315 a_28392_41214# sar_ctrl_async_phys_0.sg13g2_nand2b_1_0.A_N 0.3992f
C5316 a_30746_31356# VDD 0.09738f
C5317 sar_ctrl_async_phys_0.sg13g2_nor4_1_0.C sar_ctrl_async_phys_0.sg13g2_a22oi_1_1.A2 0.01552f
C5318 a_27800_41342# a_27984_41342# 0.0524f
C5319 a_34904_33688# VDD 0.22106f
C5320 sar_ctrl_async_phys_0.sg13g2_buf_1_2.A sar_ctrl_async_phys_0.sg13g2_inv_1_2.A 0.15573f
C5321 sar_ctrl_async_phys_0.sg13g2_a22oi_1_1.B2 VDD 0.67264f
C5322 sar_ctrl_async_phys_0.sg13g2_a21oi_1_1.Y sar_ctrl_async_phys_0.sg13g2_buf_1_4.A 0.03234f
C5323 sar_ctrl_async_phys_0.sg13g2_a21oi_1_1.Y sar_ctrl_async_phys_0.sg13g2_and2_1_0.B 0.17302f
C5324 sar_ctrl_async_phys_0.sg13g2_a22oi_1_0.B1 a_30229_33629# 0.05656f
C5325 VDD result[7] 0.16366f
C5326 sar_ctrl_async_phys_0.sg13g2_buf_1_2.A a_30650_35892# 0.24033f
C5327 oa_sar8_acore18_opt_0.sw_bitcell_opt_b1_0.bot m3_34580_n2380# 0.01682f
C5328 sar_ctrl_async_phys_0.dac_code_n[5] vcm 0.06598f
C5329 a_32991_45357# a_33658_44996# 0.0894f
C5330 sar_ctrl_async_phys_0.sg13g2_dfrbpq_1_0.CLK a_31195_35935# 0.02739f
C5331 sar_ctrl_async_phys_0.sg13g2_a21oi_1_0.A1 a_34731_37436# 0.03809f
C5332 sar_ctrl_async_phys_0.sg13g2_nand2_1_2.B a_36248_44366# 0.0243f
C5333 a_29238_40898# a_29941_40471# 0.02432f
C5334 w_39600_n9960# oa_sar8_acore18_opt_0.sw_bitcell_opt_b3_0.bot 0.02055f
C5335 sar_ctrl_async_phys_0.bit_active[0] VDD 0.1674f
C5336 a_32602_39996# a_32984_39830# 0.01012f
C5337 sar_ctrl_async_phys_0.sg13g2_a21oi_1_1.Y sar_ctrl_async_phys_0.sg13g2_buf_1_8.A 0.44231f
C5338 a_30938_46476# a_30964_46512# 0.36952f
C5339 sar_ctrl_async_phys_0.dac_code_n[2] oa_sar8_acore18_opt_0.sw_bitcell_opt_term_1.bot 0.06773f
C5340 a_33818_36897# a_34261_36653# 0.02242f
C5341 a_34549_32911# a_35297_33261# 0.01058f
C5342 sar_ctrl_async_phys_0.sg13g2_buf_1_14.A sar_ctrl_async_phys_0.sg13g2_dfrbpq_1_2.Q 0.02441f
C5343 sar_ctrl_async_phys_0.sg13g2_nor2_1_0.Y sar_ctrl_async_phys_0.sg13g2_nor2b_1_0.A 0.5181f
C5344 m3_41836_n2380# m3_45264_n2380# 0.0157f
C5345 sar_ctrl_async_phys_0.sg13g2_buf_1_2.X a_31640_34498# 0.02143f
C5346 sar_ctrl_async_phys_0.sg13g2_o21ai_1_1.B1 a_31195_39820# 0.42878f
C5347 sar_ctrl_async_phys_0.sg13g2_buf_1_4.A sar_ctrl_async_phys_0.bit_active[2] 0.11116f
C5348 sar_ctrl_async_phys_0.sg13g2_buf_1_6.A sar_ctrl_async_phys_0.dac_code[7] 0.27052f
C5349 sar_ctrl_async_phys_0.sg13g2_and2_1_0.B sar_ctrl_async_phys_0.bit_active[2] 0.18453f
C5350 a_31446_35162# a_32149_35141# 0.02454f
C5351 sar_ctrl_async_phys_0.sg13g2_buf_1_3.A sar_ctrl_async_phys_0.sg13g2_buf_1_20.A 0.02326f
C5352 sar_ctrl_async_phys_0.sg13g2_a22oi_1_2.B1 sar_ctrl_async_phys_0.sg13g2_buf_1_5.A 0.46688f
C5353 sar_ctrl_async_phys_0.sg13g2_buf_1_2.X a_34636_31749# 0.44647f
C5354 a_33936_31675# a_34055_31352# 0.0894f
C5355 sar_ctrl_async_phys_0.sg13g2_nor2_1_2.A a_34036_35928# 0.03495f
C5356 sar_ctrl_async_phys_0.sg13g2_buf_1_20.A a_32888_43570# 0.02355f
C5357 sar_ctrl_async_phys_0.sg13g2_nor2_1_1.Y a_33558_43922# 0.30026f
C5358 sar_ctrl_async_phys_0.sg13g2_dfrbpq_1_11.D VDD 0.31769f
C5359 sar_ctrl_async_phys_0.dac_code_n[3] sar_ctrl_async_phys_0.sg13g2_nand2_1_3.A 0.03445f
C5360 sar_ctrl_async_phys_0.dac_code[5] oa_sar8_acore18_opt_0.sw_bitcell_opt_term_0.bot 0.16277f
C5361 a_27894_35924# VDD 0.27286f
C5362 sar_ctrl_async_phys_0.sg13g2_and2_1_0.B a_34731_37436# 0.10441f
C5363 sar_ctrl_async_phys_0.sg13g2_dfrbpq_1_9.RESET_B a_33944_46594# 0.02118f
C5364 a_30632_22281# VDD 0.75713f
C5365 sar_ctrl_async_phys_0.dac_code[6] oa_sar8_acore18_opt_0.sw_bitcell_opt_b2_0.bot 0.18621f
C5366 a_28760_42058# VDD 0.1655f
C5367 sar_ctrl_async_phys_0.sg13g2_buf_1_32.A a_34228_44247# 0.02175f
C5368 sar_ctrl_async_phys_0.sg13g2_buf_1_23.A a_35280_35365# 0.02709f
C5369 a_29232_43570# VDD 0.08647f
C5370 sar_ctrl_async_phys_0.sg13g2_nand2_1_2.A sar_ctrl_async_phys_0.sg13g2_nand2_1_3.B 0.019f
C5371 sar_ctrl_async_phys_0.sg13g2_a21oi_1_0.A1 sar_ctrl_async_phys_0.sg13g2_buf_1_22.A 0.42834f
C5372 sar_ctrl_async_phys_0.sg13g2_nand2_1_2.A sar_ctrl_async_phys_0.sg13g2_nand2b_1_1.Y 0.25566f
C5373 sar_ctrl_async_phys_0.sg13g2_nor2_1_11.A VDD 0.57042f
C5374 a_35770_36972# sar_ctrl_async_phys_0.bit_active[3] 0.03584f
C5375 sar_ctrl_async_phys_0.dac_code[7] m3_34580_n2380# 0.04394f
C5376 sar_ctrl_async_phys_0.sg13g2_nand2b_1_0.Y sar_ctrl_async_phys_0.sg13g2_nor2_1_6.A 0.43689f
C5377 a_33951_45823# VDD 0.17454f
C5378 sar_ctrl_async_phys_0.sg13g2_buf_1_20.A sar_ctrl_async_phys_0.dac_code[1] 0.02105f
C5379 sar_ctrl_async_phys_0.sg13g2_nor2_1_7.B sar_ctrl_async_phys_0.sg13g2_nor2_1_7.Y 1.13105f
C5380 sar_ctrl_async_phys_0.sg13g2_nor4_1_0.C sar_ctrl_async_phys_0.sg13g2_nor4_1_0.Y 0.20897f
C5381 sar_ctrl_async_phys_0.sg13g2_nand2b_1_2.Y sar_ctrl_async_phys_0.sg13g2_nand2_1_2.A 0.91084f
C5382 a_31542_37874# a_32347_37447# 0.097f
C5383 sar_ctrl_async_phys_0.sg13g2_nor2_1_1.A a_33844_36992# 0.01831f
C5384 sar_ctrl_async_phys_0.sg13g2_buf_1_4.A sar_ctrl_async_phys_0.sg13g2_buf_1_1.A 0.13529f
C5385 a_35578_41508# VDD 0.38131f
C5386 sar_ctrl_async_phys_0.sg13g2_dfrbpq_1_0.CLK sar_ctrl_async_phys_0.sg13g2_inv_1_1.Y 0.10038f
C5387 a_33654_44234# VDD 0.7761f
C5388 sar_ctrl_async_phys_0.dac_code_n[4] sar_ctrl_async_phys_0.dac_code[2] 0.06321f
C5389 result[5] result[6] 0.13482f
C5390 sar_ctrl_async_phys_0.cmp_valid sar_ctrl_async_phys_0.dac_code_n[2] 0.01423f
C5391 a_32192_36166# a_31935_36285# 0.34468f
C5392 a_33183_32215# a_33850_32436# 0.0894f
C5393 sar_ctrl_async_phys_0.sg13g2_a21oi_1_1.B1 sar_ctrl_async_phys_0.sg13g2_nand2_1_6.B 0.01163f
C5394 sar_ctrl_async_phys_0.dac_code_n[7] oa_sar8_acore18_opt_0.sw_bitcell_opt_b5_0.bot 0.42877f
C5395 sar_ctrl_async_phys_0.sg13g2_dfrbpq_1_11.D a_31830_40898# 0.2814f
C5396 sar_ctrl_async_phys_0.sample oa_sar8_acore18_opt_0.sw_bitcell_opt_b7_1.VSS 0.17303f
C5397 a_31732_45000# a_32991_45357# 0.01529f
C5398 sar_ctrl_async_phys_0.sg13g2_buf_1_0.A a_32251_35284# 0.01908f
C5399 sar_ctrl_async_phys_0.sg13g2_dfrbpq_1_1.D sar_ctrl_async_phys_0.sg13g2_buf_1_2.X 0.06267f
C5400 sar_ctrl_async_phys_0.sg13g2_nand2_1_0.Y VDD 0.52314f
C5401 sar_ctrl_async_phys_0.sg13g2_and2_1_5.X a_33652_41528# 0.02475f
C5402 a_32580_43448# a_33085_43832# 0.01771f
C5403 sar_ctrl_async_phys_0.sg13g2_inv_1_0.A result[4] 1.97557f
C5404 sar_ctrl_async_phys_0.sg13g2_nor2b_1_0.A sar_ctrl_async_phys_0.sg13g2_a22oi_1_2.B1 0.17277f
C5405 sar_ctrl_async_phys_0.sg13g2_nand2_1_2.B a_35199_44311# 0.02869f
C5406 sar_ctrl_async_phys_0.sg13g2_buf_1_3.A sar_ctrl_async_phys_0.sg13g2_buf_1_9.A 0.669f
C5407 a_34808_35200# VDD 0.22069f
C5408 a_32192_39918# a_32602_39996# 0.10373f
C5409 sar_ctrl_async_phys_0.dac_code_n[0] oa_sar8_acore18_opt_0.bstrap_opt_w2_c1200_1.out 1.87221f
C5410 sar_ctrl_async_phys_0.sg13g2_a21oi_1_0.B1 sar_ctrl_async_phys_0.sg13g2_a21oi_1_0.A1 1.02503f
C5411 sar_ctrl_async_phys_0.sg13g2_nor2_1_0.Y VDD 0.8738f
C5412 sar_ctrl_async_phys_0.sg13g2_dfrbpq_1_0.CLK a_31644_36638# 0.04296f
C5413 sar_ctrl_async_phys_0.sg13g2_nor2_1_10.Y a_29562_39996# 0.01635f
C5414 a_33846_33338# a_34651_32911# 0.097f
C5415 sar_ctrl_async_phys_0.dac_code_n[0] sar_ctrl_async_phys_0.dac_code[3] 0.06405f
C5416 a_35664_37695# VDD 0.38799f
C5417 a_35028_n9612# a_35948_n9612# 0.23797f
C5418 a_32319_44311# VDD 0.17445f
C5419 sar_ctrl_async_phys_0.sg13g2_a22oi_1_1.Y a_31823_32876# 0.17399f
C5420 oa_sar8_acore18_opt_0.sw_tg_opt_0.bot oa_sar8_acore18_opt_0.sw_bitcell_opt_term_0.vin 0.20174f
C5421 sar_ctrl_async_phys_0.sg13g2_dfrbpq_1_0.CLK sar_ctrl_async_phys_0.sg13g2_a22oi_1_5.A2 0.34644f
C5422 oa_sar8_acore18_opt_0.bstrap_opt_w2_c1200_1.gb a_20412_n9612# 3.45782f
C5423 oa_sar8_acore18_opt_0.sw_bitcell_opt_term_0.VSS oa_sar8_acore18_opt_0.sw_bitcell_opt_term_0.gb 0.0224f
C5424 sar_ctrl_async_phys_0.sg13g2_nand2_1_2.B sar_ctrl_async_phys_0.dac_code_n[7] 0.02254f
C5425 a_34261_43495# VDD 0.24129f
C5426 sar_ctrl_async_phys_0.hold_req oa_sar8_acore18_opt_0.sw_bitcell_opt_term_0.gb 0.05514f
C5427 sar_ctrl_async_phys_0.sg13g2_a21oi_1_6.B1 sar_ctrl_async_phys_0.sg13g2_nor2_1_2.Y 0.01437f
C5428 a_32031_31749# a_32698_31388# 0.0894f
C5429 sar_ctrl_async_phys_0.sg13g2_buf_1_2.X a_32288_31630# 0.10624f
C5430 a_30772_31392# a_31937_31749# 0.43239f
C5431 a_28782_40460# VDD 0.01742f
C5432 a_30830_35166# sar_ctrl_async_phys_0.sg13g2_dfrbpq_1_1.D 0.21526f
C5433 sar_ctrl_async_phys_0.sg13g2_o21ai_1_1.B1 sar_ctrl_async_phys_0.sg13g2_a21oi_1_0.A1 0.38258f
C5434 oa_sar8_acore18_opt_0.sw_bitcell_opt_b1_1.bot a_20412_n9612# 0.08205f
C5435 sar_ctrl_async_phys_0.sg13g2_buf_1_14.A sar_ctrl_async_phys_0.bit_active[2] 0.02346f
C5436 sar_ctrl_async_phys_0.sample oa_sar8_acore18_opt_0.sw_bitcell_opt_b2_1.bot 1.66251f
C5437 sar_ctrl_async_phys_0.sg13g2_nand3_1_0.C a_25496_39830# 0.01893f
C5438 sar_ctrl_async_phys_0.sg13g2_a21oi_1_1.B1 sar_ctrl_async_phys_0.dac_code_n[3] 0.08829f
C5439 sar_ctrl_async_phys_0.sg13g2_nand2_1_3.A sar_ctrl_async_phys_0.sg13g2_nand2b_1_7.A_N 1.23344f
C5440 sar_ctrl_async_phys_0.sg13g2_buf_1_6.A a_35672_38948# 0.02087f
C5441 sar_ctrl_async_phys_0.sg13g2_nor2_1_0.Y a_31830_40898# 0.03861f
C5442 sar_ctrl_async_phys_0.sg13g2_a21oi_1_0.A1 a_29755_38959# 0.03124f
C5443 sar_ctrl_async_phys_0.sg13g2_buf_1_3.A sar_ctrl_async_phys_0.sg13g2_and2_1_5.X 0.01237f
C5444 sar_ctrl_async_phys_0.sg13g2_a21oi_1_0.B1 sar_ctrl_async_phys_0.sg13g2_and2_1_0.B 0.08468f
C5445 sar_ctrl_async_phys_0.sg13g2_buf_1_3.A sar_ctrl_async_phys_0.sg13g2_buf_1_16.A 0.14925f
C5446 sar_ctrl_async_phys_0.sample sar_ctrl_async_phys_0.cmp_n 0.12068f
C5447 sar_ctrl_async_phys_0.sg13g2_a22oi_1_0.B2 result[0] 0.04755f
C5448 a_31542_37874# a_32245_37447# 0.02432f
C5449 a_33366_41210# VDD 0.77583f
C5450 sar_ctrl_async_phys_0.sg13g2_nand2_1_2.A a_33844_43488# 0.03783f
C5451 sar_ctrl_async_phys_0.sg13g2_nor2_1_2.Y a_33556_40016# 0.01062f
C5452 sar_ctrl_async_phys_0.sg13g2_nand2b_1_0.Y a_28651_39740# 0.29748f
C5453 sar_ctrl_async_phys_0.dac_code_n[7] oa_sar8_acore18_opt_0.sw_bitcell_opt_b1_0.bot 0.10459f
C5454 sar_ctrl_async_phys_0.sg13g2_buf_1_5.A a_32443_32260# 0.02101f
C5455 sar_ctrl_async_phys_0.sg13g2_dfrbpq_1_0.CLK sar_ctrl_async_phys_0.sg13g2_nand2b_1_1.Y 0.02183f
C5456 sar_ctrl_async_phys_0.sg13g2_a21oi_1_4.B1 sar_ctrl_async_phys_0.dac_code_n[0] 0.03333f
C5457 a_30676_35928# a_30964_36349# 0.43707f
C5458 sar_ctrl_async_phys_0.sg13g2_buf_1_3.A sar_ctrl_async_phys_0.sg13g2_buf_1_23.A 0.01128f
C5459 a_31924_32456# a_33183_32215# 0.01529f
C5460 sar_ctrl_async_phys_0.sg13g2_a22oi_1_5.Y a_30671_32876# 0.175f
C5461 a_34904_47296# sar_ctrl_async_phys_0.dac_code_n[0] 0.24585f
C5462 a_32223_46869# a_32890_46508# 0.0894f
C5463 sar_ctrl_async_phys_0.sg13g2_dfrbpq_1_0.CLK sar_ctrl_async_phys_0.sg13g2_nand2b_1_2.Y 0.31723f
C5464 a_34132_30944# result[1] 0.03083f
C5465 sar_ctrl_async_phys_0.sg13g2_nor2_1_7.Y sar_ctrl_async_phys_0.sg13g2_buf_1_2.A 0.01701f
C5466 a_26550_41214# VDD 0.22669f
C5467 sar_ctrl_async_phys_0.sg13g2_buf_1_2.X sar_ctrl_async_phys_0.sg13g2_inv_1_1.Y 0.37482f
C5468 sar_ctrl_async_phys_0.sg13g2_nor2_1_11.Y a_29620_43488# 0.04571f
C5469 sar_ctrl_async_phys_0.sg13g2_a22oi_1_2.A2 a_33248_35382# 0.04007f
C5470 sar_ctrl_async_phys_0.sg13g2_a22oi_1_5.Y sar_ctrl_async_phys_0.sg13g2_a22oi_1_1.Y 0.0749f
C5471 sar_ctrl_async_phys_0.sg13g2_a22oi_1_0.B1 a_31832_34412# 0.26555f
C5472 sar_ctrl_async_phys_0.sg13g2_dfrbpq_1_0.CLK a_31450_40460# 0.01908f
C5473 a_31706_44964# a_31732_45000# 0.36952f
C5474 sar_ctrl_async_phys_0.sg13g2_a22oi_1_0.B2 a_33464_30664# 0.27031f
C5475 sar_ctrl_async_phys_0.sg13g2_buf_1_3.A a_32696_30664# 0.2475f
C5476 sar_ctrl_async_phys_0.sg13g2_nor2_1_0.A a_31802_37404# 0.02649f
C5477 sar_ctrl_async_phys_0.sg13g2_a21oi_1_0.A2 a_35664_37695# 0.31876f
C5478 a_31933_43832# sar_ctrl_async_phys_0.sg13g2_buf_1_20.A 0.11005f
C5479 sar_ctrl_async_phys_0.sg13g2_a22oi_1_2.B1 VDD 0.68976f
C5480 sar_ctrl_async_phys_0.sg13g2_a21oi_1_4.B1 sar_ctrl_async_phys_0.sg13g2_a21oi_1_0.B1 0.01963f
C5481 sar_ctrl_async_phys_0.sg13g2_nand2b_1_1.Y a_31640_41342# 0.019f
C5482 sar_ctrl_async_phys_0.sg13g2_dfrbpq_1_0.CLK a_29238_41972# 0.017f
C5483 sar_ctrl_async_phys_0.sg13g2_a21oi_1_5.B1 sar_ctrl_async_phys_0.dac_code_n[1] 0.20052f
C5484 sar_ctrl_async_phys_0.dac_code[1] sar_ctrl_async_phys_0.dac_code[4] 0.19129f
C5485 sar_ctrl_async_phys_0.sg13g2_a22oi_1_2.A2 a_33087_37797# 0.04332f
C5486 a_25496_34412# sar_ctrl_async_phys_0.cmp_n 0.26679f
C5487 sar_ctrl_async_phys_0.sg13g2_dfrbpq_1_0.CLK a_30037_43495# 0.27531f
C5488 sar_ctrl_async_phys_0.sg13g2_nand2b_1_1.Y a_35725_45266# 0.03771f
C5489 sar_ctrl_async_phys_0.sg13g2_nor2_1_12.A a_28130_40838# 0.09805f
C5490 a_30650_39921# sar_ctrl_async_phys_0.sg13g2_dfrbpq_1_22.D 0.01036f
C5491 a_33846_33338# a_34549_32911# 0.02432f
C5492 sar_ctrl_async_phys_0.sg13g2_nor2_1_6.A sar_ctrl_async_phys_0.sg13g2_nor2_1_7.B 0.0482f
C5493 sar_ctrl_async_phys_0.dac_code_n[2] sar_ctrl_async_phys_0.dac_code[1] 0.06321f
C5494 sar_ctrl_async_phys_0.dac_code_n[6] oa_sar8_acore18_opt_0.sw_tg_opt_1.bot 0.07694f
C5495 a_31440_37522# VDD 0.06906f
C5496 sar_ctrl_async_phys_0.sg13g2_a21oi_1_1.Y sar_ctrl_async_phys_0.sg13g2_buf_1_0.A 0.37257f
C5497 sar_ctrl_async_phys_0.dac_code_n[3] oa_sar8_acore18_opt_0.sw_tg_opt_1.bot 0.07612f
C5498 sar_ctrl_async_phys_0.sg13g2_o21ai_1_1.B1 a_32692_46064# 0.40031f
C5499 a_32666_45969# a_33109_45725# 0.02242f
C5500 a_33944_46594# VDD 0.14546f
C5501 sar_ctrl_async_phys_0.sg13g2_a21oi_1_4.B1 sar_ctrl_async_phys_0.sg13g2_o21ai_1_1.B1 0.01859f
C5502 sar_ctrl_async_phys_0.sg13g2_dfrbpq_1_9.RESET_B sar_ctrl_async_phys_0.sg13g2_dfrbpq_1_9.Q 0.09189f
C5503 sar_ctrl_async_phys_0.sg13g2_dfrbpq_1_0.CLK result[5] 0.06235f
C5504 sar_ctrl_async_phys_0.sg13g2_o21ai_1_1.B1 a_34171_41332# 0.4205f
C5505 oa_sar8_acore18_opt_0.sw_bitcell_opt_term_0.vin m3_48572_n2380# 0.05057f
C5506 sar_ctrl_async_phys_0.sg13g2_buf_1_20.A sar_ctrl_async_phys_0.dac_code[4] 0.06319f
C5507 sar_ctrl_async_phys_0.sg13g2_nor2_1_1.Y a_33844_39711# 0.01155f
C5508 oa_sar8_acore18_opt_0.sw_tg_opt_1.bot oa_sar8_acore18_opt_0.sw_bitcell_opt_term_0.trkb 2.17679f
C5509 a_35672_38948# sar_ctrl_async_phys_0.sg13g2_buf_1_21.A 0.03514f
C5510 sar_ctrl_async_phys_0.sg13g2_nand3_1_0.Y sar_ctrl_async_phys_0.sg13g2_dlygate4sd3_1_4.X 0.03854f
C5511 sar_ctrl_async_phys_0.sg13g2_dlygate4sd3_1_7.X a_26280_41214# 0.40903f
C5512 a_30772_31392# a_32031_31749# 0.01529f
C5513 sar_ctrl_async_phys_0.sample oa_sar8_acore18_opt_0.sw_bitcell_opt_b6_1.bot 1.89979f
C5514 sar_ctrl_async_phys_0.sg13g2_a21oi_1_0.B1 sar_ctrl_async_phys_0.sg13g2_nand2_1_3.Y 0.29221f
C5515 sar_ctrl_async_phys_0.sg13g2_buf_1_13.X sar_ctrl_async_phys_0.sg13g2_and2_1_2.X 0.31033f
C5516 sar_ctrl_async_phys_0.sg13g2_and2_1_2.X a_26566_39766# 0.0131f
C5517 sar_ctrl_async_phys_0.dac_code_n[7] sar_ctrl_async_phys_0.dac_code[7] 0.13774f
C5518 sar_ctrl_async_phys_0.sg13g2_a22oi_1_5.A2 sar_ctrl_async_phys_0.sg13g2_buf_1_2.X 0.02193f
C5519 sar_ctrl_async_phys_0.sg13g2_a22oi_1_1.B2 a_32698_31388# 0.12475f
C5520 sar_ctrl_async_phys_0.sg13g2_nand2b_1_0.Y VDD 0.51464f
C5521 a_33168_32986# VDD 0.07504f
C5522 sar_ctrl_async_phys_0.sg13g2_and2_1_5.X sar_ctrl_async_phys_0.sg13g2_nand2_1_1.B 0.0131f
C5523 sar_ctrl_async_phys_0.dac_code[2] oa_sar8_acore18_opt_0.sw_tg_opt_0.bot 0.89256f
C5524 sar_ctrl_async_phys_0.sg13g2_a21oi_1_0.A1 sar_ctrl_async_phys_0.sg13g2_buf_1_6.A 1.00269f
C5525 sar_ctrl_async_phys_0.sg13g2_a21oi_1_1.B1 sar_ctrl_async_phys_0.sg13g2_nand2b_1_7.A_N 0.04603f
C5526 sar_ctrl_async_phys_0.sg13g2_buf_1_13.X track 0.203f
C5527 a_33675_43020# VDD 0.24867f
C5528 sar_ctrl_async_phys_0.sg13g2_buf_1_5.A sar_ctrl_async_phys_0.sg13g2_buf_1_25.A 0.61524f
C5529 sar_ctrl_async_phys_0.sg13g2_and2_1_2.X track 0.11415f
C5530 result[7] done 0.20772f
C5531 a_33375_40821# a_33281_40821# 0.28931f
C5532 sar_ctrl_async_phys_0.sg13g2_a22oi_1_0.A2 a_35211_37436# 0.16353f
C5533 sar_ctrl_async_phys_0.sg13g2_buf_1_4.A a_33844_36992# 0.02163f
C5534 sar_ctrl_async_phys_0.sg13g2_a21oi_1_0.B1 sar_ctrl_async_phys_0.sg13g2_buf_1_14.A 0.23344f
C5535 sar_ctrl_async_phys_0.cmp_p oa_sar8_acore18_opt_0.sw_tg_opt_1.bot 0.1185f
C5536 sar_ctrl_async_phys_0.sg13g2_o21ai_1_1.B1 sar_ctrl_async_phys_0.sg13g2_nand2_1_3.Y 0.01608f
C5537 sar_ctrl_async_phys_0.sg13g2_and2_1_0.B a_33844_36992# 0.01759f
C5538 a_31898_32361# a_31924_32456# 0.36952f
C5539 sar_ctrl_async_phys_0.sg13g2_nor4_1_0.C sar_ctrl_async_phys_0.cmp_fault 0.04362f
C5540 sar_ctrl_async_phys_0.dac_code[0] oa_sar8_acore18_opt_0.sw_bitcell_opt_term_0.gb 0.18846f
C5541 sar_ctrl_async_phys_0.sg13g2_buf_1_25.A a_34132_32904# 0.04239f
C5542 sar_ctrl_async_phys_0.sg13g2_nor4_1_0.C sar_ctrl_async_phys_0.sg13g2_a21oi_1_6.B1 0.05267f
C5543 sar_ctrl_async_phys_0.sg13g2_dfrbpq_1_0.CLK a_33844_43488# 0.0761f
C5544 a_29941_40471# a_30689_40821# 0.01058f
C5545 sar_ctrl_async_phys_0.bit_active[0] done 0.01514f
C5546 sar_ctrl_async_phys_0.sg13g2_nor4_1_0.C a_34520_47296# 0.26245f
C5547 sar_ctrl_async_phys_0.sg13g2_a21oi_1_0.A1 a_31665_42748# 0.01119f
C5548 sar_ctrl_async_phys_0.sg13g2_nand2b_1_1.Y sar_ctrl_async_phys_0.sg13g2_buf_1_33.A 0.03968f
C5549 sar_ctrl_async_phys_0.sg13g2_nor2_1_10.Y a_29048_40546# 0.03153f
C5550 sar_ctrl_async_phys_0.dac_code[5] oa_sar8_acore18_opt_0.sw_bitcell_opt_term_0.vin 1.93454f
C5551 sar_ctrl_async_phys_0.sg13g2_a22oi_1_5.A2 a_30830_35166# 0.03453f
C5552 sar_ctrl_async_phys_0.sg13g2_buf_1_6.A sar_ctrl_async_phys_0.sg13g2_buf_1_4.A 0.72133f
C5553 sar_ctrl_async_phys_0.sg13g2_nand2_1_3.A sar_ctrl_async_phys_0.sg13g2_a21oi_1_2.B1 0.22633f
C5554 sar_ctrl_async_phys_0.sg13g2_buf_1_6.A sar_ctrl_async_phys_0.sg13g2_and2_1_0.B 0.92325f
C5555 sar_ctrl_async_phys_0.sg13g2_inv_1_2.A a_34520_33688# 0.01148f
C5556 sar_ctrl_async_phys_0.sample oa_sar8_acore18_opt_0.sw_bitcell_opt_term_1.bot 1.5824f
C5557 sar_ctrl_async_phys_0.bit_active[2] sar_ctrl_async_phys_0.bit_active[4] 0.0309f
C5558 sar_ctrl_async_phys_0.sg13g2_o21ai_1_1.B1 sar_ctrl_async_phys_0.sg13g2_buf_1_14.A 0.06724f
C5559 sar_ctrl_async_phys_0.sg13g2_a21oi_1_2.B1 a_34817_41287# 0.0179f
C5560 oa_sar8_acore18_opt_0.sw_bitcell_opt_term_0.gb VDD 3.92089f
C5561 sar_ctrl_async_phys_0.sg13g2_a22oi_1_1.Y a_30848_32358# 0.02839f
C5562 a_34106_30849# a_34132_30944# 0.36952f
C5563 a_30390_39698# a_30676_40016# 0.41329f
C5564 sar_ctrl_async_phys_0.sg13g2_o21ai_1_1.B1 a_29941_40471# 0.05745f
C5565 sar_ctrl_async_phys_0.sg13g2_a22oi_1_5.A2 a_30650_35892# 0.03052f
C5566 vinn VSS 4.87559f
C5567 vinp VSS 1.35533f
C5568 vcm VSS 5.66386f
C5569 result[1] VSS 0.47498f
C5570 result[0] VSS 0.97789f
C5571 result[3] VSS 0.52907f
C5572 result[2] VSS 0.42055f
C5573 result[6] VSS 0.65874f
C5574 busy VSS 0.47342f
C5575 done VSS 0.55609f
C5576 result[7] VSS 0.40587f
C5577 result[5] VSS 0.61098f
C5578 result[4] VSS 0.46999f
C5579 VDD VSS 0.38309p
C5580 m3_60844_n2380# VSS 0.11538f ; **FLOATING
C5581 m3_57896_n2380# VSS 0.1082f ; **FLOATING
C5582 m3_54868_n2380# VSS 0.11186f ; **FLOATING
C5583 m3_51760_n2380# VSS 0.11552f ; **FLOATING
C5584 m3_48572_n2380# VSS 0.11918f ; **FLOATING
C5585 m3_45264_n2380# VSS 0.12467f ; **FLOATING
C5586 m3_41836_n2380# VSS 0.13016f ; **FLOATING
C5587 m3_38288_n2380# VSS 0.13565f ; **FLOATING
C5588 m3_34580_n2380# VSS 0.15298f ; **FLOATING
C5589 a_35948_n9612# VSS 24.28841f
C5590 a_35028_n9612# VSS 2.29596f
C5591 a_21332_n9711# VSS 2.27891f
C5592 a_20412_n9612# VSS 22.56145f
C5593 oa_sar8_acore18_opt_0.sw_bitcell_opt_term_0.gb VSS 54.20868f
C5594 oa_sar8_acore18_opt_0.sw_bitcell_opt_term_0.VSS VSS 49.47074f
C5595 oa_sar8_acore18_opt_0.sw_bitcell_opt_b7_1.VSS VSS 71.81371f
C5596 oa_sar8_acore18_opt_0.sw_bitcell_opt_term_0.bot VSS 27.4593f
C5597 oa_sar8_acore18_opt_0.sw_bitcell_opt_b0_0.bot VSS 22.87421f
C5598 oa_sar8_acore18_opt_0.sw_bitcell_opt_b1_0.bot VSS 22.09615f
C5599 oa_sar8_acore18_opt_0.sw_bitcell_opt_b2_0.bot VSS 21.41547f
C5600 oa_sar8_acore18_opt_0.sw_bitcell_opt_b3_0.bot VSS 21.20692f
C5601 oa_sar8_acore18_opt_0.sw_bitcell_opt_b4_0.bot VSS 24.71159f
C5602 oa_sar8_acore18_opt_0.sw_bitcell_opt_b5_0.bot VSS 22.13711f
C5603 oa_sar8_acore18_opt_0.sw_bitcell_opt_b6_0.bot VSS 24.46802f
C5604 oa_sar8_acore18_opt_0.sw_bitcell_opt_term_0.vin VSS 26.76735f
C5605 oa_sar8_acore18_opt_0.sw_bitcell_opt_b7_0.bot VSS 44.07689f
C5606 oa_sar8_acore18_opt_0.sw_bitcell_opt_b7_1.bot VSS 46.04301f
C5607 oa_sar8_acore18_opt_0.sw_bitcell_opt_b6_1.bot VSS 24.58449f
C5608 oa_sar8_acore18_opt_0.sw_bitcell_opt_b5_1.bot VSS 19.91119f
C5609 oa_sar8_acore18_opt_0.sw_bitcell_opt_b4_1.bot VSS 24.15418f
C5610 oa_sar8_acore18_opt_0.sw_bitcell_opt_b3_1.bot VSS 20.41868f
C5611 oa_sar8_acore18_opt_0.sw_bitcell_opt_b2_1.bot VSS 20.55488f
C5612 oa_sar8_acore18_opt_0.sw_bitcell_opt_b1_1.bot VSS 21.12036f
C5613 oa_sar8_acore18_opt_0.sw_bitcell_opt_b0_1.bot VSS 21.71081f
C5614 oa_sar8_acore18_opt_0.sw_bitcell_opt_term_0.trkb VSS 0.10425p
C5615 oa_sar8_acore18_opt_0.bstrap_opt_w2_c1200_1.out VSS 30.25471f
C5616 oa_sar8_acore18_opt_0.sw_bitcell_opt_term_1.bot VSS 26.27051f
C5617 a_30632_22281# VSS 1.43141f
C5618 oa_sar8_acore18_opt_0.sw_tg_opt_0.bot VSS 80.01308f
C5619 a_26184_21025# VSS 8.94945f
C5620 oa_sar8_acore18_opt_0.sw_tg_opt_1.bot VSS 80.94533f
C5621 a_28008_23477# VSS 2.45424f
C5622 a_35297_30703# VSS 0.09495f
C5623 a_34358_30639# VSS 0.02047f
C5624 a_34420_30639# VSS 0.05718f
C5625 a_35593_30941# VSS 0.1831f
C5626 a_33940_30626# VSS 0.23244f
C5627 a_34489_31017# VSS 0.9597f
C5628 a_33846_30626# VSS 0.59618f
C5629 a_34106_30849# VSS 0.08336f
C5630 a_33464_30664# VSS 0.13307f
C5631 a_30872_30758# VSS 0.10678f ; **FLOATING
C5632 a_35659_31435# VSS 0.78108f
C5633 a_36210_31826# VSS 0.41526f
C5634 a_35463_31435# VSS 0.60825f
C5635 a_35814_31813# VSS 12.26233f
C5636 a_35418_31668# VSS 0.29594f
C5637 a_32233_31511# VSS 0.10874f
C5638 a_34526_31826# VSS 0.33317f
C5639 a_32450_31826# VSS 0.01483f
C5640 a_31937_31749# VSS 0.17832f
C5641 a_33464_31388# VSS 0.0747f
C5642 a_31060_31813# VSS 0.79811f
C5643 a_30998_31813# VSS 0.7611f
C5644 a_30384_31474# VSS 0.04075f ; **FLOATING
C5645 a_30772_31392# VSS 0.19554f
C5646 a_30580_31826# VSS 0.21313f
C5647 a_30486_31826# VSS 0.83932f
C5648 a_29912_31474# VSS 0.10632f ; **FLOATING
C5649 a_35166_32120# VSS 0.13546f
C5650 a_34590_32120# VSS 0.12368f
C5651 a_34319_32120# VSS 0.21984f
C5652 a_34895_32460# VSS 0.42779f
C5653 a_34319_32460# VSS 0.24063f
C5654 a_33089_32215# VSS 0.31478f
C5655 a_32150_32151# VSS 1.00604f
C5656 a_32212_32151# VSS 1.13945f
C5657 a_33385_32453# VSS 0.39954f
C5658 sar_ctrl_async_phys_0.sg13g2_a22oi_1_0.B2 VSS 0.02455f
C5659 a_33850_32436# VSS 0.04168f
C5660 a_32281_32529# VSS 0.04168f
C5661 a_31638_32138# VSS 0.39404f
C5662 a_30497_32215# VSS 0.17913f
C5663 a_29558_32151# VSS 0.83648f
C5664 a_29620_32151# VSS 0.82465f
C5665 a_30793_32453# VSS 0.07047f
C5666 a_29689_32529# VSS 0.22535f
C5667 a_29332_32456# VSS 0.26096f
C5668 a_29046_32138# VSS 0.99181f
C5669 sar_ctrl_async_phys_0.sg13g2_inv_1_6.Y VSS 0.05928f
C5670 a_28856_32270# VSS 0.10337f ; **FLOATING
C5671 a_34489_32947# VSS 0.15171f
C5672 a_33359_32876# VSS 0.39147f
C5673 a_35810_33338# VSS 0.14389f
C5674 a_35297_33261# VSS 0.24906f
C5675 a_34420_33325# VSS 0.79632f
C5676 a_34358_33325# VSS 0.75961f
C5677 a_33168_32986# VSS 0.04159f ; **FLOATING
C5678 a_32687_32876# VSS 0.19935f
C5679 a_31823_32876# VSS 0.41143f
C5680 a_31247_32876# VSS 0.84725f
C5681 a_30671_32876# VSS 0.8798f
C5682 a_34132_32904# VSS 0.08955f
C5683 a_33940_33338# VSS 0.27875f
C5684 a_33846_33338# VSS 0.57575f
C5685 a_33630_33292# VSS 0.29781f
C5686 a_32958_33292# VSS 0.12413f
C5687 a_32687_33292# VSS 0.10269f
C5688 a_30480_32986# VSS 0.04082f ; **FLOATING
C5689 sar_ctrl_async_phys_0.sg13g2_inv_1_1.A VSS 0.18232f
C5690 a_32094_33292# VSS 1.18789f
C5691 a_31823_33292# VSS 0.1111f
C5692 a_31518_33292# VSS 0.12413f
C5693 a_30942_33292# VSS 0.12432f
C5694 a_30671_33292# VSS 0.83288f
C5695 sar_ctrl_async_phys_0.bit_active[1] VSS 0.92988f
C5696 a_31490_33650# VSS 0.38162f
C5697 sar_ctrl_async_phys_0.sg13g2_inv_1_2.A VSS 0.22291f
C5698 sar_ctrl_async_phys_0.sg13g2_buf_1_5.A VSS 0.21341f
C5699 a_30977_33727# VSS 0.17925f
C5700 a_30038_33663# VSS 1.75715f
C5701 a_30100_33663# VSS 0.98928f
C5702 a_31273_33965# VSS 0.07116f
C5703 a_29620_33650# VSS 0.36255f
C5704 a_29526_33650# VSS 0.6244f
C5705 sar_ctrl_async_phys_0.sg13g2_inv_1_5.Y VSS 0.18903f
C5706 a_29786_33873# VSS 0.04168f
C5707 a_34489_34459# VSS 0.89127f
C5708 a_35297_34773# VSS 0.17867f
C5709 a_34420_34837# VSS 0.13257f
C5710 a_34358_34837# VSS 6.29089f
C5711 a_34549_34423# VSS 0.16672f
C5712 a_34106_34380# VSS 0.09586f
C5713 a_33940_34850# VSS 0.51186f
C5714 a_33846_34850# VSS 0.71464f
C5715 a_31640_34498# VSS 0.07781f ; **FLOATING
C5716 a_31370_34782# VSS 0.22129f
C5717 a_25496_34412# VSS 3.45043f
C5718 sar_ctrl_async_phys_0.bit_active[4] VSS 1.0338f
C5719 a_35417_35208# VSS 0.06917f
C5720 sar_ctrl_async_phys_0.bit_active[3] VSS 0.61803f
C5721 sar_ctrl_async_phys_0.bit_active[2] VSS 0.54047f
C5722 a_33410_35162# VSS 0.14642f
C5723 sar_ctrl_async_phys_0.bit_active[0] VSS 0.44072f
C5724 a_32897_35239# VSS 0.43924f
C5725 a_31958_35175# VSS 0.07325f
C5726 a_32020_35175# VSS 0.32029f
C5727 a_31540_35162# VSS 0.80659f
C5728 a_30944_35166# VSS 0.44891f
C5729 a_32089_35553# VSS 0.75951f
C5730 a_31446_35162# VSS 0.43628f
C5731 a_31706_35385# VSS 0.04168f
C5732 a_31007_35460# VSS 0.39231f
C5733 a_30733_35460# VSS 0.06671f
C5734 a_30384_35294# VSS 0.03856f ; **FLOATING
C5735 a_30200_35294# VSS 0.10028f ; **FLOATING
C5736 a_30830_35166# VSS 0.81195f
C5737 a_36336_36010# VSS 0.08079f ; **FLOATING
C5738 a_34393_35971# VSS 0.86678f
C5739 a_35201_36285# VSS 0.17801f
C5740 a_34324_36349# VSS 0.13346f
C5741 a_33648_36010# VSS 0.05647f ; **FLOATING
C5742 a_32137_36047# VSS 0.16634f
C5743 a_34036_35928# VSS 0.11782f
C5744 a_34010_35892# VSS 0.08336f
C5745 a_33844_36362# VSS 3.21709f
C5746 a_33750_36362# VSS 3.51366f
C5747 a_31033_35971# VSS 0.98332f
C5748 a_32354_36362# VSS 0.51241f
C5749 a_31841_36285# VSS 0.17851f
C5750 a_30964_36349# VSS 0.1241f
C5751 a_30902_36349# VSS 0.86999f
C5752 a_30390_36362# VSS 0.2486f
C5753 a_27504_36010# VSS 0.06074f ; **FLOATING
C5754 a_28488_35965# VSS 0.10191f
C5755 a_36336_36806# VSS 0.07477f ; **FLOATING
C5756 a_36152_36806# VSS 0.07861f ; **FLOATING
C5757 a_35009_36751# VSS 0.57821f
C5758 a_34070_36687# VSS 0.0866f
C5759 a_34132_36687# VSS 0.22061f
C5760 a_33652_36674# VSS 1.07561f
C5761 a_34201_37065# VSS 0.75832f
C5762 a_33558_36674# VSS 0.47358f
C5763 a_33210_36972# VSS 0.217f
C5764 a_32888_36806# VSS 0.08083f ; **FLOATING
C5765 a_32538_36972# VSS 0.21709f
C5766 a_32304_36806# VSS 0.04618f ; **FLOATING
C5767 a_31352_36806# VSS 0.08688f ; **FLOATING
C5768 a_29862_36682# VSS 0.18774f
C5769 a_29760_36682# VSS 0.45884f
C5770 sar_ctrl_async_phys_0.sg13g2_dlygate4sd3_1_0.X VSS 0.10174f
C5771 a_28026_36972# VSS 0.27127f
C5772 a_28862_36863# VSS 0.17245f
C5773 a_35211_37436# VSS 0.02853f
C5774 a_34266_37436# VSS 0.04658f
C5775 a_33289_37559# VSS 0.1803f
C5776 sar_ctrl_async_phys_0.bit_active[5] VSS 0.44862f
C5777 a_35801_37784# VSS 0.16183f
C5778 a_36056_37436# VSS 0.13137f
C5779 a_35313_37784# VSS 0.54872f
C5780 a_34833_37784# VSS 0.27562f
C5781 a_35664_37695# VSS 0.15529f
C5782 sar_ctrl_async_phys_0.sg13g2_a21oi_1_0.A2 VSS 0.07476f
C5783 a_32185_37483# VSS 0.04865f
C5784 a_33506_37874# VSS 0.19377f
C5785 a_32993_37797# VSS 0.37391f
C5786 a_32116_37861# VSS 1.01276f
C5787 a_32054_37861# VSS 0.97605f
C5788 a_31440_37522# VSS 0.03501f ; **FLOATING
C5789 a_31256_37522# VSS 0.09404f ; **FLOATING
C5790 a_29660_37436# VSS 0.06614f
C5791 a_29276_37436# VSS 0.02936f
C5792 a_28506_37436# VSS 0.23281f
C5793 a_31636_37874# VSS 0.10892f
C5794 a_31542_37874# VSS 0.48911f
C5795 sar_ctrl_async_phys_0.sg13g2_nor2_1_5.B VSS 3.4077f
C5796 a_28272_37522# VSS 0.06002f ; **FLOATING
C5797 a_27354_37436# VSS 1.04628f
C5798 sar_ctrl_async_phys_0.sg13g2_nor2_1_7.A VSS 0.20368f
C5799 a_27120_37522# VSS 0.04261f ; **FLOATING
C5800 a_26630_37814# VSS 0.27454f
C5801 a_26160_37522# VSS 0.05963f ; **FLOATING
C5802 sar_ctrl_async_phys_0.bit_active[7] VSS 0.36797f
C5803 a_34266_38484# VSS 0.76223f
C5804 a_33882_38484# VSS 0.30734f
C5805 a_36056_38224# VSS 0.10437f
C5806 a_35672_38224# VSS 0.03027f
C5807 a_34520_38224# VSS 0.06355f
C5808 sar_ctrl_async_phys_0.sg13g2_nor2_1_2.A VSS 0.09377f
C5809 a_32120_38318# VSS 0.08748f ; **FLOATING
C5810 a_31355_38232# VSS 0.28762f
C5811 a_31064_38318# VSS 0.08804f ; **FLOATING
C5812 sar_ctrl_async_phys_0.sg13g2_nor2_1_0.A VSS 0.25353f
C5813 a_31261_38232# VSS 0.15364f
C5814 a_29084_38484# VSS 0.19761f
C5815 a_26681_38232# VSS 1.17176f
C5816 a_26352_38318# VSS 0.03868f ; **FLOATING
C5817 a_26168_38318# VSS 0.09823f ; **FLOATING
C5818 a_26544_38389# VSS 0.06262f
C5819 sar_ctrl_async_phys_0.dac_code[6] VSS 53.48529f
C5820 a_35402_39318# VSS 0.59131f
C5821 sar_ctrl_async_phys_0.bit_active[6] VSS 0.6475f
C5822 a_34800_39034# VSS 0.04683f ; **FLOATING
C5823 a_32156_38948# VSS 1.534f
C5824 a_30697_39071# VSS 0.14085f
C5825 a_29593_38995# VSS 0.05153f
C5826 a_30914_39386# VSS 0.11708f
C5827 a_30401_39309# VSS 0.32302f
C5828 a_29524_39373# VSS 0.87481f
C5829 a_29462_39373# VSS 0.78919f
C5830 a_29236_38952# VSS 0.02084f
C5831 a_29044_39386# VSS 0.51f
C5832 a_28950_39386# VSS 0.79965f
C5833 a_28560_39034# VSS 0.03749f ; **FLOATING
C5834 a_28376_39034# VSS 0.10133f ; **FLOATING
C5835 a_27304_38928# VSS 0.34479f
C5836 a_27032_39034# VSS 0.08558f ; **FLOATING
C5837 a_25914_38948# VSS 0.21506f
C5838 a_27206_39326# VSS 0.22896f
C5839 a_26385_39214# VSS 0.07039f
C5840 a_25680_39034# VSS 0.0381f ; **FLOATING
C5841 a_25496_39034# VSS 0.11471f ; **FLOATING
C5842 a_26666_38912# VSS 0.08864f
C5843 a_36336_39830# VSS 0.07955f ; **FLOATING
C5844 a_36089_39744# VSS 0.20739f
C5845 sar_ctrl_async_phys_0.sg13g2_buf_1_23.A VSS 0.62103f
C5846 a_34721_39775# VSS 0.24991f
C5847 a_33844_39711# VSS 0.13414f
C5848 a_33364_39698# VSS 0.04701f
C5849 a_33913_40089# VSS 0.90013f
C5850 a_33270_39698# VSS 0.44432f
C5851 a_33168_39830# VSS 0.03437f ; **FLOATING
C5852 a_32984_39830# VSS 0.07994f ; **FLOATING
C5853 a_32354_39698# VSS 0.05195f
C5854 a_31841_39775# VSS 0.17922f
C5855 a_30902_39711# VSS 0.93379f
C5856 a_30964_39711# VSS 0.97096f
C5857 a_32137_40013# VSS 0.12163f
C5858 a_30129_39724# VSS 0.01152f
C5859 a_30390_39698# VSS 0.19955f
C5860 a_30027_39996# VSS 0.07092f
C5861 a_29808_39830# VSS 0.04073f ; **FLOATING
C5862 a_29562_39996# VSS 0.03458f
C5863 a_29328_39830# VSS 0.04154f ; **FLOATING
C5864 a_29144_39830# VSS 0.08252f ; **FLOATING
C5865 a_28853_39702# VSS 0.89877f
C5866 a_28176_39830# VSS 0.04246f ; **FLOATING
C5867 sar_ctrl_async_phys_0.sg13g2_nor2_1_7.B VSS 0.10887f
C5868 a_25896_39706# VSS 0.04978f
C5869 a_25794_39706# VSS 0.37599f
C5870 a_27134_39887# VSS 0.11385f
C5871 sar_ctrl_async_phys_0.sg13g2_nand3_1_0.Y VSS 0.42179f
C5872 a_25496_39830# VSS 0.11788f ; **FLOATING
C5873 a_36336_40546# VSS 0.07802f ; **FLOATING
C5874 a_35595_40460# VSS 0.61703f
C5875 a_36074_40830# VSS 0.28098f
C5876 a_35697_40808# VSS 0.02155f
C5877 a_34896_40546# VSS 0.04036f ; **FLOATING
C5878 a_33577_40583# VSS 0.17851f
C5879 a_35053_40730# VSS 0.14768f
C5880 a_34596_40424# VSS 0.0383f
C5881 a_33281_40821# VSS 0.09499f
C5882 a_32404_40885# VSS 0.96877f
C5883 a_32342_40885# VSS 0.93205f
C5884 a_30985_40583# VSS 0.08308f
C5885 a_31924_40898# VSS 0.2124f
C5886 a_31830_40898# VSS 4.65136f
C5887 a_31202_40898# VSS 0.1453f
C5888 a_30689_40821# VSS 0.16695f
C5889 a_29812_40885# VSS 0.81494f
C5890 a_29750_40885# VSS 0.7763f
C5891 a_29048_40546# VSS 0.08245f ; **FLOATING
C5892 a_28578_40460# VSS 0.09543f
C5893 a_28236_40440# VSS 0.15777f
C5894 a_27738_40460# VSS 0.3681f
C5895 a_29524_40464# VSS 0.24767f
C5896 a_29332_40898# VSS 0.23113f
C5897 a_29238_40898# VSS 0.84872f
C5898 sar_ctrl_async_phys_0.sg13g2_nor2_1_10.Y VSS 0.03168f
C5899 a_28130_40838# VSS 0.64272f
C5900 sar_ctrl_async_phys_0.sg13g2_dlygate4sd3_1_4.A VSS 0.09585f
C5901 a_25488_40546# VSS 0.0801f ; **FLOATING
C5902 a_25878_40460# VSS 0.1868f
C5903 sar_ctrl_async_phys_0.sg13g2_o21ai_1_1.A2 VSS 0.75367f
C5904 a_26954_40424# VSS 0.31544f
C5905 a_25990_40484# VSS 0.17354f
C5906 a_36336_41342# VSS 0.07872f ; **FLOATING
C5907 a_34817_41287# VSS 0.48336f
C5908 a_33878_41223# VSS 0.82976f
C5909 a_33940_41223# VSS 0.86647f
C5910 a_35113_41525# VSS 0.17163f
C5911 a_33366_41210# VSS 0.95985f
C5912 a_33114_41508# VSS 0.66947f
C5913 a_32792_41342# VSS 0.08164f ; **FLOATING
C5914 a_32049_41236# VSS 2.96982f
C5915 a_31947_41508# VSS 0.56644f
C5916 a_31640_41342# VSS 0.09007f ; **FLOATING
C5917 a_27984_41342# VSS 0.0367f ; **FLOATING
C5918 a_27800_41342# VSS 0.10015f ; **FLOATING
C5919 a_26550_41214# VSS 0.08787f
C5920 sar_ctrl_async_phys_0.sg13g2_nor4_1_0.Y VSS 1.25485f
C5921 a_35327_42342# VSS 0.11971f
C5922 a_36056_41972# VSS 0.40746f
C5923 a_34224_42058# VSS 0.04147f ; **FLOATING
C5924 a_28760_42058# VSS 0.08984f ; **FLOATING
C5925 a_29238_41972# VSS 0.16523f
C5926 a_28968_42013# VSS 0.26038f
C5927 sar_ctrl_async_phys_0.sg13g2_dlygate4sd3_1_7.X VSS 0.14423f
C5928 a_26454_41972# VSS 0.30322f
C5929 a_35402_42726# VSS 0.07239f
C5930 a_35018_42726# VSS 0.07372f
C5931 a_34175_42726# VSS 0.23969f
C5932 a_33777_42748# VSS 0.66702f
C5933 a_33072_42854# VSS 0.04369f ; **FLOATING
C5934 a_32817_42748# VSS 0.21168f
C5935 a_31665_42748# VSS 0.21185f
C5936 a_36056_42760# VSS 0.03182f
C5937 sar_ctrl_async_phys_0.sg13g2_nand2_1_2.Y VSS 0.03902f
C5938 a_31563_43020# VSS 0.76657f
C5939 a_30480_42854# VSS 0.03886f ; **FLOATING
C5940 a_30296_42854# VSS 0.09837f ; **FLOATING
C5941 sar_ctrl_async_phys_0.sg13g2_dlygate4sd3_1_6.X VSS 0.04233f
C5942 a_25820_43020# VSS 0.6056f
C5943 a_25496_42854# VSS 0.11857f ; **FLOATING
C5944 a_36336_43570# VSS 0.07482f ; **FLOATING
C5945 a_36152_43570# VSS 0.0784f ; **FLOATING
C5946 a_35522_43922# VSS 0.25259f
C5947 a_35009_43845# VSS 0.51703f
C5948 a_34132_43909# VSS 0.81603f
C5949 a_34070_43909# VSS 0.77932f
C5950 a_33844_43488# VSS 0.04857f
C5951 a_33652_43922# VSS 0.53309f
C5952 a_33179_43832# VSS 0.43132f
C5953 a_32888_43570# VSS 0.07963f ; **FLOATING
C5954 a_32538_43484# VSS 0.35839f
C5955 a_33558_43922# VSS 0.75782f
C5956 sar_ctrl_async_phys_0.sg13g2_nor2_1_1.Y VSS 0.10023f
C5957 a_32027_43832# VSS 0.06951f
C5958 a_29977_43531# VSS 0.99087f
C5959 a_30785_43845# VSS 0.24834f
C5960 a_29908_43909# VSS 0.0385f
C5961 a_29232_43570# VSS 0.06362f ; **FLOATING
C5962 a_29620_43488# VSS 0.20597f
C5963 a_29334_43922# VSS 0.72048f
C5964 sar_ctrl_async_phys_0.sample VSS 0.41145f
C5965 a_36248_44366# VSS 0.11961f ; **FLOATING
C5966 a_35105_44311# VSS 0.39418f
C5967 a_34166_44247# VSS 0.82884f
C5968 a_34228_44247# VSS 0.86555f
C5969 a_35401_44549# VSS 0.07096f
C5970 a_33654_44234# VSS 0.75453f
C5971 a_33552_44366# VSS 0.03458f ; **FLOATING
C5972 a_33368_44366# VSS 0.07746f ; **FLOATING
C5973 a_32738_44234# VSS 0.2542f
C5974 a_32225_44311# VSS 0.095f
C5975 a_31286_44247# VSS 0.86928f
C5976 a_31348_44247# VSS 1.00323f
C5977 a_32521_44549# VSS 0.20961f
C5978 a_30868_44234# VSS 0.26452f
C5979 a_31060_44552# VSS 0.09055f
C5980 a_30774_44234# VSS 0.66586f
C5981 a_30584_44366# VSS 0.09006f ; **FLOATING
C5982 a_36336_45082# VSS 0.07463f ; **FLOATING
C5983 a_36152_45082# VSS 0.07562f ; **FLOATING
C5984 a_35807_45366# VSS 0.12166f
C5985 a_35327_45366# VSS 0.25186f
C5986 a_34847_45366# VSS 0.10609f
C5987 a_34224_45082# VSS 0.03578f ; **FLOATING
C5988 a_34040_45082# VSS 0.07765f ; **FLOATING
C5989 a_35725_45266# VSS 0.33323f
C5990 a_34765_45266# VSS 0.76483f
C5991 a_32897_45357# VSS 0.17779f
C5992 a_32020_45421# VSS 3.55733f
C5993 a_31958_45421# VSS 3.42432f
C5994 a_31732_45000# VSS 0.08913f
C5995 a_31540_45434# VSS 2.08673f
C5996 a_31446_45434# VSS 0.66199f
C5997 a_30872_45082# VSS 0.10148f ; **FLOATING
C5998 a_35000_45878# VSS 0.08425f ; **FLOATING
C5999 a_33857_45823# VSS 0.09495f
C6000 a_32980_45759# VSS 0.03671f
C6001 a_34153_46061# VSS 0.15523f
C6002 a_33049_46137# VSS 1.08226f
C6003 a_32406_45746# VSS 0.91284f
C6004 sar_ctrl_async_phys_0.sg13g2_nor2_1_0.Y VSS 0.90306f
C6005 a_26160_45878# VSS 0.06157f ; **FLOATING
C6006 sar_ctrl_async_phys_0.sg13g2_buf_1_44.A VSS 0.29078f
C6007 a_35402_46878# VSS 0.52706f
C6008 sar_ctrl_async_phys_0.dac_code_n[3] VSS 0.02781f
C6009 sar_ctrl_async_phys_0.dac_code_n[1] VSS 81.5553f
C6010 sar_ctrl_async_phys_0.sg13g2_buf_1_3.A VSS 8.601f
C6011 a_33944_46594# VSS 0.10188f ; **FLOATING
C6012 a_32425_46631# VSS 0.23282f
C6013 a_31321_46555# VSS 0.83163f
C6014 a_32642_46946# VSS 0.11332f
C6015 a_32129_46869# VSS 0.34245f
C6016 a_31252_46933# VSS 0.03671f
C6017 a_30576_46594# VSS 0.04589f ; **FLOATING
C6018 a_30678_46946# VSS 0.19316f
C6019 sar_ctrl_async_phys_0.dac_code_n[2] VSS 0.39206f
C6020 sar_ctrl_async_phys_0.cmp_valid VSS 0.43732f
C6021 sar_ctrl_async_phys_0.cmp_fault VSS 2.36519f
C6022 a_33944_47390# VSS 0.10581f ; **FLOATING
C6023 a_35288_47296# VSS 0.12168f
C6024 sar_ctrl_async_phys_0.sg13g2_a21oi_1_5.B1 VSS 0.1105f
C6025 w_39600_n9960# VSS 2.35291f
C6026 sar_ctrl_async_phys_0.sg13g2_dfrbpq_1_0.CLK.n0 VSS 1.95499f
C6027 sar_ctrl_async_phys_0.sg13g2_dfrbpq_1_0.CLK.n1 VSS 1.37946f
C6028 sar_ctrl_async_phys_0.sg13g2_dfrbpq_1_0.CLK.n2 VSS 1.71608f
C6029 sar_ctrl_async_phys_0.sg13g2_dfrbpq_1_0.CLK.n3 VSS 1.30449f
C6030 sar_ctrl_async_phys_0.sg13g2_dfrbpq_1_0.CLK.n4 VSS 1.36173f
C6031 sar_ctrl_async_phys_0.sg13g2_dfrbpq_1_0.CLK.n5 VSS 0.83037f
C6032 sar_ctrl_async_phys_0.sg13g2_dfrbpq_1_0.CLK.n6 VSS 0.79904f
C6033 sar_ctrl_async_phys_0.sg13g2_dfrbpq_1_0.CLK.n7 VSS 1.58615f
C6034 sar_ctrl_async_phys_0.sg13g2_dfrbpq_1_0.CLK.n8 VSS 1.64832f
C6035 sar_ctrl_async_phys_0.sg13g2_dfrbpq_1_0.CLK.n9 VSS 1.67754f
C6036 sar_ctrl_async_phys_0.sg13g2_dfrbpq_1_0.CLK.n10 VSS 0.66215f
C6037 sar_ctrl_async_phys_0.sg13g2_dfrbpq_1_0.CLK.n11 VSS 2.71363f
C6038 sar_ctrl_async_phys_0.sg13g2_dfrbpq_1_0.CLK.n12 VSS 1.33697f
C6039 sar_ctrl_async_phys_0.sg13g2_dfrbpq_1_0.CLK.n13 VSS 1.9299f
C6040 sar_ctrl_async_phys_0.sg13g2_dfrbpq_1_0.CLK.n14 VSS 1.91664f
C6041 sar_ctrl_async_phys_0.sg13g2_dfrbpq_1_0.CLK.n15 VSS 2.08697f
C6042 sar_ctrl_async_phys_0.sg13g2_dfrbpq_1_0.CLK.n16 VSS 1.51293f
C6043 sar_ctrl_async_phys_0.sg13g2_dfrbpq_1_0.CLK.n17 VSS 2.38129f
C6044 sar_ctrl_async_phys_0.sg13g2_dfrbpq_1_0.CLK.n18 VSS 1.43014f
C6045 sar_ctrl_async_phys_0.sg13g2_dfrbpq_1_0.CLK.n19 VSS 0.95923f
C6046 sar_ctrl_async_phys_0.sg13g2_dfrbpq_1_0.CLK.n20 VSS 1.1747f
C6047 sar_ctrl_async_phys_0.sg13g2_dfrbpq_1_0.CLK.n21 VSS 0.99941f
C6048 sar_ctrl_async_phys_0.sg13g2_dfrbpq_1_0.CLK.n22 VSS 2.03572f
C6049 sar_ctrl_async_phys_0.sg13g2_dfrbpq_1_0.CLK.n23 VSS 0.79374f
C6050 sar_ctrl_async_phys_0.sg13g2_dfrbpq_1_0.CLK.n24 VSS 1.68227f
C6051 sar_ctrl_async_phys_0.sg13g2_dfrbpq_1_0.CLK.n25 VSS 1.5804f
C6052 sar_ctrl_async_phys_0.sg13g2_dfrbpq_1_0.CLK.n26 VSS 1.74987f
C6053 sar_ctrl_async_phys_0.sg13g2_dfrbpq_1_0.CLK.t0 VSS 0.52285f
C6054 sar_ctrl_async_phys_0.sg13g2_buf_1_3.A.t0 VSS 0.55567f
C6055 sar_ctrl_async_phys_0.sg13g2_buf_1_3.A.n0 VSS 7.75316f
C6056 sar_ctrl_async_phys_0.sg13g2_buf_1_3.A.n1 VSS 7.81718f
C6057 sar_ctrl_async_phys_0.dac_code_n[1].n0 VSS 2.33352f
C6058 sar_ctrl_async_phys_0.dac_code_n[1].t0 VSS 0.13579f
C6059 sar_ctrl_async_phys_0.sg13g2_buf_1_13.X.t0 VSS 0.29711f
C6060 sar_ctrl_async_phys_0.sg13g2_buf_1_13.X.n0 VSS 2.44757f
C6061 sar_ctrl_async_phys_0.sg13g2_buf_1_13.X.n1 VSS 4.66732f
C6062 sar_ctrl_async_phys_0.sg13g2_buf_1_13.X.n2 VSS 2.79348f
C6063 sar_ctrl_async_phys_0.sg13g2_buf_1_13.X.n3 VSS 1.53647f
C6064 sar_ctrl_async_phys_0.sg13g2_buf_1_13.X.n4 VSS 2.37257f
C6065 sar_ctrl_async_phys_0.sg13g2_buf_1_13.X.n5 VSS 0.87774f
C6066 sar_ctrl_async_phys_0.sg13g2_buf_1_13.X.n6 VSS 1.84444f
C6067 sar_ctrl_async_phys_0.sg13g2_nor2b_1_0.A.t0 VSS 0.47655f
C6068 sar_ctrl_async_phys_0.sg13g2_nor2b_1_0.A.n0 VSS 1.05511f
C6069 sar_ctrl_async_phys_0.sg13g2_nor2b_1_0.A.n1 VSS 3.48844f
C6070 sar_ctrl_async_phys_0.sg13g2_nor2b_1_0.A.n2 VSS 3.28349f
C6071 sar_ctrl_async_phys_0.sg13g2_nor2b_1_0.A.n3 VSS 1.785f
C6072 sar_ctrl_async_phys_0.sg13g2_nor2b_1_0.A.n4 VSS 2.86005f
C6073 sar_ctrl_async_phys_0.sg13g2_nor2b_1_0.A.n5 VSS 2.44193f
C6074 sar_ctrl_async_phys_0.sg13g2_nor2b_1_0.A.n6 VSS 1.4252f
C6075 sar_ctrl_async_phys_0.sg13g2_a21oi_1_0.A1.t0 VSS 0.36333f
C6076 sar_ctrl_async_phys_0.sg13g2_a21oi_1_0.A1.n0 VSS 2.12215f
C6077 sar_ctrl_async_phys_0.sg13g2_a21oi_1_0.A1.n1 VSS 3.73676f
C6078 sar_ctrl_async_phys_0.sg13g2_a21oi_1_0.A1.n2 VSS 1.99727f
C6079 sar_ctrl_async_phys_0.sg13g2_a21oi_1_0.A1.n3 VSS 1.28731f
C6080 sar_ctrl_async_phys_0.sg13g2_a21oi_1_0.A1.n4 VSS 0.97938f
C6081 sar_ctrl_async_phys_0.sg13g2_a21oi_1_0.A1.n5 VSS 4.35242f
C6082 sar_ctrl_async_phys_0.sg13g2_a21oi_1_0.A1.n6 VSS 3.28662f
C6083 sar_ctrl_async_phys_0.dac_code[6].n0 VSS 1.41349f
C6084 sar_ctrl_async_phys_0.dac_code[6].t0 VSS 0.16792f
C6085 sar_ctrl_async_phys_0.sg13g2_a22oi_1_0.A1.t0 VSS 0.39541f
C6086 sar_ctrl_async_phys_0.sg13g2_a22oi_1_0.A1.n0 VSS 1.44418f
C6087 sar_ctrl_async_phys_0.sg13g2_a22oi_1_0.A1.n1 VSS 1.43104f
C6088 sar_ctrl_async_phys_0.sg13g2_a22oi_1_0.A1.n2 VSS 0.5428f
C6089 sar_ctrl_async_phys_0.sg13g2_a22oi_1_0.A1.n3 VSS 1.1913f
C6090 sar_ctrl_async_phys_0.sg13g2_a22oi_1_0.A1.n4 VSS 0.97422f
C6091 sar_ctrl_async_phys_0.sg13g2_a22oi_1_0.A1.n5 VSS 3.14433f
C6092 sar_ctrl_async_phys_0.sg13g2_a22oi_1_0.A1.n6 VSS 3.82726f
C6093 sar_ctrl_async_phys_0.sg13g2_buf_1_2.A.n0 VSS 1.96701f
C6094 sar_ctrl_async_phys_0.sg13g2_buf_1_2.A.n1 VSS 1.22315f
C6095 sar_ctrl_async_phys_0.sg13g2_buf_1_2.A.n2 VSS 2.56048f
C6096 sar_ctrl_async_phys_0.sg13g2_buf_1_2.A.n3 VSS 1.04775f
C6097 sar_ctrl_async_phys_0.sg13g2_buf_1_2.A.n4 VSS 1.3258f
C6098 sar_ctrl_async_phys_0.sg13g2_buf_1_2.A.n5 VSS 1.49611f
C6099 sar_ctrl_async_phys_0.sg13g2_buf_1_2.A.n6 VSS 1.62553f
C6100 sar_ctrl_async_phys_0.sg13g2_buf_1_2.X.n0 VSS 1.73714f
C6101 sar_ctrl_async_phys_0.sg13g2_buf_1_2.X.n1 VSS 1.17413f
C6102 sar_ctrl_async_phys_0.sg13g2_buf_1_2.X.n2 VSS 1.94062f
C6103 sar_ctrl_async_phys_0.sg13g2_buf_1_2.X.n3 VSS 1.45659f
C6104 sar_ctrl_async_phys_0.sg13g2_buf_1_2.X.n4 VSS 1.68805f
C6105 sar_ctrl_async_phys_0.sg13g2_buf_1_2.X.n5 VSS 1.93956f
C6106 sar_ctrl_async_phys_0.sg13g2_buf_1_2.X.n6 VSS 0.7641f
C6107 oa_sar8_acore18_opt_0.sw_tg_opt_1.bot.t0 VSS 1.15889f
C6108 oa_sar8_acore18_opt_0.sw_tg_opt_1.bot.t1 VSS 0.18777f
C6109 oa_sar8_acore18_opt_0.sw_tg_opt_0.bot.t0 VSS 1.16457f
C6110 oa_sar8_acore18_opt_0.sw_tg_opt_0.bot.t1 VSS 0.20623f
C6111 oa_sar8_acore18_opt_0.sw_bitcell_opt_term_1.bot.t3 VSS 0.62679f
C6112 oa_sar8_acore18_opt_0.sw_bitcell_opt_term_1.bot.t0 VSS 3.49842f
C6113 oa_sar8_acore18_opt_0.sw_bitcell_opt_term_1.bot.t1 VSS 2.35394f
C6114 oa_sar8_acore18_opt_0.sw_bitcell_opt_term_1.bot.n0 VSS 23.9499f
C6115 oa_sar8_acore18_opt_0.sw_bitcell_opt_term_0.trkb.n0 VSS 4.37762f
C6116 oa_sar8_acore18_opt_0.sw_bitcell_opt_term_0.trkb.t3 VSS 15.0863f
C6117 oa_sar8_acore18_opt_0.sw_bitcell_opt_term_0.trkb.t1 VSS 2.23162f
C6118 oa_sar8_acore18_opt_0.sw_bitcell_opt_term_0.trkb.t4 VSS 3.06833f
C6119 oa_sar8_acore18_opt_0.sw_bitcell_opt_term_0.trkb.n1 VSS 4.42405f
C6120 oa_sar8_acore18_opt_0.sw_bitcell_opt_term_0.trkb.n2 VSS 6.3393f
C6121 oa_sar8_acore18_opt_0.sw_bitcell_opt_term_0.trkb.n3 VSS 11.8898f
C6122 oa_sar8_acore18_opt_0.sw_bitcell_opt_term_0.trkb.n4 VSS 1.09146f
C6123 oa_sar8_acore18_opt_0.sw_bitcell_opt_term_0.trkb.n5 VSS 1.56951f
C6124 oa_sar8_acore18_opt_0.sw_bitcell_opt_term_0.trkb.n6 VSS 4.42403f
C6125 oa_sar8_acore18_opt_0.sw_bitcell_opt_b0_1.bot.t1 VSS 10.99132f
C6126 oa_sar8_acore18_opt_0.sw_bitcell_opt_b0_1.bot.t0 VSS 4.01177f
C6127 oa_sar8_acore18_opt_0.sw_bitcell_opt_b0_1.bot.t2 VSS 4.55681f
C6128 oa_sar8_acore18_opt_0.sw_bitcell_opt_b0_1.bot.n0 VSS 29.0973f
C6129 oa_sar8_acore18_opt_0.sw_bitcell_opt_b1_1.bot.t5 VSS 1.61337f
C6130 oa_sar8_acore18_opt_0.sw_bitcell_opt_b1_1.bot.t0 VSS 5.01036f
C6131 oa_sar8_acore18_opt_0.sw_bitcell_opt_b1_1.bot.t3 VSS 3.44643f
C6132 oa_sar8_acore18_opt_0.sw_bitcell_opt_b1_1.bot.t1 VSS 2.1101f
C6133 oa_sar8_acore18_opt_0.sw_bitcell_opt_b1_1.bot.n0 VSS 9.25302f
C6134 oa_sar8_acore18_opt_0.sw_bitcell_opt_b1_1.bot.n1 VSS 19.3049f
C6135 oa_sar8_acore18_opt_0.sw_bitcell_opt_b2_1.bot.n0 VSS 5.15312f
C6136 oa_sar8_acore18_opt_0.sw_bitcell_opt_b2_1.bot.t1 VSS 7.36135f
C6137 oa_sar8_acore18_opt_0.sw_bitcell_opt_b2_1.bot.t0 VSS 14.83225f
C6138 oa_sar8_acore18_opt_0.sw_bitcell_opt_b2_1.bot.t6 VSS 1.99247f
C6139 oa_sar8_acore18_opt_0.sw_bitcell_opt_b2_1.bot.t8 VSS 1.94788f
C6140 oa_sar8_acore18_opt_0.sw_bitcell_opt_b2_1.bot.n1 VSS 4.59986f
C6141 oa_sar8_acore18_opt_0.sw_bitcell_opt_b2_1.bot.t2 VSS 2.09474f
C6142 oa_sar8_acore18_opt_0.sw_bitcell_opt_b2_1.bot.t4 VSS 2.09474f
C6143 oa_sar8_acore18_opt_0.sw_bitcell_opt_b2_1.bot.n2 VSS 17.9585f
C6144 oa_sar8_acore18_opt_0.sw_bitcell_opt_b3_1.bot.n0 VSS 0.99672f
C6145 oa_sar8_acore18_opt_0.sw_bitcell_opt_b3_1.bot.n1 VSS 1.12654f
C6146 oa_sar8_acore18_opt_0.sw_bitcell_opt_b3_1.bot.n2 VSS 3.61863f
C6147 oa_sar8_acore18_opt_0.sw_bitcell_opt_b3_1.bot.t1 VSS 0.67688f
C6148 oa_sar8_acore18_opt_0.sw_bitcell_opt_b3_1.bot.t0 VSS 14.39949f
C6149 oa_sar8_acore18_opt_0.sw_bitcell_opt_b3_1.bot.t10 VSS 1.71411f
C6150 oa_sar8_acore18_opt_0.sw_bitcell_opt_b3_1.bot.t12 VSS 1.64524f
C6151 oa_sar8_acore18_opt_0.sw_bitcell_opt_b3_1.bot.t14 VSS 1.64524f
C6152 oa_sar8_acore18_opt_0.sw_bitcell_opt_b3_1.bot.t16 VSS 1.64524f
C6153 oa_sar8_acore18_opt_0.sw_bitcell_opt_b3_1.bot.t2 VSS 1.97353f
C6154 oa_sar8_acore18_opt_0.sw_bitcell_opt_b3_1.bot.t4 VSS 1.97353f
C6155 oa_sar8_acore18_opt_0.sw_bitcell_opt_b3_1.bot.t6 VSS 0.12492p
C6156 oa_sar8_acore18_opt_0.sw_bitcell_opt_b3_1.bot.t8 VSS 1.97353f
C6157 oa_sar8_acore18_opt_0.sw_bitcell_opt_b3_1.bot.n3 VSS 2.66089f
C6158 oa_sar8_acore18_opt_0.sw_bitcell_opt_b3_1.bot.n4 VSS 16.1607f
C6159 oa_sar8_acore18_opt_0.sw_bitcell_opt_b4_1.bot.n0 VSS 0.90364f
C6160 oa_sar8_acore18_opt_0.sw_bitcell_opt_b4_1.bot.n1 VSS 1.41411f
C6161 oa_sar8_acore18_opt_0.sw_bitcell_opt_b4_1.bot.n2 VSS 0.86987f
C6162 oa_sar8_acore18_opt_0.sw_bitcell_opt_b4_1.bot.n3 VSS 1.62545f
C6163 oa_sar8_acore18_opt_0.sw_bitcell_opt_b4_1.bot.n4 VSS 0.86987f
C6164 oa_sar8_acore18_opt_0.sw_bitcell_opt_b4_1.bot.n5 VSS 0.90364f
C6165 oa_sar8_acore18_opt_0.sw_bitcell_opt_b4_1.bot.n6 VSS 1.16728f
C6166 oa_sar8_acore18_opt_0.sw_bitcell_opt_b4_1.bot.t33 VSS 0.57511f
C6167 oa_sar8_acore18_opt_0.sw_bitcell_opt_b4_1.bot.t0 VSS 9.91525f
C6168 oa_sar8_acore18_opt_0.sw_bitcell_opt_b4_1.bot.t1 VSS 1.6497f
C6169 oa_sar8_acore18_opt_0.sw_bitcell_opt_b4_1.bot.t3 VSS 1.6428f
C6170 oa_sar8_acore18_opt_0.sw_bitcell_opt_b4_1.bot.t5 VSS 1.6428f
C6171 oa_sar8_acore18_opt_0.sw_bitcell_opt_b4_1.bot.t7 VSS 1.6428f
C6172 oa_sar8_acore18_opt_0.sw_bitcell_opt_b4_1.bot.t9 VSS 1.6428f
C6173 oa_sar8_acore18_opt_0.sw_bitcell_opt_b4_1.bot.t11 VSS 1.6428f
C6174 oa_sar8_acore18_opt_0.sw_bitcell_opt_b4_1.bot.t13 VSS 1.6428f
C6175 oa_sar8_acore18_opt_0.sw_bitcell_opt_b4_1.bot.t15 VSS 1.6428f
C6176 oa_sar8_acore18_opt_0.sw_bitcell_opt_b4_1.bot.t17 VSS 1.22602f
C6177 oa_sar8_acore18_opt_0.sw_bitcell_opt_b4_1.bot.t19 VSS 1.22602f
C6178 oa_sar8_acore18_opt_0.sw_bitcell_opt_b4_1.bot.t21 VSS 1.22602f
C6179 oa_sar8_acore18_opt_0.sw_bitcell_opt_b4_1.bot.t23 VSS 1.22602f
C6180 oa_sar8_acore18_opt_0.sw_bitcell_opt_b4_1.bot.t25 VSS 1.22602f
C6181 oa_sar8_acore18_opt_0.sw_bitcell_opt_b4_1.bot.t27 VSS 1.22602f
C6182 oa_sar8_acore18_opt_0.sw_bitcell_opt_b4_1.bot.t29 VSS 1.22602f
C6183 oa_sar8_acore18_opt_0.sw_bitcell_opt_b4_1.bot.t31 VSS 1.22602f
C6184 oa_sar8_acore18_opt_0.sw_bitcell_opt_b4_1.bot.n7 VSS 11.6835f
C6185 oa_sar8_acore18_opt_0.sw_bitcell_opt_b5_1.bot.t21 VSS 6.00147f
C6186 oa_sar8_acore18_opt_0.sw_bitcell_opt_b5_1.bot.t1 VSS 6.00147f
C6187 oa_sar8_acore18_opt_0.sw_bitcell_opt_b5_1.bot.t41 VSS 6.90513f
C6188 oa_sar8_acore18_opt_0.sw_bitcell_opt_b5_1.bot.t0 VSS 2.74485f
C6189 oa_sar8_acore18_opt_0.sw_bitcell_opt_b5_1.bot.t14 VSS 4.45481f
C6190 oa_sar8_acore18_opt_0.sw_bitcell_opt_b5_1.bot.t19 VSS 4.24198f
C6191 oa_sar8_acore18_opt_0.sw_bitcell_opt_b5_1.bot.t9 VSS 4.45481f
C6192 oa_sar8_acore18_opt_0.sw_bitcell_opt_b5_1.bot.n0 VSS 3.37979f
C6193 oa_sar8_acore18_opt_0.sw_bitcell_opt_b5_1.bot.t34 VSS 4.45481f
C6194 oa_sar8_acore18_opt_0.sw_bitcell_opt_b5_1.bot.t39 VSS 4.24198f
C6195 oa_sar8_acore18_opt_0.sw_bitcell_opt_b5_1.bot.t29 VSS 4.45481f
C6196 oa_sar8_acore18_opt_0.sw_bitcell_opt_b5_1.bot.n1 VSS 6.59327f
C6197 oa_sar8_acore18_opt_0.sw_bitcell_opt_b6_1.bot.t61 VSS 4.61805f
C6198 oa_sar8_acore18_opt_0.sw_bitcell_opt_b6_1.bot.t41 VSS 4.61805f
C6199 oa_sar8_acore18_opt_0.sw_bitcell_opt_b6_1.bot.t21 VSS 4.61805f
C6200 oa_sar8_acore18_opt_0.sw_bitcell_opt_b6_1.bot.t1 VSS 4.61805f
C6201 oa_sar8_acore18_opt_0.sw_bitcell_opt_b6_1.bot.n0 VSS 5.28407f
C6202 oa_sar8_acore18_opt_0.sw_bitcell_opt_b6_1.bot.n1 VSS 3.39319f
C6203 oa_sar8_acore18_opt_0.sw_bitcell_opt_b6_1.bot.t81 VSS 0.40244f
C6204 oa_sar8_acore18_opt_0.sw_bitcell_opt_b6_1.bot.t0 VSS 8.74037f
C6205 oa_sar8_acore18_opt_0.sw_bitcell_opt_b6_1.bot.t14 VSS 3.42791f
C6206 oa_sar8_acore18_opt_0.sw_bitcell_opt_b6_1.bot.t19 VSS 3.38536f
C6207 oa_sar8_acore18_opt_0.sw_bitcell_opt_b6_1.bot.t9 VSS 3.42791f
C6208 oa_sar8_acore18_opt_0.sw_bitcell_opt_b6_1.bot.t34 VSS 3.42791f
C6209 oa_sar8_acore18_opt_0.sw_bitcell_opt_b6_1.bot.t39 VSS 3.38536f
C6210 oa_sar8_acore18_opt_0.sw_bitcell_opt_b6_1.bot.t29 VSS 3.42791f
C6211 oa_sar8_acore18_opt_0.sw_bitcell_opt_b6_1.bot.t54 VSS 3.42791f
C6212 oa_sar8_acore18_opt_0.sw_bitcell_opt_b6_1.bot.t59 VSS 3.38536f
C6213 oa_sar8_acore18_opt_0.sw_bitcell_opt_b6_1.bot.t49 VSS 3.42791f
C6214 oa_sar8_acore18_opt_0.sw_bitcell_opt_b6_1.bot.t74 VSS 3.42791f
C6215 oa_sar8_acore18_opt_0.sw_bitcell_opt_b6_1.bot.t79 VSS 3.38536f
C6216 oa_sar8_acore18_opt_0.sw_bitcell_opt_b6_1.bot.t69 VSS 3.42791f
C6217 oa_sar8_acore18_opt_0.sw_bitcell_opt_b7_1.bot.t169 VSS 7.7017f
C6218 oa_sar8_acore18_opt_0.sw_bitcell_opt_b7_1.bot.t0 VSS 2.27364f
C6219 oa_sar8_acore18_opt_0.sw_bitcell_opt_b7_1.bot.t35 VSS 2.67113f
C6220 oa_sar8_acore18_opt_0.sw_bitcell_opt_b7_1.bot.t40 VSS 2.73068f
C6221 oa_sar8_acore18_opt_0.sw_bitcell_opt_b7_1.bot.t30 VSS 2.67113f
C6222 oa_sar8_acore18_opt_0.sw_bitcell_opt_b7_1.bot.t25 VSS 2.33724f
C6223 oa_sar8_acore18_opt_0.sw_bitcell_opt_b7_1.bot.t21 VSS 1.26128f
C6224 oa_sar8_acore18_opt_0.sw_bitcell_opt_b7_1.bot.n0 VSS 0.51124f
C6225 oa_sar8_acore18_opt_0.sw_bitcell_opt_b7_1.bot.t14 VSS 2.67113f
C6226 oa_sar8_acore18_opt_0.sw_bitcell_opt_b7_1.bot.t19 VSS 2.73068f
C6227 oa_sar8_acore18_opt_0.sw_bitcell_opt_b7_1.bot.t9 VSS 6.46539f
C6228 oa_sar8_acore18_opt_0.sw_bitcell_opt_b7_1.bot.t4 VSS 2.33724f
C6229 oa_sar8_acore18_opt_0.sw_bitcell_opt_b7_1.bot.t1 VSS 1.26128f
C6230 oa_sar8_acore18_opt_0.sw_bitcell_opt_b7_1.bot.n1 VSS 0.6195f
C6231 oa_sar8_acore18_opt_0.sw_bitcell_opt_b7_1.bot.t57 VSS 2.67113f
C6232 oa_sar8_acore18_opt_0.sw_bitcell_opt_b7_1.bot.t62 VSS 2.73068f
C6233 oa_sar8_acore18_opt_0.sw_bitcell_opt_b7_1.bot.t52 VSS 2.67113f
C6234 oa_sar8_acore18_opt_0.sw_bitcell_opt_b7_1.bot.t47 VSS 2.33724f
C6235 oa_sar8_acore18_opt_0.sw_bitcell_opt_b7_1.bot.t43 VSS 1.26128f
C6236 oa_sar8_acore18_opt_0.sw_bitcell_opt_b7_1.bot.n2 VSS 0.6195f
C6237 oa_sar8_acore18_opt_0.sw_bitcell_opt_b7_1.bot.t78 VSS 2.67113f
C6238 oa_sar8_acore18_opt_0.sw_bitcell_opt_b7_1.bot.t83 VSS 2.73068f
C6239 oa_sar8_acore18_opt_0.sw_bitcell_opt_b7_1.bot.t73 VSS 2.67113f
C6240 oa_sar8_acore18_opt_0.sw_bitcell_opt_b7_1.bot.t68 VSS 2.33724f
C6241 oa_sar8_acore18_opt_0.sw_bitcell_opt_b7_1.bot.t64 VSS 1.26128f
C6242 oa_sar8_acore18_opt_0.sw_bitcell_opt_b7_1.bot.n3 VSS 2.18335f
C6243 oa_sar8_acore18_opt_0.sw_bitcell_opt_b7_1.bot.t99 VSS 2.67113f
C6244 oa_sar8_acore18_opt_0.sw_bitcell_opt_b7_1.bot.t104 VSS 2.73068f
C6245 oa_sar8_acore18_opt_0.sw_bitcell_opt_b7_1.bot.t94 VSS 2.67113f
C6246 oa_sar8_acore18_opt_0.sw_bitcell_opt_b7_1.bot.t89 VSS 2.33724f
C6247 oa_sar8_acore18_opt_0.sw_bitcell_opt_b7_1.bot.t85 VSS 1.26128f
C6248 oa_sar8_acore18_opt_0.sw_bitcell_opt_b7_1.bot.n4 VSS 2.18335f
C6249 oa_sar8_acore18_opt_0.sw_bitcell_opt_b7_1.bot.t120 VSS 2.67113f
C6250 oa_sar8_acore18_opt_0.sw_bitcell_opt_b7_1.bot.t125 VSS 2.73068f
C6251 oa_sar8_acore18_opt_0.sw_bitcell_opt_b7_1.bot.t115 VSS 2.67113f
C6252 oa_sar8_acore18_opt_0.sw_bitcell_opt_b7_1.bot.t110 VSS 2.33724f
C6253 oa_sar8_acore18_opt_0.sw_bitcell_opt_b7_1.bot.t106 VSS 1.26128f
C6254 oa_sar8_acore18_opt_0.sw_bitcell_opt_b7_1.bot.n5 VSS 0.6195f
C6255 oa_sar8_acore18_opt_0.sw_bitcell_opt_b7_1.bot.t141 VSS 2.67113f
C6256 oa_sar8_acore18_opt_0.sw_bitcell_opt_b7_1.bot.t146 VSS 2.73068f
C6257 oa_sar8_acore18_opt_0.sw_bitcell_opt_b7_1.bot.t136 VSS 2.67113f
C6258 oa_sar8_acore18_opt_0.sw_bitcell_opt_b7_1.bot.t131 VSS 2.33724f
C6259 oa_sar8_acore18_opt_0.sw_bitcell_opt_b7_1.bot.t127 VSS 1.26128f
C6260 oa_sar8_acore18_opt_0.sw_bitcell_opt_b7_1.bot.n6 VSS 0.6195f
C6261 oa_sar8_acore18_opt_0.sw_bitcell_opt_b7_1.bot.t162 VSS 2.67113f
C6262 oa_sar8_acore18_opt_0.sw_bitcell_opt_b7_1.bot.t167 VSS 10.1701f
C6263 oa_sar8_acore18_opt_0.sw_bitcell_opt_b7_1.bot.t157 VSS 2.67113f
C6264 oa_sar8_acore18_opt_0.sw_bitcell_opt_b7_1.bot.t152 VSS 2.33724f
C6265 oa_sar8_acore18_opt_0.sw_bitcell_opt_b7_1.bot.t148 VSS 1.26128f
C6266 oa_sar8_acore18_opt_0.sw_bitcell_opt_b7_1.bot.n7 VSS 1.21048f
C6267 oa_sar8_acore18_opt_0.sw_bitcell_opt_b7_1.bot.n8 VSS 0.5584f
C6268 oa_sar8_acore18_opt_0.sw_bitcell_opt_b7_0.bot.t1 VSS 0.48204f
C6269 oa_sar8_acore18_opt_0.sw_bitcell_opt_b7_0.bot.t0 VSS 18.32115f
C6270 oa_sar8_acore18_opt_0.sw_bitcell_opt_b7_0.bot.t35 VSS 2.87971f
C6271 oa_sar8_acore18_opt_0.sw_bitcell_opt_b7_0.bot.t40 VSS 1.55402f
C6272 oa_sar8_acore18_opt_0.sw_bitcell_opt_b7_0.bot.t30 VSS 3.29109f
C6273 oa_sar8_acore18_opt_0.sw_bitcell_opt_b7_0.bot.t25 VSS 3.29109f
C6274 oa_sar8_acore18_opt_0.sw_bitcell_opt_b7_0.bot.t22 VSS 3.36446f
C6275 oa_sar8_acore18_opt_0.sw_bitcell_opt_b7_0.bot.n0 VSS 0.6299f
C6276 oa_sar8_acore18_opt_0.sw_bitcell_opt_b7_0.bot.t15 VSS 7.04696f
C6277 oa_sar8_acore18_opt_0.sw_bitcell_opt_b7_0.bot.t20 VSS 1.55402f
C6278 oa_sar8_acore18_opt_0.sw_bitcell_opt_b7_0.bot.t10 VSS 3.29109f
C6279 oa_sar8_acore18_opt_0.sw_bitcell_opt_b7_0.bot.t5 VSS 3.29109f
C6280 oa_sar8_acore18_opt_0.sw_bitcell_opt_b7_0.bot.t2 VSS 3.36446f
C6281 oa_sar8_acore18_opt_0.sw_bitcell_opt_b7_0.bot.n1 VSS 0.76328f
C6282 oa_sar8_acore18_opt_0.sw_bitcell_opt_b7_0.bot.t57 VSS 2.87971f
C6283 oa_sar8_acore18_opt_0.sw_bitcell_opt_b7_0.bot.t62 VSS 1.55402f
C6284 oa_sar8_acore18_opt_0.sw_bitcell_opt_b7_0.bot.t52 VSS 3.29109f
C6285 oa_sar8_acore18_opt_0.sw_bitcell_opt_b7_0.bot.t47 VSS 3.29109f
C6286 oa_sar8_acore18_opt_0.sw_bitcell_opt_b7_0.bot.t44 VSS 3.36446f
C6287 oa_sar8_acore18_opt_0.sw_bitcell_opt_b7_0.bot.n2 VSS 0.76328f
C6288 oa_sar8_acore18_opt_0.sw_bitcell_opt_b7_0.bot.t78 VSS 2.87971f
C6289 oa_sar8_acore18_opt_0.sw_bitcell_opt_b7_0.bot.t83 VSS 1.55402f
C6290 oa_sar8_acore18_opt_0.sw_bitcell_opt_b7_0.bot.t73 VSS 3.29109f
C6291 oa_sar8_acore18_opt_0.sw_bitcell_opt_b7_0.bot.t68 VSS 3.29109f
C6292 oa_sar8_acore18_opt_0.sw_bitcell_opt_b7_0.bot.t65 VSS 3.36446f
C6293 oa_sar8_acore18_opt_0.sw_bitcell_opt_b7_0.bot.n3 VSS 2.6901f
C6294 oa_sar8_acore18_opt_0.sw_bitcell_opt_b7_0.bot.t99 VSS 2.87971f
C6295 oa_sar8_acore18_opt_0.sw_bitcell_opt_b7_0.bot.t104 VSS 1.55402f
C6296 oa_sar8_acore18_opt_0.sw_bitcell_opt_b7_0.bot.t94 VSS 0.13852p
C6297 oa_sar8_acore18_opt_0.sw_bitcell_opt_b7_0.bot.t89 VSS 3.29109f
C6298 oa_sar8_acore18_opt_0.sw_bitcell_opt_b7_0.bot.t86 VSS 3.36446f
C6299 oa_sar8_acore18_opt_0.sw_bitcell_opt_b7_0.bot.n4 VSS 2.6901f
C6300 oa_sar8_acore18_opt_0.sw_bitcell_opt_b7_0.bot.t120 VSS 2.87971f
C6301 oa_sar8_acore18_opt_0.sw_bitcell_opt_b7_0.bot.t125 VSS 1.55402f
C6302 oa_sar8_acore18_opt_0.sw_bitcell_opt_b7_0.bot.t115 VSS 3.29109f
C6303 oa_sar8_acore18_opt_0.sw_bitcell_opt_b7_0.bot.t110 VSS 3.29109f
C6304 oa_sar8_acore18_opt_0.sw_bitcell_opt_b7_0.bot.t107 VSS 3.36446f
C6305 oa_sar8_acore18_opt_0.sw_bitcell_opt_b7_0.bot.n5 VSS 0.76328f
C6306 oa_sar8_acore18_opt_0.sw_bitcell_opt_b7_0.bot.t141 VSS 2.87971f
C6307 oa_sar8_acore18_opt_0.sw_bitcell_opt_b7_0.bot.t146 VSS 1.55402f
C6308 oa_sar8_acore18_opt_0.sw_bitcell_opt_b7_0.bot.t136 VSS 3.29109f
C6309 oa_sar8_acore18_opt_0.sw_bitcell_opt_b7_0.bot.t131 VSS 3.29109f
C6310 oa_sar8_acore18_opt_0.sw_bitcell_opt_b7_0.bot.t128 VSS 3.36446f
C6311 oa_sar8_acore18_opt_0.sw_bitcell_opt_b7_0.bot.n6 VSS 0.76328f
C6312 oa_sar8_acore18_opt_0.sw_bitcell_opt_b7_0.bot.t162 VSS 2.87971f
C6313 oa_sar8_acore18_opt_0.sw_bitcell_opt_b7_0.bot.t167 VSS 1.55402f
C6314 oa_sar8_acore18_opt_0.sw_bitcell_opt_b7_0.bot.t157 VSS 3.29109f
C6315 oa_sar8_acore18_opt_0.sw_bitcell_opt_b7_0.bot.t152 VSS 11.16469f
C6316 oa_sar8_acore18_opt_0.sw_bitcell_opt_b7_0.bot.t149 VSS 3.36446f
C6317 oa_sar8_acore18_opt_0.sw_bitcell_opt_b7_0.bot.n7 VSS 1.41498f
C6318 oa_sar8_acore18_opt_0.sw_bitcell_opt_b7_0.bot.n8 VSS 0.73211f
C6319 oa_sar8_acore18_opt_0.sw_bitcell_opt_b6_0.bot.t75 VSS 5.91855f
C6320 oa_sar8_acore18_opt_0.sw_bitcell_opt_b6_0.bot.t55 VSS 5.91855f
C6321 oa_sar8_acore18_opt_0.sw_bitcell_opt_b6_0.bot.t35 VSS 5.91855f
C6322 oa_sar8_acore18_opt_0.sw_bitcell_opt_b6_0.bot.t15 VSS 5.91855f
C6323 oa_sar8_acore18_opt_0.sw_bitcell_opt_b6_0.bot.n0 VSS 6.7619f
C6324 oa_sar8_acore18_opt_0.sw_bitcell_opt_b6_0.bot.n1 VSS 4.34875f
C6325 oa_sar8_acore18_opt_0.sw_bitcell_opt_b6_0.bot.t0 VSS 1.24593f
C6326 oa_sar8_acore18_opt_0.sw_bitcell_opt_b6_0.bot.t1 VSS 3.91986f
C6327 oa_sar8_acore18_opt_0.sw_bitcell_opt_b6_0.bot.t10 VSS 4.39325f
C6328 oa_sar8_acore18_opt_0.sw_bitcell_opt_b6_0.bot.t5 VSS 4.39325f
C6329 oa_sar8_acore18_opt_0.sw_bitcell_opt_b6_0.bot.t2 VSS 4.33872f
C6330 oa_sar8_acore18_opt_0.sw_bitcell_opt_b6_0.bot.t30 VSS 4.39325f
C6331 oa_sar8_acore18_opt_0.sw_bitcell_opt_b6_0.bot.t25 VSS 4.39325f
C6332 oa_sar8_acore18_opt_0.sw_bitcell_opt_b6_0.bot.t22 VSS 4.33872f
C6333 oa_sar8_acore18_opt_0.sw_bitcell_opt_b6_0.bot.t50 VSS 4.39325f
C6334 oa_sar8_acore18_opt_0.sw_bitcell_opt_b6_0.bot.t45 VSS 4.39325f
C6335 oa_sar8_acore18_opt_0.sw_bitcell_opt_b6_0.bot.t42 VSS 4.33872f
C6336 oa_sar8_acore18_opt_0.sw_bitcell_opt_b6_0.bot.t70 VSS 4.39325f
C6337 oa_sar8_acore18_opt_0.sw_bitcell_opt_b6_0.bot.t65 VSS 4.39325f
C6338 oa_sar8_acore18_opt_0.sw_bitcell_opt_b6_0.bot.t62 VSS 4.33872f
C6339 oa_sar8_acore18_opt_0.sw_bitcell_opt_b5_0.bot.t35 VSS 7.03813f
C6340 oa_sar8_acore18_opt_0.sw_bitcell_opt_b5_0.bot.t15 VSS 7.03813f
C6341 oa_sar8_acore18_opt_0.sw_bitcell_opt_b5_0.bot.t1 VSS 8.13206f
C6342 oa_sar8_acore18_opt_0.sw_bitcell_opt_b5_0.bot.t0 VSS 3.72243f
C6343 oa_sar8_acore18_opt_0.sw_bitcell_opt_b5_0.bot.t10 VSS 5.2243f
C6344 oa_sar8_acore18_opt_0.sw_bitcell_opt_b5_0.bot.t5 VSS 5.2243f
C6345 oa_sar8_acore18_opt_0.sw_bitcell_opt_b5_0.bot.t2 VSS 4.97472f
C6346 oa_sar8_acore18_opt_0.sw_bitcell_opt_b5_0.bot.n0 VSS 3.96359f
C6347 oa_sar8_acore18_opt_0.sw_bitcell_opt_b5_0.bot.t30 VSS 5.2243f
C6348 oa_sar8_acore18_opt_0.sw_bitcell_opt_b5_0.bot.t25 VSS 5.2243f
C6349 oa_sar8_acore18_opt_0.sw_bitcell_opt_b5_0.bot.t22 VSS 4.97472f
C6350 oa_sar8_acore18_opt_0.sw_bitcell_opt_b5_0.bot.n1 VSS 7.81737f
C6351 oa_sar8_acore18_opt_0.sw_bitcell_opt_b4_0.bot.n0 VSS 0.99802f
C6352 oa_sar8_acore18_opt_0.sw_bitcell_opt_b4_0.bot.n1 VSS 1.5618f
C6353 oa_sar8_acore18_opt_0.sw_bitcell_opt_b4_0.bot.n2 VSS 0.96072f
C6354 oa_sar8_acore18_opt_0.sw_bitcell_opt_b4_0.bot.n3 VSS 1.79521f
C6355 oa_sar8_acore18_opt_0.sw_bitcell_opt_b4_0.bot.n4 VSS 0.96072f
C6356 oa_sar8_acore18_opt_0.sw_bitcell_opt_b4_0.bot.n5 VSS 0.99802f
C6357 oa_sar8_acore18_opt_0.sw_bitcell_opt_b4_0.bot.n6 VSS 1.28919f
C6358 oa_sar8_acore18_opt_0.sw_bitcell_opt_b4_0.bot.t1 VSS 7.50415f
C6359 oa_sar8_acore18_opt_0.sw_bitcell_opt_b4_0.bot.t0 VSS 4.14586f
C6360 oa_sar8_acore18_opt_0.sw_bitcell_opt_b4_0.bot.t16 VSS 1.822f
C6361 oa_sar8_acore18_opt_0.sw_bitcell_opt_b4_0.bot.t14 VSS 1.81437f
C6362 oa_sar8_acore18_opt_0.sw_bitcell_opt_b4_0.bot.t12 VSS 1.81437f
C6363 oa_sar8_acore18_opt_0.sw_bitcell_opt_b4_0.bot.t10 VSS 1.81437f
C6364 oa_sar8_acore18_opt_0.sw_bitcell_opt_b4_0.bot.t8 VSS 1.81437f
C6365 oa_sar8_acore18_opt_0.sw_bitcell_opt_b4_0.bot.t6 VSS 1.81437f
C6366 oa_sar8_acore18_opt_0.sw_bitcell_opt_b4_0.bot.t4 VSS 1.81437f
C6367 oa_sar8_acore18_opt_0.sw_bitcell_opt_b4_0.bot.t2 VSS 1.81437f
C6368 oa_sar8_acore18_opt_0.sw_bitcell_opt_b4_0.bot.t32 VSS 1.35407f
C6369 oa_sar8_acore18_opt_0.sw_bitcell_opt_b4_0.bot.t30 VSS 1.35407f
C6370 oa_sar8_acore18_opt_0.sw_bitcell_opt_b4_0.bot.t28 VSS 1.35407f
C6371 oa_sar8_acore18_opt_0.sw_bitcell_opt_b4_0.bot.t26 VSS 1.35407f
C6372 oa_sar8_acore18_opt_0.sw_bitcell_opt_b4_0.bot.t24 VSS 1.35407f
C6373 oa_sar8_acore18_opt_0.sw_bitcell_opt_b4_0.bot.t22 VSS 1.35407f
C6374 oa_sar8_acore18_opt_0.sw_bitcell_opt_b4_0.bot.t20 VSS 1.35407f
C6375 oa_sar8_acore18_opt_0.sw_bitcell_opt_b4_0.bot.t18 VSS 1.35407f
C6376 oa_sar8_acore18_opt_0.sw_bitcell_opt_b4_0.bot.n7 VSS 12.3535f
C6377 oa_sar8_acore18_opt_0.sw_bitcell_opt_b3_0.bot.n0 VSS 1.17173f
C6378 oa_sar8_acore18_opt_0.sw_bitcell_opt_b3_0.bot.n1 VSS 1.32434f
C6379 oa_sar8_acore18_opt_0.sw_bitcell_opt_b3_0.bot.n2 VSS 4.25401f
C6380 oa_sar8_acore18_opt_0.sw_bitcell_opt_b3_0.bot.t1 VSS 7.62583f
C6381 oa_sar8_acore18_opt_0.sw_bitcell_opt_b3_0.bot.t0 VSS 4.86896f
C6382 oa_sar8_acore18_opt_0.sw_bitcell_opt_b3_0.bot.t16 VSS 2.01509f
C6383 oa_sar8_acore18_opt_0.sw_bitcell_opt_b3_0.bot.t14 VSS 1.93412f
C6384 oa_sar8_acore18_opt_0.sw_bitcell_opt_b3_0.bot.t12 VSS 1.93412f
C6385 oa_sar8_acore18_opt_0.sw_bitcell_opt_b3_0.bot.t10 VSS 1.93412f
C6386 oa_sar8_acore18_opt_0.sw_bitcell_opt_b3_0.bot.t8 VSS 2.32005f
C6387 oa_sar8_acore18_opt_0.sw_bitcell_opt_b3_0.bot.t6 VSS 2.32005f
C6388 oa_sar8_acore18_opt_0.sw_bitcell_opt_b3_0.bot.t4 VSS 2.32005f
C6389 oa_sar8_acore18_opt_0.sw_bitcell_opt_b3_0.bot.t2 VSS 2.32005f
C6390 oa_sar8_acore18_opt_0.sw_bitcell_opt_b3_0.bot.n3 VSS 3.12811f
C6391 oa_sar8_acore18_opt_0.sw_bitcell_opt_b3_0.bot.n4 VSS 18.0808f
C6392 oa_sar8_acore18_opt_0.sw_bitcell_opt_b2_0.bot.n0 VSS 6.1145f
C6393 oa_sar8_acore18_opt_0.sw_bitcell_opt_b2_0.bot.t1 VSS 8.04075f
C6394 oa_sar8_acore18_opt_0.sw_bitcell_opt_b2_0.bot.t0 VSS 5.1593f
C6395 oa_sar8_acore18_opt_0.sw_bitcell_opt_b2_0.bot.t8 VSS 2.36419f
C6396 oa_sar8_acore18_opt_0.sw_bitcell_opt_b2_0.bot.t6 VSS 2.31128f
C6397 oa_sar8_acore18_opt_0.sw_bitcell_opt_b2_0.bot.n1 VSS 5.45802f
C6398 oa_sar8_acore18_opt_0.sw_bitcell_opt_b2_0.bot.t4 VSS 2.48554f
C6399 oa_sar8_acore18_opt_0.sw_bitcell_opt_b2_0.bot.t2 VSS 2.48554f
C6400 oa_sar8_acore18_opt_0.sw_bitcell_opt_b2_0.bot.n2 VSS 20.0745f
C6401 oa_sar8_acore18_opt_0.sw_bitcell_opt_b1_0.bot.t1 VSS 8.66118f
C6402 oa_sar8_acore18_opt_0.sw_bitcell_opt_b1_0.bot.t0 VSS 5.31354f
C6403 oa_sar8_acore18_opt_0.sw_bitcell_opt_b1_0.bot.t4 VSS 4.19215f
C6404 oa_sar8_acore18_opt_0.sw_bitcell_opt_b1_0.bot.t2 VSS 2.56668f
C6405 oa_sar8_acore18_opt_0.sw_bitcell_opt_b1_0.bot.n0 VSS 11.2552f
C6406 oa_sar8_acore18_opt_0.sw_bitcell_opt_b1_0.bot.n1 VSS 21.9253f
C6407 oa_sar8_acore18_opt_0.sw_bitcell_opt_b0_0.bot.t1 VSS 9.60675f
C6408 oa_sar8_acore18_opt_0.sw_bitcell_opt_b0_0.bot.t0 VSS 5.5688f
C6409 oa_sar8_acore18_opt_0.sw_bitcell_opt_b0_0.bot.t2 VSS 5.67893f
C6410 oa_sar8_acore18_opt_0.sw_bitcell_opt_b0_0.bot.n0 VSS 34.3903f
C6411 oa_sar8_acore18_opt_0.sw_bitcell_opt_term_0.bot.t1 VSS 0.80495f
C6412 oa_sar8_acore18_opt_0.sw_bitcell_opt_term_0.bot.t0 VSS 5.31831f
C6413 oa_sar8_acore18_opt_0.sw_bitcell_opt_term_0.bot.t2 VSS 3.27067f
C6414 oa_sar8_acore18_opt_0.sw_bitcell_opt_term_0.bot.n0 VSS 31.4411f
C6415 oa_sar8_acore18_opt_0.sw_bitcell_opt_term_0.gb.t1 VSS 1.57798f
C6416 VSS.t552 VSS 0.25008f
C6417 VSS.t151 VSS 0.25008f
C6418 VSS.t94 VSS 0.33344f
C6419 VSS.t109 VSS 0.16672f
C6420 VSS.t241 VSS 10.3548f
C6421 VSS.t325 VSS 0.07365f
C6422 VSS.t529 VSS 0.16672f
C6423 VSS.t1070 VSS 0.21257f
C6424 VSS.t193 VSS 0.16672f
C6425 VSS.t606 VSS 0.3892f
C6426 VSS.t393 VSS 0.25008f
C6427 VSS.t331 VSS 0.16672f
C6428 VSS.t125 VSS 0.16672f
C6429 VSS.t106 VSS 0.16672f
C6430 VSS.t69 VSS 0.16672f
C6431 VSS.t40 VSS 0.64839f
C6432 VSS.t854 VSS 0.10817f
C6433 VSS.t852 VSS 0.55504f
C6434 VSS.t369 VSS 1.11902f
C6435 VSS.t425 VSS 0.16672f
C6436 VSS.t1054 VSS 0.07693f
C6437 VSS.t1064 VSS 0.66509f
C6438 VSS.t510 VSS 0.10991f
C6439 VSS.t436 VSS 0.7438f
C6440 VSS.t413 VSS 0.7438f
C6441 VSS.t544 VSS 0.7438f
C6442 VSS.t439 VSS 0.7438f
C6443 VSS.t343 VSS 0.14312f
C6444 VSS.t464 VSS 0.04168f
C6445 VSS.t113 VSS 1.09973f
C6446 VSS.t101 VSS 0.70289f
C6447 VSS.t186 VSS 0.2956f
C6448 VSS.t764 VSS 0.20189f
C6449 VSS.t787 VSS 0.57392f
C6450 VSS.t767 VSS 0.18903f
C6451 VSS.t770 VSS 0.17031f
C6452 VSS.t769 VSS 0.17031f
C6453 VSS.t794 VSS 0.15236f
C6454 VSS.t779 VSS 0.10298f
C6455 VSS.t782 VSS 0.17002f
C6456 VSS.t312 VSS 0.17002f
C6457 VSS.t263 VSS 0.15278f
C6458 VSS.t103 VSS 0.85822f
C6459 VSS.t205 VSS 0.08884f
C6460 VSS.t253 VSS 0.2923f
C6461 VSS.t616 VSS 0.2341f
C6462 VSS.t711 VSS 0.12781f
C6463 VSS.t62 VSS 2.38893f
C6464 VSS.t75 VSS 0.71545f
C6465 VSS.t684 VSS 0.62717f
C6466 VSS.t677 VSS 3.72577f
C6467 VSS.t733 VSS 0.1074f
C6468 VSS.t727 VSS 0.65325f
C6469 VSS.t231 VSS 0.56544f
C6470 VSS.t718 VSS 0.02316f
C6471 VSS.t749 VSS 0.23497f
C6472 VSS.t720 VSS 0.02316f
C6473 VSS.t741 VSS 0.82357f
C6474 VSS.t22 VSS 3.43861f
C6475 VSS.t485 VSS 0.5731f
C6476 VSS.t174 VSS 1.30534f
C6477 VSS.t82 VSS 0.12694f
C6478 VSS.t25 VSS 0.08285f
C6479 VSS.t837 VSS 0.56331f
C6480 VSS.t133 VSS 0.08476f
C6481 VSS.t33 VSS 0.24767f
C6482 VSS.t60 VSS 0.16125f
C6483 VSS.t834 VSS 0.55476f
C6484 VSS.t58 VSS 0.38694f
C6485 VSS.t832 VSS 0.3502f
C6486 VSS.t66 VSS 0.01904f
C6487 VSS.t154 VSS 3.09163f
C6488 VSS.t982 VSS 2.22941f
C6489 VSS.t984 VSS 2.09357f
C6490 VSS.t979 VSS 0.22214f
C6491 VSS.t977 VSS 0.60082f
C6492 VSS.t972 VSS 0.21615f
C6493 VSS.t966 VSS 0.17176f
C6494 VSS.t967 VSS 0.64065f
C6495 VSS.t962 VSS 1.33961f
C6496 VSS.t957 VSS 2.7738f
C6497 VSS.t11 VSS 12.31392f
C6498 VSS.t64 VSS 0.09981f
C6499 VSS.t350 VSS 0.09388f
C6500 VSS.t148 VSS 0.33967f
C6501 VSS.t931 VSS 0.6243f
C6502 VSS.t920 VSS 0.59034f
C6503 VSS.t84 VSS 0.31648f
C6504 VSS.t892 VSS 12.56136f
C6505 VSS.t886 VSS 0.21775f
C6506 VSS.t887 VSS 0.74724f
C6507 VSS.t894 VSS 4.18712f
C6508 VSS.t897 VSS 1.63059f
C6509 VSS.t899 VSS 0.32612f
C6510 VSS.t182 VSS 8.25273f
C6511 VSS.t905 VSS 0.0973f
C6512 VSS.t368 VSS 0.40167f
C6513 VSS.t283 VSS 0.54953f
C6514 VSS.t918 VSS 0.26293f
C6515 VSS.t372 VSS 0.61472f
C6516 VSS.t417 VSS 0.8526f
C6517 VSS.t403 VSS 0.8241f
C6518 VSS.t172 VSS 0.27892f
C6519 VSS.t429 VSS 0.06355f
C6520 VSS.t88 VSS 1.3341f
C6521 VSS.t237 VSS 0.3662f
C6522 VSS.t562 VSS 0.02223f
C6523 VSS.t90 VSS 0.15832f
C6524 VSS.t850 VSS 0.41521f
C6525 VSS.t160 VSS 0.64292f
C6526 VSS.t295 VSS 0.56748f
C6527 VSS.t54 VSS 0.02084f
C6528 VSS.t37 VSS 0.04202f
C6529 VSS.t190 VSS 4.86899f
C6530 VSS.t858 VSS 4.14464f
C6531 VSS.t56 VSS 0.34088f
C6532 VSS.t857 VSS 4.14464f
C6533 VSS.t50 VSS 2.78685f
C6534 VSS.t166 VSS 0.48139f
C6535 VSS.t31 VSS 2.72542f
C6536 VSS.t432 VSS 0.38845f
C6537 VSS.t1202 VSS 0.73605f
C6538 VSS.t1229 VSS 0.3641f
C6539 VSS.t354 VSS 0.77232f
C6540 VSS.t848 VSS 2.25667f
C6541 VSS.t293 VSS 2.25667f
C6542 VSS.t48 VSS 0.13584f
C6543 VSS.t20 VSS 0.30613f
C6544 VSS.t27 VSS 0.17769f
C6545 VSS.t260 VSS 0.36203f
C6546 VSS.t137 VSS 0.23359f
C6547 VSS.t178 VSS 0.3494f
C6548 VSS.t273 VSS 0.14851f
C6549 VSS.t780 VSS 0.10298f
C6550 VSS.t777 VSS 0.12746f
C6551 VSS.t1029 VSS 2.26191f
C6552 VSS.t1028 VSS 1.96233f
C6553 VSS.t1044 VSS 0.12732f
C6554 VSS.t1049 VSS 0.4326f
C6555 VSS.t1046 VSS 0.12732f
C6556 VSS.t1051 VSS 0.34847f
C6557 VSS.t1031 VSS 0.29959f
C6558 VSS.t98 VSS 0.88237f
C6559 VSS.t9 VSS 12.54857f
C6560 VSS.t434 VSS 0.20411f
C6561 VSS.t217 VSS 13.67576f
C6562 VSS.t220 VSS 0.11392f
C6563 VSS.t271 VSS 0.43504f
C6564 VSS.t1073 VSS 0.62091f
C6565 VSS.t1068 VSS 0.32248f
C6566 VSS.t239 VSS 1.10114f
C6567 VSS.t1056 VSS 0.07693f
C6568 VDD.t13 VSS 16.6039f
C6569 VDD.n1 VSS 0.27167f
C6570 VDD.t54 VSS 0.07116f
C6571 VDD.n2 VSS 0.037f
C6572 VDD.n3 VSS 0.05053f
C6573 VDD.t323 VSS 1.56558f
C6574 VDD.n7 VSS 0.01399f
C6575 VDD.n8 VSS 0.08756f
C6576 VDD.n9 VSS 0.01394f
C6577 VDD.n10 VSS 0.08663f
C6578 VDD.n11 VSS 0.10255f
C6579 VDD.n12 VSS 0.24206f
C6580 VDD.n13 VSS 0.08756f
C6581 VDD.n14 VSS 0.01394f
C6582 VDD.n15 VSS 0.16841f
C6583 VDD.n16 VSS 0.10255f
C6584 VDD.n17 VSS 0.24206f
C6585 VDD.n18 VSS 0.07579f
C6586 VDD.n20 VSS 0.01684f
C6587 VDD.n21 VSS 0.07579f
C6588 VDD.t325 VSS 1.40654f
C6589 VDD.n23 VSS 0.05053f
C6590 VDD.n24 VSS 0.07872f
C6591 VDD.n25 VSS 0.05053f
C6592 VDD.n26 VSS 0.03744f
C6593 VDD.t340 VSS 2.36864f
C6594 VDD.n27 VSS 0.06618f
C6595 VDD.n28 VSS 0.28286f
C6596 VDD.n29 VSS 0.04664f
C6597 VDD.n30 VSS 0.01902f
C6598 VDD.n31 VSS 0.06587f
C6599 VDD.n32 VSS 0.09194f
C6600 VDD.n33 VSS 0.03974f
C6601 VDD.n34 VSS 0.17231f
C6602 VDD.n35 VSS 0.10302f
C6603 VDD.n36 VSS 0.31819f
C6604 VDD.n37 VSS 0.18246f
C6605 VDD.n38 VSS 0.25553f
C6606 VDD.n39 VSS 0.01992f
C6607 VDD.n40 VSS 0.3143f
C6608 VDD.n41 VSS 0.18977f
C6609 VDD.n43 VSS 0.26218f
C6610 VDD.n44 VSS 0.1226f
C6611 VDD.n45 VSS 0.01328f
C6612 VDD.n46 VSS 0.04618f
C6613 VDD.n47 VSS 0.08681f
C6614 VDD.n48 VSS 0.2423f
C6615 VDD.n49 VSS 0.12252f
C6616 VDD.n50 VSS 0.2423f
C6617 VDD.n51 VSS 0.12252f
C6618 VDD.n52 VSS 0.2423f
C6619 VDD.n53 VSS 0.12252f
C6620 VDD.n54 VSS 0.15117f
C6621 VDD.n55 VSS 0.21573f
C6622 VDD.n58 VSS 0.1499f
C6623 VDD.n59 VSS 0.11715f
C6624 VDD.n60 VSS 0.11509f
C6625 VDD.n61 VSS 0.01646f
C6626 VDD.n63 VSS 0.04501f
C6627 VDD.n64 VSS 0.0365f
C6628 VDD.n65 VSS 0.33793f
C6629 VDD.n66 VSS 0.20942f
C6630 VDD.n67 VSS 0.22237f
C6631 VDD.n68 VSS 0.03354f
C6632 VDD.n69 VSS 0.0892f
C6633 VDD.n70 VSS 0.03317f
C6634 VDD.n71 VSS 0.01645f
C6635 VDD.n72 VSS 0.03907f
C6636 VDD.n74 VSS 0.03256f
C6637 VDD.n75 VSS 0.02245f
C6638 VDD.n76 VSS 0.02601f
C6639 VDD.n78 VSS 0.04557f
C6640 VDD.n79 VSS 0.35094f
C6641 VDD.n81 VSS 0.29741f
C6642 VDD.n82 VSS 0.16242f
C6643 VDD.n83 VSS 0.03967f
C6644 VDD.n84 VSS 0.25182f
C6645 VDD.n85 VSS 0.03308f
C6646 VDD.n86 VSS 0.02287f
C6647 VDD.n87 VSS 0.02666f
C6648 VDD.n88 VSS 0.3143f
C6649 VDD.n89 VSS 0.08423f
C6650 VDD.n90 VSS 0.02559f
C6651 VDD.n91 VSS 0.2343f
C6652 VDD.n92 VSS 0.05895f
C6653 VDD.n93 VSS 0.10924f
C6654 VDD.n94 VSS 0.10946f
C6655 VDD.n95 VSS 0.031f
C6656 VDD.n96 VSS 0.31594f
C6657 VDD.n98 VSS 0.05142f
C6658 VDD.n99 VSS 0.07579f
C6659 VDD.n100 VSS 0.08463f
C6660 VDD.n101 VSS 0.10025f
C6661 VDD.n102 VSS 0.25554f
C6662 VDD.n103 VSS 0.01992f
C6663 VDD.n104 VSS 0.27725f
C6664 VDD.n105 VSS 0.15504f
C6665 VDD.n107 VSS 0.01965f
C6666 VDD.n108 VSS 0.03905f
C6667 VDD.n109 VSS 0.08389f
C6668 VDD.n110 VSS 0.17768f
C6669 VDD.n111 VSS 0.03902f
C6670 VDD.n112 VSS 0.08233f
C6671 VDD.t37 VSS 14.88189f
C6672 VDD.n113 VSS 0.2736f
C6673 VDD.n114 VSS 0.06031f
C6674 VDD.n117 VSS 0.04552f
C6675 VDD.n119 VSS 0.04702f
C6676 VDD.n121 VSS 0.09263f
C6677 VDD.n122 VSS 0.09457f
C6678 VDD.t162 VSS 9.82094f
C6679 VDD.n123 VSS 3.76923f
C6680 VDD.n124 VSS 0.18096f
C6681 VDD.n125 VSS 0.27917f
C6682 VDD.n126 VSS 0.15863f
C6683 VDD.n129 VSS 0.02583f
C6684 VDD.n130 VSS 0.02062f
C6685 VDD.n131 VSS 0.27622f
C6686 VDD.n132 VSS 0.01832f
C6687 VDD.n134 VSS 0.02574f
C6688 VDD.t315 VSS 0.91091f
C6689 VDD.n135 VSS 0.04233f
C6690 VDD.n137 VSS 0.21896f
C6691 VDD.n140 VSS 0.11892f
C6692 VDD.n141 VSS 0.14481f
C6693 VDD.n142 VSS 0.07263f
C6694 VDD.n143 VSS 0.29667f
C6695 VDD.n144 VSS 0.19625f
C6696 VDD.n146 VSS 0.03902f
C6697 VDD.n147 VSS 0.0284f
C6698 VDD.n148 VSS 0.14619f
C6699 VDD.n149 VSS 0.01645f
C6700 VDD.n151 VSS 0.03331f
C6701 VDD.n152 VSS 0.01656f
C6702 VDD.t447 VSS 2.04108f
C6703 VDD.n153 VSS 0.18684f
C6704 VDD.n154 VSS 0.01951f
C6705 VDD.t949 VSS 1.50274f
C6706 VDD.n155 VSS 0.01965f
C6707 VDD.n159 VSS 0.01988f
C6708 VDD.n160 VSS 0.01329f
C6709 VDD.n161 VSS 0.02002f
C6710 VDD.n162 VSS 0.01329f
C6711 VDD.n163 VSS 0.02016f
C6712 VDD.n165 VSS 0.01338f
C6713 VDD.n166 VSS 0.02021f
C6714 VDD.n167 VSS 0.01951f
C6715 VDD.n169 VSS 0.11162f
C6716 VDD.n170 VSS 0.07401f
C6717 VDD.n171 VSS 0.2009f
C6718 VDD.n172 VSS 0.01282f
C6719 VDD.n174 VSS 0.11162f
C6720 VDD.n176 VSS 0.074f
C6721 VDD.n177 VSS 0.01993f
C6722 VDD.n178 VSS 0.02049f
C6723 VDD.n179 VSS 0.01979f
C6724 VDD.n182 VSS 0.01988f
C6725 VDD.n183 VSS 0.01329f
C6726 VDD.n185 VSS 0.08937f
C6727 VDD.n186 VSS 0.01333f
C6728 VDD.n187 VSS 0.09656f
C6729 VDD.n188 VSS 0.0262f
C6730 VDD.n189 VSS 0.05051f
C6731 VDD.n190 VSS 0.01396f
C6732 VDD.n192 VSS 0.01965f
C6733 VDD.n193 VSS 0.03986f
C6734 VDD.n194 VSS 0.07436f
C6735 VDD.n195 VSS 0.01848f
C6736 VDD.n196 VSS 0.01988f
C6737 VDD.n199 VSS 0.01988f
C6738 VDD.n200 VSS 0.01329f
C6739 VDD.n201 VSS 0.11162f
C6740 VDD.n202 VSS 0.07401f
C6741 VDD.t842 VSS 1.09824f
C6742 VDD.t844 VSS 1.09824f
C6743 VDD.n204 VSS 0.60441f
C6744 VDD.n205 VSS 0.24248f
C6745 VDD.n207 VSS 0.11909f
C6746 VDD.n208 VSS 0.29052f
C6747 VDD.n210 VSS 0.07964f
C6748 VDD.n212 VSS 0.53914f
C6749 VDD.t311 VSS 14.3922f
C6750 VDD.n215 VSS 0.01684f
C6751 VDD.n217 VSS 0.01684f
C6752 VDD.n218 VSS 0.07275f
C6753 VDD.n220 VSS 0.07073f
C6754 VDD.n224 VSS 0.01684f
C6755 VDD.n225 VSS 0.01684f
C6756 VDD.n226 VSS 0.01684f
C6757 VDD.n228 VSS 0.02526f
C6758 VDD.n230 VSS 0.01684f
C6759 VDD.t576 VSS 0.06808f
C6760 VDD.t485 VSS 0.80691f
C6761 VDD.n231 VSS 0.26434f
C6762 VDD.n233 VSS 0.60397f
C6763 VDD.n234 VSS 0.01684f
C6764 VDD.t346 VSS 11.66072f
C6765 VDD.n235 VSS 0.07169f
C6766 VDD.n236 VSS 0.25473f
C6767 VDD.n239 VSS 0.58143f
C6768 VDD.n240 VSS 0.77364f
C6769 VDD.t15 VSS 8.77279f
C6770 VDD.n241 VSS 0.87447f
C6771 VDD.t22 VSS 6.80774f
C6772 VDD.t345 VSS 0.751f
C6773 VDD.t337 VSS 0.1325f
C6774 VDD.n242 VSS 0.08399f
C6775 VDD.n243 VSS 0.19708f
C6776 VDD.t68 VSS 0.43875f
C6777 VDD.t114 VSS 0.50558f
C6778 VDD.t35 VSS 2.66453f
C6779 VDD.n244 VSS 0.36178f
C6780 VDD.t426 VSS 0.58983f
C6781 VDD.t31 VSS 0.48545f
C6782 VDD.t51 VSS 0.68059f
C6783 VDD.t67 VSS 0.39821f
C6784 VDD.t77 VSS 0.36556f
C6785 VDD.t29 VSS 12.8996f
C6786 VDD.n245 VSS 1.73027f
C6787 VDD.t79 VSS 0.38053f
C6788 VDD.t96 VSS 0.93985f
C6789 VDD.t97 VSS 0.15209f
C6790 VDD.t70 VSS 0.12609f
C6791 VDD.t568 VSS 0.81224f
C6792 VDD.t415 VSS 6.62221f
C6793 VDD.t117 VSS 1.86987f
C6794 VDD.t401 VSS 0.18247f
C6795 VDD.n246 VSS 0.18711f
C6796 VDD.n247 VSS 1.21961f
C6797 VDD.t69 VSS 12.7961f
C6798 VDD.n248 VSS 1.07023f
C6799 VDD.t161 VSS 0.12944f
C6800 VDD.t174 VSS 0.48765f
C6801 VDD.t146 VSS 0.06576f
C6802 VDD.t2 VSS 0.28361f
C6803 VDD.t1 VSS 0.04339f
C6804 VDD.t132 VSS 0.62944f
C6805 VDD.t151 VSS 0.45263f
C6806 VDD.n249 VSS 0.12354f
C6807 VDD.t155 VSS 0.36722f
C6808 VDD.t434 VSS 0.77936f
C6809 VDD.t144 VSS 0.67322f
C6810 VDD.t173 VSS 0.55528f
C6811 VDD.t389 VSS 0.62354f
C6812 VDD.t600 VSS 0.8057f
C6813 VDD.t611 VSS 0.11281f
C6814 VDD.t366 VSS 0.03154f
C6815 VDD.t1089 VSS 0.10566f
C6816 VDD.t736 VSS 3.01175f
C6817 VDD.t137 VSS 0.22994f
C6818 VDD.t528 VSS 0.54818f
C6819 VDD.t136 VSS 0.37484f
C6820 VDD.n250 VSS 0.44348f
C6821 VDD.t0 VSS 12.8996f
C6822 VDD.n251 VSS 1.07023f
C6823 VDD.n252 VSS 0.02737f
C6824 VDD.t12 VSS 0.31511f
C6825 VDD.t176 VSS 0.80734f
C6826 VDD.t10 VSS 0.80734f
C6827 VDD.t8 VSS 1.76634f
C6828 VDD.t6 VSS 0.41956f
C6829 VDD.t428 VSS 0.85434f
C6830 VDD.t186 VSS 1.25126f
C6831 VDD.t187 VSS 0.25224f
C6832 VDD.t179 VSS 0.15469f
C6833 VDD.t177 VSS 0.20546f
C6834 VDD.t450 VSS 0.35448f
C6835 VDD.t668 VSS 0.54952f
C6836 VDD.n253 VSS 0.92107f
C6837 VDD.t36 VSS 1.60393f
C6838 VDD.t5 VSS 13.003f
C6839 VDD.n254 VSS 0.24423f
C6840 VDD.n255 VSS 1.07023f
C6841 VDD.t334 VSS 0.31156f
C6842 VDD.t312 VSS 0.7595f
C6843 VDD.n256 VSS 0.0696f
C6844 VDD.t319 VSS 0.53006f
C6845 VDD.t605 VSS 1.32504f
C6846 VDD.t384 VSS 1.32612f
C6847 VDD.t314 VSS 2.18352f
C6848 VDD.t328 VSS 4.7941f
C6849 VDD.n257 VSS 0.1708f
C6850 VDD.t419 VSS 0.57238f
C6851 VDD.t363 VSS 0.83047f
C6852 VDD.t339 VSS 2.04826f
C6853 VDD.n258 VSS 1.07023f
C6854 VDD.t276 VSS 0.89879f
C6855 VDD.n259 VSS 0.71533f
C6856 VDD.n260 VSS 0.01126f
C6857 VDD.t196 VSS 3.56037f
C6858 VDD.t354 VSS 3.56037f
C6859 VDD.t351 VSS 1.61755f
C6860 VDD.t818 VSS 0.66911f
C6861 VDD.t413 VSS 0.29468f
C6862 VDD.n261 VSS 1.07023f
C6863 VDD.t471 VSS 0.71305f
C6864 VDD.n262 VSS 0.06387f
C6865 VDD.n263 VSS 0.22387f
C6866 VDD.t766 VSS 0.55361f
C6867 VDD.t625 VSS 0.29758f
C6868 VDD.t349 VSS 0.49135f
C6869 VDD.t14 VSS 1.28142f
C6870 VDD.t676 VSS 0.52437f
C6871 VDD.t500 VSS 1.3854f
C6872 VDD.t382 VSS 0.28301f
C6873 VDD.t819 VSS 0.43104f
C6874 VDD.n264 VSS 1.07023f
C6875 VDD.n265 VSS 0.64241f
C6876 VDD.n266 VSS 1.03777f
C6877 VDD.t46 VSS 0.65224f
C6878 VDD.t185 VSS 0.10517f
C6879 VDD.t457 VSS 1.16448f
C6880 VDD.t42 VSS 0.20737f
C6881 VDD.n267 VSS 1.07023f
C6882 VDD.t237 VSS 0.05907f
C6883 VDD.t254 VSS 1.87067f
C6884 VDD.t299 VSS 0.04247f
C6885 VDD.t212 VSS 0.11526f
C6886 VDD.t56 VSS 6.31696f
C6887 VDD.t371 VSS 1.9271f
C6888 VDD.t556 VSS 0.14699f
C6889 VDD.t338 VSS 1.19756f
C6890 VDD.t211 VSS 0.04734f
C6891 VDD.t301 VSS 0.14125f
C6892 VDD.n268 VSS 1.07023f
C6893 VDD.t228 VSS 1.27822f
C6894 VDD.t229 VSS 0.92369f
C6895 VDD.t119 VSS 7.59884f
C6896 VDD.t342 VSS 1.7923f
C6897 VDD.n269 VSS 0.27627f
C6898 VDD.t343 VSS 2.58844f
C6899 VDD.t647 VSS 0.39611f
C6900 VDD.t205 VSS 0.18903f
C6901 VDD.t118 VSS 12.7961f
C6902 VDD.n271 VSS 1.07023f
C6903 VDD.t62 VSS 0.04207f
C6904 VDD.n272 VSS 0.22463f
C6905 VDD.t61 VSS 0.739f
C6906 VDD.t44 VSS 0.66509f
C6907 VDD.t40 VSS 1.81621f
C6908 VDD.t43 VSS 1.01437f
C6909 VDD.n273 VSS 0.26957f
C6910 VDD.t489 VSS 0.66479f
C6911 VDD.t573 VSS 1.65799f
C6912 VDD.n274 VSS 0.16671f
C6913 VDD.t547 VSS 1.59171f
C6914 VDD.t39 VSS 14.95739f
C6915 VDD.n275 VSS 18.2236f
C6916 VDD.t559 VSS 1.50274f
C6917 VDD.n276 VSS 0.10207f
C6918 VDD.n277 VSS 0.08413f
C6919 VDD.n278 VSS 0.07039f
C6920 VDD.t510 VSS 1.24542f
C6921 VDD.n279 VSS 0.10707f
C6922 VDD.t1001 VSS 1.60567f
C6923 VDD.n280 VSS 0.11393f
C6924 VDD.t661 VSS 1.60168f
C6925 VDD.n281 VSS 0.08427f
C6926 VDD.t595 VSS 1.7086f
C6927 VDD.n282 VSS 0.12272f
C6928 VDD.t640 VSS 1.24542f
C6929 VDD.n283 VSS 0.09645f
C6930 VDD.n284 VSS 0.08439f
C6931 VDD.t587 VSS 1.81152f
C6932 VDD.n285 VSS 0.12209f
C6933 VDD.n286 VSS 0.07041f
C6934 VDD.t703 VSS 1.24542f
C6935 VDD.n287 VSS 0.10713f
C6936 VDD.t809 VSS 1.96591f
C6937 VDD.n288 VSS 0.11754f
C6938 VDD.t618 VSS 1.24542f
C6939 VDD.n289 VSS 0.10775f
C6940 VDD.n290 VSS 0.01951f
C6941 VDD.n291 VSS 0.02588f
C6942 VDD.n292 VSS 0.02797f
C6943 VDD.t1012 VSS 2.12031f
C6944 VDD.n293 VSS 0.12162f
C6945 VDD.t613 VSS 1.60176f
C6946 VDD.n294 VSS 0.08655f
C6947 VDD.t804 VSS 2.2747f
C6948 VDD.n295 VSS 0.12779f
C6949 VDD.t710 VSS 1.6022f
C6950 VDD.t1020 VSS 2.48055f
C6951 VDD.n296 VSS 0.12398f
C6952 VDD.t616 VSS 1.60237f
C6953 VDD.n297 VSS 0.01956f
C6954 VDD.n298 VSS 0.04632f
C6955 VDD.t386 VSS 2.48055f
C6956 VDD.n299 VSS 0.12366f
C6957 VDD.t641 VSS 1.24542f
C6958 VDD.n300 VSS 0.10775f
C6959 VDD.n301 VSS 0.03876f
C6960 VDD.n302 VSS 0.01928f
C6961 VDD.t305 VSS 2.2747f
C6962 VDD.n303 VSS 0.11505f
C6963 VDD.t969 VSS 1.60199f
C6964 VDD.n304 VSS 0.08617f
C6965 VDD.t983 VSS 2.12031f
C6966 VDD.n305 VSS 0.11982f
C6967 VDD.t971 VSS 1.60247f
C6968 VDD.t621 VSS 1.96591f
C6969 VDD.n306 VSS 0.11515f
C6970 VDD.t512 VSS 1.60168f
C6971 VDD.n307 VSS 0.01439f
C6972 VDD.n308 VSS 0.02685f
C6973 VDD.n309 VSS 0.07714f
C6974 VDD.n310 VSS 0.02011f
C6975 VDD.t632 VSS 1.81152f
C6976 VDD.n311 VSS 0.11809f
C6977 VDD.t511 VSS 1.60228f
C6978 VDD.n312 VSS 0.07498f
C6979 VDD.n313 VSS 0.02215f
C6980 VDD.t478 VSS 1.7086f
C6981 VDD.n314 VSS 0.11731f
C6982 VDD.t704 VSS 1.60251f
C6983 VDD.t497 VSS 2.05631f
C6984 VDD.t617 VSS 1.6025f
C6985 VDD.t680 VSS 1.9267f
C6986 VDD.t615 VSS 1.6025f
C6987 VDD.t875 VSS 1.50274f
C6988 VDD.n315 VSS 0.11849f
C6989 VDD.n316 VSS 0.07041f
C6990 VDD.t614 VSS 1.24542f
C6991 VDD.n317 VSS 0.32491f
C6992 VDD.t876 VSS 0.25777f
C6993 VDD.t878 VSS 0.09187f
C6994 VDD.n318 VSS 0.21017f
C6995 VDD.n319 VSS 0.22218f
C6996 VDD.n320 VSS 0.04339f
C6997 VDD.n321 VSS 0.56646f
C6998 VDD.n322 VSS 0.24015f
C6999 VDD.n323 VSS 0.46845f
C7000 VDD.t681 VSS 8.968f
C7001 VDD.t682 VSS 0.09187f
C7002 VDD.n324 VSS 0.21017f
C7003 VDD.n325 VSS 0.13594f
C7004 VDD.n326 VSS 0.38177f
C7005 VDD.n327 VSS 0.49854f
C7006 VDD.t498 VSS 8.00306f
C7007 VDD.t499 VSS 0.10586f
C7008 VDD.n328 VSS 0.22166f
C7009 VDD.n329 VSS 0.14296f
C7010 VDD.n330 VSS 0.38503f
C7011 VDD.n331 VSS 0.50554f
C7012 VDD.t479 VSS 7.38934f
C7013 VDD.t480 VSS 0.12226f
C7014 VDD.n332 VSS 0.22845f
C7015 VDD.n333 VSS 0.14998f
C7016 VDD.n334 VSS 0.14559f
C7017 VDD.n335 VSS 0.51279f
C7018 VDD.t633 VSS 0.13273f
C7019 VDD.t634 VSS 7.0222f
C7020 VDD.n336 VSS 0.23635f
C7021 VDD.n337 VSS 0.15699f
C7022 VDD.n338 VSS 0.14559f
C7023 VDD.n339 VSS 0.52392f
C7024 VDD.t622 VSS 7.03808f
C7025 VDD.t623 VSS 0.16181f
C7026 VDD.n340 VSS 0.24778f
C7027 VDD.n341 VSS 0.16752f
C7028 VDD.n342 VSS 0.14559f
C7029 VDD.n343 VSS 0.53366f
C7030 VDD.t984 VSS 7.68768f
C7031 VDD.t985 VSS 0.24948f
C7032 VDD.n344 VSS 0.25985f
C7033 VDD.n345 VSS 0.17805f
C7034 VDD.n346 VSS 0.14559f
C7035 VDD.n347 VSS 0.54466f
C7036 VDD.t306 VSS 0.93394f
C7037 VDD.t307 VSS 0.2112f
C7038 VDD.n348 VSS 0.26673f
C7039 VDD.n349 VSS 0.18857f
C7040 VDD.n350 VSS 0.14559f
C7041 VDD.n351 VSS 0.32998f
C7042 VDD.t387 VSS 0.28695f
C7043 VDD.t388 VSS 0.24533f
C7044 VDD.n352 VSS 0.27693f
C7045 VDD.n353 VSS 0.20261f
C7046 VDD.n354 VSS 0.26445f
C7047 VDD.t800 VSS 2.40993f
C7048 VDD.n355 VSS 3.90387f
C7049 VDD.t970 VSS 1.60237f
C7050 VDD.t709 VSS 1.24542f
C7051 VDD.n356 VSS 0.10189f
C7052 VDD.n357 VSS 0.07041f
C7053 VDD.t713 VSS 1.24542f
C7054 VDD.n358 VSS 0.10713f
C7055 VDD.t467 VSS 1.24542f
C7056 VDD.n359 VSS 0.10775f
C7057 VDD.t888 VSS 0.81987f
C7058 VDD.n360 VSS 3.67892f
C7059 VDD.n361 VSS 0.36939f
C7060 VDD.t468 VSS 0.05581f
C7061 VDD.t469 VSS 0.0577f
C7062 VDD.n362 VSS 0.17989f
C7063 VDD.n363 VSS 0.1184f
C7064 VDD.n364 VSS 0.36963f
C7065 VDD.n365 VSS 0.5178f
C7066 VDD.n366 VSS 0.57042f
C7067 VDD.n367 VSS 1.00441f
C7068 VDD.n368 VSS 1.34943f
C7069 VDD.t838 VSS 1.44973f
C7070 VDD.t840 VSS 1.44973f
C7071 VDD.n369 VSS 0.01965f
C7072 VDD.n370 VSS 0.06153f
C7073 VDD.n371 VSS 0.04359f
C7074 VDD.n372 VSS 0.11094f
C7075 VDD.t473 VSS 1.93852f
C7076 VDD.n373 VSS 0.01601f
C7077 VDD.n374 VSS 0.01601f
C7078 VDD.t845 VSS 7.01218f
C7079 VDD.n375 VSS 0.35907f
C7080 VDD.n376 VSS 0.1346f
C7081 VDD.t843 VSS 0.13233f
C7082 VDD.n377 VSS 0.17949f
C7083 VDD.n378 VSS 0.34635f
C7084 VDD.t475 VSS 0.08844f
C7085 VDD.t474 VSS 0.09172f
C7086 VDD.n379 VSS 0.2156f
C7087 VDD.n380 VSS 0.33163f
C7088 VDD.t952 VSS 0.08845f
C7089 VDD.t950 VSS 0.13373f
C7090 VDD.n381 VSS 0.2156f
C7091 VDD.n382 VSS 0.33163f
C7092 VDD.n383 VSS 0.12005f
C7093 VDD.t841 VSS 0.13233f
C7094 VDD.n384 VSS 0.17949f
C7095 VDD.n385 VSS 0.33186f
C7096 VDD.t839 VSS 0.30037f
C7097 VDD.n386 VSS 0.16545f
C7098 VDD.n387 VSS 1.69584f
C7099 VDD.n388 VSS 2.12841f
C7100 VDD.n389 VSS 0.55981f
C7101 VDD.t1021 VSS 7.58802f
C7102 VDD.t1022 VSS 0.24533f
C7103 VDD.n390 VSS 0.27693f
C7104 VDD.n391 VSS 0.20261f
C7105 VDD.n392 VSS 0.14559f
C7106 VDD.n393 VSS 0.54445f
C7107 VDD.t805 VSS 0.20379f
C7108 VDD.t806 VSS 0.21155f
C7109 VDD.n394 VSS 0.26638f
C7110 VDD.n395 VSS 0.18857f
C7111 VDD.n396 VSS 0.14559f
C7112 VDD.n397 VSS 0.53436f
C7113 VDD.t1013 VSS 6.60729f
C7114 VDD.t1014 VSS 0.18553f
C7115 VDD.n398 VSS 0.25953f
C7116 VDD.n399 VSS 0.17805f
C7117 VDD.n400 VSS 0.14559f
C7118 VDD.n401 VSS 0.29489f
C7119 VDD.t810 VSS 0.16784f
C7120 VDD.t811 VSS 0.16209f
C7121 VDD.n402 VSS 0.2475f
C7122 VDD.n403 VSS 0.16752f
C7123 VDD.n404 VSS 0.14559f
C7124 VDD.n405 VSS 0.28437f
C7125 VDD.t588 VSS 0.17883f
C7126 VDD.t589 VSS 0.13813f
C7127 VDD.n406 VSS 0.23612f
C7128 VDD.n407 VSS 0.15699f
C7129 VDD.n408 VSS 0.14559f
C7130 VDD.n409 VSS 0.27735f
C7131 VDD.t596 VSS 6.78349f
C7132 VDD.t597 VSS 0.16981f
C7133 VDD.n410 VSS 0.22824f
C7134 VDD.n411 VSS 0.14998f
C7135 VDD.n412 VSS 0.14559f
C7136 VDD.n413 VSS 0.49936f
C7137 VDD.t1002 VSS 1.09044f
C7138 VDD.t1003 VSS 0.10604f
C7139 VDD.n414 VSS 0.22149f
C7140 VDD.n415 VSS 0.14296f
C7141 VDD.n416 VSS 0.14559f
C7142 VDD.n417 VSS 0.26331f
C7143 VDD.t560 VSS 10.49626f
C7144 VDD.t561 VSS 0.09202f
C7145 VDD.n418 VSS 0.21002f
C7146 VDD.n419 VSS 0.13594f
C7147 VDD.n420 VSS 0.04112f
C7148 VDD.t708 VSS 1.60252f
C7149 VDD.t870 VSS 1.92674f
C7150 VDD.n421 VSS 0.52257f
C7151 VDD.n422 VSS 0.52472f
C7152 VDD.t871 VSS 0.25777f
C7153 VDD.t873 VSS 0.09202f
C7154 VDD.n423 VSS 0.21002f
C7155 VDD.n424 VSS 0.13594f
C7156 VDD.n425 VSS 0.47045f
C7157 VDD.n426 VSS 2.61174f
C7158 VDD.n427 VSS 67.6234f
.ends
