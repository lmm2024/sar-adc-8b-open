* Extracted by KLayout with SG13G2 LVS runset on : 15/08/2026 23:22

.SUBCKT sw_bitcell11 VDD VSS VSSB bot ctl gb trkb vin
M$1 VDD ctl bot VDD sg13_lv_pmos L=0.13u W=4u AS=1.09p AD=1.09p PS=7.09u
+ PD=7.09u rfmode=1
M$3 vin trkb bot VDD sg13_lv_pmos L=0.13u W=4u AS=1.09p AD=1.09p PS=7.09u
+ PD=7.09u rfmode=1
M$5 VSS ctl bot VSSB sg13_lv_nmos L=0.13u W=2u AS=0.545p AD=0.545p PS=4.09u
+ PD=4.09u rfmode=1
M$7 vin gb bot VSSB sg13_lv_nmos L=0.13u W=2u AS=0.545p AD=0.545p PS=4.09u
+ PD=4.09u rfmode=1
.ENDS sw_bitcell11
