* parameterized plain transmission gate
.subckt sw_tg_fast bot vin trk trkb VDD VSS
MNT bot trk vin VSS sg13_lv_nmos w=8.0u l=0.13u rfmode=1
MPT bot trkb vin VDD sg13_lv_pmos w=16.0u l=0.13u rfmode=1
.ends
