* NGSPICE file created from sar_ctrl.ext - technology: ihp-sg13g2

* Black-box entry subcircuit for sg13g2_fill_1 abstract view
.subckt sg13g2_fill_1 VDD VSS
.ends

* Black-box entry subcircuit for sg13g2_nor2_1 abstract view
.subckt sg13g2_nor2_1 Y A B VDD VSS
.ends

* Black-box entry subcircuit for sg13g2_nor2b_1 abstract view
.subckt sg13g2_nor2b_1 Y A B_N VDD VSS
.ends

* Black-box entry subcircuit for sg13g2_decap_4 abstract view
.subckt sg13g2_decap_4 VDD VSS
.ends

* Black-box entry subcircuit for sg13g2_inv_1 abstract view
.subckt sg13g2_inv_1 Y A VDD VSS
.ends

* Black-box entry subcircuit for sg13g2_buf_1 abstract view
.subckt sg13g2_buf_1 X A VDD VSS
.ends

* Black-box entry subcircuit for sg13g2_nand2_1 abstract view
.subckt sg13g2_nand2_1 Y A B VDD VSS
.ends

* Black-box entry subcircuit for sg13g2_dfrbpq_1 abstract view
.subckt sg13g2_dfrbpq_1 Q CLK D RESET_B VDD VSS
.ends

* Black-box entry subcircuit for sg13g2_and3_1 abstract view
.subckt sg13g2_and3_1 X A B C VDD VSS
.ends

* Black-box entry subcircuit for sg13g2_fill_2 abstract view
.subckt sg13g2_fill_2 VDD VSS
.ends

* Black-box entry subcircuit for sg13g2_a21oi_1 abstract view
.subckt sg13g2_a21oi_1 Y A1 A2 B1 VDD VSS
.ends

* Black-box entry subcircuit for sg13g2_o21ai_1 abstract view
.subckt sg13g2_o21ai_1 Y A1 A2 B1 VDD VSS
.ends

* Black-box entry subcircuit for sg13g2_decap_8 abstract view
.subckt sg13g2_decap_8 VDD VSS
.ends

* Black-box entry subcircuit for sg13g2_mux2_1 abstract view
.subckt sg13g2_mux2_1 X A0 A1 S VDD VSS
.ends

* Black-box entry subcircuit for sg13g2_and2_1 abstract view
.subckt sg13g2_and2_1 X A B VDD VSS
.ends

* Black-box entry subcircuit for sg13g2_or2_1 abstract view
.subckt sg13g2_or2_1 X A B VDD VSS
.ends

* Black-box entry subcircuit for sg13g2_nor3_1 abstract view
.subckt sg13g2_nor3_1 Y A B C VDD VSS
.ends

* Black-box entry subcircuit for sg13g2_buf_16 abstract view
.subckt sg13g2_buf_16 X A VDD VSS
.ends

* Black-box entry subcircuit for sg13g2_nand3_1 abstract view
.subckt sg13g2_nand3_1 Y A B C VDD VSS
.ends

* Black-box entry subcircuit for sg13g2_a21o_1 abstract view
.subckt sg13g2_a21o_1 X A1 A2 B1 VDD VSS
.ends

* Black-box entry subcircuit for sg13g2_nand2b_1 abstract view
.subckt sg13g2_nand2b_1 Y A_N B VDD VSS
.ends

* Black-box entry subcircuit for sg13g2_a22oi_1 abstract view
.subckt sg13g2_a22oi_1 Y A1 A2 B1 B2 VDD VSS
.ends

* Black-box entry subcircuit for sg13g2_or3_1 abstract view
.subckt sg13g2_or3_1 X A B C VDD VSS
.ends

* Black-box entry subcircuit for sg13g2_nand3b_1 abstract view
.subckt sg13g2_nand3b_1 Y A_N B C VDD VSS
.ends

* Black-box entry subcircuit for sg13g2_a221oi_1 abstract view
.subckt sg13g2_a221oi_1 Y A1 A2 B1 B2 C1 VDD VSS
.ends

* Black-box entry subcircuit for sg13g2_nand4_1 abstract view
.subckt sg13g2_nand4_1 Y A B C D VDD VSS
.ends

.subckt sar_ctrl VDD VSS busy clk clk_cmp cmp cmp_n dac_code[0] dac_code[1] dac_code[2]
+ dac_code[3] dac_code[4] dac_code[5] dac_code[6] dac_code[7] dac_code_n[0] dac_code_n[1]
+ dac_code_n[2] dac_code_n[3] dac_code_n[4] dac_code_n[5] dac_code_n[6] dac_code_n[7]
+ done hold result[0] result[1] result[2] result[3] result[4] result[5] result[6]
+ result[7] rst_n sample start
XFILLER_0_46 VDD VSS sg13g2_fill_1
X_131_ _131_/Y _131_/A _263_/Q VDD VSS sg13g2_nor2_1
X_200_ _201_/B _260_/Q _213_/B VDD VSS sg13g2_nor2b_1
XFILLER_22_7 VDD VSS sg13g2_decap_4
X_114_ _129_/A _243_/Q VDD VSS sg13g2_inv_1
Xoutput7 dac_code[0] _143_/A VDD VSS sg13g2_buf_1
Xoutput31 result[6] _252_/Q VDD VSS sg13g2_buf_1
Xoutput20 dac_code_n[5] _128_/Y VDD VSS sg13g2_buf_1
X_130_ _130_/Y _130_/A _146_/B VDD VSS sg13g2_nand2_1
X_113_ _130_/A _244_/Q VDD VSS sg13g2_inv_1
X_259_ _259_/Q _261_/CLK _259_/D fanout45/X VDD VSS sg13g2_dfrbpq_1
XFILLER_13_4 VDD VSS sg13g2_fill_1
Xoutput8 dac_code[1] _146_/A VDD VSS sg13g2_buf_1
Xoutput32 result[7] _253_/Q VDD VSS sg13g2_buf_1
Xoutput21 dac_code_n[6] _129_/Y VDD VSS sg13g2_buf_1
Xoutput10 dac_code[3] _144_/A VDD VSS sg13g2_buf_1
X_189_ _191_/B _213_/C _189_/B _189_/C VDD VSS sg13g2_and3_1
X_258_ _258_/Q _258_/CLK _258_/D fanout46/X VDD VSS sg13g2_dfrbpq_1
Xoutput9 dac_code[2] _145_/A VDD VSS sg13g2_buf_1
Xoutput33 sample _131_/Y VDD VSS sg13g2_buf_1
Xoutput22 dac_code_n[7] _130_/Y VDD VSS sg13g2_buf_1
Xoutput11 dac_code[4] _127_/A VDD VSS sg13g2_buf_1
XFILLER_12_79 VDD VSS sg13g2_fill_2
X_188_ _191_/A _213_/C _189_/C _239_/Q VDD VSS sg13g2_a21oi_1
X_257_ _257_/Q _261_/CLK _257_/D fanout46/X VDD VSS sg13g2_dfrbpq_1
XFILLER_15_24 VDD VSS sg13g2_fill_1
Xoutput23 done _262_/Q VDD VSS sg13g2_buf_1
Xoutput12 dac_code[5] _128_/A VDD VSS sg13g2_buf_1
X_187_ _238_/D _180_/A _186_/Y _183_/Y VDD VSS sg13g2_o21ai_1
X_256_ _256_/Q _261_/CLK _256_/D fanout46/X VDD VSS sg13g2_dfrbpq_1
Xclkload0 clkload0/Y _262_/CLK VDD VSS sg13g2_inv_1
X_239_ _239_/Q _262_/CLK _239_/D fanout44/X VDD VSS sg13g2_dfrbpq_1
XFILLER_10_80 VDD VSS sg13g2_fill_2
XFILLER_15_36 VDD VSS sg13g2_fill_2
XFILLER_6_49 VDD VSS sg13g2_fill_2
Xoutput24 hold _131_/A VDD VSS sg13g2_buf_1
Xoutput13 dac_code[6] _129_/A VDD VSS sg13g2_buf_1
XFILLER_12_59 VDD VSS sg13g2_decap_8
X_186_ _186_/Y _184_/X _185_/Y _137_/Y VDD VSS sg13g2_a21oi_1
Xclkload1 clkload1/Y _252_/CLK VDD VSS sg13g2_inv_1
X_255_ _255_/Q _261_/CLK _255_/D fanout46/X VDD VSS sg13g2_dfrbpq_1
XFILLER_20_48 VDD VSS sg13g2_fill_2
X_169_ _259_/D _168_/X _137_/Y _213_/B VDD VSS sg13g2_mux2_1
X_238_ _238_/Q _258_/CLK _238_/D fanout45/X VDD VSS sg13g2_dfrbpq_1
Xoutput25 result[0] _246_/Q VDD VSS sg13g2_buf_1
Xoutput14 dac_code[7] _130_/A VDD VSS sg13g2_buf_1
XFILLER_12_27 VDD VSS sg13g2_decap_8
XFILLER_12_49 VDD VSS sg13g2_fill_1
XFILLER_13_81 VDD VSS sg13g2_fill_1
X_185_ _185_/Y _189_/B _184_/B _189_/C VDD VSS sg13g2_a21oi_1
X_254_ _254_/Q _261_/CLK _254_/D fanout45/X VDD VSS sg13g2_dfrbpq_1
X_168_ _168_/X _232_/B _256_/D VDD VSS sg13g2_and2_1
Xclkload2 clkload2/Y _261_/CLK VDD VSS sg13g2_inv_1
X_237_ _237_/Q _258_/CLK _237_/D fanout45/X VDD VSS sg13g2_dfrbpq_1
XFILLER_13_9 VDD VSS sg13g2_fill_2
XFILLER_15_38 VDD VSS sg13g2_fill_1
Xoutput26 result[1] _247_/Q VDD VSS sg13g2_buf_1
Xoutput15 dac_code_n[0] _143_/Y VDD VSS sg13g2_buf_1
XFILLER_18_49 VDD VSS sg13g2_fill_1
X_184_ _184_/X _238_/Q _184_/B VDD VSS sg13g2_or2_1
X_253_ _253_/Q _262_/CLK _253_/D fanout43/X VDD VSS sg13g2_dfrbpq_1
XFILLER_18_0 VDD VSS sg13g2_fill_2
XFILLER_20_39 VDD VSS sg13g2_decap_4
X_167_ _258_/D _167_/A _167_/B _167_/C VDD VSS sg13g2_nor3_1
X_219_ _219_/Y _244_/Q _219_/B VDD VSS sg13g2_nor2_1
XFILLER_15_17 VDD VSS sg13g2_decap_8
Xoutput27 result[2] _248_/Q VDD VSS sg13g2_buf_1
Xoutput16 dac_code_n[1] _146_/Y VDD VSS sg13g2_buf_1
Xclkbuf_0_clk clkbuf_0_clk/X clk VDD VSS sg13g2_buf_16
X_166_ _167_/C _258_/Q _178_/B VDD VSS sg13g2_nor2b_1
X_183_ _183_/Y _238_/Q _212_/B VDD VSS sg13g2_nand2_1
Xfanout40 _213_/C _260_/Q VDD VSS sg13g2_buf_1
X_252_ _252_/Q _252_/CLK _252_/D fanout43/X VDD VSS sg13g2_dfrbpq_1
X_235_ _252_/D _243_/Q _230_/B _234_/Y VDD VSS sg13g2_o21ai_1
XFILLER_15_29 VDD VSS sg13g2_decap_8
X_149_ _162_/A _172_/A _172_/B _149_/C VDD VSS sg13g2_nand3_1
X_218_ _219_/B _160_/Y _180_/B _213_/Y VDD VSS sg13g2_a21oi_1
Xoutput28 result[3] _249_/Q VDD VSS sg13g2_buf_1
Xoutput17 dac_code_n[2] _145_/Y VDD VSS sg13g2_buf_1
X_182_ _237_/D _237_/Q _181_/Y _263_/D VDD VSS sg13g2_a21o_1
Xu_sr_q _189_/B u_sr_q/A u_sr_q/B VDD VSS sg13g2_nand2_1
Xfanout41 _213_/B _259_/Q VDD VSS sg13g2_buf_1
Xclkbuf_2_0__f_clk _262_/CLK clkbuf_0_clk/X VDD VSS sg13g2_buf_16
X_251_ _251_/Q _252_/CLK _251_/D fanout44/X VDD VSS sg13g2_dfrbpq_1
X_148_ _253_/D _244_/Q _234_/B _147_/Y VDD VSS sg13g2_o21ai_1
X_165_ _257_/D _141_/B _162_/Y _164_/Y VDD VSS sg13g2_o21ai_1
X_217_ _243_/D _180_/A _216_/Y _212_/Y VDD VSS sg13g2_o21ai_1
X_234_ _234_/Y _252_/Q _234_/B VDD VSS sg13g2_nand2_1
XFILLER_18_2 VDD VSS sg13g2_fill_1
Xoutput29 result[4] _250_/Q VDD VSS sg13g2_buf_1
Xoutput18 dac_code_n[3] _144_/Y VDD VSS sg13g2_buf_1
XFILLER_16_40 VDD VSS sg13g2_fill_1
XFILLER_13_52 VDD VSS sg13g2_fill_2
X_164_ _164_/Y _162_/Y _163_/Y _257_/Q VDD VSS sg13g2_o21ai_1
X_181_ _181_/Y _184_/B _160_/Y _180_/Y VDD VSS sg13g2_o21ai_1
Xfanout42 _172_/A _256_/Q VDD VSS sg13g2_buf_1
X_250_ _250_/Q _252_/CLK _250_/D fanout43/X VDD VSS sg13g2_dfrbpq_1
X_233_ _251_/D _242_/Q _232_/B _232_/Y VDD VSS sg13g2_o21ai_1
XFILLER_19_51 VDD VSS sg13g2_fill_1
X_147_ _147_/Y _253_/Q _234_/B VDD VSS sg13g2_nand2_1
X_216_ _216_/Y _213_/Y _215_/Y _137_/Y VDD VSS sg13g2_a21oi_1
Xoutput19 dac_code_n[4] _127_/Y VDD VSS sg13g2_buf_1
XFILLER_13_20 VDD VSS sg13g2_decap_4
XFILLER_13_31 VDD VSS sg13g2_fill_1
X_180_ _180_/Y _180_/A _180_/B VDD VSS sg13g2_nand2_1
Xfanout43 fanout43/X fanout44/X VDD VSS sg13g2_buf_1
XFILLER_10_65 VDD VSS sg13g2_fill_2
XFILLER_10_76 VDD VSS sg13g2_decap_4
XFILLER_19_30 VDD VSS sg13g2_decap_4
X_163_ _163_/Y _178_/B _167_/A _256_/D VDD VSS sg13g2_nor3_1
X_232_ _232_/Y _251_/Q _232_/B VDD VSS sg13g2_nand2_1
X_129_ _129_/Y _129_/A _146_/B VDD VSS sg13g2_nand2_1
X_146_ _146_/Y _146_/A _146_/B VDD VSS sg13g2_nand2_1
X_215_ _215_/Y _129_/A _208_/Y _214_/Y VDD VSS sg13g2_o21ai_1
XFILLER_16_53 VDD VSS sg13g2_fill_2
XFILLER_4_45 VDD VSS sg13g2_fill_1
X_162_ _162_/Y _162_/A _162_/B _162_/C VDD VSS sg13g2_nand3_1
Xfanout44 fanout44/X input3/X VDD VSS sg13g2_buf_1
X_231_ _250_/D _241_/Q _230_/B _230_/Y VDD VSS sg13g2_o21ai_1
XFILLER_1_46 VDD VSS sg13g2_fill_1
X_145_ _145_/Y _145_/A _146_/B VDD VSS sg13g2_nand2_1
X_214_ _214_/Y _207_/Y _214_/B VDD VSS sg13g2_nand2b_1
Xinput1 input1/X cmp VDD VSS sg13g2_buf_1
X_128_ _128_/Y _128_/A _146_/B VDD VSS sg13g2_nand2_1
XFILLER_8_4 VDD VSS sg13g2_fill_1
Xfanout45 fanout45/X input3/X VDD VSS sg13g2_buf_1
Xfanout34 _180_/A _160_/Y VDD VSS sg13g2_buf_1
X_161_ _256_/D _180_/A VDD VSS sg13g2_inv_1
Xinput2 u_sr_q/A cmp_n VDD VSS sg13g2_buf_1
X_230_ _230_/Y _250_/Q _230_/B VDD VSS sg13g2_nand2_1
X_127_ _127_/Y _127_/A _146_/B VDD VSS sg13g2_nand2_1
X_144_ _144_/Y _144_/A _146_/B VDD VSS sg13g2_nand2_1
X_213_ _213_/Y _213_/A _213_/B _213_/C VDD VSS sg13g2_nand3_1
XFILLER_13_45 VDD VSS sg13g2_decap_8
Xfanout46 fanout46/X input3/X VDD VSS sg13g2_buf_1
Xfanout35 _234_/B _230_/B VDD VSS sg13g2_buf_1
XFILLER_10_24 VDD VSS sg13g2_fill_2
XFILLER_19_11 VDD VSS sg13g2_fill_1
X_143_ _143_/Y _143_/A _146_/B VDD VSS sg13g2_nand2_1
X_160_ _160_/Y _254_/Q _132_/Y _172_/B _172_/A VDD VSS sg13g2_a22oi_1
X_212_ _212_/Y _243_/Q _212_/B VDD VSS sg13g2_nand2_1
Xinput3 input3/X rst_n VDD VSS sg13g2_buf_1
XFILLER_21_78 VDD VSS sg13g2_decap_4
X_126_ _126_/Y _245_/Q VDD VSS sg13g2_inv_1
XFILLER_13_24 VDD VSS sg13g2_fill_2
Xfanout36 _230_/B _232_/B VDD VSS sg13g2_buf_1
Xinput4 _178_/A start VDD VSS sg13g2_buf_1
Xclkbuf_2_1__f_clk _252_/CLK clkbuf_0_clk/X VDD VSS sg13g2_buf_16
XFILLER_10_36 VDD VSS sg13g2_fill_2
XFILLER_10_47 VDD VSS sg13g2_fill_2
XFILLER_10_58 VDD VSS sg13g2_decap_8
XFILLER_4_0 VDD VSS sg13g2_fill_1
X_125_ _214_/B _189_/B VDD VSS sg13g2_inv_1
X_142_ _262_/D _234_/B VDD VSS sg13g2_inv_1
X_211_ _242_/D _128_/A _180_/Y _210_/Y VDD VSS sg13g2_o21ai_1
XFILLER_16_35 VDD VSS sg13g2_fill_2
Xfanout37 _232_/B _141_/X VDD VSS sg13g2_buf_1
XFILLER_10_15 VDD VSS sg13g2_fill_1
X_124__47 output6/A _258_/CLK VDD VSS sg13g2_inv_1
X_141_ _141_/X _141_/A _141_/B _149_/C VDD VSS sg13g2_or3_1
X_210_ _210_/Y _137_/Y _209_/Y _256_/D VDD VSS sg13g2_o21ai_1
XFILLER_8_81 VDD VSS sg13g2_fill_1
Xfanout38 _146_/B _131_/A VDD VSS sg13g2_buf_1
XFILLER_13_37 VDD VSS sg13g2_fill_1
X_140_ _149_/C _213_/A _213_/B _213_/C VDD VSS sg13g2_or3_1
X_123_ _141_/A _172_/A VDD VSS sg13g2_inv_1
XFILLER_8_9 VDD VSS sg13g2_fill_1
Xfanout39 _213_/A _261_/Q VDD VSS sg13g2_buf_1
XFILLER_5_72 VDD VSS sg13g2_fill_2
XFILLER_16_27 VDD VSS sg13g2_fill_1
XFILLER_21_27 VDD VSS sg13g2_fill_2
X_122_ _122_/Y _254_/Q VDD VSS sg13g2_inv_1
X_199_ _199_/Y _241_/Q _212_/B VDD VSS sg13g2_nand2_1
XFILLER_22_81 VDD VSS sg13g2_fill_1
X_236__48 _263_/CLK _258_/CLK VDD VSS sg13g2_inv_1
X_198_ _240_/D _180_/A _196_/Y _197_/Y VDD VSS sg13g2_o21ai_1
XFILLER_11_61 VDD VSS sg13g2_fill_1
XFILLER_22_60 VDD VSS sg13g2_decap_8
XFILLER_8_40 VDD VSS sg13g2_fill_1
X_121_ _131_/A _257_/Q VDD VSS sg13g2_inv_1
XFILLER_8_62 VDD VSS sg13g2_fill_2
XFILLER_10_0 VDD VSS sg13g2_fill_1
XFILLER_19_39 VDD VSS sg13g2_decap_4
XFILLER_21_29 VDD VSS sg13g2_fill_1
X_120_ _143_/A _237_/Q VDD VSS sg13g2_inv_1
X_197_ _197_/Y _240_/Q _212_/B VDD VSS sg13g2_nand2_1
X_249_ _249_/Q _252_/CLK _249_/D fanout43/X VDD VSS sg13g2_dfrbpq_1
X_196_ _196_/Y _172_/C _195_/X _137_/Y VDD VSS sg13g2_a21oi_1
XFILLER_0_0 VDD VSS sg13g2_fill_2
X_179_ _212_/B _180_/A _180_/B VDD VSS sg13g2_and2_1
Xclkbuf_2_2__f_clk _258_/CLK clkbuf_0_clk/X VDD VSS sg13g2_buf_16
X_248_ _248_/Q _262_/CLK _248_/D fanout43/X VDD VSS sg13g2_dfrbpq_1
XFILLER_17_40 VDD VSS sg13g2_fill_2
XFILLER_11_75 VDD VSS sg13g2_fill_2
X_195_ _195_/X _240_/Q _214_/B _195_/S VDD VSS sg13g2_mux2_1
X_247_ _247_/Q _262_/CLK _247_/D fanout43/X VDD VSS sg13g2_dfrbpq_1
XFILLER_22_74 VDD VSS sg13g2_decap_8
XFILLER_8_54 VDD VSS sg13g2_fill_2
X_178_ _180_/B _178_/A _178_/B VDD VSS sg13g2_nand2_1
XFILLER_2_56 VDD VSS sg13g2_fill_1
X_194_ _195_/S _261_/Q _194_/B VDD VSS sg13g2_nor2_1
X_263_ _263_/Q _263_/CLK _263_/D fanout46/X VDD VSS sg13g2_dfrbpq_1
XFILLER_22_53 VDD VSS sg13g2_decap_8
X_177_ _261_/D _206_/B _177_/B VDD VSS sg13g2_nand2_1
X_246_ _246_/Q _262_/CLK _246_/D fanout44/X VDD VSS sg13g2_dfrbpq_1
XFILLER_19_0 VDD VSS sg13g2_decap_8
X_229_ _249_/D _240_/Q _230_/B _228_/Y VDD VSS sg13g2_o21ai_1
XFILLER_11_77 VDD VSS sg13g2_fill_1
X_193_ _239_/D _145_/A _180_/Y _192_/Y VDD VSS sg13g2_o21ai_1
X_262_ _262_/Q _262_/CLK _262_/D fanout43/X VDD VSS sg13g2_dfrbpq_1
XFILLER_22_32 VDD VSS sg13g2_decap_8
XFILLER_8_56 VDD VSS sg13g2_fill_1
X_159_ _255_/D _162_/C _159_/B VDD VSS sg13g2_nand2_1
X_176_ _177_/B _213_/A _168_/X _162_/A VDD VSS sg13g2_o21ai_1
X_245_ _245_/Q _258_/CLK _245_/D fanout45/X VDD VSS sg13g2_dfrbpq_1
X_228_ _228_/Y _249_/Q _230_/B VDD VSS sg13g2_nand2_1
XFILLER_10_5 VDD VSS sg13g2_fill_2
X_192_ _192_/Y _137_/Y _191_/Y _256_/D VDD VSS sg13g2_o21ai_1
X_261_ _261_/Q _261_/CLK _261_/D fanout45/X VDD VSS sg13g2_dfrbpq_1
XFILLER_11_34 VDD VSS sg13g2_fill_2
X_175_ _206_/B _213_/B _260_/Q _213_/A VDD VSS sg13g2_o21ai_1
X_244_ _244_/Q _258_/CLK _244_/D fanout45/X VDD VSS sg13g2_dfrbpq_1
X_158_ _159_/B _122_/Y _132_/Y _157_/B _141_/A VDD VSS sg13g2_a22oi_1
X_227_ _248_/D _239_/Q _234_/B _226_/Y VDD VSS sg13g2_o21ai_1
XFILLER_0_80 VDD VSS sg13g2_fill_2
X_191_ _191_/Y _191_/A _191_/B _191_/C VDD VSS sg13g2_nor3_1
X_260_ _260_/Q _261_/CLK _260_/D fanout45/X VDD VSS sg13g2_dfrbpq_1
XFILLER_22_67 VDD VSS sg13g2_decap_8
X_157_ _162_/C _167_/B _157_/B _256_/Q VDD VSS sg13g2_nand3b_1
X_174_ _260_/D _174_/A VDD VSS sg13g2_inv_1
X_243_ _243_/Q _262_/CLK _243_/D fanout44/X VDD VSS sg13g2_dfrbpq_1
X_226_ _226_/Y _248_/Q _234_/B VDD VSS sg13g2_nand2_1
XFILLER_17_0 VDD VSS sg13g2_fill_2
X_209_ _209_/Y _128_/A _201_/Y _206_/Y _201_/B _208_/Y VDD VSS sg13g2_a221oi_1
X_173_ _174_/A _260_/Q _180_/A _168_/X _172_/Y VDD VSS sg13g2_a22oi_1
X_190_ _191_/C _172_/C _194_/B _213_/A VDD VSS sg13g2_a21oi_1
X_242_ _242_/Q _252_/CLK _242_/D fanout43/X VDD VSS sg13g2_dfrbpq_1
XFILLER_22_46 VDD VSS sg13g2_decap_8
X_156_ _167_/B _178_/A _258_/Q VDD VSS sg13g2_nor2_1
X_225_ _247_/D _238_/Q _234_/B _224_/Y VDD VSS sg13g2_o21ai_1
XFILLER_5_27 VDD VSS sg13g2_fill_1
X_139_ _189_/C _213_/A _213_/B VDD VSS sg13g2_nor2_1
X_208_ _208_/Y _213_/B _207_/Y _149_/C VDD VSS sg13g2_o21ai_1
Xclkbuf_2_3__f_clk _261_/CLK clkbuf_0_clk/X VDD VSS sg13g2_buf_16
XFILLER_22_25 VDD VSS sg13g2_decap_8
X_155_ _167_/A _256_/Q _157_/B VDD VSS sg13g2_and2_1
X_172_ _172_/Y _172_/A _172_/B _172_/C _194_/B VDD VSS sg13g2_nand4_1
X_241_ _241_/Q _252_/CLK _241_/D fanout44/X VDD VSS sg13g2_dfrbpq_1
X_224_ _224_/Y _247_/Q _234_/B VDD VSS sg13g2_nand2_1
XFILLER_17_2 VDD VSS sg13g2_fill_1
XFILLER_9_81 VDD VSS sg13g2_fill_1
X_138_ _184_/B _213_/A _213_/C VDD VSS sg13g2_nor2_1
X_207_ _207_/Y _213_/A _213_/C VDD VSS sg13g2_nand2_1
XFILLER_22_0 VDD VSS sg13g2_decap_8
X_171_ _194_/B _259_/Q _213_/C VDD VSS sg13g2_nand2_1
Xu_sr_qb u_sr_q/B input1/X _189_/B VDD VSS sg13g2_nand2_1
X_240_ _240_/Q _252_/CLK _240_/D fanout44/X VDD VSS sg13g2_dfrbpq_1
XFILLER_12_81 VDD VSS sg13g2_fill_1
X_154_ _157_/B _255_/Q _254_/Q VDD VSS sg13g2_nor2b_1
X_223_ _246_/D _214_/B _230_/B _222_/Y VDD VSS sg13g2_o21ai_1
XFILLER_15_0 VDD VSS sg13g2_fill_2
X_137_ _137_/Y _172_/A _172_/B VDD VSS sg13g2_nand2_1
X_206_ _206_/Y _214_/B _206_/B VDD VSS sg13g2_nor2_1
XFILLER_15_81 VDD VSS sg13g2_fill_1
X_170_ _172_/C _213_/B _213_/C VDD VSS sg13g2_or2_1
XFILLER_19_7 VDD VSS sg13g2_decap_4
XFILLER_9_61 VDD VSS sg13g2_fill_2
X_136_ _141_/B _255_/Q _254_/Q VDD VSS sg13g2_or2_1
X_153_ _254_/D _162_/A _162_/B _153_/C VDD VSS sg13g2_and3_1
X_205_ _241_/D _180_/A _204_/Y _199_/Y VDD VSS sg13g2_o21ai_1
X_222_ _222_/Y _246_/Q _230_/B VDD VSS sg13g2_nand2_1
XFILLER_14_39 VDD VSS sg13g2_fill_1
X_119_ _146_/A _238_/Q VDD VSS sg13g2_inv_1
XFILLER_22_39 VDD VSS sg13g2_decap_8
X_152_ _153_/C _255_/Q _256_/Q _254_/Q VDD VSS sg13g2_a21oi_1
X_221_ _245_/D _167_/A _167_/B _180_/B _126_/Y VDD VSS sg13g2_a22oi_1
X_118_ _145_/A _239_/Q VDD VSS sg13g2_inv_1
X_135_ _172_/B _255_/Q _254_/Q VDD VSS sg13g2_nor2_1
X_204_ _204_/Y _201_/Y _203_/Y _137_/Y VDD VSS sg13g2_a21oi_1
XFILLER_7_4 VDD VSS sg13g2_fill_1
X_134_ _263_/D _134_/A VDD VSS sg13g2_inv_1
X_151_ _162_/B _178_/A _178_/B VDD VSS sg13g2_nand2b_1
X_203_ _203_/Y _127_/A _172_/C _202_/Y VDD VSS sg13g2_a21oi_1
X_220_ _244_/D _162_/A _180_/Y _219_/B _189_/B _219_/Y VDD VSS sg13g2_a221oi_1
X_117_ _144_/A _240_/Q VDD VSS sg13g2_inv_1
XFILLER_15_51 VDD VSS sg13g2_fill_2
X_150_ _178_/B _255_/Q _254_/Q _172_/A VDD VSS sg13g2_nor3_1
XFILLER_0_33 VDD VSS sg13g2_fill_1
XFILLER_0_55 VDD VSS sg13g2_fill_1
X_133_ _134_/A _172_/A _254_/Q _255_/Q VDD VSS sg13g2_nand3b_1
X_202_ _202_/Y _261_/Q _214_/B _172_/C VDD VSS sg13g2_a21oi_1
X_116_ _127_/A _241_/Q VDD VSS sg13g2_inv_1
XFILLER_15_63 VDD VSS sg13g2_fill_1
Xoutput5 busy _245_/Q VDD VSS sg13g2_buf_1
XFILLER_12_42 VDD VSS sg13g2_decap_8
X_132_ _132_/Y _172_/A _255_/Q VDD VSS sg13g2_nor2b_1
X_201_ _201_/Y _261_/Q _201_/B VDD VSS sg13g2_nand2_1
XFILLER_9_54 VDD VSS sg13g2_fill_2
X_115_ _128_/A _242_/Q VDD VSS sg13g2_inv_1
Xoutput6 clk_cmp output6/A VDD VSS sg13g2_buf_1
Xoutput30 result[5] _251_/Q VDD VSS sg13g2_buf_1
.ends
