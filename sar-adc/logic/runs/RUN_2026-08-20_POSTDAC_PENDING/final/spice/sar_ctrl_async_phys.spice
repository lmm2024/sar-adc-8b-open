* NGSPICE file created from sar_ctrl_async_phys.ext - technology: ihp-sg13g2

* Black-box entry subcircuit for sg13g2_decap_8 abstract view
.subckt sg13g2_decap_8 VDD VSS
.ends

* Black-box entry subcircuit for sg13g2_inv_1 abstract view
.subckt sg13g2_inv_1 Y A VDD VSS
.ends

* Black-box entry subcircuit for sg13g2_and2_1 abstract view
.subckt sg13g2_and2_1 X A B VDD VSS
.ends

* Black-box entry subcircuit for sg13g2_fill_2 abstract view
.subckt sg13g2_fill_2 VDD VSS
.ends

* Black-box entry subcircuit for sg13g2_decap_4 abstract view
.subckt sg13g2_decap_4 VDD VSS
.ends

* Black-box entry subcircuit for sg13g2_buf_1 abstract view
.subckt sg13g2_buf_1 X A VDD VSS
.ends

* Black-box entry subcircuit for sg13g2_dlygate4sd3_1 abstract view
.subckt sg13g2_dlygate4sd3_1 X A VDD VSS
.ends

* Black-box entry subcircuit for sg13g2_a22oi_1 abstract view
.subckt sg13g2_a22oi_1 Y A1 A2 B1 B2 VDD VSS
.ends

* Black-box entry subcircuit for sg13g2_nor2_1 abstract view
.subckt sg13g2_nor2_1 Y A B VDD VSS
.ends

* Black-box entry subcircuit for sg13g2_nand2_1 abstract view
.subckt sg13g2_nand2_1 Y A B VDD VSS
.ends

* Black-box entry subcircuit for sg13g2_fill_1 abstract view
.subckt sg13g2_fill_1 VDD VSS
.ends

* Black-box entry subcircuit for sg13g2_a21oi_1 abstract view
.subckt sg13g2_a21oi_1 Y A1 A2 B1 VDD VSS
.ends

* Black-box entry subcircuit for sg13g2_nor4_1 abstract view
.subckt sg13g2_nor4_1 Y A B C D VDD VSS
.ends

* Black-box entry subcircuit for sg13g2_nand2b_1 abstract view
.subckt sg13g2_nand2b_1 Y A_N B VDD VSS
.ends

* Black-box entry subcircuit for sg13g2_dfrbpq_1 abstract view
.subckt sg13g2_dfrbpq_1 Q CLK D RESET_B VDD VSS
.ends

* Black-box entry subcircuit for sg13g2_nor2b_1 abstract view
.subckt sg13g2_nor2b_1 Y A B_N VDD VSS
.ends

* Black-box entry subcircuit for sg13g2_o21ai_1 abstract view
.subckt sg13g2_o21ai_1 Y A1 A2 B1 VDD VSS
.ends

* Black-box entry subcircuit for sg13g2_nand3_1 abstract view
.subckt sg13g2_nand3_1 Y A B C VDD VSS
.ends

* Black-box entry subcircuit for sg13g2_nand3b_1 abstract view
.subckt sg13g2_nand3b_1 Y A_N B C VDD VSS
.ends

* Black-box entry subcircuit for sg13g2_mux2_1 abstract view
.subckt sg13g2_mux2_1 X A0 A1 S VDD VSS
.ends

.subckt sar_ctrl_async_phys VDD VSS bit_active[0] bit_active[1] bit_active[2] bit_active[3]
+ bit_active[4] bit_active[5] bit_active[6] bit_active[7] busy cmp_fault cmp_fire
+ cmp_n cmp_p cmp_valid dac_code[0] dac_code[1] dac_code[2] dac_code[3] dac_code[4]
+ dac_code[5] dac_code[6] dac_code[7] dac_code_n[0] dac_code_n[1] dac_code_n[2] dac_code_n[3]
+ dac_code_n[4] dac_code_n[5] dac_code_n[6] dac_code_n[7] done hold_req result[0]
+ result[1] result[2] result[3] result[4] result[5] result[6] result[7] rst_n sample
+ track
XFILLER_7_7 VDD VSS sg13g2_decap_8
XFILLER_5_4 VDD VSS sg13g2_decap_8
X_131_ _142_/D _131_/A VDD VSS sg13g2_inv_1
X_062_ _062_/X _165_/A _164_/Q VDD VSS sg13g2_and2_1
XFILLER_0_35 VDD VSS sg13g2_decap_8
XFILLER_0_68 VDD VSS sg13g2_decap_8
XFILLER_9_22 VDD VSS sg13g2_decap_8
X_114_ _148_/D _147_/D VDD VSS sg13g2_inv_1
XFILLER_18_53 VDD VSS sg13g2_fill_2
XFILLER_18_42 VDD VSS sg13g2_decap_8
XFILLER_20_54 VDD VSS sg13g2_decap_8
XFILLER_6_89 VDD VSS sg13g2_decap_4
Xoutput20 dac_code[4] _119_/Y VDD VSS sg13g2_buf_1
Xoutput31 dac_code_n[7] _123_/Y VDD VSS sg13g2_buf_1
Xoutput42 sample _110_/Y VDD VSS sg13g2_buf_1
Xoutput7 bit_active[3] _082_/X VDD VSS sg13g2_buf_1
Xu_event_clock_delay.u_d0 u_event_clock_delay.u_d1/A _111_/A_N VDD VSS sg13g2_dlygate4sd3_1
XFILLER_11_0 VDD VSS sg13g2_fill_2
XFILLER_3_35 VDD VSS sg13g2_decap_8
X_130_ _131_/A _083_/A _081_/B _113_/Y _142_/Q VDD VSS sg13g2_a22oi_1
XFILLER_0_14 VDD VSS sg13g2_decap_8
X_061_ _156_/D _164_/D _061_/B VDD VSS sg13g2_nor2_1
X_113_ _113_/Y _165_/A _113_/B VDD VSS sg13g2_nand2_1
XFILLER_18_21 VDD VSS sg13g2_decap_8
XFILLER_20_99 VDD VSS sg13g2_fill_2
XFILLER_20_33 VDD VSS sg13g2_decap_8
XFILLER_6_35 VDD VSS sg13g2_decap_8
XFILLER_15_66 VDD VSS sg13g2_decap_8
Xoutput10 bit_active[6] _067_/X VDD VSS sg13g2_buf_1
Xoutput21 dac_code[5] _120_/Y VDD VSS sg13g2_buf_1
Xoutput32 done _148_/Q VDD VSS sg13g2_buf_1
Xoutput8 bit_active[4] _077_/X VDD VSS sg13g2_buf_1
Xu_event_clock_delay.u_d1 _112_/B u_event_clock_delay.u_d1/A VDD VSS sg13g2_dlygate4sd3_1
XFILLER_13_113 VDD VSS sg13g2_fill_1
XFILLER_3_14 VDD VSS sg13g2_decap_8
XFILLER_12_78 VDD VSS sg13g2_fill_2
XFILLER_12_45 VDD VSS sg13g2_fill_1
Xu_event_pending.u_q _111_/A_N _108_/Y u_event_pending.u_q/B VDD VSS sg13g2_nor2_1
X_060_ _061_/B _056_/Y _164_/Q _156_/Q VDD VSS sg13g2_a21oi_1
XFILLER_9_46 VDD VSS sg13g2_decap_4
X_112_ _112_/Y _164_/D _112_/B _112_/C _112_/D VDD VSS sg13g2_nor4_1
XFILLER_20_12 VDD VSS sg13g2_decap_8
XFILLER_6_14 VDD VSS sg13g2_decap_8
Xoutput11 bit_active[7] _062_/X VDD VSS sg13g2_buf_1
Xoutput22 dac_code[6] _121_/Y VDD VSS sg13g2_buf_1
Xoutput33 hold_req _165_/X VDD VSS sg13g2_buf_1
Xoutput9 bit_active[5] _072_/X VDD VSS sg13g2_buf_1
XFILLER_15_45 VDD VSS sg13g2_decap_8
XFILLER_15_34 VDD VSS sg13g2_fill_2
XFILLER_15_23 VDD VSS sg13g2_decap_8
XFILLER_11_2 VDD VSS sg13g2_fill_1
XFILLER_0_49 VDD VSS sg13g2_decap_8
Xu_settle_latch.u_q _111_/B _109_/Y u_settle_latch.u_q/B VDD VSS sg13g2_nor2_1
X_111_ _112_/D _111_/A_N _111_/B VDD VSS sg13g2_nand2b_1
XFILLER_20_68 VDD VSS sg13g2_decap_4
XFILLER_20_7 VDD VSS sg13g2_fill_1
Xoutput12 busy _122_/A VDD VSS sg13g2_buf_1
Xoutput23 dac_code[7] _122_/Y VDD VSS sg13g2_buf_1
Xoutput34 result[0] _139_/Q VDD VSS sg13g2_buf_1
XFILLER_0_28 VDD VSS sg13g2_decap_8
XFILLER_18_35 VDD VSS sg13g2_decap_8
X_110_ _110_/Y _165_/A _110_/B VDD VSS sg13g2_nor2_1
XFILLER_20_47 VDD VSS sg13g2_decap_8
XFILLER_6_49 VDD VSS sg13g2_fill_2
Xoutput13 cmp_fault _097_/Y VDD VSS sg13g2_buf_1
Xoutput24 dac_code_n[0] _094_/Y VDD VSS sg13g2_buf_1
Xoutput35 result[1] _140_/Q VDD VSS sg13g2_buf_1
XFILLER_3_28 VDD VSS sg13g2_decap_8
XFILLER_18_14 VDD VSS sg13g2_decap_8
XFILLER_20_26 VDD VSS sg13g2_decap_8
Xu_interbit_delay.u_d0 u_interbit_delay.u_d1/A _112_/B VDD VSS sg13g2_dlygate4sd3_1
XFILLER_6_28 VDD VSS sg13g2_decap_8
XFILLER_19_111 VDD VSS sg13g2_fill_2
XFILLER_15_59 VDD VSS sg13g2_decap_8
Xoutput14 cmp_fire _112_/Y VDD VSS sg13g2_buf_1
Xoutput25 dac_code_n[1] _089_/Y VDD VSS sg13g2_buf_1
Xoutput36 result[2] _141_/Q VDD VSS sg13g2_buf_1
XFILLER_12_38 VDD VSS sg13g2_fill_2
XFILLER_9_17 VDD VSS sg13g2_fill_1
XFILLER_3_7 VDD VSS sg13g2_decap_8
XFILLER_1_4 VDD VSS sg13g2_decap_8
X_099_ _112_/C _106_/B VDD VSS sg13g2_inv_1
XFILLER_1_51 VDD VSS sg13g2_fill_1
XFILLER_10_82 VDD VSS sg13g2_decap_4
Xu_interbit_delay.u_d1 u_interbit_delay.u_d2/A u_interbit_delay.u_d1/A VDD VSS sg13g2_dlygate4sd3_1
XFILLER_19_91 VDD VSS sg13g2_fill_1
XFILLER_15_16 VDD VSS sg13g2_decap_8
Xoutput15 cmp_valid _112_/C VDD VSS sg13g2_buf_1
Xoutput26 dac_code_n[2] _084_/Y VDD VSS sg13g2_buf_1
Xoutput37 result[3] _142_/Q VDD VSS sg13g2_buf_1
XFILLER_21_81 VDD VSS sg13g2_decap_8
XFILLER_8_111 VDD VSS sg13g2_fill_2
XFILLER_12_28 VDD VSS sg13g2_fill_1
XFILLER_9_29 VDD VSS sg13g2_fill_1
Xfanout50 _165_/A _147_/Q VDD VSS sg13g2_buf_1
Xu_decision_hold.u_qn u_decision_hold.u_q/B _101_/Y _056_/A VDD VSS sg13g2_nor2_1
XFILLER_18_49 VDD VSS sg13g2_decap_4
X_098_ _106_/B _101_/A _098_/B VDD VSS sg13g2_and2_1
Xu_interbit_delay.u_d2 _103_/A u_interbit_delay.u_d2/A VDD VSS sg13g2_dlygate4sd3_1
XFILLER_19_113 VDD VSS sg13g2_fill_1
XFILLER_18_0 VDD VSS sg13g2_decap_8
Xoutput16 dac_code[0] _115_/Y VDD VSS sg13g2_buf_1
Xoutput27 dac_code_n[3] _079_/Y VDD VSS sg13g2_buf_1
Xoutput38 result[4] _143_/Q VDD VSS sg13g2_buf_1
XFILLER_7_40 VDD VSS sg13g2_decap_8
Xfanout51 fanout51/X _109_/A VDD VSS sg13g2_buf_1
XFILLER_18_28 VDD VSS sg13g2_decap_8
X_097_ _097_/Y _101_/A _098_/B VDD VSS sg13g2_nor2_1
XFILLER_10_40 VDD VSS sg13g2_decap_8
X_149_ _149_/Q _112_/B _149_/D _108_/B1 VDD VSS sg13g2_dfrbpq_1
Xoutput17 dac_code[1] _116_/Y VDD VSS sg13g2_buf_1
Xoutput28 dac_code_n[4] _074_/Y VDD VSS sg13g2_buf_1
Xoutput39 result[5] _144_/Q VDD VSS sg13g2_buf_1
XFILLER_7_85 VDD VSS sg13g2_fill_1
XFILLER_16_50 VDD VSS sg13g2_fill_2
XFILLER_8_113 VDD VSS sg13g2_fill_1
Xfanout52 _109_/A input3/X VDD VSS sg13g2_buf_1
XFILLER_8_0 VDD VSS sg13g2_decap_8
X_165_ _165_/X _165_/A VDD VSS sg13g2_buf_1
X_096_ _149_/D _157_/D _096_/B VDD VSS sg13g2_nor2_1
XFILLER_1_32 VDD VSS sg13g2_decap_8
XFILLER_20_19 VDD VSS sg13g2_decap_8
X_148_ _148_/Q _112_/B _148_/D _109_/A VDD VSS sg13g2_dfrbpq_1
Xoutput18 dac_code[2] _117_/Y VDD VSS sg13g2_buf_1
Xoutput29 dac_code_n[5] _069_/Y VDD VSS sg13g2_buf_1
X_079_ _079_/Y _152_/Q _123_/B VDD VSS sg13g2_nand2b_1
XFILLER_4_76 VDD VSS sg13g2_decap_4
XFILLER_4_21 VDD VSS sg13g2_decap_8
Xfanout53 _108_/B1 input3/X VDD VSS sg13g2_buf_1
X_164_ _164_/Q _112_/B _164_/D _108_/B1 VDD VSS sg13g2_dfrbpq_1
X_095_ _096_/B _056_/Y _157_/Q _094_/Y VDD VSS sg13g2_a21oi_1
XFILLER_1_11 VDD VSS sg13g2_decap_8
XFILLER_10_75 VDD VSS sg13g2_decap_8
X_147_ _147_/Q _112_/B _147_/D _109_/A VDD VSS sg13g2_dfrbpq_1
X_078_ _160_/D _113_/B _077_/X VDD VSS sg13g2_nor2b_1
Xoutput19 dac_code[3] _118_/Y VDD VSS sg13g2_buf_1
XFILLER_7_21 VDD VSS sg13g2_fill_1
XFILLER_16_0 VDD VSS sg13g2_fill_2
XFILLER_16_52 VDD VSS sg13g2_fill_1
Xfanout43 _147_/D _113_/Y VDD VSS sg13g2_buf_1
Xfanout54 fanout54/X input3/X VDD VSS sg13g2_buf_1
X_163_ _163_/Q _112_/B _163_/D _108_/B1 VDD VSS sg13g2_dfrbpq_1
X_094_ _094_/Y _149_/Q _123_/B VDD VSS sg13g2_nand2b_1
XFILLER_10_54 VDD VSS sg13g2_decap_4
XFILLER_10_65 VDD VSS sg13g2_decap_4
X_146_ _146_/Q _112_/B _146_/D fanout51/X VDD VSS sg13g2_dfrbpq_1
X_077_ _077_/X _077_/A _161_/Q VDD VSS sg13g2_and2_1
XFILLER_21_53 VDD VSS sg13g2_fill_1
XFILLER_21_42 VDD VSS sg13g2_decap_8
X_129_ _141_/D _129_/A VDD VSS sg13g2_inv_1
Xfanout44 _083_/A _113_/B VDD VSS sg13g2_buf_1
XFILLER_13_98 VDD VSS sg13g2_fill_1
X_162_ _162_/Q _112_/B _162_/D fanout54/X VDD VSS sg13g2_dfrbpq_1
X_093_ _157_/D _113_/B _092_/X VDD VSS sg13g2_nor2b_1
XFILLER_6_0 VDD VSS sg13g2_decap_8
XFILLER_1_46 VDD VSS sg13g2_fill_2
XFILLER_10_22 VDD VSS sg13g2_decap_8
Xinput1 _101_/A cmp_n VDD VSS sg13g2_buf_1
XFILLER_19_42 VDD VSS sg13g2_decap_8
X_145_ _145_/Q _112_/B _145_/D fanout51/X VDD VSS sg13g2_dfrbpq_1
X_076_ _153_/D _161_/D _076_/B VDD VSS sg13g2_nor2_1
XFILLER_21_21 VDD VSS sg13g2_decap_8
X_128_ _129_/A _083_/A _086_/B _147_/D _141_/Q VDD VSS sg13g2_a22oi_1
X_059_ _110_/B track VDD VSS sg13g2_inv_1
XFILLER_7_78 VDD VSS sg13g2_decap_8
XFILLER_16_43 VDD VSS sg13g2_decap_8
XFILLER_12_113 VDD VSS sg13g2_fill_1
XFILLER_21_0 VDD VSS sg13g2_decap_8
XFILLER_4_35 VDD VSS sg13g2_decap_8
Xfanout45 _113_/B _157_/Q VDD VSS sg13g2_buf_1
X_161_ _161_/Q _112_/B _161_/D fanout54/X VDD VSS sg13g2_dfrbpq_1
X_092_ _092_/X _122_/A _158_/Q VDD VSS sg13g2_and2_1
XFILLER_1_25 VDD VSS sg13g2_decap_8
Xinput2 _098_/B cmp_p VDD VSS sg13g2_buf_1
X_144_ _144_/Q _112_/B _144_/D fanout51/X VDD VSS sg13g2_dfrbpq_1
X_075_ _076_/B _056_/Y _161_/Q _074_/Y VDD VSS sg13g2_a21oi_1
XFILLER_19_21 VDD VSS sg13g2_decap_8
XFILLER_21_88 VDD VSS sg13g2_fill_2
X_127_ _140_/D _127_/A VDD VSS sg13g2_inv_1
X_058_ _058_/Y _112_/B VDD VSS sg13g2_inv_1
XFILLER_16_22 VDD VSS sg13g2_decap_8
XFILLER_4_14 VDD VSS sg13g2_decap_8
XFILLER_4_69 VDD VSS sg13g2_decap_8
Xfanout46 _123_/B _077_/A VDD VSS sg13g2_buf_1
X_160_ _160_/Q _112_/B _160_/D _108_/B1 VDD VSS sg13g2_dfrbpq_1
X_091_ _150_/D _158_/D _091_/B VDD VSS sg13g2_nor2_1
Xinput3 input3/X rst_n VDD VSS sg13g2_buf_1
X_143_ _143_/Q _112_/B _143_/D fanout51/X VDD VSS sg13g2_dfrbpq_1
X_074_ _074_/Y _153_/Q _123_/B VDD VSS sg13g2_nand2b_1
XFILLER_18_7 VDD VSS sg13g2_decap_8
X_126_ _127_/A _083_/A _091_/B _147_/D _140_/Q VDD VSS sg13g2_a22oi_1
X_057_ _164_/D _165_/A VDD VSS sg13g2_inv_1
XFILLER_7_47 VDD VSS sg13g2_decap_4
XFILLER_7_14 VDD VSS sg13g2_decap_8
XFILLER_16_67 VDD VSS sg13g2_decap_8
X_109_ _109_/Y _109_/A _109_/B VDD VSS sg13g2_nand2_1
Xfanout47 _119_/A _077_/A VDD VSS sg13g2_buf_1
XFILLER_5_80 VDD VSS sg13g2_decap_8
X_090_ _091_/B _056_/Y _158_/Q _089_/Y VDD VSS sg13g2_a21oi_1
XFILLER_10_47 VDD VSS sg13g2_decap_8
XFILLER_10_58 VDD VSS sg13g2_fill_2
XFILLER_10_69 VDD VSS sg13g2_fill_2
X_142_ _142_/Q _112_/B _142_/D fanout51/X VDD VSS sg13g2_dfrbpq_1
XFILLER_19_89 VDD VSS sg13g2_fill_2
XFILLER_19_56 VDD VSS sg13g2_fill_2
X_073_ _161_/D _113_/B _072_/X VDD VSS sg13g2_nor2b_1
XFILLER_4_0 VDD VSS sg13g2_decap_8
XFILLER_21_35 VDD VSS sg13g2_decap_8
X_125_ _139_/D _125_/A VDD VSS sg13g2_inv_1
X_056_ _056_/Y _056_/A VDD VSS sg13g2_inv_1
XFILLER_16_79 VDD VSS sg13g2_fill_1
X_108_ _108_/Y _058_/Y _107_/Y _108_/B1 VDD VSS sg13g2_o21ai_1
Xfanout48 _077_/A _147_/Q VDD VSS sg13g2_buf_1
XFILLER_8_7 VDD VSS sg13g2_decap_8
Xu_event_pending.u_qn u_event_pending.u_q/B _107_/Y _111_/A_N VDD VSS sg13g2_nor2_1
XFILLER_1_39 VDD VSS sg13g2_decap_8
XFILLER_10_15 VDD VSS sg13g2_decap_8
XFILLER_19_35 VDD VSS sg13g2_decap_8
X_141_ _141_/Q _112_/B _141_/D fanout51/X VDD VSS sg13g2_dfrbpq_1
X_072_ _072_/X _162_/Q _165_/A VDD VSS sg13g2_and2_1
X_124_ _125_/A _083_/A _096_/B _147_/D _139_/Q VDD VSS sg13g2_a22oi_1
XFILLER_21_14 VDD VSS sg13g2_decap_8
XFILLER_16_36 VDD VSS sg13g2_decap_8
X_107_ _107_/Y _106_/B _101_/B _106_/Y VDD VSS sg13g2_o21ai_1
XFILLER_4_28 VDD VSS sg13g2_decap_8
Xfanout49 _122_/A _147_/Q VDD VSS sg13g2_buf_1
XFILLER_12_0 VDD VSS sg13g2_fill_2
XFILLER_13_37 VDD VSS sg13g2_fill_2
XFILLER_1_18 VDD VSS sg13g2_decap_8
XFILLER_19_14 VDD VSS sg13g2_decap_8
X_140_ _140_/Q _112_/B _140_/D fanout51/X VDD VSS sg13g2_dfrbpq_1
X_071_ _154_/D _162_/D _071_/B VDD VSS sg13g2_nor2_1
XFILLER_18_112 VDD VSS sg13g2_fill_2
X_123_ _123_/Y _156_/Q _123_/B VDD VSS sg13g2_nand2b_1
XFILLER_16_15 VDD VSS sg13g2_decap_8
X_106_ _106_/Y _106_/A _106_/B _106_/C VDD VSS sg13g2_nand3_1
XFILLER_8_71 VDD VSS sg13g2_fill_1
XFILLER_14_4 VDD VSS sg13g2_decap_4
X_070_ _071_/B _056_/Y _162_/Q _069_/Y VDD VSS sg13g2_a21oi_1
XFILLER_21_49 VDD VSS sg13g2_decap_4
X_122_ _122_/Y _122_/A _156_/Q VDD VSS sg13g2_nand2_1
XFILLER_2_0 VDD VSS sg13g2_decap_8
XFILLER_11_93 VDD VSS sg13g2_decap_4
X_105_ _106_/C track _105_/B VDD VSS sg13g2_nor2_1
XFILLER_8_61 VDD VSS sg13g2_fill_2
XFILLER_8_50 VDD VSS sg13g2_decap_8
XFILLER_22_81 VDD VSS sg13g2_decap_8
XFILLER_5_73 VDD VSS sg13g2_decap_8
XFILLER_6_7 VDD VSS sg13g2_decap_8
XFILLER_14_60 VDD VSS sg13g2_decap_4
XFILLER_10_29 VDD VSS sg13g2_decap_8
XFILLER_19_49 VDD VSS sg13g2_decap_8
XFILLER_21_28 VDD VSS sg13g2_decap_8
XFILLER_11_72 VDD VSS sg13g2_decap_8
X_121_ _121_/Y _122_/A _155_/Q VDD VSS sg13g2_nand2_1
X_104_ _104_/Y _103_/X _109_/A _165_/A VDD VSS sg13g2_nand3b_1
XFILLER_7_113 VDD VSS sg13g2_fill_1
XFILLER_22_60 VDD VSS sg13g2_decap_8
XFILLER_21_7 VDD VSS sg13g2_decap_8
XFILLER_10_0 VDD VSS sg13g2_decap_8
XFILLER_19_28 VDD VSS sg13g2_decap_8
X_120_ _120_/Y _123_/B _154_/Q VDD VSS sg13g2_nand2_1
XFILLER_16_29 VDD VSS sg13g2_decap_8
X_103_ _103_/X _103_/A _109_/B VDD VSS sg13g2_and2_1
XFILLER_5_64 VDD VSS sg13g2_fill_2
XFILLER_5_53 VDD VSS sg13g2_decap_8
XFILLER_2_21 VDD VSS sg13g2_decap_8
XFILLER_11_30 VDD VSS sg13g2_fill_2
XFILLER_0_0 VDD VSS sg13g2_decap_8
X_102_ _109_/B _164_/D _112_/B VDD VSS sg13g2_nor2_1
XFILLER_5_32 VDD VSS sg13g2_decap_8
XFILLER_4_7 VDD VSS sg13g2_decap_8
XFILLER_11_97 VDD VSS sg13g2_fill_1
XFILLER_11_86 VDD VSS sg13g2_decap_8
X_101_ _101_/Y _101_/A _101_/B VDD VSS sg13g2_nor2_1
XFILLER_22_74 VDD VSS sg13g2_decap_8
XFILLER_8_21 VDD VSS sg13g2_decap_4
Xu_decision_hold.u_q _056_/A _104_/Y u_decision_hold.u_q/B VDD VSS sg13g2_nor2_1
XFILLER_5_11 VDD VSS sg13g2_decap_8
XFILLER_14_64 VDD VSS sg13g2_fill_2
XFILLER_14_53 VDD VSS sg13g2_decap_8
XFILLER_11_32 VDD VSS sg13g2_fill_1
X_100_ _101_/B _101_/A _098_/B _165_/A VDD VSS sg13g2_o21ai_1
XFILLER_22_53 VDD VSS sg13g2_decap_8
XFILLER_8_77 VDD VSS sg13g2_fill_2
XFILLER_19_0 VDD VSS sg13g2_decap_8
XFILLER_14_76 VDD VSS sg13g2_fill_2
XFILLER_2_35 VDD VSS sg13g2_fill_2
XFILLER_8_67 VDD VSS sg13g2_decap_4
XFILLER_22_32 VDD VSS sg13g2_decap_8
X_159_ _159_/Q _112_/B _159_/D _109_/A VDD VSS sg13g2_dfrbpq_1
XFILLER_17_32 VDD VSS sg13g2_decap_8
XFILLER_5_46 VDD VSS sg13g2_decap_8
XFILLER_9_0 VDD VSS sg13g2_decap_8
XFILLER_2_14 VDD VSS sg13g2_decap_8
XFILLER_11_23 VDD VSS sg13g2_decap_8
XFILLER_2_7 VDD VSS sg13g2_decap_8
XFILLER_22_88 VDD VSS sg13g2_fill_2
XFILLER_22_11 VDD VSS sg13g2_decap_8
X_158_ _158_/Q _112_/B _158_/D _109_/A VDD VSS sg13g2_dfrbpq_1
X_089_ _089_/Y _150_/Q _123_/B VDD VSS sg13g2_nand2b_1
XFILLER_8_57 VDD VSS sg13g2_decap_4
XFILLER_17_77 VDD VSS sg13g2_fill_2
XFILLER_17_11 VDD VSS sg13g2_decap_8
Xu_launch_width.u_d0 u_launch_width.u_d1/A _106_/A VDD VSS sg13g2_dlygate4sd3_1
XFILLER_5_25 VDD VSS sg13g2_decap_8
XFILLER_14_113 VDD VSS sg13g2_fill_1
XFILLER_11_79 VDD VSS sg13g2_decap_8
XFILLER_3_80 VDD VSS sg13g2_fill_1
XFILLER_22_67 VDD VSS sg13g2_decap_8
X_157_ _157_/Q _112_/B _157_/D _109_/A VDD VSS sg13g2_dfrbpq_1
X_088_ _158_/D _113_/B _087_/X VDD VSS sg13g2_nor2b_1
XFILLER_8_14 VDD VSS sg13g2_decap_8
Xu_launch_width.u_d1 u_launch_width.u_d2/A u_launch_width.u_d1/A VDD VSS sg13g2_dlygate4sd3_1
XFILLER_10_7 VDD VSS sg13g2_fill_2
XFILLER_14_46 VDD VSS sg13g2_decap_8
XFILLER_14_24 VDD VSS sg13g2_fill_2
XFILLER_17_111 VDD VSS sg13g2_fill_2
XFILLER_22_46 VDD VSS sg13g2_decap_8
X_156_ _156_/Q _112_/B _156_/D _108_/B1 VDD VSS sg13g2_dfrbpq_1
X_087_ _087_/X _122_/A _159_/Q VDD VSS sg13g2_and2_1
X_139_ _139_/Q _112_/B _139_/D fanout51/X VDD VSS sg13g2_dfrbpq_1
Xu_launch_width.u_d2 u_launch_width.u_d3/A u_launch_width.u_d2/A VDD VSS sg13g2_dlygate4sd3_1
XFILLER_2_28 VDD VSS sg13g2_decap_8
Xu_hold_delay.u_d0 u_hold_delay.u_d1/A _110_/B VDD VSS sg13g2_dlygate4sd3_1
XFILLER_7_0 VDD VSS sg13g2_decap_8
XFILLER_22_25 VDD VSS sg13g2_decap_8
XFILLER_0_7 VDD VSS sg13g2_decap_8
X_155_ _155_/Q _112_/B _155_/D _108_/B1 VDD VSS sg13g2_dfrbpq_1
X_086_ _151_/D _159_/D _086_/B VDD VSS sg13g2_nor2_1
XFILLER_12_80 VDD VSS sg13g2_fill_1
XFILLER_17_25 VDD VSS sg13g2_decap_8
X_138_ _146_/D _146_/Q _061_/B _148_/D VDD VSS sg13g2_mux2_1
X_069_ _069_/Y _154_/Q _077_/A VDD VSS sg13g2_nand2b_1
XFILLER_0_61 VDD VSS sg13g2_decap_8
Xu_launch_width.u_d3 _105_/B u_launch_width.u_d3/A VDD VSS sg13g2_dlygate4sd3_1
XFILLER_10_9 VDD VSS sg13g2_fill_1
XFILLER_5_39 VDD VSS sg13g2_decap_8
XFILLER_14_26 VDD VSS sg13g2_fill_1
Xu_settle_latch.u_qn u_settle_latch.u_q/B _103_/X _111_/B VDD VSS sg13g2_nor2_1
Xu_hold_delay.u_d1 u_hold_delay.u_d2/A u_hold_delay.u_d1/A VDD VSS sg13g2_dlygate4sd3_1
XFILLER_17_113 VDD VSS sg13g2_fill_1
XFILLER_15_91 VDD VSS sg13g2_fill_1
XFILLER_15_80 VDD VSS sg13g2_decap_8
XFILLER_11_16 VDD VSS sg13g2_fill_2
X_154_ _154_/Q _112_/B _154_/D fanout54/X VDD VSS sg13g2_dfrbpq_1
X_085_ _086_/B _056_/Y _159_/Q _084_/Y VDD VSS sg13g2_a21oi_1
X_137_ _145_/D _137_/A VDD VSS sg13g2_inv_1
X_068_ _162_/D _113_/B _067_/X VDD VSS sg13g2_nor2b_1
XFILLER_9_60 VDD VSS sg13g2_fill_2
XFILLER_5_18 VDD VSS sg13g2_decap_8
XFILLER_15_0 VDD VSS sg13g2_decap_8
Xu_hold_delay.u_d2 u_hold_delay.u_d3/A u_hold_delay.u_d2/A VDD VSS sg13g2_dlygate4sd3_1
X_153_ _153_/Q _112_/B _153_/D fanout54/X VDD VSS sg13g2_dfrbpq_1
X_084_ _084_/Y _151_/Q _123_/B VDD VSS sg13g2_nand2b_1
XFILLER_19_7 VDD VSS sg13g2_decap_8
X_136_ _137_/A _083_/A _066_/B _147_/D _145_/Q VDD VSS sg13g2_a22oi_1
X_067_ _067_/X _163_/Q _122_/A VDD VSS sg13g2_and2_1
XFILLER_17_4 VDD VSS sg13g2_decap_8
X_119_ _119_/Y _119_/A _153_/Q VDD VSS sg13g2_nand2_1
XFILLER_14_39 VDD VSS sg13g2_decap_8
XFILLER_14_17 VDD VSS sg13g2_decap_8
XFILLER_6_51 VDD VSS sg13g2_fill_1
Xu_hold_delay.u_d3 _106_/A u_hold_delay.u_d3/A VDD VSS sg13g2_dlygate4sd3_1
XFILLER_3_52 VDD VSS sg13g2_fill_1
XFILLER_22_39 VDD VSS sg13g2_decap_8
X_152_ _152_/Q _112_/B _152_/D _108_/B1 VDD VSS sg13g2_dfrbpq_1
X_083_ _159_/D _083_/A _082_/X VDD VSS sg13g2_nor2b_1
XFILLER_17_39 VDD VSS sg13g2_fill_1
XFILLER_0_42 VDD VSS sg13g2_decap_8
X_135_ _144_/D _135_/A VDD VSS sg13g2_inv_1
X_066_ _155_/D _163_/D _066_/B VDD VSS sg13g2_nor2_1
XFILLER_9_62 VDD VSS sg13g2_fill_1
X_118_ _118_/Y _123_/B _152_/Q VDD VSS sg13g2_nand2_1
XFILLER_18_82 VDD VSS sg13g2_fill_2
XFILLER_20_61 VDD VSS sg13g2_decap_8
XFILLER_20_0 VDD VSS sg13g2_decap_8
XFILLER_9_7 VDD VSS sg13g2_fill_1
XFILLER_3_42 VDD VSS sg13g2_decap_8
XFILLER_22_18 VDD VSS sg13g2_decap_8
X_151_ _151_/Q _112_/B _151_/D fanout54/X VDD VSS sg13g2_dfrbpq_1
X_082_ _082_/X _122_/A _160_/Q VDD VSS sg13g2_and2_1
XFILLER_12_40 VDD VSS sg13g2_fill_1
XFILLER_17_18 VDD VSS sg13g2_decap_8
XFILLER_0_21 VDD VSS sg13g2_decap_8
X_134_ _135_/A _083_/A _071_/B _147_/D _144_/Q VDD VSS sg13g2_a22oi_1
X_065_ _066_/B _056_/Y _163_/Q _064_/Y VDD VSS sg13g2_a21oi_1
X_117_ _117_/Y _119_/A _151_/Q VDD VSS sg13g2_nand2_1
XFILLER_22_4 VDD VSS sg13g2_decap_8
XFILLER_20_40 VDD VSS sg13g2_decap_8
XFILLER_6_42 VDD VSS sg13g2_decap_8
XFILLER_13_0 VDD VSS sg13g2_fill_1
Xoutput4 bit_active[0] _148_/D VDD VSS sg13g2_buf_1
XFILLER_15_73 VDD VSS sg13g2_decap_8
XFILLER_3_21 VDD VSS sg13g2_decap_8
X_150_ _150_/Q _112_/B _150_/D fanout54/X VDD VSS sg13g2_dfrbpq_1
X_081_ _152_/D _160_/D _081_/B VDD VSS sg13g2_nor2_1
X_133_ _143_/D _133_/A VDD VSS sg13g2_inv_1
X_064_ _064_/Y _155_/Q _122_/A VDD VSS sg13g2_nand2b_1
XFILLER_9_53 VDD VSS sg13g2_decap_8
XFILLER_18_84 VDD VSS sg13g2_fill_1
X_116_ _116_/Y _119_/A _150_/Q VDD VSS sg13g2_nand2_1
XFILLER_6_21 VDD VSS sg13g2_decap_8
Xoutput40 result[6] _145_/Q VDD VSS sg13g2_buf_1
Xoutput5 bit_active[1] _092_/X VDD VSS sg13g2_buf_1
XFILLER_15_52 VDD VSS sg13g2_decap_8
XFILLER_15_30 VDD VSS sg13g2_decap_4
X_080_ _081_/B _056_/Y _160_/Q _079_/Y VDD VSS sg13g2_a21oi_1
X_132_ _133_/A _083_/A _076_/B _147_/D _143_/Q VDD VSS sg13g2_a22oi_1
X_063_ _163_/D _113_/B _062_/X VDD VSS sg13g2_nor2b_1
XFILLER_3_0 VDD VSS sg13g2_decap_8
XFILLER_0_56 VDD VSS sg13g2_fill_2
X_115_ _115_/Y _119_/A _149_/Q VDD VSS sg13g2_nand2_1
Xoutput30 dac_code_n[6] _064_/Y VDD VSS sg13g2_buf_1
Xoutput41 result[7] _146_/Q VDD VSS sg13g2_buf_1
Xoutput6 bit_active[2] _087_/X VDD VSS sg13g2_buf_1
.ends
