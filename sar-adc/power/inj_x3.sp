* X1: bootstrap cap x4 (150 -> 600 fF), both sides
XCbP w_18920_n9960# a_15268_n9612# cap_cmim l=9.94u w=9.94u m=3
XCbN w_36972_n9960# a_40692_n9612# cap_cmim l=9.94u w=9.94u m=3
* X2: pmos in parallel with the bootstrap series switch Msw (gate = trkb), both sides
XswpP bstrap_1.out bstrap_1.ckb vinp VDD sg13_lv_pmos w=8u l=0.13u
XswpN bstrap_0.out bstrap_1.ckb vinn VDD sg13_lv_pmos w=8u l=0.13u
