* Ron flatness via 2-phase transient (charge then track), bootstrap vs TG
.lib /foss/pdks/ihp-sg13g2/libs.tech/ngspice/models/cornerMOSlv.lib mos_tt
.param vdd=1.5
.include ./bootstrap.cir
.subckt sw_tg bot vin trk trkb VDD VSS
XMNT bot trk vin VSS sg13_lv_nmos w=2.0u l=0.13u
XMPT bot trkb vin VDD sg13_lv_pmos w=4.0u l=0.13u
.ends

VDDs VDD 0 {vdd}
VSSs VSS 0 0
Vck  ck  0 pulse(0 {vdd} 50n 0.2n 0.2n 70n 200n)
Vckb ckb 0 pulse({vdd} 0 50n 0.2n 0.2n 70n 200n)

Vin  vin 0 0.75
Vb   outb 0 0.745
Vt   outt 0 0.745
Xb vin outb ck ckb VDD VSS bstrap
Xt outt vin ck ckb VDD VSS sw_tg

.control
let pts = 15
let i = 0
echo "# vin ron_boot ron_tg vg_minus_vin" > ron2.txt
dowhile i < pts
  let vv = 0.05 + i * 0.1
  let vs = vv - 0.005
  alter Vin dc = $&vv
  alter Vb  dc = $&vs
  alter Vt  dc = $&vs
  tran 0.1n 115n
  meas tran ib find i(Vb) at=110n
  meas tran it find i(Vt) at=110n
  meas tran vg find v(xb.g) at=110n
  let rb = 0.005 / abs(ib)
  let rt = 0.005 / abs(it)
  let dg = vg - vv
  echo "$&vv $&rb $&rt $&dg" >> ron2.txt
  destroy all
  let i = i + 1
end
quit
.endc
.end
